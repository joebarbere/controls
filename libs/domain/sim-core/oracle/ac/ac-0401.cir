controls oracle ac-0401
* Generated (plan F2.7, ADR 0012): do not edit; regenerate with `pnpm sim oracle regen`. ac seed 20261031 index 401 nodes 20 elements 33
.options sparse gmin=1e-12 noopac
RG1 1 0 1000000000000
RG2 2 0 1000000000000
RG3 3 0 1000000000000
RG4 4 0 1000000000000
RG5 5 0 1000000000000
RG6 6 0 1000000000000
RG7 7 0 1000000000000
RG8 8 0 1000000000000
RG9 9 0 1000000000000
RG10 10 0 1000000000000
RG11 11 0 1000000000000
RG12 12 0 1000000000000
RG13 13 0 1000000000000
RG14 14 0 1000000000000
RG15 15 0 1000000000000
RG16 16 0 1000000000000
RG17 17 0 1000000000000
RG18 18 0 1000000000000
RG19 19 0 1000000000000
VS0 3 s0 0
L0 s0 2 22e-2
VS1 2 s1 0
R1 s1 7 27e-1
VS2 5 s2 0
R2 s2 7 33e3
VS3 9 s3 0
R3 s3 13 22e-1
VS4 0 s4 0
V4 e4 s4 DC 0 AC 39e-1 120
RI4 e4 12 22e-3
VS5 2 s5 0
C5 s5 12 12e-5
VS6 0 s6 0
C6 s6 5 82e-7
VS7 15 s7 0
R7 s7 4 18e-2
VS8 11 s8 0
L8 s8 17 68e-2
VS9 10 s9 0
V9 e9 s9 DC 0 AC 18e1 120
RI9 e9 m9 22e-2
LI9 m9 9 68e-5
VS10 11 s10 0
C10 s10 3 10e-5
VS11 15 s11 0
L11 s11 9 56e-4
VS12 9 s12 0
R12 s12 16 56e-2
VS13 1 s13 0
R13 s13 13 68e-2
VS14 7 s14 0
R14 s14 11 18e3
VS15 18 s15 0
L15 s15 7 12e-3
VS16 0 s16 0
R16 s16 3 47e-2
VS17 8 s17 0
L17 s17 17 22e-4
VS18 3 s18 0
L18 s18 9 56e-2
VS19 16 s19 0
V19 e19 s19 DC 0 AC 39e0 0
RI19 e19 12 33e-1
VS20 6 s20 0
V20 e20 s20 DC 0 AC 82e0 120
RI20 e20 2 47e-1
VS21 5 s21 0
R21 s21 15 18e2
VS22 12 s22 0
L22 s22 4 39e-3
VS23 13 s23 0
C23 s23 1 12e-4
VS24 17 s24 0
L24 s24 1 15e-4
VS25 7 s25 0
C25 s25 8 33e-6
VS26 9 s26 0
C26 s26 14 27e-4
VS27 16 s27 0
C27 s27 4 56e-5
VS28 13 s28 0
V28 e28 s28 DC 0 AC 33e-1 180
RI28 e28 11 18e-3
VS29 17 s29 0
C29 s29 6 18e-7
VS30 14 s30 0
V30 e30 s30 DC 0 AC 33e0 -120
RI30 e30 m30 68e-2
LI30 m30 18 56e-5
VS31 10 s31 0
L31 s31 19 27e-3
VS32 13 s32 0
C32 s32 19 15e-4
.control
set numdgt=17
ac lin 1 60 60
print v(1) v(2) v(3) v(4) v(5) v(6) v(7) v(8) v(9) v(10)
print v(11) v(12) v(13) v(14) v(15) v(16) v(17) v(18) v(19)
print i(vs0) i(vs1) i(vs2) i(vs3) i(vs4) i(vs5) i(vs6) i(vs7) i(vs8) i(vs9)
print i(vs10) i(vs11) i(vs12) i(vs13) i(vs14) i(vs15) i(vs16) i(vs17) i(vs18) i(vs19)
print i(vs20) i(vs21) i(vs22) i(vs23) i(vs24) i(vs25) i(vs26) i(vs27) i(vs28) i(vs29)
print i(vs30) i(vs31) i(vs32)
.endc
.end
