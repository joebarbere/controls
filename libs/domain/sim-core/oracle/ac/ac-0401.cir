controls oracle ac-0401
* Generated (plan F2.7, ADR 0012): do not edit; regenerate with `pnpm sim oracle regen`. ac seed 20261031 index 401 nodes 20 elements 31
.options sparse gmin=1e-12 noopac
RG1 1 0 1000000000000
RG2 2 0 1000000000000
RG3 3 0 1000000000000
RG4 4 0 1000000000000
RG5 5 0 1000000000000
RG6 6 0 1000000000000
RG7 7 0 1000000000000
RG8 8 0 1000000000000
RG9 9 0 1000000000000
RG10 10 0 1000000000000
RG11 11 0 1000000000000
RG12 12 0 1000000000000
RG13 13 0 1000000000000
RG14 14 0 1000000000000
RG15 15 0 1000000000000
RG16 16 0 1000000000000
RG17 17 0 1000000000000
RG18 18 0 1000000000000
RG19 19 0 1000000000000
VS0 0 s0 0
V0 e0 s0 DC 0 AC 82e0 120
RI0 e0 2 47e-1
VS1 6 s1 0
R1 s1 16 56e-2
VS2 12 s2 0
R2 s2 15 68e0
VS3 13 s3 0
R3 s3 18 47e-2
VS4 10 s4 0
C4 s4 5 27e-4
VS5 6 s5 0
R5 s5 13 22e-1
VS6 18 s6 0
R6 s6 12 15e-2
VS7 2 s7 0
R7 s7 10 12e0
VS8 16 s8 0
C8 s8 19 47e-7
VS9 9 s9 0
V9 e9 s9 DC 0 AC 39e-1 120
RI9 e9 12 22e-3
VS10 12 s10 0
L10 s10 5 33e-5
VS11 12 s11 0
L11 s11 4 39e-3
VS12 3 s12 0
L12 s12 16 82e-2
VS13 10 s13 0
V13 e13 s13 DC 0 AC 18e1 120
RI13 e13 6 22e-2
VS14 3 s14 0
C14 s14 4 18e-4
VS15 19 s15 0
L15 s15 6 10e-3
VS16 16 s16 0
C16 s16 14 18e-7
VS17 7 s17 0
C17 s17 11 22e-5
VS18 9 s18 0
R18 s18 4 22e1
VS19 6 s19 0
V19 e19 s19 DC 0 AC 33e0 -120
RI19 e19 8 68e-2
VS20 0 s20 0
R20 s20 17 10e-2
VS21 7 s21 0
C21 s21 8 15e-5
VS22 16 s22 0
C22 s22 4 56e-5
VS23 0 s23 0
V23 e23 s23 DC 0 AC 15e1 120
RI23 e23 4 47e-3
VS24 13 s24 0
C24 s24 1 12e-4
VS25 17 s25 0
L25 s25 1 15e-4
VS26 19 s26 0
V26 e26 s26 DC 0 AC 56e0 120
RI26 e26 7 27e-2
VS27 6 s27 0
C27 s27 3 82e-7
VS28 15 s28 0
C28 s28 18 33e-6
VS29 18 s29 0
L29 s29 11 82e-5
VS30 3 s30 0
V30 e30 s30 DC 0 AC 12e-1 0
RI30 e30 14 10e-1
.control
set numdgt=17
ac lin 1 60 60
print v(1) v(2) v(3) v(4) v(5) v(6) v(7) v(8) v(9) v(10)
print v(11) v(12) v(13) v(14) v(15) v(16) v(17) v(18) v(19)
print i(vs0) i(vs1) i(vs2) i(vs3) i(vs4) i(vs5) i(vs6) i(vs7) i(vs8) i(vs9)
print i(vs10) i(vs11) i(vs12) i(vs13) i(vs14) i(vs15) i(vs16) i(vs17) i(vs18) i(vs19)
print i(vs20) i(vs21) i(vs22) i(vs23) i(vs24) i(vs25) i(vs26) i(vs27) i(vs28) i(vs29)
print i(vs30)
.endc
.end
