controls oracle ac-0401
* Generated (plan F2.7, ADR 0012): do not edit; regenerate with `pnpm sim oracle regen`. ac seed 20261031 index 401 nodes 20 elements 29
.options sparse gmin=1e-12 noopac
RG1 1 0 1000000000000
RG2 2 0 1000000000000
RG3 3 0 1000000000000
RG4 4 0 1000000000000
RG5 5 0 1000000000000
RG6 6 0 1000000000000
RG7 7 0 1000000000000
RG8 8 0 1000000000000
RG9 9 0 1000000000000
RG10 10 0 1000000000000
RG11 11 0 1000000000000
RG12 12 0 1000000000000
RG13 13 0 1000000000000
RG14 14 0 1000000000000
RG15 15 0 1000000000000
RG16 16 0 1000000000000
RG17 17 0 1000000000000
RG18 18 0 1000000000000
RG19 19 0 1000000000000
VS0 0 s0 0
V0 e0 s0 DC 0 AC 33e0 -120
RI0 e0 8 68e-2
VS1 9 s1 0
V1 e1 s1 DC 0 AC 39e-1 120
RI1 e1 12 22e-3
VS2 10 s2 0
V2 e2 s2 DC 0 AC 18e1 120
RI2 e2 0 22e-2
VS3 6 s3 0
V3 e3 s3 DC 0 AC 82e0 120
RI3 e3 2 47e-1
VS4 16 s4 0
C4 s4 19 47e-7
VS5 3 s5 0
L5 s5 16 82e-2
VS6 10 s6 0
C6 s6 5 27e-4
VS7 18 s7 0
R7 s7 12 15e-2
VS8 19 s8 0
L8 s8 0 10e-3
VS9 12 s9 0
L9 s9 4 39e-3
VS10 13 s10 0
C10 s10 1 12e-4
VS11 15 s11 0
C11 s11 18 33e-6
VS12 7 s12 0
C12 s12 11 22e-5
VS13 0 s13 0
R13 s13 13 22e-1
VS14 16 s14 0
C14 s14 4 56e-5
VS15 2 s15 0
R15 s15 10 12e0
VS16 3 s16 0
V16 e16 s16 DC 0 AC 12e-1 0
RI16 e16 14 10e-1
VS17 0 s17 0
C17 s17 3 82e-7
VS18 16 s18 0
C18 s18 14 18e-7
VS19 12 s19 0
R19 s19 15 68e0
VS20 13 s20 0
R20 s20 18 47e-2
VS21 17 s21 0
L21 s21 1 15e-4
VS22 0 s22 0
R22 s22 16 56e-2
VS23 12 s23 0
L23 s23 5 33e-5
VS24 7 s24 0
C24 s24 8 15e-5
VS25 19 s25 0
V25 e25 s25 DC 0 AC 56e0 120
RI25 e25 7 27e-2
VS26 6 s26 0
V26 e26 s26 DC 0 AC 15e1 120
RI26 e26 4 47e-3
VS27 3 s27 0
C27 s27 4 18e-4
VS28 6 s28 0
R28 s28 17 10e-2
.control
set numdgt=17
ac lin 1 60 60
print v(1) v(2) v(3) v(4) v(5) v(6) v(7) v(8) v(9) v(10)
print v(11) v(12) v(13) v(14) v(15) v(16) v(17) v(18) v(19)
print i(vs0) i(vs1) i(vs2) i(vs3) i(vs4) i(vs5) i(vs6) i(vs7) i(vs8) i(vs9)
print i(vs10) i(vs11) i(vs12) i(vs13) i(vs14) i(vs15) i(vs16) i(vs17) i(vs18) i(vs19)
print i(vs20) i(vs21) i(vs22) i(vs23) i(vs24) i(vs25) i(vs26) i(vs27) i(vs28)
.endc
.end
