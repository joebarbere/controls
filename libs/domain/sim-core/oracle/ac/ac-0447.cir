controls oracle ac-0447
* Generated (plan F2.7, ADR 0012): do not edit; regenerate with `pnpm sim oracle regen`. ac seed 20261031 index 447 nodes 21 elements 30
.options sparse gmin=1e-12 noopac
RG1 1 0 1000000000000
RG2 2 0 1000000000000
RG3 3 0 1000000000000
RG4 4 0 1000000000000
RG5 5 0 1000000000000
RG6 6 0 1000000000000
RG7 7 0 1000000000000
RG8 8 0 1000000000000
RG9 9 0 1000000000000
RG10 10 0 1000000000000
RG11 11 0 1000000000000
RG12 12 0 1000000000000
RG13 13 0 1000000000000
RG14 14 0 1000000000000
RG15 15 0 1000000000000
RG16 16 0 1000000000000
RG17 17 0 1000000000000
RG18 18 0 1000000000000
RG19 19 0 1000000000000
RG20 20 0 1000000000000
VS0 15 s0 0
R0 s0 2 18e2
VS1 7 s1 0
L1 s1 18 68e-3
VS2 16 s2 0
R2 s2 2 27e0
VS3 19 s3 0
R3 s3 4 47e0
VS4 15 s4 0
R4 s4 18 27e3
VS5 1 s5 0
L5 s5 2 18e-5
VS6 7 s6 0
C6 s6 0 18e-6
VS7 6 s7 0
C7 s7 8 22e-6
VS8 0 s8 0
V8 e8 s8 DC 0 AC 27e-1 -120
RI8 e8 m8 15e-1
LI8 m8 3 10e-6
VS9 17 s9 0
L9 s9 1 12e-5
VS10 4 s10 0
C10 s10 13 47e-5
VS11 4 s11 0
V11 e11 s11 DC 0 AC 56e-1 0
RI11 e11 12 68e-1
VS12 11 s12 0
L12 s12 14 39e-3
VS13 17 s13 0
L13 s13 11 56e-2
VS14 8 s14 0
L14 s14 2 27e-3
VS15 13 s15 0
V15 e15 s15 DC 0 AC 68e-1 180
RI15 e15 9 39e-3
VS16 5 s16 0
R16 s16 3 15e3
VS17 14 s17 0
L17 s17 13 68e-5
VS18 6 s18 0
R18 s18 0 82e3
VS19 20 s19 0
L19 s19 5 18e-4
VS20 3 s20 0
C20 s20 16 39e-5
VS21 19 s21 0
V21 e21 s21 DC 0 AC 18e-1 -120
RI21 e21 9 10e-1
VS22 10 s22 0
C22 s22 17 12e-5
VS23 4 s23 0
V23 e23 s23 DC 0 AC 33e0 120
RI23 e23 m23 47e-3
LI23 m23 16 39e-5
VS24 14 s24 0
C24 s24 12 18e-7
VS25 10 s25 0
R25 s25 9 56e1
VS26 9 s26 0
L26 s26 14 47e-5
VS27 2 s27 0
V27 e27 s27 DC 0 AC 12e-1 0
RI27 e27 20 27e-3
VS28 9 s28 0
L28 s28 15 22e-3
VS29 1 s29 0
C29 s29 16 33e-4
.control
set numdgt=17
ac lin 1 60 60
print v(1) v(2) v(3) v(4) v(5) v(6) v(7) v(8) v(9) v(10)
print v(11) v(12) v(13) v(14) v(15) v(16) v(17) v(18) v(19) v(20)
print i(vs0) i(vs1) i(vs2) i(vs3) i(vs4) i(vs5) i(vs6) i(vs7) i(vs8) i(vs9)
print i(vs10) i(vs11) i(vs12) i(vs13) i(vs14) i(vs15) i(vs16) i(vs17) i(vs18) i(vs19)
print i(vs20) i(vs21) i(vs22) i(vs23) i(vs24) i(vs25) i(vs26) i(vs27) i(vs28) i(vs29)
.endc
.end
