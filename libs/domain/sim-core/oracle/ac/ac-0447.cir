controls oracle ac-0447
* Generated (plan F2.7, ADR 0012): do not edit; regenerate with `pnpm sim oracle regen`. ac seed 20261031 index 447 nodes 21 elements 22
.options sparse gmin=1e-12 noopac
RG1 1 0 1000000000000
RG2 2 0 1000000000000
RG3 3 0 1000000000000
RG4 4 0 1000000000000
RG5 5 0 1000000000000
RG6 6 0 1000000000000
RG7 7 0 1000000000000
RG8 8 0 1000000000000
RG9 9 0 1000000000000
RG10 10 0 1000000000000
RG11 11 0 1000000000000
RG12 12 0 1000000000000
RG13 13 0 1000000000000
RG14 14 0 1000000000000
RG15 15 0 1000000000000
RG16 16 0 1000000000000
RG17 17 0 1000000000000
RG18 18 0 1000000000000
RG19 19 0 1000000000000
RG20 20 0 1000000000000
VS0 6 s0 0
C0 s0 8 22e-6
VS1 8 s1 0
L1 s1 2 27e-3
VS2 8 s2 0
R2 s2 13 15e0
VS3 2 s3 0
L3 s3 1 18e-4
VS4 0 s4 0
V4 e4 s4 DC 0 AC 68e-1 180
RI4 e4 8 39e-3
VS5 10 s5 0
R5 s5 9 56e1
VS6 7 s6 0
C6 s6 5 18e-6
VS7 2 s7 0
V7 e7 s7 DC 0 AC 12e-1 0
RI7 e7 20 27e-3
VS8 14 s8 0
V8 e8 s8 DC 0 AC 56e-1 0
RI8 e8 12 18e-1
VS9 4 s9 0
C9 s9 13 47e-5
VS10 14 s10 0
L10 s10 19 47e-5
VS11 15 s11 0
R11 s11 2 18e2
VS12 11 s12 0
L12 s12 14 39e-3
VS13 9 s13 0
L13 s13 15 22e-3
VS14 14 s14 0
R14 s14 9 82e1
VS15 14 s15 0
L15 s15 13 68e-5
VS16 4 s16 0
V16 e16 s16 DC 0 AC 33e0 120
RI16 e16 16 47e-3
VS17 2 s17 0
V17 e17 s17 DC 0 AC 47e-1 -120
RI17 e17 7 33e-3
VS18 17 s18 0
L18 s18 11 56e-2
VS19 15 s19 0
R19 s19 18 27e3
VS20 0 s20 0
V20 e20 s20 DC 0 AC 27e-1 -120
RI20 e20 3 15e-1
VS21 15 s21 0
V21 e21 s21 DC 0 AC 56e1 0
RI21 e21 16 82e-1
.control
set numdgt=17
ac lin 1 60 60
print v(1) v(2) v(3) v(4) v(5) v(6) v(7) v(8) v(9) v(10)
print v(11) v(12) v(13) v(14) v(15) v(16) v(17) v(18) v(19) v(20)
print i(vs0) i(vs1) i(vs2) i(vs3) i(vs4) i(vs5) i(vs6) i(vs7) i(vs8) i(vs9)
print i(vs10) i(vs11) i(vs12) i(vs13) i(vs14) i(vs15) i(vs16) i(vs17) i(vs18) i(vs19)
print i(vs20) i(vs21)
.endc
.end
