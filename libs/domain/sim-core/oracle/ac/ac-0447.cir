controls oracle ac-0447
* Generated (plan F2.7, ADR 0012): do not edit; regenerate with `pnpm sim oracle regen`. ac seed 20261031 index 447 nodes 21 elements 33
.options sparse gmin=1e-12 noopac
RG1 1 0 1000000000000
RG2 2 0 1000000000000
RG3 3 0 1000000000000
RG4 4 0 1000000000000
RG5 5 0 1000000000000
RG6 6 0 1000000000000
RG7 7 0 1000000000000
RG8 8 0 1000000000000
RG9 9 0 1000000000000
RG10 10 0 1000000000000
RG11 11 0 1000000000000
RG12 12 0 1000000000000
RG13 13 0 1000000000000
RG14 14 0 1000000000000
RG15 15 0 1000000000000
RG16 16 0 1000000000000
RG17 17 0 1000000000000
RG18 18 0 1000000000000
RG19 19 0 1000000000000
RG20 20 0 1000000000000
VS0 0 s0 0
L0 s0 19 47e-5
VS1 0 s1 0
V1 e1 s1 DC 0 AC 56e-1 0
RI1 e1 m1 18e-1
LI1 m1 n1 68e-6
H1 n1 h1 VS2 -68e-4
ED1 h1 12 d1 0 68e-7
F1 0 d1 VS2 1
LD1 d1 0 1
VS2 2 s2 0
V2 e2 s2 DC 0 AC 68e-1 180
RI2 e2 n2 39e-3
H2 n2 h2 VS1 -68e-4
ED2 h2 8 d2 0 68e-7
F2 0 d2 VS1 1
LD2 d2 0 1
VS3 8 s3 0
L3 s3 14 27e-3
VS4 8 s4 0
R4 s4 13 15e0
VS5 14 s5 0
L5 s5 5 22e-3
VS6 0 s6 0
L6 s6 13 68e-5
VS7 7 s7 0
C7 s7 5 18e-6
VS8 12 s8 0
R8 s8 19 68e3
VS9 14 s9 0
V9 e9 s9 DC 0 AC 12e-1 0
RI9 e9 20 27e-3
VS10 10 s10 0
R10 s10 9 56e1
VS11 15 s11 0
R11 s11 14 18e2
VS12 13 s12 0
R12 s12 17 18e0
VS13 15 s13 0
R13 s13 18 27e3
VS14 12 s14 0
L14 s14 18 56e-2
VS15 14 s15 0
V15 e15 s15 DC 0 AC 47e-1 -120
RI15 e15 m15 33e-3
LI15 m15 7 56e-6
VS16 20 s16 0
R16 s16 9 12e0
VS17 17 s17 0
L17 s17 11 56e-2
VS18 14 s18 0
L18 s18 1 18e-4
VS19 1 s19 0
L19 s19 0 18e-5
VS20 4 s20 0
V20 e20 s20 DC 0 AC 33e0 120
RI20 e20 m20 47e-3
LI20 m20 16 27e-6
VS21 15 s21 0
V21 e21 s21 DC 0 AC 56e1 0
RI21 e21 m21 82e-1
LI21 m21 16 15e-7
VS22 2 s22 0
V22 e22 s22 DC 0 AC 27e-1 -120
RI22 e22 m22 15e-1
LI22 m22 3 12e-6
VS23 4 s23 0
C23 s23 13 47e-5
VS24 8 s24 0
R24 s24 3 33e3
VS25 11 s25 0
L25 s25 0 39e-3
VS26 6 s26 0
C26 s26 8 22e-6
VS27 12 s27 0
R27 s27 7 56e-2
VS28 9 s28 0
L28 s28 15 22e-3
VS29 3 s29 0
R29 s29 15 12e1
VS30 0 s30 0
R30 s30 9 82e1
VS31 6 s31 0
V31 e31 s31 DC 0 AC 12e0 120
RI31 e31 9 47e-3
VS32 16 s32 0
L32 s32 10 18e-5
.control
set numdgt=17
ac lin 1 60 60
print v(1) v(2) v(3) v(4) v(5) v(6) v(7) v(8) v(9) v(10)
print v(11) v(12) v(13) v(14) v(15) v(16) v(17) v(18) v(19) v(20)
print i(vs0) i(vs1) i(vs2) i(vs3) i(vs4) i(vs5) i(vs6) i(vs7) i(vs8) i(vs9)
print i(vs10) i(vs11) i(vs12) i(vs13) i(vs14) i(vs15) i(vs16) i(vs17) i(vs18) i(vs19)
print i(vs20) i(vs21) i(vs22) i(vs23) i(vs24) i(vs25) i(vs26) i(vs27) i(vs28) i(vs29)
print i(vs30) i(vs31) i(vs32)
.endc
.end
