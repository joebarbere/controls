controls oracle ac-0010
* Generated (plan F2.7, ADR 0012): do not edit; regenerate with `pnpm sim oracle regen`. ac seed 20261031 index 10 nodes 13 elements 17
.options sparse gmin=1e-12 noopac
RG1 1 0 1000000000000
RG2 2 0 1000000000000
RG3 3 0 1000000000000
RG4 4 0 1000000000000
RG5 5 0 1000000000000
RG6 6 0 1000000000000
RG7 7 0 1000000000000
RG8 8 0 1000000000000
RG9 9 0 1000000000000
RG10 10 0 1000000000000
RG11 11 0 1000000000000
RG12 12 0 1000000000000
VS0 4 s0 0
R0 s0 5 18e3
VS1 0 s1 0
V1 e1 s1 DC 0 AC 33e0 0
RI1 e1 m1 18e-1
LI1 m1 8 12e-5
VS2 3 s2 0
L2 s2 1 10e-3
VS3 5 s3 0
L3 s3 2 27e-2
VS4 6 s4 0
R4 s4 11 10e1
VS5 2 s5 0
C5 s5 9 56e-6
VS6 1 s6 0
R6 s6 11 47e0
VS7 8 s7 0
R7 s7 7 12e-1
VS8 6 s8 0
V8 e8 s8 DC 0 AC 22e0 180
RI8 e8 4 68e-2
VS9 9 s9 0
L9 s9 8 15e-4
VS10 0 s10 0
V10 e10 s10 DC 0 AC 39e1 0
RI10 e10 m10 10e-2
LI10 m10 1 39e-7
VS11 8 s11 0
V11 e11 s11 DC 0 AC 10e1 180
RI11 e11 m11 12e-2
LI11 m11 12 56e-5
VS12 10 s12 0
R12 s12 5 82e-1
VS13 10 s13 0
C13 s13 11 82e-7
VS14 3 s14 0
R14 s14 12 47e-2
VS15 4 s15 0
C15 s15 12 18e-4
VS16 7 s16 0
V16 e16 s16 DC 0 AC 47e-1 0
RI16 e16 m16 82e-3
LI16 m16 5 27e-7
.control
set numdgt=17
ac lin 1 60 60
print v(1) v(2) v(3) v(4) v(5) v(6) v(7) v(8) v(9) v(10)
print v(11) v(12)
print i(vs0) i(vs1) i(vs2) i(vs3) i(vs4) i(vs5) i(vs6) i(vs7) i(vs8) i(vs9)
print i(vs10) i(vs11) i(vs12) i(vs13) i(vs14) i(vs15) i(vs16)
.endc
.end
