controls oracle ac-0010
* Generated (plan F2.7, ADR 0012): do not edit; regenerate with `pnpm sim oracle regen`. ac seed 20261031 index 10 nodes 13 elements 18
.options sparse gmin=1e-12 noopac
RG1 1 0 1000000000000
RG2 2 0 1000000000000
RG3 3 0 1000000000000
RG4 4 0 1000000000000
RG5 5 0 1000000000000
RG6 6 0 1000000000000
RG7 7 0 1000000000000
RG8 8 0 1000000000000
RG9 9 0 1000000000000
RG10 10 0 1000000000000
RG11 11 0 1000000000000
RG12 12 0 1000000000000
VS0 0 s0 0
V0 e0 s0 DC 0 AC 82e1 180
RI0 e0 8 18e-1
VS1 5 s1 0
L1 s1 11 68e-4
VS2 5 s2 0
R2 s2 9 56e-2
VS3 6 s3 0
L3 s3 9 47e-2
VS4 6 s4 0
R4 s4 4 27e0
VS5 8 s5 0
V5 e5 s5 DC 0 AC 10e1 180
RI5 e5 m5 12e-2
LI5 m5 12 33e-7
VS6 5 s6 0
L6 s6 4 15e-5
VS7 12 s7 0
L7 s7 7 18e-5
VS8 0 s8 0
V8 e8 s8 DC 0 AC 15e-1 0
RI8 e8 10 18e-1
VS9 8 s9 0
R9 s9 6 12e-1
VS10 3 s10 0
R10 s10 2 47e0
VS11 11 s11 0
V11 e11 s11 DC 0 AC 56e1 0
RI11 e11 1 10e-1
VS12 10 s12 0
R12 s12 2 22e1
VS13 2 s13 0
R13 s13 6 12e-2
VS14 3 s14 0
L14 s14 4 10e-3
VS15 6 s15 0
V15 e15 s15 DC 0 AC 12e0 120
RI15 e15 m15 56e-2
LI15 m15 1 68e-6
VS16 7 s16 0
C16 s16 2 39e-6
VS17 7 s17 0
L17 s17 11 10e-3
.control
set numdgt=17
ac lin 1 60 60
print v(1) v(2) v(3) v(4) v(5) v(6) v(7) v(8) v(9) v(10)
print v(11) v(12)
print i(vs0) i(vs1) i(vs2) i(vs3) i(vs4) i(vs5) i(vs6) i(vs7) i(vs8) i(vs9)
print i(vs10) i(vs11) i(vs12) i(vs13) i(vs14) i(vs15) i(vs16) i(vs17)
.endc
.end
