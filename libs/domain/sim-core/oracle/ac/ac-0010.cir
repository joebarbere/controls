controls oracle ac-0010
* Generated (plan F2.7, ADR 0012): do not edit; regenerate with `pnpm sim oracle regen`. ac seed 20261031 index 10 nodes 13 elements 16
.options sparse gmin=1e-12 noopac
RG1 1 0 1000000000000
RG2 2 0 1000000000000
RG3 3 0 1000000000000
RG4 4 0 1000000000000
RG5 5 0 1000000000000
RG6 6 0 1000000000000
RG7 7 0 1000000000000
RG8 8 0 1000000000000
RG9 9 0 1000000000000
RG10 10 0 1000000000000
RG11 11 0 1000000000000
RG12 12 0 1000000000000
VS0 0 s0 0
V0 e0 s0 DC 0 AC 15e-1 0
RI0 e0 10 18e-1
VS1 6 s1 0
R1 s1 4 27e0
VS2 6 s2 0
L2 s2 9 47e-2
VS3 0 s3 0
V3 e3 s3 DC 0 AC 82e1 180
RI3 e3 8 18e-1
VS4 8 s4 0
R4 s4 6 12e-1
VS5 3 s5 0
L5 s5 4 10e-3
VS6 5 s6 0
L6 s6 4 15e-5
VS7 3 s7 0
R7 s7 2 47e0
VS8 7 s8 0
L8 s8 11 10e-3
VS9 7 s9 0
C9 s9 2 39e-6
VS10 8 s10 0
V10 e10 s10 DC 0 AC 10e1 180
RI10 e10 12 12e-2
VS11 5 s11 0
L11 s11 11 68e-4
VS12 6 s12 0
V12 e12 s12 DC 0 AC 12e0 120
RI12 e12 1 56e-2
VS13 2 s13 0
R13 s13 6 12e-2
VS14 5 s14 0
R14 s14 9 56e-2
VS15 12 s15 0
L15 s15 7 18e-5
.control
set numdgt=17
ac lin 1 60 60
print v(1) v(2) v(3) v(4) v(5) v(6) v(7) v(8) v(9) v(10)
print v(11) v(12)
print i(vs0) i(vs1) i(vs2) i(vs3) i(vs4) i(vs5) i(vs6) i(vs7) i(vs8) i(vs9)
print i(vs10) i(vs11) i(vs12) i(vs13) i(vs14) i(vs15)
.endc
.end
