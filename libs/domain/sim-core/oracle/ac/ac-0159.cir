controls oracle ac-0159
* Generated (plan F2.7, ADR 0012): do not edit; regenerate with `pnpm sim oracle regen`. ac seed 20261031 index 159 nodes 8 elements 12
.options sparse gmin=1e-12 noopac
RG1 1 0 1000000000000
RG2 2 0 1000000000000
RG3 3 0 1000000000000
RG4 4 0 1000000000000
RG5 5 0 1000000000000
RG6 6 0 1000000000000
RG7 7 0 1000000000000
VS0 4 s0 0
L0 s0 7 22e-2
VS1 1 s1 0
L1 s1 6 33e-2
VS2 0 s2 0
V2 e2 s2 DC 0 AC 10e-1 180
RI2 e2 3 82e-1
VS3 4 s3 0
R3 s3 6 82e-2
VS4 2 s4 0
V4 e4 s4 DC 0 AC 39e0 180
RI4 e4 6 15e-1
VS5 5 s5 0
C5 s5 4 56e-6
VS6 4 s6 0
L6 s6 3 10e-3
VS7 1 s7 0
C7 s7 7 33e-5
VS8 7 s8 0
L8 s8 6 27e-4
VS9 7 s9 0
L9 s9 0 39e-4
VS10 5 s10 0
L10 s10 6 18e-4
VS11 2 s11 0
V11 e11 s11 DC 0 AC 22e1 120
RI11 e11 m11 27e-3
LI11 m11 0 82e-7
.control
set numdgt=17
ac lin 1 60 60
print v(1) v(2) v(3) v(4) v(5) v(6) v(7)
print i(vs0) i(vs1) i(vs2) i(vs3) i(vs4) i(vs5) i(vs6) i(vs7) i(vs8) i(vs9)
print i(vs10) i(vs11)
.endc
.end
