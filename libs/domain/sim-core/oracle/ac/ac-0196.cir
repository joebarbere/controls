controls oracle ac-0196
* Generated (plan F2.7, ADR 0012): do not edit; regenerate with `pnpm sim oracle regen`. ac seed 20261031 index 196 nodes 10 elements 15
.options sparse gmin=1e-12 noopac
RG1 1 0 1000000000000
RG2 2 0 1000000000000
RG3 3 0 1000000000000
RG4 4 0 1000000000000
RG5 5 0 1000000000000
RG6 6 0 1000000000000
RG7 7 0 1000000000000
RG8 8 0 1000000000000
RG9 9 0 1000000000000
VS0 0 s0 0
R0 s0 3 82e3
VS1 3 s1 0
R1 s1 1 27e0
VS2 2 s2 0
R2 s2 4 10e2
VS3 4 s3 0
C3 s3 1 12e-7
VS4 1 s4 0
R4 s4 9 18e-1
VS5 5 s5 0
C5 s5 8 18e-4
VS6 5 s6 0
R6 s6 6 22e0
VS7 8 s7 0
L7 s7 3 56e-2
VS8 0 s8 0
V8 e8 s8 DC 0 AC 82e-1 180
RI8 e8 1 68e-2
VS9 5 s9 0
L9 s9 3 18e-3
VS10 8 s10 0
L10 s10 0 18e-3
VS11 5 s11 0
C11 s11 7 22e-5
VS12 9 s12 0
R12 s12 2 33e3
VS13 9 s13 0
L13 s13 6 10e-4
VS14 3 s14 0
L14 s14 5 39e-3
.control
set numdgt=17
ac lin 1 60 60
print v(1) v(2) v(3) v(4) v(5) v(6) v(7) v(8) v(9)
print i(vs0) i(vs1) i(vs2) i(vs3) i(vs4) i(vs5) i(vs6) i(vs7) i(vs8) i(vs9)
print i(vs10) i(vs11) i(vs12) i(vs13) i(vs14)
.endc
.end
