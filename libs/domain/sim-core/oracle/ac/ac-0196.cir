controls oracle ac-0196
* Generated (plan F2.7, ADR 0012): do not edit; regenerate with `pnpm sim oracle regen`. ac seed 20261031 index 196 nodes 10 elements 16
.options sparse gmin=1e-12 noopac
RG1 1 0 1000000000000
RG2 2 0 1000000000000
RG3 3 0 1000000000000
RG4 4 0 1000000000000
RG5 5 0 1000000000000
RG6 6 0 1000000000000
RG7 7 0 1000000000000
RG8 8 0 1000000000000
RG9 9 0 1000000000000
VS0 9 s0 0
L0 s0 6 10e-4
VS1 1 s1 0
R1 s1 9 18e-1
VS2 0 s2 0
V2 e2 s2 DC 0 AC 82e-1 180
RI2 e2 1 68e-2
VS3 8 s3 0
R3 s3 7 12e0
VS4 4 s4 0
C4 s4 1 12e-7
VS5 5 s5 0
R5 s5 6 22e0
VS6 0 s6 0
R6 s6 3 82e3
VS7 8 s7 0
L7 s7 3 56e-2
VS8 3 s8 0
R8 s8 1 27e0
VS9 3 s9 0
L9 s9 5 39e-3
VS10 5 s10 0
C10 s10 8 18e-4
VS11 8 s11 0
L11 s11 0 18e-3
VS12 5 s12 0
C12 s12 7 22e-5
VS13 5 s13 0
L13 s13 3 18e-3
VS14 2 s14 0
R14 s14 4 10e2
VS15 9 s15 0
R15 s15 2 33e3
.control
set numdgt=17
ac lin 1 60 60
print v(1) v(2) v(3) v(4) v(5) v(6) v(7) v(8) v(9)
print i(vs0) i(vs1) i(vs2) i(vs3) i(vs4) i(vs5) i(vs6) i(vs7) i(vs8) i(vs9)
print i(vs10) i(vs11) i(vs12) i(vs13) i(vs14) i(vs15)
.endc
.end
