controls oracle ac-0196
* Generated (plan F2.7, ADR 0012): do not edit; regenerate with `pnpm sim oracle regen`. ac seed 20261031 index 196 nodes 10 elements 16
.options sparse gmin=1e-12 noopac
RG1 1 0 1000000000000
RG2 2 0 1000000000000
RG3 3 0 1000000000000
RG4 4 0 1000000000000
RG5 5 0 1000000000000
RG6 6 0 1000000000000
RG7 7 0 1000000000000
RG8 8 0 1000000000000
RG9 9 0 1000000000000
VS0 0 s0 0
V0 e0 s0 DC 0 AC 82e-1 180
RI0 e0 1 68e-2
VS1 1 s1 0
R1 s1 9 18e-1
VS2 3 s2 0
L2 s2 5 39e-3
VS3 9 s3 0
R3 s3 2 33e3
VS4 5 s4 0
C4 s4 7 22e-5
VS5 4 s5 0
C5 s5 1 12e-7
VS6 5 s6 0
L6 s6 3 18e-3
VS7 7 s7 0
R7 s7 3 68e-1
VS8 9 s8 0
L8 s8 6 10e-4
VS9 3 s9 0
R9 s9 1 27e0
VS10 5 s10 0
C10 s10 8 18e-4
VS11 8 s11 0
L11 s11 0 18e-3
VS12 0 s12 0
R12 s12 3 82e3
VS13 5 s13 0
R13 s13 6 22e0
VS14 2 s14 0
R14 s14 4 10e2
VS15 8 s15 0
L15 s15 3 56e-2
.control
set numdgt=17
ac lin 1 60 60
print v(1) v(2) v(3) v(4) v(5) v(6) v(7) v(8) v(9)
print i(vs0) i(vs1) i(vs2) i(vs3) i(vs4) i(vs5) i(vs6) i(vs7) i(vs8) i(vs9)
print i(vs10) i(vs11) i(vs12) i(vs13) i(vs14) i(vs15)
.endc
.end
