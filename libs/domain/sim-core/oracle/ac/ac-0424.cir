controls oracle ac-0424
* Generated (plan F2.7, ADR 0012): do not edit; regenerate with `pnpm sim oracle regen`. ac seed 20261031 index 424 nodes 17 elements 31
.options sparse gmin=1e-12 noopac
RG1 1 0 1000000000000
RG2 2 0 1000000000000
RG3 3 0 1000000000000
RG4 4 0 1000000000000
RG5 5 0 1000000000000
RG6 6 0 1000000000000
RG7 7 0 1000000000000
RG8 8 0 1000000000000
RG9 9 0 1000000000000
RG10 10 0 1000000000000
RG11 11 0 1000000000000
RG12 12 0 1000000000000
RG13 13 0 1000000000000
RG14 14 0 1000000000000
RG15 15 0 1000000000000
RG16 16 0 1000000000000
VS0 13 s0 0
C0 s0 1 82e-6
VS1 7 s1 0
R1 s1 6 47e0
VS2 10 s2 0
C2 s2 11 33e-6
VS3 12 s3 0
R3 s3 16 33e3
VS4 7 s4 0
R4 s4 9 82e1
VS5 6 s5 0
R5 s5 13 10e-1
VS6 12 s6 0
L6 s6 10 56e-5
VS7 16 s7 0
R7 s7 14 68e-2
VS8 6 s8 0
R8 s8 1 47e2
VS9 0 s9 0
V9 e9 s9 DC 0 AC 39e0 -120
RI9 e9 10 15e-3
VS10 5 s10 0
V10 e10 s10 DC 0 AC 33e0 0
RI10 e10 m10 27e-3
LI10 m10 14 10e-5
VS11 14 s11 0
C11 s11 2 15e-4
VS12 12 s12 0
C12 s12 9 10e-7
VS13 4 s13 0
R13 s13 14 39e0
VS14 16 s14 0
R14 s14 13 27e0
VS15 10 s15 0
V15 e15 s15 DC 0 AC 12e1 120
RI15 e15 1 15e-3
VS16 14 s16 0
R16 s16 3 12e0
VS17 4 s17 0
L17 s17 6 15e-4
VS18 4 s18 0
C18 s18 0 33e-5
VS19 9 s19 0
R19 s19 15 68e3
VS20 11 s20 0
R20 s20 13 22e0
VS21 3 s21 0
C21 s21 14 12e-4
VS22 10 s22 0
L22 s22 12 39e-3
VS23 14 s23 0
C23 s23 10 82e-7
VS24 10 s24 0
L24 s24 2 47e-4
VS25 8 s25 0
R25 s25 4 10e-2
VS26 6 s26 0
R26 s26 12 56e1
VS27 3 s27 0
C27 s27 4 18e-7
VS28 15 s28 0
L28 s28 8 10e-5
VS29 5 s29 0
L29 s29 6 15e-3
VS30 9 s30 0
R30 s30 7 22e-2
.control
set numdgt=17
ac lin 1 60 60
print v(1) v(2) v(3) v(4) v(5) v(6) v(7) v(8) v(9) v(10)
print v(11) v(12) v(13) v(14) v(15) v(16)
print i(vs0) i(vs1) i(vs2) i(vs3) i(vs4) i(vs5) i(vs6) i(vs7) i(vs8) i(vs9)
print i(vs10) i(vs11) i(vs12) i(vs13) i(vs14) i(vs15) i(vs16) i(vs17) i(vs18) i(vs19)
print i(vs20) i(vs21) i(vs22) i(vs23) i(vs24) i(vs25) i(vs26) i(vs27) i(vs28) i(vs29)
print i(vs30)
.endc
.end
