controls oracle ac-0424
* Generated (plan F2.7, ADR 0012): do not edit; regenerate with `pnpm sim oracle regen`. ac seed 20261031 index 424 nodes 17 elements 28
.options sparse gmin=1e-12 noopac
RG1 1 0 1000000000000
RG2 2 0 1000000000000
RG3 3 0 1000000000000
RG4 4 0 1000000000000
RG5 5 0 1000000000000
RG6 6 0 1000000000000
RG7 7 0 1000000000000
RG8 8 0 1000000000000
RG9 9 0 1000000000000
RG10 10 0 1000000000000
RG11 11 0 1000000000000
RG12 12 0 1000000000000
RG13 13 0 1000000000000
RG14 14 0 1000000000000
RG15 15 0 1000000000000
RG16 16 0 1000000000000
VS0 0 s0 0
V0 e0 s0 DC 0 AC 12e1 120
RI0 e0 1 15e-3
VS1 6 s1 0
R1 s1 13 10e-1
VS2 4 s2 0
C2 s2 12 33e-5
VS3 6 s3 0
R3 s3 10 56e1
VS4 16 s4 0
R4 s4 13 27e0
VS5 5 s5 0
L5 s5 6 15e-3
VS6 11 s6 0
R6 s6 13 22e0
VS7 0 s7 0
L7 s7 10 39e-3
VS8 9 s8 0
R8 s8 15 68e3
VS9 10 s9 0
L9 s9 0 56e-5
VS10 10 s10 0
C10 s10 9 10e-7
VS11 15 s11 0
L11 s11 8 10e-5
VS12 6 s12 0
R12 s12 1 47e2
VS13 3 s13 0
C13 s13 14 12e-4
VS14 8 s14 0
R14 s14 4 10e-2
VS15 4 s15 0
R15 s15 14 39e0
VS16 13 s16 0
C16 s16 1 82e-6
VS17 7 s17 0
R17 s17 9 82e1
VS18 14 s18 0
R18 s18 3 12e0
VS19 0 s19 0
L19 s19 2 47e-4
VS20 14 s20 0
C20 s20 2 15e-4
VS21 3 s21 0
C21 s21 4 18e-7
VS22 9 s22 0
R22 s22 7 22e-2
VS23 10 s23 0
R23 s23 16 33e3
VS24 16 s24 0
R24 s24 14 68e-2
VS25 14 s25 0
C25 s25 0 82e-7
VS26 4 s26 0
L26 s26 6 15e-4
VS27 0 s27 0
C27 s27 11 33e-6
.control
set numdgt=17
ac lin 1 60 60
print v(1) v(2) v(3) v(4) v(5) v(6) v(7) v(8) v(9) v(10)
print v(11) v(12) v(13) v(14) v(15) v(16)
print i(vs0) i(vs1) i(vs2) i(vs3) i(vs4) i(vs5) i(vs6) i(vs7) i(vs8) i(vs9)
print i(vs10) i(vs11) i(vs12) i(vs13) i(vs14) i(vs15) i(vs16) i(vs17) i(vs18) i(vs19)
print i(vs20) i(vs21) i(vs22) i(vs23) i(vs24) i(vs25) i(vs26) i(vs27)
.endc
.end
