controls oracle ac-0424
* Generated (plan F2.7, ADR 0012): do not edit; regenerate with `pnpm sim oracle regen`. ac seed 20261031 index 424 nodes 17 elements 31
.options sparse gmin=1e-12 noopac
RG1 1 0 1000000000000
RG2 2 0 1000000000000
RG3 3 0 1000000000000
RG4 4 0 1000000000000
RG5 5 0 1000000000000
RG6 6 0 1000000000000
RG7 7 0 1000000000000
RG8 8 0 1000000000000
RG9 9 0 1000000000000
RG10 10 0 1000000000000
RG11 11 0 1000000000000
RG12 12 0 1000000000000
RG13 13 0 1000000000000
RG14 14 0 1000000000000
RG15 15 0 1000000000000
RG16 16 0 1000000000000
VS0 14 s0 0
C0 s0 2 15e-4
VS1 16 s1 0
R1 s1 13 27e0
VS2 13 s2 0
C2 s2 1 82e-6
VS3 16 s3 0
R3 s3 14 68e-2
VS4 5 s4 0
L4 s4 6 15e-3
VS5 0 s5 0
C5 s5 14 12e-4
VS6 4 s6 0
R6 s6 14 39e0
VS7 14 s7 0
R7 s7 0 12e0
VS8 11 s8 0
R8 s8 13 22e0
VS9 10 s9 0
L9 s9 2 47e-4
VS10 4 s10 0
C10 s10 12 33e-5
VS11 6 s11 0
R11 s11 3 56e1
VS12 0 s12 0
V12 e12 s12 DC 0 AC 39e-1 180
RI12 e12 m12 22e-1
LI12 m12 n12 82e-5
H12 n12 h12 VS13 -27e-3
ED12 h12 5 d12 0 -47e-6
F12 0 d12 VS13 1
LD12 d12 0 1
VS13 12 s13 0
V13 e13 s13 DC 0 AC 12e-1 -120
RI13 e13 m13 18e-2
LI13 m13 n13 68e-5
H13 n13 h13 VS12 -27e-3
ED13 h13 15 d13 0 -47e-6
F13 0 d13 VS12 1
LD13 d13 0 1
VS14 4 s14 0
L14 s14 6 15e-4
VS15 15 s15 0
L15 s15 8 10e-5
VS16 10 s16 0
L16 s16 3 39e-3
VS17 7 s17 0
R17 s17 9 82e1
VS18 8 s18 0
R18 s18 4 10e-2
VS19 14 s19 0
L19 s19 7 68e-4
VS20 6 s20 0
R20 s20 13 10e-1
VS21 6 s21 0
R21 s21 1 47e2
VS22 3 s22 0
C22 s22 9 10e-7
VS23 3 s23 0
R23 s23 16 33e3
VS24 10 s24 0
V24 e24 s24 DC 0 AC 12e1 120
RI24 e24 1 15e-3
VS25 3 s25 0
L25 s25 10 56e-5
VS26 9 s26 0
R26 s26 15 68e3
VS27 10 s27 0
C27 s27 11 33e-6
VS28 0 s28 0
C28 s28 4 18e-7
VS29 14 s29 0
C29 s29 10 82e-7
VS30 9 s30 0
R30 s30 7 22e-2
.control
set numdgt=17
ac lin 1 60 60
print v(1) v(2) v(3) v(4) v(5) v(6) v(7) v(8) v(9) v(10)
print v(11) v(12) v(13) v(14) v(15) v(16)
print i(vs0) i(vs1) i(vs2) i(vs3) i(vs4) i(vs5) i(vs6) i(vs7) i(vs8) i(vs9)
print i(vs10) i(vs11) i(vs12) i(vs13) i(vs14) i(vs15) i(vs16) i(vs17) i(vs18) i(vs19)
print i(vs20) i(vs21) i(vs22) i(vs23) i(vs24) i(vs25) i(vs26) i(vs27) i(vs28) i(vs29)
print i(vs30)
.endc
.end
