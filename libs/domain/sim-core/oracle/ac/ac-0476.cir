controls oracle ac-0476
* Generated (plan F2.7, ADR 0012): do not edit; regenerate with `pnpm sim oracle regen`. ac seed 20261031 index 476 nodes 13 elements 20
.options sparse gmin=1e-12 noopac
RG1 1 0 1000000000000
RG2 2 0 1000000000000
RG3 3 0 1000000000000
RG4 4 0 1000000000000
RG5 5 0 1000000000000
RG6 6 0 1000000000000
RG7 7 0 1000000000000
RG8 8 0 1000000000000
RG9 9 0 1000000000000
RG10 10 0 1000000000000
RG11 11 0 1000000000000
RG12 12 0 1000000000000
VS0 0 s0 0
V0 e0 s0 DC 0 AC 39e-1 120
RI0 e0 n0 18e-2
H0 n0 h0 VS1 -22e-3
ED0 h0 2 d0 0 12e-5
F0 0 d0 VS1 1
LD0 d0 0 1
VS1 8 s1 0
V1 e1 s1 DC 0 AC 18e1 -120
RI1 e1 n1 82e-1
H1 n1 h1 VS0 -22e-3
ED1 h1 2 d1 0 12e-5
F1 0 d1 VS0 1
LD1 d1 0 1
VS2 7 s2 0
V2 e2 s2 DC 0 AC 12e0 -120
RI2 e2 6 82e-1
VS3 7 s3 0
C3 s3 5 10e-7
VS4 9 s4 0
C4 s4 2 68e-7
VS5 12 s5 0
L5 s5 2 12e-5
VS6 5 s6 0
R6 s6 11 33e0
VS7 10 s7 0
L7 s7 0 10e-4
VS8 8 s8 0
C8 s8 1 82e-5
VS9 0 s9 0
R9 s9 5 27e-2
VS10 6 s10 0
V10 e10 s10 DC 0 AC 10e-1 120
RI10 e10 m10 10e-1
LI10 m10 3 10e-5
VS11 12 s11 0
V11 e11 s11 DC 0 AC 47e1 -120
RI11 e11 m11 12e-3
LI11 m11 10 22e-6
VS12 2 s12 0
R12 s12 11 22e3
VS13 11 s13 0
C13 s13 10 10e-6
VS14 2 s14 0
R14 s14 6 18e3
VS15 8 s15 0
L15 s15 5 82e-2
VS16 4 s16 0
V16 e16 s16 DC 0 AC 12e1 180
RI16 e16 2 10e-1
VS17 9 s17 0
R17 s17 4 15e0
VS18 1 s18 0
R18 s18 3 68e0
VS19 0 s19 0
L19 s19 9 39e-3
.control
set numdgt=17
ac lin 1 60 60
print v(1) v(2) v(3) v(4) v(5) v(6) v(7) v(8) v(9) v(10)
print v(11) v(12)
print i(vs0) i(vs1) i(vs2) i(vs3) i(vs4) i(vs5) i(vs6) i(vs7) i(vs8) i(vs9)
print i(vs10) i(vs11) i(vs12) i(vs13) i(vs14) i(vs15) i(vs16) i(vs17) i(vs18) i(vs19)
.endc
.end
