controls oracle ac-0476
* Generated (plan F2.7, ADR 0012): do not edit; regenerate with `pnpm sim oracle regen`. ac seed 20261031 index 476 nodes 13 elements 16
.options sparse gmin=1e-12 noopac
RG1 1 0 1000000000000
RG2 2 0 1000000000000
RG3 3 0 1000000000000
RG4 4 0 1000000000000
RG5 5 0 1000000000000
RG6 6 0 1000000000000
RG7 7 0 1000000000000
RG8 8 0 1000000000000
RG9 9 0 1000000000000
RG10 10 0 1000000000000
RG11 11 0 1000000000000
RG12 12 0 1000000000000
VS0 4 s0 0
C0 s0 10 10e-6
VS1 8 s1 0
C1 s1 1 82e-5
VS2 2 s2 0
R2 s2 6 18e3
VS3 8 s3 0
L3 s3 5 82e-2
VS4 0 s4 0
V4 e4 s4 DC 0 AC 12e1 180
RI4 e4 2 10e-1
VS5 11 s5 0
V5 e5 s5 DC 0 AC 39e-1 120
RI5 e5 2 18e-2
VS6 8 s6 0
V6 e6 s6 DC 0 AC 18e1 -120
RI6 e6 2 82e-1
VS7 11 s7 0
R7 s7 5 27e-2
VS8 9 s8 0
R8 s8 0 15e0
VS9 12 s9 0
V9 e9 s9 DC 0 AC 47e1 -120
RI9 e9 10 12e-3
VS10 2 s10 0
R10 s10 4 22e3
VS11 12 s11 0
L11 s11 2 12e-5
VS12 5 s12 0
R12 s12 4 33e0
VS13 10 s13 0
L13 s13 11 10e-4
VS14 7 s14 0
C14 s14 5 10e-7
VS15 6 s15 0
V15 e15 s15 DC 0 AC 10e-1 120
RI15 e15 3 10e-1
.control
set numdgt=17
ac lin 1 60 60
print v(1) v(2) v(3) v(4) v(5) v(6) v(7) v(8) v(9) v(10)
print v(11) v(12)
print i(vs0) i(vs1) i(vs2) i(vs3) i(vs4) i(vs5) i(vs6) i(vs7) i(vs8) i(vs9)
print i(vs10) i(vs11) i(vs12) i(vs13) i(vs14) i(vs15)
.endc
.end
