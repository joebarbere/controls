controls oracle ac-0071
* Generated (plan F2.7, ADR 0012): do not edit; regenerate with `pnpm sim oracle regen`. ac seed 20261031 index 71 nodes 20 elements 34
.options sparse gmin=1e-12 noopac
RG1 1 0 1000000000000
RG2 2 0 1000000000000
RG3 3 0 1000000000000
RG4 4 0 1000000000000
RG5 5 0 1000000000000
RG6 6 0 1000000000000
RG7 7 0 1000000000000
RG8 8 0 1000000000000
RG9 9 0 1000000000000
RG10 10 0 1000000000000
RG11 11 0 1000000000000
RG12 12 0 1000000000000
RG13 13 0 1000000000000
RG14 14 0 1000000000000
RG15 15 0 1000000000000
RG16 16 0 1000000000000
RG17 17 0 1000000000000
RG18 18 0 1000000000000
RG19 19 0 1000000000000
VS0 12 s0 0
L0 s0 10 27e-5
VS1 10 s1 0
R1 s1 0 68e0
VS2 17 s2 0
L2 s2 0 39e-4
VS3 0 s3 0
L3 s3 18 15e-3
VS4 7 s4 0
C4 s4 11 10e-5
VS5 4 s5 0
R5 s5 12 15e0
VS6 13 s6 0
R6 s6 11 39e2
VS7 18 s7 0
L7 s7 17 22e-4
VS8 2 s8 0
R8 s8 15 82e3
VS9 13 s9 0
C9 s9 4 56e-7
VS10 14 s10 0
R10 s10 1 10e-2
VS11 0 s11 0
V11 e11 s11 DC 0 AC 33e1 -120
RI11 e11 m11 12e-2
LI11 m11 15 18e-6
VS12 13 s12 0
C12 s12 14 12e-7
VS13 3 s13 0
L13 s13 4 10e-2
VS14 6 s14 0
R14 s14 12 56e1
VS15 19 s15 0
C15 s15 4 22e-4
VS16 7 s16 0
L16 s16 14 82e-2
VS17 0 s17 0
R17 s17 13 56e3
VS18 19 s18 0
C18 s18 4 18e-6
VS19 14 s19 0
R19 s19 15 33e0
VS20 19 s20 0
V20 e20 s20 DC 0 AC 33e1 -120
RI20 e20 5 33e-1
VS21 2 s21 0
V21 e21 s21 DC 0 AC 12e-1 180
RI21 e21 0 39e-1
VS22 17 s22 0
C22 s22 15 82e-7
VS23 11 s23 0
C23 s23 19 82e-6
VS24 1 s24 0
R24 s24 8 39e-2
VS25 12 s25 0
C25 s25 9 27e-5
VS26 4 s26 0
R26 s26 5 68e-1
VS27 4 s27 0
R27 s27 15 82e0
VS28 13 s28 0
L28 s28 16 18e-3
VS29 9 s29 0
V29 e29 s29 DC 0 AC 68e0 0
RI29 e29 m29 33e-3
LI29 m29 11 12e-7
VS30 6 s30 0
V30 e30 s30 DC 0 AC 82e0 -120
RI30 e30 m30 27e-1
LI30 m30 16 22e-5
VS31 8 s31 0
R31 s31 9 68e-2
VS32 0 s32 0
L32 s32 2 22e-4
VS33 3 s33 0
R33 s33 6 18e-2
.control
set numdgt=17
ac lin 1 60 60
print v(1) v(2) v(3) v(4) v(5) v(6) v(7) v(8) v(9) v(10)
print v(11) v(12) v(13) v(14) v(15) v(16) v(17) v(18) v(19)
print i(vs0) i(vs1) i(vs2) i(vs3) i(vs4) i(vs5) i(vs6) i(vs7) i(vs8) i(vs9)
print i(vs10) i(vs11) i(vs12) i(vs13) i(vs14) i(vs15) i(vs16) i(vs17) i(vs18) i(vs19)
print i(vs20) i(vs21) i(vs22) i(vs23) i(vs24) i(vs25) i(vs26) i(vs27) i(vs28) i(vs29)
print i(vs30) i(vs31) i(vs32) i(vs33)
.endc
.end
