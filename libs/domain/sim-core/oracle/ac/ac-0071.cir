controls oracle ac-0071
* Generated (plan F2.7, ADR 0012): do not edit; regenerate with `pnpm sim oracle regen`. ac seed 20261031 index 71 nodes 20 elements 34
.options sparse gmin=1e-12 noopac
RG1 1 0 1000000000000
RG2 2 0 1000000000000
RG3 3 0 1000000000000
RG4 4 0 1000000000000
RG5 5 0 1000000000000
RG6 6 0 1000000000000
RG7 7 0 1000000000000
RG8 8 0 1000000000000
RG9 9 0 1000000000000
RG10 10 0 1000000000000
RG11 11 0 1000000000000
RG12 12 0 1000000000000
RG13 13 0 1000000000000
RG14 14 0 1000000000000
RG15 15 0 1000000000000
RG16 16 0 1000000000000
RG17 17 0 1000000000000
RG18 18 0 1000000000000
RG19 19 0 1000000000000
VS0 0 s0 0
V0 e0 s0 DC 0 AC 33e-1 120
RI0 e0 2 33e-2
VS1 13 s1 0
C1 s1 14 68e-6
VS2 5 s2 0
V2 e2 s2 DC 0 AC 33e0 120
RI2 e2 m2 33e-1
LI2 m2 12 47e-5
VS3 8 s3 0
R3 s3 10 68e0
VS4 18 s4 0
C4 s4 1 56e-6
VS5 10 s5 0
R5 s5 13 56e3
VS6 7 s6 0
V6 e6 s6 DC 0 AC 82e-1 180
RI6 e6 11 18e-2
VS7 10 s7 0
R7 s7 1 68e1
VS8 11 s8 0
L8 s8 15 39e-2
VS9 13 s9 0
V9 e9 s9 DC 0 AC 68e0 120
RI9 e9 m9 39e-3
LI9 m9 11 12e-6
VS10 6 s10 0
L10 s10 9 39e-5
VS11 13 s11 0
R11 s11 10 39e-1
VS12 18 s12 0
L12 s12 7 15e-4
VS13 10 s13 0
L13 s13 2 22e-4
VS14 0 s14 0
L14 s14 6 15e-4
VS15 9 s15 0
C15 s15 5 22e-6
VS16 10 s16 0
V16 e16 s16 DC 0 AC 33e1 -120
RI16 e16 15 12e-2
VS17 14 s17 0
V17 e17 s17 DC 0 AC 27e-1 0
RI17 e17 m17 82e-2
LI17 m17 16 33e-6
VS18 13 s18 0
C18 s18 14 12e-7
VS19 6 s19 0
C19 s19 8 82e-7
VS20 9 s20 0
C20 s20 19 33e-4
VS21 4 s21 0
C21 s21 15 22e-5
VS22 4 s22 0
V22 e22 s22 DC 0 AC 12e0 -120
RI22 e22 16 22e-3
VS23 15 s23 0
V23 e23 s23 DC 0 AC 33e0 180
RI23 e23 18 18e-2
VS24 9 s24 0
V24 e24 s24 DC 0 AC 15e0 180
RI24 e24 19 33e-1
VS25 12 s25 0
L25 s25 8 27e-5
VS26 12 s26 0
C26 s26 9 27e-5
VS27 3 s27 0
R27 s27 19 12e2
VS28 14 s28 0
L28 s28 17 22e-5
VS29 0 s29 0
V29 e29 s29 DC 0 AC 12e-1 -120
RI29 e29 m29 27e-1
LI29 m29 7 82e-5
VS30 3 s30 0
R30 s30 13 18e2
VS31 17 s31 0
L31 s31 10 39e-4
VS32 8 s32 0
L32 s32 10 12e-2
VS33 3 s33 0
R33 s33 10 15e3
.control
set numdgt=17
ac lin 1 60 60
print v(1) v(2) v(3) v(4) v(5) v(6) v(7) v(8) v(9) v(10)
print v(11) v(12) v(13) v(14) v(15) v(16) v(17) v(18) v(19)
print i(vs0) i(vs1) i(vs2) i(vs3) i(vs4) i(vs5) i(vs6) i(vs7) i(vs8) i(vs9)
print i(vs10) i(vs11) i(vs12) i(vs13) i(vs14) i(vs15) i(vs16) i(vs17) i(vs18) i(vs19)
print i(vs20) i(vs21) i(vs22) i(vs23) i(vs24) i(vs25) i(vs26) i(vs27) i(vs28) i(vs29)
print i(vs30) i(vs31) i(vs32) i(vs33)
.endc
.end
