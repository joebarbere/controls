controls oracle ac-0071
* Generated (plan F2.7, ADR 0012): do not edit; regenerate with `pnpm sim oracle regen`. ac seed 20261031 index 71 nodes 20 elements 31
.options sparse gmin=1e-12 noopac
RG1 1 0 1000000000000
RG2 2 0 1000000000000
RG3 3 0 1000000000000
RG4 4 0 1000000000000
RG5 5 0 1000000000000
RG6 6 0 1000000000000
RG7 7 0 1000000000000
RG8 8 0 1000000000000
RG9 9 0 1000000000000
RG10 10 0 1000000000000
RG11 11 0 1000000000000
RG12 12 0 1000000000000
RG13 13 0 1000000000000
RG14 14 0 1000000000000
RG15 15 0 1000000000000
RG16 16 0 1000000000000
RG17 17 0 1000000000000
RG18 18 0 1000000000000
RG19 19 0 1000000000000
VS0 0 s0 0
V0 e0 s0 DC 0 AC 82e-1 180
RI0 e0 11 18e-2
VS1 14 s1 0
V1 e1 s1 DC 0 AC 27e-1 0
RI1 e1 16 82e-2
VS2 5 s2 0
V2 e2 s2 DC 0 AC 33e0 120
RI2 e2 12 33e-1
VS3 8 s3 0
L3 s3 6 15e-4
VS4 7 s4 0
L4 s4 10 12e-2
VS5 4 s5 0
C5 s5 15 22e-5
VS6 10 s6 0
V6 e6 s6 DC 0 AC 33e1 -120
RI6 e6 15 12e-2
VS7 6 s7 0
C7 s7 7 82e-7
VS8 4 s8 0
V8 e8 s8 DC 0 AC 12e0 -120
RI8 e8 16 22e-3
VS9 9 s9 0
C9 s9 19 33e-4
VS10 10 s10 0
R10 s10 13 56e3
VS11 18 s11 0
L11 s11 0 15e-4
VS12 12 s12 0
C12 s12 9 27e-5
VS13 13 s13 0
V13 e13 s13 DC 0 AC 68e0 120
RI13 e13 11 39e-3
VS14 7 s14 0
R14 s14 10 68e0
VS15 18 s15 0
C15 s15 1 56e-6
VS16 14 s16 0
L16 s16 17 22e-5
VS17 9 s17 0
V17 e17 s17 DC 0 AC 15e0 180
RI17 e17 19 33e-1
VS18 3 s18 0
R18 s18 10 15e3
VS19 10 s19 0
R19 s19 1 68e1
VS20 13 s20 0
R20 s20 10 39e-1
VS21 6 s21 0
L21 s21 9 39e-5
VS22 12 s22 0
L22 s22 7 27e-5
VS23 13 s23 0
C23 s23 14 12e-7
VS24 15 s24 0
V24 e24 s24 DC 0 AC 33e0 180
RI24 e24 18 18e-2
VS25 10 s25 0
L25 s25 2 22e-4
VS26 13 s26 0
C26 s26 14 68e-6
VS27 8 s27 0
V27 e27 s27 DC 0 AC 12e-1 -120
RI27 e27 0 27e-1
VS28 17 s28 0
L28 s28 10 39e-4
VS29 11 s29 0
L29 s29 15 39e-2
VS30 3 s30 0
R30 s30 13 18e2
.control
set numdgt=17
ac lin 1 60 60
print v(1) v(2) v(3) v(4) v(5) v(6) v(7) v(8) v(9) v(10)
print v(11) v(12) v(13) v(14) v(15) v(16) v(17) v(18) v(19)
print i(vs0) i(vs1) i(vs2) i(vs3) i(vs4) i(vs5) i(vs6) i(vs7) i(vs8) i(vs9)
print i(vs10) i(vs11) i(vs12) i(vs13) i(vs14) i(vs15) i(vs16) i(vs17) i(vs18) i(vs19)
print i(vs20) i(vs21) i(vs22) i(vs23) i(vs24) i(vs25) i(vs26) i(vs27) i(vs28) i(vs29)
print i(vs30)
.endc
.end
