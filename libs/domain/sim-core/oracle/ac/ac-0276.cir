controls oracle ac-0276
* Generated (plan F2.7, ADR 0012): do not edit; regenerate with `pnpm sim oracle regen`. ac seed 20261031 index 276 nodes 5 elements 7
.options sparse gmin=1e-12 noopac
RG1 1 0 1000000000000
RG2 2 0 1000000000000
RG3 3 0 1000000000000
RG4 4 0 1000000000000
VS0 2 s0 0
R0 s0 4 82e0
VS1 0 s1 0
V1 e1 s1 DC 0 AC 82e0 0
RI1 e1 m1 12e-3
LI1 m1 2 27e-5
VS2 4 s2 0
V2 e2 s2 DC 0 AC 39e0 -120
RI2 e2 3 27e-2
VS3 0 s3 0
C3 s3 1 39e-7
VS4 4 s4 0
V4 e4 s4 DC 0 AC 12e-1 120
RI4 e4 1 68e-2
VS5 1 s5 0
V5 e5 s5 DC 0 AC 56e-1 120
RI5 e5 m5 10e-2
LI5 m5 2 15e-7
VS6 2 s6 0
V6 e6 s6 DC 0 AC 56e0 0
RI6 e6 m6 27e-2
LI6 m6 3 47e-5
.control
set numdgt=17
ac lin 1 60 60
print v(1) v(2) v(3) v(4)
print i(vs0) i(vs1) i(vs2) i(vs3) i(vs4) i(vs5) i(vs6)
.endc
.end
