controls oracle ac-0276
* Generated (plan F2.7, ADR 0012): do not edit; regenerate with `pnpm sim oracle regen`. ac seed 20261031 index 276 nodes 5 elements 8
.options sparse gmin=1e-12 noopac
RG1 1 0 1000000000000
RG2 2 0 1000000000000
RG3 3 0 1000000000000
RG4 4 0 1000000000000
VS0 2 s0 0
L0 s0 4 82e-4
VS1 0 s1 0
V1 e1 s1 DC 0 AC 18e1 0
RI1 e1 m1 10e-2
LI1 m1 n1 12e-7
H1 n1 h1 VS4 -39e-3
ED1 h1 1 d1 0 10e-5
F1 0 d1 VS4 1
LD1 d1 0 1
VS2 0 s2 0
L2 s2 1 10e-2
VS3 1 s3 0
C3 s3 3 68e-5
VS4 4 s4 0
V4 e4 s4 DC 0 AC 39e0 -120
RI4 e4 m4 27e-2
LI4 m4 n4 39e-6
H4 n4 h4 VS1 -39e-3
ED4 h4 3 d4 0 10e-5
F4 0 d4 VS1 1
LD4 d4 0 1
VS5 4 s5 0
L5 s5 3 15e-4
VS6 2 s6 0
V6 e6 s6 DC 0 AC 82e0 0
RI6 e6 0 12e-3
VS7 4 s7 0
V7 e7 s7 DC 0 AC 56e1 120
RI7 e7 m7 82e-1
LI7 m7 0 82e-7
.control
set numdgt=17
ac lin 1 60 60
print v(1) v(2) v(3) v(4)
print i(vs0) i(vs1) i(vs2) i(vs3) i(vs4) i(vs5) i(vs6) i(vs7)
.endc
.end
