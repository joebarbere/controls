controls oracle ac-0168
* Generated (plan F2.7, ADR 0012): do not edit; regenerate with `pnpm sim oracle regen`. ac seed 20261031 index 168 nodes 17 elements 31
.options sparse gmin=1e-12 noopac
RG1 1 0 1000000000000
RG2 2 0 1000000000000
RG3 3 0 1000000000000
RG4 4 0 1000000000000
RG5 5 0 1000000000000
RG6 6 0 1000000000000
RG7 7 0 1000000000000
RG8 8 0 1000000000000
RG9 9 0 1000000000000
RG10 10 0 1000000000000
RG11 11 0 1000000000000
RG12 12 0 1000000000000
RG13 13 0 1000000000000
RG14 14 0 1000000000000
RG15 15 0 1000000000000
RG16 16 0 1000000000000
VS0 0 s0 0
V0 e0 s0 DC 0 AC 39e1 120
RI0 e0 3 39e-2
VS1 0 s1 0
R1 s1 8 39e0
VS2 15 s2 0
R2 s2 16 82e-2
VS3 15 s3 0
V3 e3 s3 DC 0 AC 39e0 0
RI3 e3 m3 33e-1
LI3 m3 2 82e-6
VS4 14 s4 0
R4 s4 13 47e-1
VS5 4 s5 0
L5 s5 10 68e-2
VS6 9 s6 0
R6 s6 11 68e3
VS7 4 s7 0
L7 s7 8 68e-2
VS8 11 s8 0
C8 s8 3 22e-4
VS9 11 s9 0
R9 s9 8 47e3
VS10 1 s10 0
L10 s10 4 56e-3
VS11 12 s11 0
R11 s11 9 27e0
VS12 15 s12 0
C12 s12 5 68e-5
VS13 5 s13 0
R13 s13 9 18e-1
VS14 0 s14 0
R14 s14 16 68e-2
VS15 2 s15 0
C15 s15 14 12e-6
VS16 7 s16 0
R16 s16 2 33e1
VS17 12 s17 0
C17 s17 10 22e-6
VS18 4 s18 0
V18 e18 s18 DC 0 AC 56e-1 120
RI18 e18 m18 15e-2
LI18 m18 15 15e-6
VS19 1 s19 0
L19 s19 13 47e-4
VS20 3 s20 0
R20 s20 15 12e0
VS21 8 s21 0
R21 s21 10 18e0
VS22 13 s22 0
V22 e22 s22 DC 0 AC 10e1 180
RI22 e22 m22 18e-3
LI22 m22 7 18e-6
VS23 7 s23 0
L23 s23 4 12e-3
VS24 10 s24 0
L24 s24 11 18e-3
VS25 13 s25 0
R25 s25 4 39e2
VS26 3 s26 0
C26 s26 11 33e-6
VS27 6 s27 0
R27 s27 8 15e-2
VS28 2 s28 0
V28 e28 s28 DC 0 AC 15e0 180
RI28 e28 1 39e-2
VS29 14 s29 0
R29 s29 0 18e3
VS30 6 s30 0
R30 s30 2 10e-1
.control
set numdgt=17
ac lin 1 60 60
print v(1) v(2) v(3) v(4) v(5) v(6) v(7) v(8) v(9) v(10)
print v(11) v(12) v(13) v(14) v(15) v(16)
print i(vs0) i(vs1) i(vs2) i(vs3) i(vs4) i(vs5) i(vs6) i(vs7) i(vs8) i(vs9)
print i(vs10) i(vs11) i(vs12) i(vs13) i(vs14) i(vs15) i(vs16) i(vs17) i(vs18) i(vs19)
print i(vs20) i(vs21) i(vs22) i(vs23) i(vs24) i(vs25) i(vs26) i(vs27) i(vs28) i(vs29)
print i(vs30)
.endc
.end
