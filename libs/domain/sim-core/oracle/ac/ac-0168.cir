controls oracle ac-0168
* Generated (plan F2.7, ADR 0012): do not edit; regenerate with `pnpm sim oracle regen`. ac seed 20261031 index 168 nodes 17 elements 17
.options sparse gmin=1e-12 noopac
RG1 1 0 1000000000000
RG2 2 0 1000000000000
RG3 3 0 1000000000000
RG4 4 0 1000000000000
RG5 5 0 1000000000000
RG6 6 0 1000000000000
RG7 7 0 1000000000000
RG8 8 0 1000000000000
RG9 9 0 1000000000000
RG10 10 0 1000000000000
RG11 11 0 1000000000000
RG12 12 0 1000000000000
RG13 13 0 1000000000000
RG14 14 0 1000000000000
RG15 15 0 1000000000000
RG16 16 0 1000000000000
VS0 9 s0 0
C0 s0 4 82e-4
VS1 3 s1 0
L1 s1 15 68e-3
VS2 13 s2 0
R2 s2 4 39e2
VS3 0 s3 0
R3 s3 1 68e-2
VS4 4 s4 0
R4 s4 5 18e1
VS5 0 s5 0
V5 e5 s5 DC 0 AC 12e0 -120
RI5 e5 3 47e-1
VS6 3 s6 0
L6 s6 2 22e-3
VS7 8 s7 0
V7 e7 s7 DC 0 AC 39e1 120
RI7 e7 3 39e-2
VS8 12 s8 0
L8 s8 1 18e-3
VS9 4 s9 0
L9 s9 11 68e-2
VS10 1 s10 0
V10 e10 s10 DC 0 AC 15e0 180
RI10 e10 6 39e-2
VS11 10 s11 0
R11 s11 11 68e3
VS12 3 s12 0
C12 s12 14 82e-4
VS13 14 s13 0
R13 s13 11 15e3
VS14 16 s14 0
R14 s14 15 12e0
VS15 8 s15 0
R15 s15 11 39e0
VS16 7 s16 0
L16 s16 4 12e-3
.control
set numdgt=17
ac lin 1 60 60
print v(1) v(2) v(3) v(4) v(5) v(6) v(7) v(8) v(9) v(10)
print v(11) v(12) v(13) v(14) v(15) v(16)
print i(vs0) i(vs1) i(vs2) i(vs3) i(vs4) i(vs5) i(vs6) i(vs7) i(vs8) i(vs9)
print i(vs10) i(vs11) i(vs12) i(vs13) i(vs14) i(vs15) i(vs16)
.endc
.end
