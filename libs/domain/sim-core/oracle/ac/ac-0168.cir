controls oracle ac-0168
* Generated (plan F2.7, ADR 0012): do not edit; regenerate with `pnpm sim oracle regen`. ac seed 20261031 index 168 nodes 17 elements 25
.options sparse gmin=1e-12 noopac
RG1 1 0 1000000000000
RG2 2 0 1000000000000
RG3 3 0 1000000000000
RG4 4 0 1000000000000
RG5 5 0 1000000000000
RG6 6 0 1000000000000
RG7 7 0 1000000000000
RG8 8 0 1000000000000
RG9 9 0 1000000000000
RG10 10 0 1000000000000
RG11 11 0 1000000000000
RG12 12 0 1000000000000
RG13 13 0 1000000000000
RG14 14 0 1000000000000
RG15 15 0 1000000000000
RG16 16 0 1000000000000
VS0 3 s0 0
C0 s0 0 82e-4
VS1 3 s1 0
L1 s1 15 68e-3
VS2 5 s2 0
R2 s2 6 47e3
VS3 11 s3 0
R3 s3 10 82e3
VS4 12 s4 0
L4 s4 1 18e-3
VS5 12 s5 0
L5 s5 14 12e-4
VS6 10 s6 0
R6 s6 14 68e3
VS7 16 s7 0
R7 s7 15 12e0
VS8 0 s8 0
V8 e8 s8 DC 0 AC 27e1 180
RI8 e8 13 68e-3
VS9 8 s9 0
R9 s9 14 39e0
VS10 4 s10 0
L10 s10 14 68e-2
VS11 16 s11 0
R11 s11 11 27e-2
VS12 7 s12 0
L12 s12 4 12e-3
VS13 13 s13 0
R13 s13 4 39e2
VS14 2 s14 0
R14 s14 7 33e-1
VS15 11 s15 0
R15 s15 1 68e-2
VS16 3 s16 0
L16 s16 2 22e-3
VS17 4 s17 0
R17 s17 5 18e1
VS18 7 s18 0
L18 s18 3 10e-2
VS19 8 s19 0
V19 e19 s19 DC 0 AC 39e1 120
RI19 e19 3 39e-2
VS20 1 s20 0
V20 e20 s20 DC 0 AC 15e0 180
RI20 e20 6 39e-2
VS21 9 s21 0
C21 s21 4 82e-4
VS22 11 s22 0
V22 e22 s22 DC 0 AC 12e0 -120
RI22 e22 3 47e-1
VS23 0 s23 0
R23 s23 14 15e3
VS24 7 s24 0
V24 e24 s24 DC 0 AC 39e1 0
RI24 e24 9 56e-3
.control
set numdgt=17
ac lin 1 60 60
print v(1) v(2) v(3) v(4) v(5) v(6) v(7) v(8) v(9) v(10)
print v(11) v(12) v(13) v(14) v(15) v(16)
print i(vs0) i(vs1) i(vs2) i(vs3) i(vs4) i(vs5) i(vs6) i(vs7) i(vs8) i(vs9)
print i(vs10) i(vs11) i(vs12) i(vs13) i(vs14) i(vs15) i(vs16) i(vs17) i(vs18) i(vs19)
print i(vs20) i(vs21) i(vs22) i(vs23) i(vs24)
.endc
.end
