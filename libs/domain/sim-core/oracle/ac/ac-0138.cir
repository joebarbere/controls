controls oracle ac-0138
* Generated (plan F2.7, ADR 0012): do not edit; regenerate with `pnpm sim oracle regen`. ac seed 20261031 index 138 nodes 8 elements 9
.options sparse gmin=1e-12 noopac
RG1 1 0 1000000000000
RG2 2 0 1000000000000
RG3 3 0 1000000000000
RG4 4 0 1000000000000
RG5 5 0 1000000000000
RG6 6 0 1000000000000
RG7 7 0 1000000000000
VS0 0 s0 0
V0 e0 s0 DC 0 AC 18e1 -120
RI0 e0 3 47e-3
VS1 7 s1 0
C1 s1 4 18e-5
VS2 0 s2 0
V2 e2 s2 DC 0 AC 27e0 120
RI2 e2 2 47e-3
VS3 6 s3 0
R3 s3 3 39e2
VS4 7 s4 0
V4 e4 s4 DC 0 AC 82e1 120
RI4 e4 0 27e-2
VS5 0 s5 0
V5 e5 s5 DC 0 AC 39e0 0
RI5 e5 4 22e-1
VS6 5 s6 0
R6 s6 1 18e3
VS7 6 s7 0
C7 s7 7 12e-5
VS8 7 s8 0
R8 s8 1 39e-1
.control
set numdgt=17
ac lin 1 60 60
print v(1) v(2) v(3) v(4) v(5) v(6) v(7)
print i(vs0) i(vs1) i(vs2) i(vs3) i(vs4) i(vs5) i(vs6) i(vs7) i(vs8)
.endc
.end
