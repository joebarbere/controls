controls oracle ac-0138
* Generated (plan F2.7, ADR 0012): do not edit; regenerate with `pnpm sim oracle regen`. ac seed 20261031 index 138 nodes 8 elements 10
.options sparse gmin=1e-12 noopac
RG1 1 0 1000000000000
RG2 2 0 1000000000000
RG3 3 0 1000000000000
RG4 4 0 1000000000000
RG5 5 0 1000000000000
RG6 6 0 1000000000000
RG7 7 0 1000000000000
VS0 0 s0 0
C0 s0 4 18e-5
VS1 0 s1 0
V1 e1 s1 DC 0 AC 82e1 120
RI1 e1 n1 27e-2
H1 n1 h1 VS7 -22e-3
ED1 h1 7 d1 0 -56e-5
F1 0 d1 VS7 1
LD1 d1 0 1
VS2 5 s2 0
R2 s2 1 18e3
VS3 5 s3 0
C3 s3 2 12e-6
VS4 6 s4 0
C4 s4 0 12e-5
VS5 6 s5 0
R5 s5 3 39e2
VS6 0 s6 0
R6 s6 1 39e-1
VS7 7 s7 0
V7 e7 s7 DC 0 AC 39e0 0
RI7 e7 n7 22e-1
H7 n7 h7 VS1 -22e-3
ED7 h7 4 d7 0 -56e-5
F7 0 d7 VS1 1
LD7 d7 0 1
VS8 7 s8 0
V8 e8 s8 DC 0 AC 18e1 -120
RI8 e8 3 47e-3
VS9 7 s9 0
V9 e9 s9 DC 0 AC 27e0 120
RI9 e9 m9 47e-3
LI9 m9 2 10e-6
.control
set numdgt=17
ac lin 1 60 60
print v(1) v(2) v(3) v(4) v(5) v(6) v(7)
print i(vs0) i(vs1) i(vs2) i(vs3) i(vs4) i(vs5) i(vs6) i(vs7) i(vs8) i(vs9)
.endc
.end
