controls oracle ac-0138
* Generated (plan F2.7, ADR 0012): do not edit; regenerate with `pnpm sim oracle regen`. ac seed 20261031 index 138 nodes 8 elements 12
.options sparse gmin=1e-12 noopac
RG1 1 0 1000000000000
RG2 2 0 1000000000000
RG3 3 0 1000000000000
RG4 4 0 1000000000000
RG5 5 0 1000000000000
RG6 6 0 1000000000000
RG7 7 0 1000000000000
VS0 5 s0 0
L0 s0 7 47e-2
VS1 2 s1 0
L1 s1 1 12e-3
VS2 0 s2 0
R2 s2 1 39e-1
VS3 4 s3 0
L3 s3 5 15e-3
VS4 0 s4 0
L4 s4 4 68e-3
VS5 4 s5 0
R5 s5 1 15e0
VS6 3 s6 0
L6 s6 6 82e-3
VS7 7 s7 0
C7 s7 5 39e-7
VS8 3 s8 0
L8 s8 7 82e-5
VS9 0 s9 0
V9 e9 s9 DC 0 AC 82e1 120
RI9 e9 7 27e-2
VS10 6 s10 0
C10 s10 0 12e-5
VS11 2 s11 0
V11 e11 s11 DC 0 AC 39e1 -120
RI11 e11 m11 12e-2
LI11 m11 3 27e-5
.control
set numdgt=17
ac lin 1 60 60
print v(1) v(2) v(3) v(4) v(5) v(6) v(7)
print i(vs0) i(vs1) i(vs2) i(vs3) i(vs4) i(vs5) i(vs6) i(vs7) i(vs8) i(vs9)
print i(vs10) i(vs11)
.endc
.end
