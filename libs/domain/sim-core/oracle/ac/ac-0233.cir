controls oracle ac-0233
* Generated (plan F2.7, ADR 0012): do not edit; regenerate with `pnpm sim oracle regen`. ac seed 20261031 index 233 nodes 8 elements 10
.options sparse gmin=1e-12 noopac
RG1 1 0 1000000000000
RG2 2 0 1000000000000
RG3 3 0 1000000000000
RG4 4 0 1000000000000
RG5 5 0 1000000000000
RG6 6 0 1000000000000
RG7 7 0 1000000000000
VS0 6 s0 0
C0 s0 2 27e-4
VS1 4 s1 0
L1 s1 3 18e-5
VS2 0 s2 0
V2 e2 s2 DC 0 AC 56e0 -120
RI2 e2 m2 10e-3
LI2 m2 1 39e-7
VS3 3 s3 0
R3 s3 2 33e-1
VS4 7 s4 0
C4 s4 4 39e-7
VS5 7 s5 0
L5 s5 0 10e-3
VS6 6 s6 0
L6 s6 4 12e-3
VS7 1 s7 0
R7 s7 3 12e2
VS8 5 s8 0
R8 s8 0 47e-2
VS9 5 s9 0
R9 s9 2 12e1
.control
set numdgt=17
ac lin 1 60 60
print v(1) v(2) v(3) v(4) v(5) v(6) v(7)
print i(vs0) i(vs1) i(vs2) i(vs3) i(vs4) i(vs5) i(vs6) i(vs7) i(vs8) i(vs9)
.endc
.end
