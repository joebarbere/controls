controls oracle ac-0233
* Generated (plan F2.7, ADR 0012): do not edit; regenerate with `pnpm sim oracle regen`. ac seed 20261031 index 233 nodes 8 elements 12
.options sparse gmin=1e-12 noopac
RG1 1 0 1000000000000
RG2 2 0 1000000000000
RG3 3 0 1000000000000
RG4 4 0 1000000000000
RG5 5 0 1000000000000
RG6 6 0 1000000000000
RG7 7 0 1000000000000
VS0 5 s0 0
C0 s0 1 27e-6
VS1 6 s1 0
R1 s1 3 56e3
VS2 7 s2 0
L2 s2 2 12e-4
VS3 3 s3 0
R3 s3 7 27e-1
VS4 0 s4 0
L4 s4 4 18e-5
VS5 4 s5 0
L5 s5 2 12e-3
VS6 0 s6 0
V6 e6 s6 DC 0 AC 82e-1 180
RI6 e6 n6 47e-3
H6 n6 h6 VS7 39e-4
ED6 h6 6 d6 0 -27e-7
F6 0 d6 VS7 1
LD6 d6 0 1
VS7 3 s7 0
V7 e7 s7 DC 0 AC 56e0 -120
RI7 e7 n7 10e-3
H7 n7 h7 VS6 39e-4
ED7 h7 1 d7 0 -27e-7
F7 0 d7 VS6 1
LD7 d7 0 1
VS8 4 s8 0
C8 s8 5 68e-4
VS9 1 s9 0
R9 s9 4 12e2
VS10 6 s10 0
L10 s10 0 56e-4
VS11 4 s11 0
R11 s11 2 33e-1
.control
set numdgt=17
ac lin 1 60 60
print v(1) v(2) v(3) v(4) v(5) v(6) v(7)
print i(vs0) i(vs1) i(vs2) i(vs3) i(vs4) i(vs5) i(vs6) i(vs7) i(vs8) i(vs9)
print i(vs10) i(vs11)
.endc
.end
