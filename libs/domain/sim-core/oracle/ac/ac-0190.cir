controls oracle ac-0190
* Generated (plan F2.7, ADR 0012): do not edit; regenerate with `pnpm sim oracle regen`. ac seed 20261031 index 190 nodes 21 elements 31
.options sparse gmin=1e-12 noopac
RG1 1 0 1000000000000
RG2 2 0 1000000000000
RG3 3 0 1000000000000
RG4 4 0 1000000000000
RG5 5 0 1000000000000
RG6 6 0 1000000000000
RG7 7 0 1000000000000
RG8 8 0 1000000000000
RG9 9 0 1000000000000
RG10 10 0 1000000000000
RG11 11 0 1000000000000
RG12 12 0 1000000000000
RG13 13 0 1000000000000
RG14 14 0 1000000000000
RG15 15 0 1000000000000
RG16 16 0 1000000000000
RG17 17 0 1000000000000
RG18 18 0 1000000000000
RG19 19 0 1000000000000
RG20 20 0 1000000000000
VS0 0 s0 0
V0 e0 s0 DC 0 AC 56e1 120
RI0 e0 m0 39e-2
LI0 m0 10 27e-6
VS1 18 s1 0
V1 e1 s1 DC 0 AC 10e1 180
RI1 e1 m1 56e-3
LI1 m1 9 12e-7
VS2 20 s2 0
R2 s2 13 56e3
VS3 1 s3 0
C3 s3 11 56e-6
VS4 17 s4 0
C4 s4 10 39e-7
VS5 19 s5 0
V5 e5 s5 DC 0 AC 27e1 120
RI5 e5 m5 22e-2
LI5 m5 3 82e-5
VS6 15 s6 0
L6 s6 2 10e-5
VS7 1 s7 0
R7 s7 10 12e-1
VS8 14 s8 0
C8 s8 6 47e-7
VS9 19 s9 0
V9 e9 s9 DC 0 AC 22e1 -120
RI9 e9 m9 39e-2
LI9 m9 7 82e-7
VS10 1 s10 0
L10 s10 16 68e-3
VS11 16 s11 0
R11 s11 2 18e1
VS12 7 s12 0
R12 s12 15 10e1
VS13 4 s13 0
L13 s13 7 39e-4
VS14 5 s14 0
R14 s14 4 10e2
VS15 18 s15 0
R15 s15 11 68e0
VS16 9 s16 0
L16 s16 6 12e-5
VS17 14 s17 0
V17 e17 s17 DC 0 AC 22e1 0
RI17 e17 m17 27e-2
LI17 m17 13 68e-5
VS18 17 s18 0
L18 s18 3 47e-3
VS19 20 s19 0
C19 s19 12 82e-5
VS20 16 s20 0
R20 s20 15 82e-1
VS21 8 s21 0
R21 s21 15 22e2
VS22 10 s22 0
V22 e22 s22 DC 0 AC 82e0 120
RI22 e22 m22 47e-2
LI22 m22 7 47e-6
VS23 4 s23 0
V23 e23 s23 DC 0 AC 68e0 -120
RI23 e23 18 27e-3
VS24 8 s24 0
V24 e24 s24 DC 0 AC 22e1 0
RI24 e24 12 22e-2
VS25 0 s25 0
R25 s25 15 56e0
VS26 20 s26 0
R26 s26 19 56e-2
VS27 10 s27 0
V27 e27 s27 DC 0 AC 47e-1 0
RI27 e27 m27 18e-3
LI27 m27 14 82e-6
VS28 17 s28 0
R28 s28 5 15e3
VS29 0 s29 0
V29 e29 s29 DC 0 AC 18e1 180
RI29 e29 m29 12e-1
LI29 m29 6 22e-6
VS30 17 s30 0
C30 s30 11 39e-5
.control
set numdgt=17
ac lin 1 60 60
print v(1) v(2) v(3) v(4) v(5) v(6) v(7) v(8) v(9) v(10)
print v(11) v(12) v(13) v(14) v(15) v(16) v(17) v(18) v(19) v(20)
print i(vs0) i(vs1) i(vs2) i(vs3) i(vs4) i(vs5) i(vs6) i(vs7) i(vs8) i(vs9)
print i(vs10) i(vs11) i(vs12) i(vs13) i(vs14) i(vs15) i(vs16) i(vs17) i(vs18) i(vs19)
print i(vs20) i(vs21) i(vs22) i(vs23) i(vs24) i(vs25) i(vs26) i(vs27) i(vs28) i(vs29)
print i(vs30)
.endc
.end
