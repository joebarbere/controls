controls oracle ac-0190
* Generated (plan F2.7, ADR 0012): do not edit; regenerate with `pnpm sim oracle regen`. ac seed 20261031 index 190 nodes 21 elements 32
.options sparse gmin=1e-12 noopac
RG1 1 0 1000000000000
RG2 2 0 1000000000000
RG3 3 0 1000000000000
RG4 4 0 1000000000000
RG5 5 0 1000000000000
RG6 6 0 1000000000000
RG7 7 0 1000000000000
RG8 8 0 1000000000000
RG9 9 0 1000000000000
RG10 10 0 1000000000000
RG11 11 0 1000000000000
RG12 12 0 1000000000000
RG13 13 0 1000000000000
RG14 14 0 1000000000000
RG15 15 0 1000000000000
RG16 16 0 1000000000000
RG17 17 0 1000000000000
RG18 18 0 1000000000000
RG19 19 0 1000000000000
RG20 20 0 1000000000000
VS0 2 s0 0
R0 s0 13 27e0
VS1 16 s1 0
L1 s1 10 33e-3
VS2 3 s2 0
R2 s2 18 39e-2
VS3 20 s3 0
L3 s3 2 33e-5
VS4 16 s4 0
C4 s4 20 47e-5
VS5 0 s5 0
V5 e5 s5 DC 0 AC 22e0 120
RI5 e5 m5 82e-3
LI5 m5 17 82e-6
VS6 16 s6 0
R6 s6 17 27e1
VS7 18 s7 0
C7 s7 12 10e-6
VS8 1 s8 0
R8 s8 9 18e2
VS9 1 s9 0
L9 s9 7 47e-5
VS10 15 s10 0
C10 s10 0 10e-6
VS11 15 s11 0
V11 e11 s11 DC 0 AC 22e0 0
RI11 e11 m11 82e-1
LI11 m11 12 39e-6
VS12 5 s12 0
R12 s12 1 15e0
VS13 10 s13 0
V13 e13 s13 DC 0 AC 82e0 120
RI13 e13 m13 47e-2
LI13 m13 20 68e-7
VS14 4 s14 0
V14 e14 s14 DC 0 AC 33e0 -120
RI14 e14 13 27e-1
VS15 8 s15 0
R15 s15 1 10e3
VS16 20 s16 0
R16 s16 11 22e0
VS17 14 s17 0
V17 e17 s17 DC 0 AC 68e-1 180
RI17 e17 0 56e-1
VS18 8 s18 0
R18 s18 15 33e1
VS19 16 s19 0
R19 s19 5 33e1
VS20 6 s20 0
R20 s20 4 27e1
VS21 19 s21 0
L21 s21 9 18e-3
VS22 20 s22 0
V22 e22 s22 DC 0 AC 18e-1 0
RI22 e22 14 18e-3
VS23 3 s23 0
V23 e23 s23 DC 0 AC 82e0 -120
RI23 e23 m23 27e-1
LI23 m23 10 15e-5
VS24 18 s24 0
L24 s24 15 12e-3
VS25 10 s25 0
L25 s25 15 39e-5
VS26 10 s26 0
C26 s26 19 47e-4
VS27 1 s27 0
R27 s27 6 68e1
VS28 13 s28 0
R28 s28 20 39e2
VS29 12 s29 0
L29 s29 6 68e-5
VS30 11 s30 0
V30 e30 s30 DC 0 AC 56e0 120
RI30 e30 5 22e-3
VS31 0 s31 0
V31 e31 s31 DC 0 AC 12e1 180
RI31 e31 7 12e-1
.control
set numdgt=17
ac lin 1 60 60
print v(1) v(2) v(3) v(4) v(5) v(6) v(7) v(8) v(9) v(10)
print v(11) v(12) v(13) v(14) v(15) v(16) v(17) v(18) v(19) v(20)
print i(vs0) i(vs1) i(vs2) i(vs3) i(vs4) i(vs5) i(vs6) i(vs7) i(vs8) i(vs9)
print i(vs10) i(vs11) i(vs12) i(vs13) i(vs14) i(vs15) i(vs16) i(vs17) i(vs18) i(vs19)
print i(vs20) i(vs21) i(vs22) i(vs23) i(vs24) i(vs25) i(vs26) i(vs27) i(vs28) i(vs29)
print i(vs30) i(vs31)
.endc
.end
