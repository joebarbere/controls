controls oracle ac-0190
* Generated (plan F2.7, ADR 0012): do not edit; regenerate with `pnpm sim oracle regen`. ac seed 20261031 index 190 nodes 21 elements 27
.options sparse gmin=1e-12 noopac
RG1 1 0 1000000000000
RG2 2 0 1000000000000
RG3 3 0 1000000000000
RG4 4 0 1000000000000
RG5 5 0 1000000000000
RG6 6 0 1000000000000
RG7 7 0 1000000000000
RG8 8 0 1000000000000
RG9 9 0 1000000000000
RG10 10 0 1000000000000
RG11 11 0 1000000000000
RG12 12 0 1000000000000
RG13 13 0 1000000000000
RG14 14 0 1000000000000
RG15 15 0 1000000000000
RG16 16 0 1000000000000
RG17 17 0 1000000000000
RG18 18 0 1000000000000
RG19 19 0 1000000000000
RG20 20 0 1000000000000
VS0 20 s0 0
C0 s0 12 82e-5
VS1 20 s1 0
R1 s1 13 56e3
VS2 4 s2 0
L2 s2 14 39e-4
VS3 17 s3 0
L3 s3 3 47e-3
VS4 16 s4 0
R4 s4 15 82e-1
VS5 0 s5 0
V5 e5 s5 DC 0 AC 22e1 0
RI5 e5 13 27e-2
VS6 8 s6 0
V6 e6 s6 DC 0 AC 22e1 0
RI6 e6 12 22e-2
VS7 17 s7 0
C7 s7 11 39e-5
VS8 1 s8 0
R8 s8 10 12e-1
VS9 19 s9 0
V9 e9 s9 DC 0 AC 27e1 120
RI9 e9 3 22e-2
VS10 1 s10 0
L10 s10 16 68e-3
VS11 19 s11 0
V11 e11 s11 DC 0 AC 22e1 -120
RI11 e11 14 39e-2
VS12 17 s12 0
R12 s12 5 15e3
VS13 9 s13 0
L13 s13 6 12e-5
VS14 0 s14 0
C14 s14 6 47e-7
VS15 5 s15 0
R15 s15 4 10e2
VS16 7 s16 0
R16 s16 15 56e0
VS17 10 s17 0
V17 e17 s17 DC 0 AC 47e-1 0
RI17 e17 0 18e-3
VS18 1 s18 0
C18 s18 11 56e-6
VS19 14 s19 0
R19 s19 15 10e1
VS20 17 s20 0
C20 s20 10 39e-7
VS21 7 s21 0
V21 e21 s21 DC 0 AC 56e1 120
RI21 e21 10 39e-2
VS22 20 s22 0
R22 s22 19 56e-2
VS23 10 s23 0
V23 e23 s23 DC 0 AC 82e0 120
RI23 e23 14 47e-2
VS24 18 s24 0
R24 s24 11 68e0
VS25 7 s25 0
V25 e25 s25 DC 0 AC 18e1 180
RI25 e25 6 12e-1
VS26 15 s26 0
L26 s26 2 10e-5
.control
set numdgt=17
ac lin 1 60 60
print v(1) v(2) v(3) v(4) v(5) v(6) v(7) v(8) v(9) v(10)
print v(11) v(12) v(13) v(14) v(15) v(16) v(17) v(18) v(19) v(20)
print i(vs0) i(vs1) i(vs2) i(vs3) i(vs4) i(vs5) i(vs6) i(vs7) i(vs8) i(vs9)
print i(vs10) i(vs11) i(vs12) i(vs13) i(vs14) i(vs15) i(vs16) i(vs17) i(vs18) i(vs19)
print i(vs20) i(vs21) i(vs22) i(vs23) i(vs24) i(vs25) i(vs26)
.endc
.end
