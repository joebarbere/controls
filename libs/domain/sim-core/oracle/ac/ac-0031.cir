controls oracle ac-0031
* Generated (plan F2.7, ADR 0012): do not edit; regenerate with `pnpm sim oracle regen`. ac seed 20261031 index 31 nodes 26 elements 39
.options sparse gmin=1e-12 noopac
RG1 1 0 1000000000000
RG2 2 0 1000000000000
RG3 3 0 1000000000000
RG4 4 0 1000000000000
RG5 5 0 1000000000000
RG6 6 0 1000000000000
RG7 7 0 1000000000000
RG8 8 0 1000000000000
RG9 9 0 1000000000000
RG10 10 0 1000000000000
RG11 11 0 1000000000000
RG12 12 0 1000000000000
RG13 13 0 1000000000000
RG14 14 0 1000000000000
RG15 15 0 1000000000000
RG16 16 0 1000000000000
RG17 17 0 1000000000000
RG18 18 0 1000000000000
RG19 19 0 1000000000000
RG20 20 0 1000000000000
RG21 21 0 1000000000000
RG22 22 0 1000000000000
RG23 23 0 1000000000000
RG24 24 0 1000000000000
RG25 25 0 1000000000000
VS0 18 s0 0
R0 s0 14 27e1
VS1 25 s1 0
C1 s1 5 68e-7
VS2 21 s2 0
R2 s2 13 82e0
VS3 7 s3 0
C3 s3 24 18e-4
VS4 16 s4 0
C4 s4 10 47e-4
VS5 0 s5 0
V5 e5 s5 DC 0 AC 39e-1 180
RI5 e5 6 56e-3
VS6 24 s6 0
C6 s6 8 18e-7
VS7 22 s7 0
V7 e7 s7 DC 0 AC 39e0 120
RI7 e7 0 33e-2
VS8 8 s8 0
L8 s8 6 18e-5
VS9 16 s9 0
R9 s9 18 27e3
VS10 18 s10 0
V10 e10 s10 DC 0 AC 68e-1 0
RI10 e10 11 82e-2
VS11 25 s11 0
R11 s11 7 82e1
VS12 5 s12 0
C12 s12 1 15e-5
VS13 8 s13 0
L13 s13 1 27e-3
VS14 23 s14 0
R14 s14 12 18e1
VS15 13 s15 0
L15 s15 2 10e-4
VS16 19 s16 0
C16 s16 23 39e-5
VS17 2 s17 0
R17 s17 23 56e-1
VS18 18 s18 0
V18 e18 s18 DC 0 AC 56e1 180
RI18 e18 m18 82e-1
LI18 m18 20 68e-7
VS19 12 s19 0
R19 s19 3 27e-1
VS20 3 s20 0
V20 e20 s20 DC 0 AC 18e-1 180
RI20 e20 22 22e-2
VS21 20 s21 0
L21 s21 8 47e-4
VS22 18 s22 0
L22 s22 2 15e-3
VS23 18 s23 0
R23 s23 25 82e1
VS24 24 s24 0
V24 e24 s24 DC 0 AC 56e-1 180
RI24 e24 14 18e-3
VS25 4 s25 0
R25 s25 6 15e3
VS26 17 s26 0
R26 s26 13 33e3
VS27 9 s27 0
L27 s27 18 18e-4
VS28 22 s28 0
C28 s28 18 12e-7
VS29 9 s29 0
L29 s29 23 82e-5
VS30 23 s30 0
C30 s30 7 47e-7
VS31 14 s31 0
R31 s31 15 82e2
VS32 4 s32 0
R32 s32 15 39e-2
VS33 13 s33 0
V33 e33 s33 DC 0 AC 68e-1 120
RI33 e33 11 82e-2
VS34 2 s34 0
L34 s34 3 18e-3
VS35 21 s35 0
C35 s35 19 22e-4
VS36 19 s36 0
R36 s36 3 56e3
VS37 10 s37 0
C37 s37 8 22e-7
VS38 17 s38 0
V38 e38 s38 DC 0 AC 10e-1 120
RI38 e38 2 39e-2
.control
set numdgt=17
ac lin 1 60 60
print v(1) v(2) v(3) v(4) v(5) v(6) v(7) v(8) v(9) v(10)
print v(11) v(12) v(13) v(14) v(15) v(16) v(17) v(18) v(19) v(20)
print v(21) v(22) v(23) v(24) v(25)
print i(vs0) i(vs1) i(vs2) i(vs3) i(vs4) i(vs5) i(vs6) i(vs7) i(vs8) i(vs9)
print i(vs10) i(vs11) i(vs12) i(vs13) i(vs14) i(vs15) i(vs16) i(vs17) i(vs18) i(vs19)
print i(vs20) i(vs21) i(vs22) i(vs23) i(vs24) i(vs25) i(vs26) i(vs27) i(vs28) i(vs29)
print i(vs30) i(vs31) i(vs32) i(vs33) i(vs34) i(vs35) i(vs36) i(vs37) i(vs38)
.endc
.end
