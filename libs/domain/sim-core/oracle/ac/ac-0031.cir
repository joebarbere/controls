controls oracle ac-0031
* Generated (plan F2.7, ADR 0012): do not edit; regenerate with `pnpm sim oracle regen`. ac seed 20261031 index 31 nodes 26 elements 27
.options sparse gmin=1e-12 noopac
RG1 1 0 1000000000000
RG2 2 0 1000000000000
RG3 3 0 1000000000000
RG4 4 0 1000000000000
RG5 5 0 1000000000000
RG6 6 0 1000000000000
RG7 7 0 1000000000000
RG8 8 0 1000000000000
RG9 9 0 1000000000000
RG10 10 0 1000000000000
RG11 11 0 1000000000000
RG12 12 0 1000000000000
RG13 13 0 1000000000000
RG14 14 0 1000000000000
RG15 15 0 1000000000000
RG16 16 0 1000000000000
RG17 17 0 1000000000000
RG18 18 0 1000000000000
RG19 19 0 1000000000000
RG20 20 0 1000000000000
RG21 21 0 1000000000000
RG22 22 0 1000000000000
RG23 23 0 1000000000000
RG24 24 0 1000000000000
RG25 25 0 1000000000000
VS0 25 s0 0
R0 s0 24 10e-1
VS1 5 s1 0
C1 s1 1 15e-5
VS2 0 s2 0
V2 e2 s2 DC 0 AC 56e1 0
RI2 e2 11 33e-2
VS3 23 s3 0
C3 s3 7 47e-7
VS4 13 s4 0
L4 s4 21 10e-4
VS5 16 s5 0
C5 s5 10 47e-4
VS6 18 s6 0
L6 s6 21 15e-3
VS7 3 s7 0
V7 e7 s7 DC 0 AC 18e-1 180
RI7 e7 22 22e-2
VS8 25 s8 0
R8 s8 11 33e3
VS9 2 s9 0
L9 s9 21 22e-2
VS10 8 s10 0
R10 s10 10 68e1
VS11 24 s11 0
V11 e11 s11 DC 0 AC 56e-1 180
RI11 e11 14 18e-3
VS12 19 s12 0
L12 s12 1 56e-5
VS13 17 s13 0
R13 s13 13 33e3
VS14 24 s14 0
V14 e14 s14 DC 0 AC 12e0 -120
RI14 e14 9 18e-3
VS15 21 s15 0
L15 s15 3 18e-3
VS16 20 s16 0
C16 s16 8 56e-7
VS17 15 s17 0
C17 s17 8 33e-7
VS18 14 s18 0
C18 s18 13 27e-6
VS19 7 s19 0
C19 s19 24 18e-4
VS20 6 s20 0
R20 s20 21 10e1
VS21 20 s21 0
V21 e21 s21 DC 0 AC 47e1 120
RI21 e21 1 39e-2
VS22 23 s22 0
R22 s22 12 18e1
VS23 25 s23 0
C23 s23 11 56e-6
VS24 21 s24 0
R24 s24 23 56e-1
VS25 24 s25 0
R25 s25 4 39e0
VS26 24 s26 0
C26 s26 8 18e-7
.control
set numdgt=17
ac lin 1 60 60
print v(1) v(2) v(3) v(4) v(5) v(6) v(7) v(8) v(9) v(10)
print v(11) v(12) v(13) v(14) v(15) v(16) v(17) v(18) v(19) v(20)
print v(21) v(22) v(23) v(24) v(25)
print i(vs0) i(vs1) i(vs2) i(vs3) i(vs4) i(vs5) i(vs6) i(vs7) i(vs8) i(vs9)
print i(vs10) i(vs11) i(vs12) i(vs13) i(vs14) i(vs15) i(vs16) i(vs17) i(vs18) i(vs19)
print i(vs20) i(vs21) i(vs22) i(vs23) i(vs24) i(vs25) i(vs26)
.endc
.end
