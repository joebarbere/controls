controls oracle ac-0106
* Generated (plan F2.7, ADR 0012): do not edit; regenerate with `pnpm sim oracle regen`. ac seed 20261031 index 106 nodes 10 elements 15
.options sparse gmin=1e-12 noopac
RG1 1 0 1000000000000
RG2 2 0 1000000000000
RG3 3 0 1000000000000
RG4 4 0 1000000000000
RG5 5 0 1000000000000
RG6 6 0 1000000000000
RG7 7 0 1000000000000
RG8 8 0 1000000000000
RG9 9 0 1000000000000
VS0 6 s0 0
R0 s0 2 82e3
VS1 1 s1 0
R1 s1 4 82e-2
VS2 0 s2 0
V2 e2 s2 DC 0 AC 18e0 0
RI2 e2 9 10e-2
VS3 5 s3 0
R3 s3 1 18e-1
VS4 1 s4 0
R4 s4 8 12e2
VS5 3 s5 0
V5 e5 s5 DC 0 AC 82e-1 180
RI5 e5 6 10e-1
VS6 0 s6 0
V6 e6 s6 DC 0 AC 39e-1 -120
RI6 e6 m6 10e-1
LI6 m6 5 15e-6
VS7 7 s7 0
V7 e7 s7 DC 0 AC 82e1 -120
RI7 e7 8 10e-2
VS8 4 s8 0
C8 s8 6 33e-4
VS9 8 s9 0
L9 s9 4 12e-4
VS10 2 s10 0
R10 s10 9 56e3
VS11 7 s11 0
V11 e11 s11 DC 0 AC 33e0 180
RI11 e11 0 47e-2
VS12 1 s12 0
V12 e12 s12 DC 0 AC 82e1 -120
RI12 e12 3 15e-2
VS13 0 s13 0
R13 s13 4 56e2
VS14 0 s14 0
C14 s14 2 68e-4
.control
set numdgt=17
ac lin 1 60 60
print v(1) v(2) v(3) v(4) v(5) v(6) v(7) v(8) v(9)
print i(vs0) i(vs1) i(vs2) i(vs3) i(vs4) i(vs5) i(vs6) i(vs7) i(vs8) i(vs9)
print i(vs10) i(vs11) i(vs12) i(vs13) i(vs14)
.endc
.end
