controls oracle ac-0106
* Generated (plan F2.7, ADR 0012): do not edit; regenerate with `pnpm sim oracle regen`. ac seed 20261031 index 106 nodes 10 elements 19
.options sparse gmin=1e-12 noopac
RG1 1 0 1000000000000
RG2 2 0 1000000000000
RG3 3 0 1000000000000
RG4 4 0 1000000000000
RG5 5 0 1000000000000
RG6 6 0 1000000000000
RG7 7 0 1000000000000
RG8 8 0 1000000000000
RG9 9 0 1000000000000
VS0 7 s0 0
L0 s0 0 68e-4
VS1 0 s1 0
V1 e1 s1 DC 0 AC 22e0 0
RI1 e1 n1 18e-2
H1 n1 h1 VS2 27e-3
ED1 h1 1 d1 0 33e-5
F1 0 d1 VS2 1
LD1 d1 0 1
VS2 6 s2 0
V2 e2 s2 DC 0 AC 82e0 -120
RI2 e2 m2 56e-1
LI2 m2 n2 10e-6
H2 n2 h2 VS1 27e-3
ED2 h2 8 d2 0 33e-5
F2 0 d2 VS1 1
LD2 d2 0 1
VS3 3 s3 0
V3 e3 s3 DC 0 AC 12e0 -120
RI3 e3 m3 82e-1
LI3 m3 1 33e-6
VS4 4 s4 0
R4 s4 1 27e0
VS5 2 s5 0
R5 s5 7 15e-1
VS6 8 s6 0
V6 e6 s6 DC 0 AC 56e1 -120
RI6 e6 4 39e-2
VS7 1 s7 0
L7 s7 9 10e-4
VS8 5 s8 0
R8 s8 1 33e3
VS9 6 s9 0
R9 s9 4 15e0
VS10 6 s10 0
R10 s10 7 15e1
VS11 8 s11 0
C11 s11 2 10e-4
VS12 4 s12 0
C12 s12 9 33e-7
VS13 6 s13 0
V13 e13 s13 DC 0 AC 39e-1 -120
RI13 e13 5 10e-1
VS14 2 s14 0
R14 s14 9 68e2
VS15 3 s15 0
C15 s15 8 12e-7
VS16 4 s16 0
R16 s16 0 39e2
VS17 9 s17 0
R17 s17 2 47e-2
VS18 9 s18 0
R18 s18 3 33e1
.control
set numdgt=17
ac lin 1 60 60
print v(1) v(2) v(3) v(4) v(5) v(6) v(7) v(8) v(9)
print i(vs0) i(vs1) i(vs2) i(vs3) i(vs4) i(vs5) i(vs6) i(vs7) i(vs8) i(vs9)
print i(vs10) i(vs11) i(vs12) i(vs13) i(vs14) i(vs15) i(vs16) i(vs17) i(vs18)
.endc
.end
