controls oracle ac-0316
* Generated (plan F2.7, ADR 0012): do not edit; regenerate with `pnpm sim oracle regen`. ac seed 20261031 index 316 nodes 2 elements 2
.options sparse gmin=1e-12 noopac
RG1 1 0 1000000000000
VS0 0 s0 0
V0 e0 s0 DC 0 AC 22e1 180
RI0 e0 m0 82e-1
LI0 m0 1 15e-7
VS1 0 s1 0
V1 e1 s1 DC 0 AC 82e-1 0
RI1 e1 1 82e-1
.control
set numdgt=17
ac lin 1 60 60
print v(1)
print i(vs0) i(vs1)
.endc
.end
