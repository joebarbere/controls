controls oracle ac-0316
* Generated (plan F2.7, ADR 0012): do not edit; regenerate with `pnpm sim oracle regen`. ac seed 20261031 index 316 nodes 2 elements 2
.options sparse gmin=1e-12 noopac
RG1 1 0 1000000000000
VS0 1 s0 0
L0 s0 0 10e-4
VS1 0 s1 0
V1 e1 s1 DC 0 AC 22e1 180
RI1 e1 1 82e-1
.control
set numdgt=17
ac lin 1 60 60
print v(1)
print i(vs0) i(vs1)
.endc
.end
