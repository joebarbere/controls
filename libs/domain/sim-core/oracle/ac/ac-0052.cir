controls oracle ac-0052
* Generated (plan F2.7, ADR 0012): do not edit; regenerate with `pnpm sim oracle regen`. ac seed 20261031 index 52 nodes 13 elements 14
.options sparse gmin=1e-12 noopac
RG1 1 0 1000000000000
RG2 2 0 1000000000000
RG3 3 0 1000000000000
RG4 4 0 1000000000000
RG5 5 0 1000000000000
RG6 6 0 1000000000000
RG7 7 0 1000000000000
RG8 8 0 1000000000000
RG9 9 0 1000000000000
RG10 10 0 1000000000000
RG11 11 0 1000000000000
RG12 12 0 1000000000000
VS0 3 s0 0
L0 s0 11 12e-2
VS1 0 s1 0
V1 e1 s1 DC 0 AC 39e1 120
RI1 e1 8 82e-2
VS2 6 s2 0
R2 s2 7 18e-2
VS3 0 s3 0
L3 s3 10 39e-2
VS4 6 s4 0
C4 s4 5 47e-6
VS5 4 s5 0
R5 s5 6 15e1
VS6 5 s6 0
R6 s6 1 39e0
VS7 11 s7 0
V7 e7 s7 DC 0 AC 39e0 120
RI7 e7 8 12e-2
VS8 5 s8 0
V8 e8 s8 DC 0 AC 68e-1 -120
RI8 e8 12 10e-3
VS9 11 s9 0
R9 s9 5 47e3
VS10 9 s10 0
R10 s10 0 27e-2
VS11 12 s11 0
C11 s11 2 33e-7
VS12 9 s12 0
V12 e12 s12 DC 0 AC 27e1 0
RI12 e12 2 68e-2
VS13 6 s13 0
V13 e13 s13 DC 0 AC 22e-1 120
RI13 e13 8 56e-2
.control
set numdgt=17
ac lin 1 60 60
print v(1) v(2) v(3) v(4) v(5) v(6) v(7) v(8) v(9) v(10)
print v(11) v(12)
print i(vs0) i(vs1) i(vs2) i(vs3) i(vs4) i(vs5) i(vs6) i(vs7) i(vs8) i(vs9)
print i(vs10) i(vs11) i(vs12) i(vs13)
.endc
.end
