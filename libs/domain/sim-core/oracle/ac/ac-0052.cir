controls oracle ac-0052
* Generated (plan F2.7, ADR 0012): do not edit; regenerate with `pnpm sim oracle regen`. ac seed 20261031 index 52 nodes 13 elements 20
.options sparse gmin=1e-12 noopac
RG1 1 0 1000000000000
RG2 2 0 1000000000000
RG3 3 0 1000000000000
RG4 4 0 1000000000000
RG5 5 0 1000000000000
RG6 6 0 1000000000000
RG7 7 0 1000000000000
RG8 8 0 1000000000000
RG9 9 0 1000000000000
RG10 10 0 1000000000000
RG11 11 0 1000000000000
RG12 12 0 1000000000000
VS0 0 s0 0
R0 s0 11 47e3
VS1 11 s1 0
R1 s1 1 39e0
VS2 5 s2 0
L2 s2 10 39e-2
VS3 0 s3 0
L3 s3 12 47e-5
VS4 0 s4 0
V4 e4 s4 DC 0 AC 68e0 180
RI4 e4 2 12e-3
VS5 11 s5 0
V5 e5 s5 DC 0 AC 68e-1 -120
RI5 e5 m5 10e-3
LI5 m5 12 18e-6
VS6 6 s6 0
R6 s6 7 18e-2
VS7 7 s7 0
V7 e7 s7 DC 0 AC 22e-1 0
RI7 e7 m7 39e-1
LI7 m7 9 39e-6
VS8 10 s8 0
C8 s8 8 22e-4
VS9 1 s9 0
L9 s9 9 12e-4
VS10 4 s10 0
C10 s10 1 68e-6
VS11 11 s11 0
R11 s11 7 56e-1
VS12 11 s12 0
V12 e12 s12 DC 0 AC 39e-1 0
RI12 e12 m12 33e-1
LI12 m12 3 22e-5
VS13 9 s13 0
L13 s13 5 27e-5
VS14 2 s14 0
R14 s14 10 27e-1
VS15 6 s15 0
C15 s15 11 47e-6
VS16 4 s16 0
C16 s16 5 12e-6
VS17 2 s17 0
V17 e17 s17 DC 0 AC 47e-1 120
RI17 e17 3 15e-2
VS18 8 s18 0
C18 s18 5 82e-7
VS19 0 s19 0
V19 e19 s19 DC 0 AC 39e0 120
RI19 e19 m19 12e-2
LI19 m19 8 15e-7
.control
set numdgt=17
ac lin 1 60 60
print v(1) v(2) v(3) v(4) v(5) v(6) v(7) v(8) v(9) v(10)
print v(11) v(12)
print i(vs0) i(vs1) i(vs2) i(vs3) i(vs4) i(vs5) i(vs6) i(vs7) i(vs8) i(vs9)
print i(vs10) i(vs11) i(vs12) i(vs13) i(vs14) i(vs15) i(vs16) i(vs17) i(vs18) i(vs19)
.endc
.end
