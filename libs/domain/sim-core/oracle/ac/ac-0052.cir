controls oracle ac-0052
* Generated (plan F2.7, ADR 0012): do not edit; regenerate with `pnpm sim oracle regen`. ac seed 20261031 index 52 nodes 13 elements 19
.options sparse gmin=1e-12 noopac
RG1 1 0 1000000000000
RG2 2 0 1000000000000
RG3 3 0 1000000000000
RG4 4 0 1000000000000
RG5 5 0 1000000000000
RG6 6 0 1000000000000
RG7 7 0 1000000000000
RG8 8 0 1000000000000
RG9 9 0 1000000000000
RG10 10 0 1000000000000
RG11 11 0 1000000000000
RG12 12 0 1000000000000
VS0 6 s0 0
R0 s0 7 18e-2
VS1 0 s1 0
V1 e1 s1 DC 0 AC 27e1 0
RI1 e1 2 68e-2
VS2 5 s2 0
V2 e2 s2 DC 0 AC 39e1 120
RI2 e2 8 82e-2
VS3 0 s3 0
R3 s3 5 27e-2
VS4 4 s4 0
R4 s4 6 15e1
VS5 11 s5 0
R5 s5 9 47e3
VS6 9 s6 0
R6 s6 4 56e3
VS7 2 s7 0
R7 s7 3 15e1
VS8 5 s8 0
C8 s8 7 56e-5
VS9 9 s9 0
V9 e9 s9 DC 0 AC 68e-1 -120
RI9 e9 12 10e-3
VS10 5 s10 0
L10 s10 10 39e-2
VS11 9 s11 0
R11 s11 1 39e0
VS12 8 s12 0
R12 s12 10 33e-1
VS13 3 s13 0
L13 s13 11 12e-2
VS14 12 s14 0
C14 s14 2 33e-7
VS15 11 s15 0
V15 e15 s15 DC 0 AC 39e0 120
RI15 e15 8 12e-2
VS16 6 s16 0
V16 e16 s16 DC 0 AC 22e-1 120
RI16 e16 8 56e-2
VS17 1 s17 0
R17 s17 4 12e2
VS18 6 s18 0
C18 s18 9 47e-6
.control
set numdgt=17
ac lin 1 60 60
print v(1) v(2) v(3) v(4) v(5) v(6) v(7) v(8) v(9) v(10)
print v(11) v(12)
print i(vs0) i(vs1) i(vs2) i(vs3) i(vs4) i(vs5) i(vs6) i(vs7) i(vs8) i(vs9)
print i(vs10) i(vs11) i(vs12) i(vs13) i(vs14) i(vs15) i(vs16) i(vs17) i(vs18)
.endc
.end
