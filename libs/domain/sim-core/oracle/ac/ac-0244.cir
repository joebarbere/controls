controls oracle ac-0244
* Generated (plan F2.7, ADR 0012): do not edit; regenerate with `pnpm sim oracle regen`. ac seed 20261031 index 244 nodes 3 elements 5
.options sparse gmin=1e-12 noopac
RG1 1 0 1000000000000
RG2 2 0 1000000000000
VS0 0 s0 0
V0 e0 s0 DC 0 AC 33e0 -120
RI0 e0 m0 47e-1
LI0 m0 1 82e-6
VS1 1 s1 0
R1 s1 2 33e3
VS2 1 s2 0
V2 e2 s2 DC 0 AC 68e1 -120
RI2 e2 m2 22e-2
LI2 m2 2 56e-7
VS3 2 s3 0
C3 s3 0 18e-5
VS4 0 s4 0
L4 s4 2 82e-3
.control
set numdgt=17
ac lin 1 60 60
print v(1) v(2)
print i(vs0) i(vs1) i(vs2) i(vs3) i(vs4)
.endc
.end
