controls oracle ac-0287
* Generated (plan F2.7, ADR 0012): do not edit; regenerate with `pnpm sim oracle regen`. ac seed 20261031 index 287 nodes 6 elements 11
.options sparse gmin=1e-12 noopac
RG1 1 0 1000000000000
RG2 2 0 1000000000000
RG3 3 0 1000000000000
RG4 4 0 1000000000000
RG5 5 0 1000000000000
VS0 0 s0 0
V0 e0 s0 DC 0 AC 22e0 180
RI0 e0 2 47e-1
VS1 5 s1 0
L1 s1 0 68e-4
VS2 2 s2 0
R2 s2 4 68e0
VS3 4 s3 0
L3 s3 5 82e-3
VS4 3 s4 0
L4 s4 5 12e-3
VS5 1 s5 0
C5 s5 0 68e-7
VS6 3 s6 0
R6 s6 1 27e3
VS7 5 s7 0
L7 s7 1 15e-2
VS8 2 s8 0
C8 s8 3 15e-6
VS9 3 s9 0
C9 s9 0 68e-5
VS10 0 s10 0
C10 s10 2 22e-7
.control
set numdgt=17
ac lin 1 60 60
print v(1) v(2) v(3) v(4) v(5)
print i(vs0) i(vs1) i(vs2) i(vs3) i(vs4) i(vs5) i(vs6) i(vs7) i(vs8) i(vs9)
print i(vs10)
.endc
.end
