controls oracle ac-0287
* Generated (plan F2.7, ADR 0012): do not edit; regenerate with `pnpm sim oracle regen`. ac seed 20261031 index 287 nodes 6 elements 6
.options sparse gmin=1e-12 noopac
RG1 1 0 1000000000000
RG2 2 0 1000000000000
RG3 3 0 1000000000000
RG4 4 0 1000000000000
RG5 5 0 1000000000000
VS0 3 s0 0
C0 s0 0 68e-5
VS1 1 s1 0
C1 s1 0 68e-7
VS2 0 s2 0
V2 e2 s2 DC 0 AC 22e0 180
RI2 e2 2 47e-1
VS3 2 s3 0
L3 s3 0 56e-3
VS4 5 s4 0
L4 s4 1 15e-2
VS5 4 s5 0
L5 s5 5 82e-3
.control
set numdgt=17
ac lin 1 60 60
print v(1) v(2) v(3) v(4) v(5)
print i(vs0) i(vs1) i(vs2) i(vs3) i(vs4) i(vs5)
.endc
.end
