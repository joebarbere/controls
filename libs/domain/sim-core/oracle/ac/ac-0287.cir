controls oracle ac-0287
* Generated (plan F2.7, ADR 0012): do not edit; regenerate with `pnpm sim oracle regen`. ac seed 20261031 index 287 nodes 6 elements 9
.options sparse gmin=1e-12 noopac
RG1 1 0 1000000000000
RG2 2 0 1000000000000
RG3 3 0 1000000000000
RG4 4 0 1000000000000
RG5 5 0 1000000000000
VS0 0 s0 0
V0 e0 s0 DC 0 AC 22e0 120
RI0 e0 3 18e-3
VS1 5 s1 0
V1 e1 s1 DC 0 AC 22e0 180
RI1 e1 2 47e-1
VS2 4 s2 0
L2 s2 0 82e-3
VS3 0 s3 0
L3 s3 1 15e-2
VS4 3 s4 0
C4 s4 5 68e-5
VS5 1 s5 0
C5 s5 5 68e-7
VS6 3 s6 0
L6 s6 4 10e-5
VS7 1 s7 0
V7 e7 s7 DC 0 AC 10e0 0
RI7 e7 3 68e-1
VS8 2 s8 0
V8 e8 s8 DC 0 AC 27e0 180
RI8 e8 3 68e-1
.control
set numdgt=17
ac lin 1 60 60
print v(1) v(2) v(3) v(4) v(5)
print i(vs0) i(vs1) i(vs2) i(vs3) i(vs4) i(vs5) i(vs6) i(vs7) i(vs8)
.endc
.end
