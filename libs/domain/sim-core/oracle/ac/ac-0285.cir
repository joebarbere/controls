controls oracle ac-0285
* Generated (plan F2.7, ADR 0012): do not edit; regenerate with `pnpm sim oracle regen`. ac seed 20261031 index 285 nodes 30 elements 48
.options sparse gmin=1e-12 noopac
RG1 1 0 1000000000000
RG2 2 0 1000000000000
RG3 3 0 1000000000000
RG4 4 0 1000000000000
RG5 5 0 1000000000000
RG6 6 0 1000000000000
RG7 7 0 1000000000000
RG8 8 0 1000000000000
RG9 9 0 1000000000000
RG10 10 0 1000000000000
RG11 11 0 1000000000000
RG12 12 0 1000000000000
RG13 13 0 1000000000000
RG14 14 0 1000000000000
RG15 15 0 1000000000000
RG16 16 0 1000000000000
RG17 17 0 1000000000000
RG18 18 0 1000000000000
RG19 19 0 1000000000000
RG20 20 0 1000000000000
RG21 21 0 1000000000000
RG22 22 0 1000000000000
RG23 23 0 1000000000000
RG24 24 0 1000000000000
RG25 25 0 1000000000000
RG26 26 0 1000000000000
RG27 27 0 1000000000000
RG28 28 0 1000000000000
RG29 29 0 1000000000000
VS0 11 s0 0
L0 s0 10 33e-4
VS1 26 s1 0
R1 s1 18 10e-1
VS2 0 s2 0
V2 e2 s2 DC 0 AC 33e1 0
RI2 e2 m2 68e-3
LI2 m2 n2 56e-7
H2 n2 h2 VS3 -15e-4
ED2 h2 17 d2 0 -68e-7
F2 0 d2 VS3 1
LD2 d2 0 1
VS3 12 s3 0
V3 e3 s3 DC 0 AC 47e1 120
RI3 e3 m3 82e-1
LI3 m3 n3 15e-7
H3 n3 h3 VS2 -15e-4
ED3 h3 26 d3 0 -68e-7
F3 0 d3 VS2 1
LD3 d3 0 1
VS4 28 s4 0
L4 s4 25 12e-2
VS5 23 s5 0
R5 s5 27 15e1
VS6 26 s6 0
C6 s6 27 12e-6
VS7 24 s7 0
L7 s7 17 68e-2
VS8 11 s8 0
R8 s8 22 10e0
VS9 8 s9 0
L9 s9 11 10e-4
VS10 20 s10 0
V10 e10 s10 DC 0 AC 15e1 120
RI10 e10 1 18e-3
VS11 5 s11 0
R11 s11 13 27e3
VS12 29 s12 0
R12 s12 26 56e-2
VS13 21 s13 0
L13 s13 29 15e-4
VS14 12 s14 0
R14 s14 11 33e3
VS15 3 s15 0
R15 s15 10 47e3
VS16 23 s16 0
L16 s16 11 56e-2
VS17 24 s17 0
L17 s17 4 18e-3
VS18 8 s18 0
V18 e18 s18 DC 0 AC 82e-1 120
RI18 e18 9 15e-3
VS19 15 s19 0
L19 s19 8 56e-4
VS20 5 s20 0
R20 s20 10 68e1
VS21 2 s21 0
C21 s21 25 18e-7
VS22 16 s22 0
C22 s22 3 82e-7
VS23 6 s23 0
R23 s23 14 39e1
VS24 22 s24 0
R24 s24 29 12e1
VS25 19 s25 0
R25 s25 16 47e3
VS26 4 s26 0
V26 e26 s26 DC 0 AC 18e-1 120
RI26 e26 m26 33e-3
LI26 m26 15 27e-5
VS27 28 s27 0
C27 s27 5 39e-7
VS28 19 s28 0
L28 s28 22 15e-3
VS29 1 s29 0
V29 e29 s29 DC 0 AC 15e-1 120
RI29 e29 m29 12e-2
LI29 m29 22 22e-6
VS30 6 s30 0
R30 s30 7 33e3
VS31 10 s31 0
C31 s31 23 10e-4
VS32 7 s32 0
R32 s32 18 12e1
VS33 19 s33 0
C33 s33 7 12e-5
VS34 0 s34 0
R34 s34 26 68e1
VS35 3 s35 0
R35 s35 7 56e3
VS36 22 s36 0
R36 s36 2 18e1
VS37 0 s37 0
R37 s37 13 22e1
VS38 21 s38 0
R38 s38 28 10e2
VS39 5 s39 0
R39 s39 9 27e3
VS40 24 s40 0
R40 s40 19 18e-2
VS41 14 s41 0
C41 s41 20 12e-7
VS42 11 s42 0
L42 s42 7 47e-5
VS43 12 s43 0
V43 e43 s43 DC 0 AC 22e0 -120
RI43 e43 15 33e-2
VS44 3 s44 0
L44 s44 0 27e-4
VS45 6 s45 0
L45 s45 25 12e-5
VS46 8 s46 0
L46 s46 24 15e-2
VS47 12 s47 0
C47 s47 24 22e-7
.control
set numdgt=17
ac lin 1 60 60
print v(1) v(2) v(3) v(4) v(5) v(6) v(7) v(8) v(9) v(10)
print v(11) v(12) v(13) v(14) v(15) v(16) v(17) v(18) v(19) v(20)
print v(21) v(22) v(23) v(24) v(25) v(26) v(27) v(28) v(29)
print i(vs0) i(vs1) i(vs2) i(vs3) i(vs4) i(vs5) i(vs6) i(vs7) i(vs8) i(vs9)
print i(vs10) i(vs11) i(vs12) i(vs13) i(vs14) i(vs15) i(vs16) i(vs17) i(vs18) i(vs19)
print i(vs20) i(vs21) i(vs22) i(vs23) i(vs24) i(vs25) i(vs26) i(vs27) i(vs28) i(vs29)
print i(vs30) i(vs31) i(vs32) i(vs33) i(vs34) i(vs35) i(vs36) i(vs37) i(vs38) i(vs39)
print i(vs40) i(vs41) i(vs42) i(vs43) i(vs44) i(vs45) i(vs46) i(vs47)
.endc
.end
