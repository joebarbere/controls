controls oracle ac-0285
* Generated (plan F2.7, ADR 0012): do not edit; regenerate with `pnpm sim oracle regen`. ac seed 20261031 index 285 nodes 30 elements 47
.options sparse gmin=1e-12 noopac
RG1 1 0 1000000000000
RG2 2 0 1000000000000
RG3 3 0 1000000000000
RG4 4 0 1000000000000
RG5 5 0 1000000000000
RG6 6 0 1000000000000
RG7 7 0 1000000000000
RG8 8 0 1000000000000
RG9 9 0 1000000000000
RG10 10 0 1000000000000
RG11 11 0 1000000000000
RG12 12 0 1000000000000
RG13 13 0 1000000000000
RG14 14 0 1000000000000
RG15 15 0 1000000000000
RG16 16 0 1000000000000
RG17 17 0 1000000000000
RG18 18 0 1000000000000
RG19 19 0 1000000000000
RG20 20 0 1000000000000
RG21 21 0 1000000000000
RG22 22 0 1000000000000
RG23 23 0 1000000000000
RG24 24 0 1000000000000
RG25 25 0 1000000000000
RG26 26 0 1000000000000
RG27 27 0 1000000000000
RG28 28 0 1000000000000
RG29 29 0 1000000000000
VS0 22 s0 0
R0 s0 10 33e2
VS1 10 s1 0
C1 s1 20 56e-4
VS2 12 s2 0
L2 s2 17 82e-5
VS3 15 s3 0
R3 s3 26 22e2
VS4 8 s4 0
C4 s4 24 22e-4
VS5 9 s5 0
R5 s5 6 10e2
VS6 26 s6 0
C6 s6 27 12e-6
VS7 22 s7 0
R7 s7 1 15e1
VS8 11 s8 0
R8 s8 22 10e0
VS9 8 s9 0
L9 s9 11 47e-2
VS10 28 s10 0
C10 s10 26 18e-5
VS11 13 s11 0
R11 s11 17 15e2
VS12 1 s12 0
R12 s12 26 56e-2
VS13 21 s13 0
R13 s13 19 18e1
VS14 12 s14 0
R14 s14 11 33e3
VS15 14 s15 0
R15 s15 10 33e-2
VS16 23 s16 0
L16 s16 11 56e-2
VS17 4 s17 0
C17 s17 2 27e-7
VS18 0 s18 0
V18 e18 s18 DC 0 AC 47e0 -120
RI18 e18 m18 10e-2
LI18 m18 1 15e-7
VS19 15 s19 0
R19 s19 10 39e3
VS20 5 s20 0
L20 s20 23 68e-4
VS21 23 s21 0
R21 s21 24 33e0
VS22 24 s22 0
V22 e22 s22 DC 0 AC 15e1 120
RI22 e22 0 18e-3
VS23 3 s23 0
L23 s23 14 47e-5
VS24 22 s24 0
R24 s24 1 12e1
VS25 16 s25 0
C25 s25 5 56e-5
VS26 10 s26 0
V26 e26 s26 DC 0 AC 33e1 180
RI26 e26 2 15e-3
VS27 15 s27 0
R27 s27 28 22e3
VS28 17 s28 0
R28 s28 0 12e2
VS29 0 s29 0
V29 e29 s29 DC 0 AC 15e-1 120
RI29 e29 22 12e-2
VS30 26 s30 0
R30 s30 6 22e3
VS31 20 s31 0
R31 s31 5 18e-2
VS32 4 s32 0
R32 s32 18 56e-2
VS33 19 s33 0
C33 s33 7 12e-5
VS34 12 s34 0
L34 s34 16 56e-5
VS35 3 s35 0
R35 s35 7 56e3
VS36 22 s36 0
R36 s36 2 18e1
VS37 29 s37 0
C37 s37 4 82e-7
VS38 18 s38 0
R38 s38 2 22e1
VS39 16 s39 0
C39 s39 9 15e-5
VS40 25 s40 0
L40 s40 19 68e-2
VS41 21 s41 0
R41 s41 20 56e0
VS42 11 s42 0
L42 s42 7 47e-5
VS43 27 s43 0
R43 s43 2 27e1
VS44 3 s44 0
L44 s44 29 27e-4
VS45 25 s45 0
V45 e45 s45 DC 0 AC 12e0 180
RI45 e45 m45 22e-3
LI45 m45 13 15e-6
VS46 10 s46 0
V46 e46 s46 DC 0 AC 27e0 -120
RI46 e46 23 10e-2
.control
set numdgt=17
ac lin 1 60 60
print v(1) v(2) v(3) v(4) v(5) v(6) v(7) v(8) v(9) v(10)
print v(11) v(12) v(13) v(14) v(15) v(16) v(17) v(18) v(19) v(20)
print v(21) v(22) v(23) v(24) v(25) v(26) v(27) v(28) v(29)
print i(vs0) i(vs1) i(vs2) i(vs3) i(vs4) i(vs5) i(vs6) i(vs7) i(vs8) i(vs9)
print i(vs10) i(vs11) i(vs12) i(vs13) i(vs14) i(vs15) i(vs16) i(vs17) i(vs18) i(vs19)
print i(vs20) i(vs21) i(vs22) i(vs23) i(vs24) i(vs25) i(vs26) i(vs27) i(vs28) i(vs29)
print i(vs30) i(vs31) i(vs32) i(vs33) i(vs34) i(vs35) i(vs36) i(vs37) i(vs38) i(vs39)
print i(vs40) i(vs41) i(vs42) i(vs43) i(vs44) i(vs45) i(vs46)
.endc
.end
