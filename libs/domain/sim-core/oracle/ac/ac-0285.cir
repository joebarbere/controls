controls oracle ac-0285
* Generated (plan F2.7, ADR 0012): do not edit; regenerate with `pnpm sim oracle regen`. ac seed 20261031 index 285 nodes 30 elements 40
.options sparse gmin=1e-12 noopac
RG1 1 0 1000000000000
RG2 2 0 1000000000000
RG3 3 0 1000000000000
RG4 4 0 1000000000000
RG5 5 0 1000000000000
RG6 6 0 1000000000000
RG7 7 0 1000000000000
RG8 8 0 1000000000000
RG9 9 0 1000000000000
RG10 10 0 1000000000000
RG11 11 0 1000000000000
RG12 12 0 1000000000000
RG13 13 0 1000000000000
RG14 14 0 1000000000000
RG15 15 0 1000000000000
RG16 16 0 1000000000000
RG17 17 0 1000000000000
RG18 18 0 1000000000000
RG19 19 0 1000000000000
RG20 20 0 1000000000000
RG21 21 0 1000000000000
RG22 22 0 1000000000000
RG23 23 0 1000000000000
RG24 24 0 1000000000000
RG25 25 0 1000000000000
RG26 26 0 1000000000000
RG27 27 0 1000000000000
RG28 28 0 1000000000000
RG29 29 0 1000000000000
VS0 26 s0 0
R0 s0 18 10e-1
VS1 11 s1 0
R1 s1 22 10e0
VS2 19 s2 0
C2 s2 7 12e-5
VS3 12 s3 0
R3 s3 11 33e3
VS4 23 s4 0
L4 s4 11 56e-2
VS5 6 s5 0
L5 s5 25 12e-5
VS6 24 s6 0
R6 s6 19 18e-2
VS7 3 s7 0
R7 s7 7 56e3
VS8 6 s8 0
R8 s8 7 33e3
VS9 29 s9 0
R9 s9 26 68e1
VS10 10 s10 0
C10 s10 23 10e-4
VS11 0 s11 0
V11 e11 s11 DC 0 AC 15e-1 120
RI11 e11 22 12e-2
VS12 11 s12 0
L12 s12 7 47e-5
VS13 15 s13 0
L13 s13 8 56e-4
VS14 19 s14 0
R14 s14 16 47e3
VS15 28 s15 0
C15 s15 5 39e-7
VS16 22 s16 0
R16 s16 1 12e1
VS17 3 s17 0
L17 s17 29 27e-4
VS18 6 s18 0
R18 s18 14 39e1
VS19 5 s19 0
R19 s19 13 27e3
VS20 12 s20 0
V20 e20 s20 DC 0 AC 22e0 -120
RI20 e20 15 33e-2
VS21 24 s21 0
L21 s21 4 18e-3
VS22 7 s22 0
R22 s22 18 12e1
VS23 12 s23 0
V23 e23 s23 DC 0 AC 47e1 120
RI23 e23 26 82e-1
VS24 29 s24 0
V24 e24 s24 DC 0 AC 33e1 0
RI24 e24 17 68e-3
VS25 5 s25 0
R25 s25 10 68e1
VS26 12 s26 0
C26 s26 24 22e-7
VS27 22 s27 0
R27 s27 2 18e1
VS28 4 s28 0
V28 e28 s28 DC 0 AC 18e-1 120
RI28 e28 15 33e-3
VS29 3 s29 0
R29 s29 10 47e3
VS30 8 s30 0
V30 e30 s30 DC 0 AC 82e-1 120
RI30 e30 9 15e-3
VS31 14 s31 0
C31 s31 20 12e-7
VS32 8 s32 0
L32 s32 11 10e-4
VS33 5 s33 0
R33 s33 9 27e3
VS34 21 s34 0
L34 s34 1 15e-4
VS35 19 s35 0
L35 s35 22 15e-3
VS36 11 s36 0
L36 s36 10 33e-4
VS37 1 s37 0
R37 s37 26 56e-2
VS38 8 s38 0
L38 s38 24 15e-2
VS39 26 s39 0
C39 s39 27 12e-6
.control
set numdgt=17
ac lin 1 60 60
print v(1) v(2) v(3) v(4) v(5) v(6) v(7) v(8) v(9) v(10)
print v(11) v(12) v(13) v(14) v(15) v(16) v(17) v(18) v(19) v(20)
print v(21) v(22) v(23) v(24) v(25) v(26) v(27) v(28) v(29)
print i(vs0) i(vs1) i(vs2) i(vs3) i(vs4) i(vs5) i(vs6) i(vs7) i(vs8) i(vs9)
print i(vs10) i(vs11) i(vs12) i(vs13) i(vs14) i(vs15) i(vs16) i(vs17) i(vs18) i(vs19)
print i(vs20) i(vs21) i(vs22) i(vs23) i(vs24) i(vs25) i(vs26) i(vs27) i(vs28) i(vs29)
print i(vs30) i(vs31) i(vs32) i(vs33) i(vs34) i(vs35) i(vs36) i(vs37) i(vs38) i(vs39)
.endc
.end
