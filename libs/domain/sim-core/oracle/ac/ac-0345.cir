controls oracle ac-0345
* Generated (plan F2.7, ADR 0012): do not edit; regenerate with `pnpm sim oracle regen`. ac seed 20261031 index 345 nodes 24 elements 37
.options sparse gmin=1e-12 noopac
RG1 1 0 1000000000000
RG2 2 0 1000000000000
RG3 3 0 1000000000000
RG4 4 0 1000000000000
RG5 5 0 1000000000000
RG6 6 0 1000000000000
RG7 7 0 1000000000000
RG8 8 0 1000000000000
RG9 9 0 1000000000000
RG10 10 0 1000000000000
RG11 11 0 1000000000000
RG12 12 0 1000000000000
RG13 13 0 1000000000000
RG14 14 0 1000000000000
RG15 15 0 1000000000000
RG16 16 0 1000000000000
RG17 17 0 1000000000000
RG18 18 0 1000000000000
RG19 19 0 1000000000000
RG20 20 0 1000000000000
RG21 21 0 1000000000000
RG22 22 0 1000000000000
RG23 23 0 1000000000000
VS0 1 s0 0
R0 s0 23 18e-2
VS1 6 s1 0
R1 s1 17 56e3
VS2 0 s2 0
R2 s2 20 18e-1
VS3 9 s3 0
R3 s3 22 47e-2
VS4 11 s4 0
C4 s4 1 39e-7
VS5 15 s5 0
L5 s5 3 68e-2
VS6 0 s6 0
V6 e6 s6 DC 0 AC 47e-1 -120
RI6 e6 n6 15e-1
H6 n6 h6 VS7 33e-4
ED6 h6 8 d6 0 -12e-5
F6 0 d6 VS7 1
LD6 d6 0 1
VS7 14 s7 0
V7 e7 s7 DC 0 AC 12e1 -120
RI7 e7 n7 39e-3
H7 n7 h7 VS6 33e-4
ED7 h7 20 d7 0 -12e-5
F7 0 d7 VS6 1
LD7 d7 0 1
VS8 1 s8 0
R8 s8 12 10e3
VS9 20 s9 0
L9 s9 17 15e-2
VS10 2 s10 0
V10 e10 s10 DC 0 AC 39e-1 120
RI10 e10 8 68e-3
VS11 3 s11 0
C11 s11 4 18e-4
VS12 4 s12 0
C12 s12 2 82e-5
VS13 7 s13 0
V13 e13 s13 DC 0 AC 47e1 120
RI13 e13 m13 27e-2
LI13 m13 17 15e-6
VS14 22 s14 0
V14 e14 s14 DC 0 AC 27e1 0
RI14 e14 21 10e-2
VS15 23 s15 0
V15 e15 s15 DC 0 AC 39e-1 0
RI15 e15 m15 22e-1
LI15 m15 3 56e-5
VS16 3 s16 0
R16 s16 22 39e2
VS17 20 s17 0
R17 s17 7 82e-1
VS18 16 s18 0
L18 s18 17 15e-2
VS19 10 s19 0
V19 e19 s19 DC 0 AC 68e-1 -120
RI19 e19 m19 47e-3
LI19 m19 0 47e-6
VS20 19 s20 0
R20 s20 18 10e2
VS21 10 s21 0
R21 s21 16 56e-1
VS22 13 s22 0
L22 s22 5 22e-3
VS23 18 s23 0
L23 s23 11 56e-4
VS24 8 s24 0
C24 s24 4 18e-6
VS25 4 s25 0
C25 s25 6 18e-4
VS26 22 s26 0
C26 s26 16 15e-5
VS27 23 s27 0
R27 s27 19 15e-1
VS28 8 s28 0
L28 s28 21 27e-4
VS29 5 s29 0
C29 s29 14 56e-7
VS30 14 s30 0
V30 e30 s30 DC 0 AC 33e1 -120
RI30 e30 15 15e-2
VS31 0 s31 0
C31 s31 23 27e-7
VS32 10 s32 0
R32 s32 13 15e-2
VS33 20 s33 0
V33 e33 s33 DC 0 AC 22e1 -120
RI33 e33 12 39e-1
VS34 20 s34 0
L34 s34 11 18e-2
VS35 23 s35 0
L35 s35 9 47e-2
VS36 5 s36 0
R36 s36 19 18e1
.control
set numdgt=17
ac lin 1 60 60
print v(1) v(2) v(3) v(4) v(5) v(6) v(7) v(8) v(9) v(10)
print v(11) v(12) v(13) v(14) v(15) v(16) v(17) v(18) v(19) v(20)
print v(21) v(22) v(23)
print i(vs0) i(vs1) i(vs2) i(vs3) i(vs4) i(vs5) i(vs6) i(vs7) i(vs8) i(vs9)
print i(vs10) i(vs11) i(vs12) i(vs13) i(vs14) i(vs15) i(vs16) i(vs17) i(vs18) i(vs19)
print i(vs20) i(vs21) i(vs22) i(vs23) i(vs24) i(vs25) i(vs26) i(vs27) i(vs28) i(vs29)
print i(vs30) i(vs31) i(vs32) i(vs33) i(vs34) i(vs35) i(vs36)
.endc
.end
