controls oracle ac-0345
* Generated (plan F2.7, ADR 0012): do not edit; regenerate with `pnpm sim oracle regen`. ac seed 20261031 index 345 nodes 24 elements 26
.options sparse gmin=1e-12 noopac
RG1 1 0 1000000000000
RG2 2 0 1000000000000
RG3 3 0 1000000000000
RG4 4 0 1000000000000
RG5 5 0 1000000000000
RG6 6 0 1000000000000
RG7 7 0 1000000000000
RG8 8 0 1000000000000
RG9 9 0 1000000000000
RG10 10 0 1000000000000
RG11 11 0 1000000000000
RG12 12 0 1000000000000
RG13 13 0 1000000000000
RG14 14 0 1000000000000
RG15 15 0 1000000000000
RG16 16 0 1000000000000
RG17 17 0 1000000000000
RG18 18 0 1000000000000
RG19 19 0 1000000000000
RG20 20 0 1000000000000
RG21 21 0 1000000000000
RG22 22 0 1000000000000
RG23 23 0 1000000000000
VS0 1 s0 0
R0 s0 0 18e-2
VS1 20 s1 0
R1 s1 7 82e-1
VS2 8 s2 0
C2 s2 4 18e-6
VS3 0 s3 0
V3 e3 s3 DC 0 AC 39e-1 0
RI3 e3 3 22e-1
VS4 2 s4 0
V4 e4 s4 DC 0 AC 39e-1 120
RI4 e4 8 68e-3
VS5 20 s5 0
L5 s5 23 15e-2
VS6 14 s6 0
V6 e6 s6 DC 0 AC 12e1 -120
RI6 e6 20 39e-3
VS7 17 s7 0
R7 s7 20 18e-1
VS8 15 s8 0
L8 s8 3 68e-2
VS9 17 s9 0
V9 e9 s9 DC 0 AC 47e-1 -120
RI9 e9 8 15e-1
VS10 22 s10 0
V10 e10 s10 DC 0 AC 27e1 0
RI10 e10 21 10e-2
VS11 0 s11 0
R11 s11 19 15e-1
VS12 5 s12 0
C12 s12 14 56e-7
VS13 18 s13 0
L13 s13 11 56e-4
VS14 10 s14 0
R14 s14 13 15e-2
VS15 20 s15 0
L15 s15 11 18e-2
VS16 6 s16 0
R16 s16 23 56e3
VS17 20 s17 0
V17 e17 s17 DC 0 AC 22e1 -120
RI17 e17 12 39e-1
VS18 17 s18 0
C18 s18 0 27e-7
VS19 13 s19 0
L19 s19 5 22e-3
VS20 3 s20 0
R20 s20 22 39e2
VS21 8 s21 0
L21 s21 21 27e-4
VS22 0 s22 0
L22 s22 9 47e-2
VS23 10 s23 0
V23 e23 s23 DC 0 AC 68e-1 -120
RI23 e23 17 47e-3
VS24 5 s24 0
R24 s24 19 18e1
VS25 10 s25 0
R25 s25 16 56e-1
.control
set numdgt=17
ac lin 1 60 60
print v(1) v(2) v(3) v(4) v(5) v(6) v(7) v(8) v(9) v(10)
print v(11) v(12) v(13) v(14) v(15) v(16) v(17) v(18) v(19) v(20)
print v(21) v(22) v(23)
print i(vs0) i(vs1) i(vs2) i(vs3) i(vs4) i(vs5) i(vs6) i(vs7) i(vs8) i(vs9)
print i(vs10) i(vs11) i(vs12) i(vs13) i(vs14) i(vs15) i(vs16) i(vs17) i(vs18) i(vs19)
print i(vs20) i(vs21) i(vs22) i(vs23) i(vs24) i(vs25)
.endc
.end
