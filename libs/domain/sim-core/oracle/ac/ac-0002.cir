controls oracle ac-0002
* Generated (plan F2.7, ADR 0012): do not edit; regenerate with `pnpm sim oracle regen`. ac seed 20261031 index 2 nodes 20 elements 29
.options sparse gmin=1e-12 noopac
RG1 1 0 1000000000000
RG2 2 0 1000000000000
RG3 3 0 1000000000000
RG4 4 0 1000000000000
RG5 5 0 1000000000000
RG6 6 0 1000000000000
RG7 7 0 1000000000000
RG8 8 0 1000000000000
RG9 9 0 1000000000000
RG10 10 0 1000000000000
RG11 11 0 1000000000000
RG12 12 0 1000000000000
RG13 13 0 1000000000000
RG14 14 0 1000000000000
RG15 15 0 1000000000000
RG16 16 0 1000000000000
RG17 17 0 1000000000000
RG18 18 0 1000000000000
RG19 19 0 1000000000000
VS0 19 s0 0
C0 s0 5 10e-4
VS1 0 s1 0
V1 e1 s1 DC 0 AC 22e1 180
RI1 e1 1 12e-1
VS2 2 s2 0
L2 s2 13 18e-2
VS3 4 s3 0
R3 s3 8 39e2
VS4 10 s4 0
C4 s4 2 47e-6
VS5 19 s5 0
L5 s5 3 12e-4
VS6 16 s6 0
C6 s6 14 82e-6
VS7 10 s7 0
R7 s7 13 10e1
VS8 14 s8 0
C8 s8 15 47e-6
VS9 12 s9 0
L9 s9 4 33e-5
VS10 14 s10 0
R10 s10 12 68e1
VS11 1 s11 0
V11 e11 s11 DC 0 AC 47e0 180
RI11 e11 2 18e-1
VS12 13 s12 0
R12 s12 5 56e-2
VS13 3 s13 0
C13 s13 4 68e-5
VS14 17 s14 0
L14 s14 0 47e-3
VS15 19 s15 0
L15 s15 7 39e-5
VS16 11 s16 0
V16 e16 s16 DC 0 AC 12e-1 -120
RI16 e16 9 56e-1
VS17 8 s17 0
R17 s17 13 33e1
VS18 7 s18 0
R18 s18 15 22e3
VS19 1 s19 0
R19 s19 9 27e-1
VS20 15 s20 0
L20 s20 18 18e-4
VS21 13 s21 0
L21 s21 6 82e-3
VS22 15 s22 0
R22 s22 13 47e1
VS23 13 s23 0
R23 s23 11 22e2
VS24 16 s24 0
C24 s24 17 39e-6
VS25 13 s25 0
L25 s25 4 10e-3
VS26 6 s26 0
L26 s26 2 15e-2
VS27 16 s27 0
R27 s27 15 15e-2
VS28 0 s28 0
R28 s28 18 10e1
.control
set numdgt=17
ac lin 1 60 60
print v(1) v(2) v(3) v(4) v(5) v(6) v(7) v(8) v(9) v(10)
print v(11) v(12) v(13) v(14) v(15) v(16) v(17) v(18) v(19)
print i(vs0) i(vs1) i(vs2) i(vs3) i(vs4) i(vs5) i(vs6) i(vs7) i(vs8) i(vs9)
print i(vs10) i(vs11) i(vs12) i(vs13) i(vs14) i(vs15) i(vs16) i(vs17) i(vs18) i(vs19)
print i(vs20) i(vs21) i(vs22) i(vs23) i(vs24) i(vs25) i(vs26) i(vs27) i(vs28)
.endc
.end
