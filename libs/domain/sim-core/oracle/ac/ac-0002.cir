controls oracle ac-0002
* Generated (plan F2.7, ADR 0012): do not edit; regenerate with `pnpm sim oracle regen`. ac seed 20261031 index 2 nodes 20 elements 27
.options sparse gmin=1e-12 noopac
RG1 1 0 1000000000000
RG2 2 0 1000000000000
RG3 3 0 1000000000000
RG4 4 0 1000000000000
RG5 5 0 1000000000000
RG6 6 0 1000000000000
RG7 7 0 1000000000000
RG8 8 0 1000000000000
RG9 9 0 1000000000000
RG10 10 0 1000000000000
RG11 11 0 1000000000000
RG12 12 0 1000000000000
RG13 13 0 1000000000000
RG14 14 0 1000000000000
RG15 15 0 1000000000000
RG16 16 0 1000000000000
RG17 17 0 1000000000000
RG18 18 0 1000000000000
RG19 19 0 1000000000000
VS0 2 s0 0
L0 s0 15 10e-4
VS1 19 s1 0
C1 s1 5 10e-4
VS2 15 s2 0
L2 s2 18 18e-4
VS3 16 s3 0
C3 s3 0 39e-6
VS4 12 s4 0
L4 s4 8 27e-2
VS5 10 s5 0
L5 s5 11 82e-3
VS6 0 s6 0
L6 s6 13 47e-3
VS7 16 s7 0
R7 s7 15 15e-2
VS8 9 s8 0
C8 s8 19 27e-5
VS9 9 s9 0
L9 s9 11 33e-4
VS10 17 s10 0
L10 s10 4 10e-3
VS11 6 s11 0
L11 s11 2 15e-2
VS12 8 s12 0
R12 s12 17 33e1
VS13 0 s13 0
V13 e13 s13 DC 0 AC 15e1 180
RI13 e13 12 15e-3
VS14 5 s14 0
C14 s14 19 22e-7
VS15 10 s15 0
R15 s15 17 10e1
VS16 7 s16 0
R16 s16 6 10e3
VS17 17 s17 0
R17 s17 11 22e2
VS18 2 s18 0
L18 s18 17 18e-2
VS19 3 s19 0
C19 s19 4 68e-5
VS20 13 s20 0
V20 e20 s20 DC 0 AC 22e1 180
RI20 e20 1 12e-1
VS21 12 s21 0
L21 s21 4 33e-5
VS22 17 s22 0
R22 s22 5 56e-2
VS23 1 s23 0
L23 s23 9 39e-5
VS24 7 s24 0
L24 s24 11 18e-5
VS25 14 s25 0
C25 s25 15 47e-6
VS26 15 s26 0
R26 s26 17 47e1
.control
set numdgt=17
ac lin 1 60 60
print v(1) v(2) v(3) v(4) v(5) v(6) v(7) v(8) v(9) v(10)
print v(11) v(12) v(13) v(14) v(15) v(16) v(17) v(18) v(19)
print i(vs0) i(vs1) i(vs2) i(vs3) i(vs4) i(vs5) i(vs6) i(vs7) i(vs8) i(vs9)
print i(vs10) i(vs11) i(vs12) i(vs13) i(vs14) i(vs15) i(vs16) i(vs17) i(vs18) i(vs19)
print i(vs20) i(vs21) i(vs22) i(vs23) i(vs24) i(vs25) i(vs26)
.endc
.end
