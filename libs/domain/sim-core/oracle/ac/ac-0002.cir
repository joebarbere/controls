controls oracle ac-0002
* Generated (plan F2.7, ADR 0012): do not edit; regenerate with `pnpm sim oracle regen`. ac seed 20261031 index 2 nodes 20 elements 30
.options sparse gmin=1e-12 noopac
RG1 1 0 1000000000000
RG2 2 0 1000000000000
RG3 3 0 1000000000000
RG4 4 0 1000000000000
RG5 5 0 1000000000000
RG6 6 0 1000000000000
RG7 7 0 1000000000000
RG8 8 0 1000000000000
RG9 9 0 1000000000000
RG10 10 0 1000000000000
RG11 11 0 1000000000000
RG12 12 0 1000000000000
RG13 13 0 1000000000000
RG14 14 0 1000000000000
RG15 15 0 1000000000000
RG16 16 0 1000000000000
RG17 17 0 1000000000000
RG18 18 0 1000000000000
RG19 19 0 1000000000000
VS0 17 s0 0
L0 s0 0 47e-3
VS1 16 s1 0
C1 s1 17 39e-6
VS2 7 s2 0
L2 s2 11 18e-5
VS3 13 s3 0
R3 s3 5 56e-2
VS4 10 s4 0
L4 s4 11 82e-3
VS5 16 s5 0
R5 s5 15 15e-2
VS6 2 s6 0
L6 s6 15 10e-4
VS7 12 s7 0
L7 s7 8 27e-2
VS8 3 s8 0
R8 s8 18 39e2
VS9 0 s9 0
V9 e9 s9 DC 0 AC 22e1 180
RI9 e9 1 12e-1
VS10 5 s10 0
C10 s10 19 22e-7
VS11 8 s11 0
R11 s11 13 33e1
VS12 14 s12 0
C12 s12 15 47e-6
VS13 13 s13 0
R13 s13 11 22e2
VS14 7 s14 0
R14 s14 6 10e3
VS15 9 s15 0
L15 s15 11 33e-4
VS16 19 s16 0
L16 s16 3 12e-4
VS17 1 s17 0
L17 s17 9 39e-5
VS18 10 s18 0
R18 s18 13 10e1
VS19 6 s19 0
L19 s19 2 15e-2
VS20 15 s20 0
L20 s20 18 18e-4
VS21 13 s21 0
L21 s21 4 10e-3
VS22 2 s22 0
L22 s22 13 18e-2
VS23 15 s23 0
R23 s23 13 47e1
VS24 3 s24 0
C24 s24 4 68e-5
VS25 9 s25 0
C25 s25 19 27e-5
VS26 11 s26 0
R26 s26 14 68e1
VS27 17 s27 0
V27 e27 s27 DC 0 AC 15e1 180
RI27 e27 12 15e-3
VS28 12 s28 0
L28 s28 4 33e-5
VS29 19 s29 0
C29 s29 5 10e-4
.control
set numdgt=17
ac lin 1 60 60
print v(1) v(2) v(3) v(4) v(5) v(6) v(7) v(8) v(9) v(10)
print v(11) v(12) v(13) v(14) v(15) v(16) v(17) v(18) v(19)
print i(vs0) i(vs1) i(vs2) i(vs3) i(vs4) i(vs5) i(vs6) i(vs7) i(vs8) i(vs9)
print i(vs10) i(vs11) i(vs12) i(vs13) i(vs14) i(vs15) i(vs16) i(vs17) i(vs18) i(vs19)
print i(vs20) i(vs21) i(vs22) i(vs23) i(vs24) i(vs25) i(vs26) i(vs27) i(vs28) i(vs29)
.endc
.end
