controls oracle ac-0065
* Generated (plan F2.7, ADR 0012): do not edit; regenerate with `pnpm sim oracle regen`. ac seed 20261031 index 65 nodes 24 elements 37
.options sparse gmin=1e-12 noopac
RG1 1 0 1000000000000
RG2 2 0 1000000000000
RG3 3 0 1000000000000
RG4 4 0 1000000000000
RG5 5 0 1000000000000
RG6 6 0 1000000000000
RG7 7 0 1000000000000
RG8 8 0 1000000000000
RG9 9 0 1000000000000
RG10 10 0 1000000000000
RG11 11 0 1000000000000
RG12 12 0 1000000000000
RG13 13 0 1000000000000
RG14 14 0 1000000000000
RG15 15 0 1000000000000
RG16 16 0 1000000000000
RG17 17 0 1000000000000
RG18 18 0 1000000000000
RG19 19 0 1000000000000
RG20 20 0 1000000000000
RG21 21 0 1000000000000
RG22 22 0 1000000000000
RG23 23 0 1000000000000
VS0 0 s0 0
V0 e0 s0 DC 0 AC 33e0 180
RI0 e0 1 27e-1
VS1 20 s1 0
V1 e1 s1 DC 0 AC 39e-1 0
RI1 e1 1 27e-2
VS2 12 s2 0
R2 s2 2 22e-1
VS3 4 s3 0
V3 e3 s3 DC 0 AC 33e0 180
RI3 e3 6 27e-1
VS4 20 s4 0
L4 s4 19 47e-4
VS5 1 s5 0
R5 s5 0 82e2
VS6 21 s6 0
L6 s6 14 15e-4
VS7 6 s7 0
L7 s7 15 18e-4
VS8 20 s8 0
L8 s8 10 27e-2
VS9 19 s9 0
R9 s9 4 82e2
VS10 13 s10 0
L10 s10 23 68e-2
VS11 6 s11 0
L11 s11 3 18e-3
VS12 12 s12 0
V12 e12 s12 DC 0 AC 22e1 -120
RI12 e12 17 12e-3
VS13 16 s13 0
C13 s13 13 68e-5
VS14 16 s14 0
C14 s14 5 27e-6
VS15 4 s15 0
L15 s15 3 18e-4
VS16 0 s16 0
L16 s16 17 82e-2
VS17 1 s17 0
R17 s17 15 18e1
VS18 9 s18 0
L18 s18 19 27e-2
VS19 21 s19 0
L19 s19 0 33e-2
VS20 22 s20 0
L20 s20 0 68e-2
VS21 20 s21 0
L21 s21 2 18e-2
VS22 8 s22 0
L22 s22 17 18e-3
VS23 3 s23 0
R23 s23 23 68e2
VS24 14 s24 0
V24 e24 s24 DC 0 AC 39e0 -120
RI24 e24 4 68e-1
VS25 14 s25 0
V25 e25 s25 DC 0 AC 68e-1 -120
RI25 e25 18 12e-2
VS26 1 s26 0
L26 s26 18 39e-3
VS27 6 s27 0
R27 s27 7 15e-2
VS28 7 s28 0
L28 s28 12 33e-3
VS29 22 s29 0
C29 s29 3 27e-4
VS30 6 s30 0
V30 e30 s30 DC 0 AC 27e1 -120
RI30 e30 m30 68e-3
LI30 m30 17 18e-5
VS31 10 s31 0
R31 s31 5 33e2
VS32 16 s32 0
L32 s32 8 68e-2
VS33 1 s33 0
R33 s33 12 47e3
VS34 11 s34 0
C34 s34 0 82e-5
VS35 11 s35 0
L35 s35 2 33e-3
VS36 1 s36 0
C36 s36 9 47e-7
.control
set numdgt=17
ac lin 1 60 60
print v(1) v(2) v(3) v(4) v(5) v(6) v(7) v(8) v(9) v(10)
print v(11) v(12) v(13) v(14) v(15) v(16) v(17) v(18) v(19) v(20)
print v(21) v(22) v(23)
print i(vs0) i(vs1) i(vs2) i(vs3) i(vs4) i(vs5) i(vs6) i(vs7) i(vs8) i(vs9)
print i(vs10) i(vs11) i(vs12) i(vs13) i(vs14) i(vs15) i(vs16) i(vs17) i(vs18) i(vs19)
print i(vs20) i(vs21) i(vs22) i(vs23) i(vs24) i(vs25) i(vs26) i(vs27) i(vs28) i(vs29)
print i(vs30) i(vs31) i(vs32) i(vs33) i(vs34) i(vs35) i(vs36)
.endc
.end
