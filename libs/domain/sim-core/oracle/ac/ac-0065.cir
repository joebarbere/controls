controls oracle ac-0065
* Generated (plan F2.7, ADR 0012): do not edit; regenerate with `pnpm sim oracle regen`. ac seed 20261031 index 65 nodes 24 elements 38
.options sparse gmin=1e-12 noopac
RG1 1 0 1000000000000
RG2 2 0 1000000000000
RG3 3 0 1000000000000
RG4 4 0 1000000000000
RG5 5 0 1000000000000
RG6 6 0 1000000000000
RG7 7 0 1000000000000
RG8 8 0 1000000000000
RG9 9 0 1000000000000
RG10 10 0 1000000000000
RG11 11 0 1000000000000
RG12 12 0 1000000000000
RG13 13 0 1000000000000
RG14 14 0 1000000000000
RG15 15 0 1000000000000
RG16 16 0 1000000000000
RG17 17 0 1000000000000
RG18 18 0 1000000000000
RG19 19 0 1000000000000
RG20 20 0 1000000000000
RG21 21 0 1000000000000
RG22 22 0 1000000000000
RG23 23 0 1000000000000
VS0 22 s0 0
C0 s0 4 27e-4
VS1 12 s1 0
R1 s1 23 39e-1
VS2 6 s2 0
C2 s2 21 27e-7
VS3 2 s3 0
C3 s3 6 22e-4
VS4 12 s4 0
R4 s4 14 68e3
VS5 5 s5 0
R5 s5 17 27e-2
VS6 19 s6 0
R6 s6 23 82e2
VS7 0 s7 0
V7 e7 s7 DC 0 AC 82e-1 120
RI7 e7 7 18e-3
VS8 5 s8 0
L8 s8 16 82e-5
VS9 16 s9 0
V9 e9 s9 DC 0 AC 82e1 0
RI9 e9 3 68e-1
VS10 1 s10 0
L10 s10 13 82e-4
VS11 10 s11 0
C11 s11 15 27e-4
VS12 6 s12 0
L12 s12 4 18e-3
VS13 15 s13 0
R13 s13 2 39e-1
VS14 19 s14 0
R14 s14 21 10e-1
VS15 3 s15 0
R15 s15 5 56e3
VS16 8 s16 0
L16 s16 18 15e-4
VS17 3 s17 0
L17 s17 7 56e-5
VS18 7 s18 0
L18 s18 13 18e-4
VS19 6 s19 0
V19 e19 s19 DC 0 AC 27e1 -120
RI19 e19 17 68e-3
VS20 9 s20 0
C20 s20 14 68e-7
VS21 17 s21 0
C21 s21 18 22e-5
VS22 10 s22 0
R22 s22 11 39e-1
VS23 1 s23 0
C23 s23 9 10e-7
VS24 8 s24 0
V24 e24 s24 DC 0 AC 39e1 120
RI24 e24 14 18e-2
VS25 23 s25 0
C25 s25 13 15e-4
VS26 22 s26 0
R26 s26 15 15e2
VS27 5 s27 0
C27 s27 12 68e-4
VS28 21 s28 0
R28 s28 2 18e1
VS29 20 s29 0
C29 s29 14 27e-7
VS30 1 s30 0
V30 e30 s30 DC 0 AC 15e0 0
RI30 e30 11 27e-2
VS31 12 s31 0
R31 s31 1 68e2
VS32 17 s32 0
V32 e32 s32 DC 0 AC 56e0 180
RI32 e32 12 22e-1
VS33 6 s33 0
L33 s33 11 47e-4
VS34 6 s34 0
C34 s34 18 12e-6
VS35 0 s35 0
V35 e35 s35 DC 0 AC 82e0 120
RI35 e35 19 22e-2
VS36 12 s36 0
R36 s36 7 18e3
VS37 13 s37 0
L37 s37 20 27e-3
.control
set numdgt=17
ac lin 1 60 60
print v(1) v(2) v(3) v(4) v(5) v(6) v(7) v(8) v(9) v(10)
print v(11) v(12) v(13) v(14) v(15) v(16) v(17) v(18) v(19) v(20)
print v(21) v(22) v(23)
print i(vs0) i(vs1) i(vs2) i(vs3) i(vs4) i(vs5) i(vs6) i(vs7) i(vs8) i(vs9)
print i(vs10) i(vs11) i(vs12) i(vs13) i(vs14) i(vs15) i(vs16) i(vs17) i(vs18) i(vs19)
print i(vs20) i(vs21) i(vs22) i(vs23) i(vs24) i(vs25) i(vs26) i(vs27) i(vs28) i(vs29)
print i(vs30) i(vs31) i(vs32) i(vs33) i(vs34) i(vs35) i(vs36) i(vs37)
.endc
.end
