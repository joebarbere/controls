controls oracle ac-0215
* Generated (plan F2.7, ADR 0012): do not edit; regenerate with `pnpm sim oracle regen`. ac seed 20261031 index 215 nodes 26 elements 42
.options sparse gmin=1e-12 noopac
RG1 1 0 1000000000000
RG2 2 0 1000000000000
RG3 3 0 1000000000000
RG4 4 0 1000000000000
RG5 5 0 1000000000000
RG6 6 0 1000000000000
RG7 7 0 1000000000000
RG8 8 0 1000000000000
RG9 9 0 1000000000000
RG10 10 0 1000000000000
RG11 11 0 1000000000000
RG12 12 0 1000000000000
RG13 13 0 1000000000000
RG14 14 0 1000000000000
RG15 15 0 1000000000000
RG16 16 0 1000000000000
RG17 17 0 1000000000000
RG18 18 0 1000000000000
RG19 19 0 1000000000000
RG20 20 0 1000000000000
RG21 21 0 1000000000000
RG22 22 0 1000000000000
RG23 23 0 1000000000000
RG24 24 0 1000000000000
RG25 25 0 1000000000000
VS0 7 s0 0
C0 s0 4 33e-5
VS1 5 s1 0
L1 s1 3 15e-5
VS2 23 s2 0
L2 s2 3 68e-5
VS3 0 s3 0
R3 s3 8 27e1
VS4 9 s4 0
R4 s4 4 15e2
VS5 18 s5 0
C5 s5 21 56e-4
VS6 24 s6 0
R6 s6 16 15e1
VS7 8 s7 0
L7 s7 17 33e-5
VS8 13 s8 0
L8 s8 7 22e-3
VS9 24 s9 0
L9 s9 20 22e-5
VS10 12 s10 0
R10 s10 16 33e1
VS11 0 s11 0
V11 e11 s11 DC 0 AC 33e1 120
RI11 e11 20 27e-2
VS12 10 s12 0
C12 s12 5 18e-6
VS13 19 s13 0
V13 e13 s13 DC 0 AC 33e1 0
RI13 e13 15 22e-3
VS14 20 s14 0
R14 s14 3 39e1
VS15 6 s15 0
R15 s15 22 12e0
VS16 23 s16 0
R16 s16 25 27e-2
VS17 16 s17 0
R17 s17 2 12e1
VS18 20 s18 0
R18 s18 6 82e3
VS19 7 s19 0
R19 s19 12 68e0
VS20 1 s20 0
V20 e20 s20 DC 0 AC 12e1 -120
RI20 e20 12 56e-3
VS21 18 s21 0
L21 s21 5 22e-2
VS22 16 s22 0
L22 s22 6 27e-3
VS23 4 s23 0
L23 s23 15 27e-5
VS24 21 s24 0
C24 s24 5 10e-7
VS25 24 s25 0
L25 s25 17 22e-4
VS26 6 s26 0
C26 s26 25 10e-4
VS27 18 s27 0
L27 s27 11 15e-2
VS28 14 s28 0
C28 s28 21 27e-6
VS29 22 s29 0
L29 s29 11 47e-2
VS30 18 s30 0
V30 e30 s30 DC 0 AC 15e0 120
RI30 e30 19 10e-2
VS31 6 s31 0
V31 e31 s31 DC 0 AC 10e1 -120
RI31 e31 14 10e-3
VS32 7 s32 0
L32 s32 11 12e-4
VS33 23 s33 0
V33 e33 s33 DC 0 AC 39e0 180
RI33 e33 5 68e-2
VS34 16 s34 0
L34 s34 22 47e-3
VS35 12 s35 0
C35 s35 4 39e-4
VS36 11 s36 0
L36 s36 21 12e-2
VS37 10 s37 0
C37 s37 14 82e-6
VS38 8 s38 0
L38 s38 13 33e-4
VS39 17 s39 0
R39 s39 1 82e3
VS40 22 s40 0
R40 s40 12 22e-1
VS41 11 s41 0
L41 s41 12 47e-5
.control
set numdgt=17
ac lin 1 60 60
print v(1) v(2) v(3) v(4) v(5) v(6) v(7) v(8) v(9) v(10)
print v(11) v(12) v(13) v(14) v(15) v(16) v(17) v(18) v(19) v(20)
print v(21) v(22) v(23) v(24) v(25)
print i(vs0) i(vs1) i(vs2) i(vs3) i(vs4) i(vs5) i(vs6) i(vs7) i(vs8) i(vs9)
print i(vs10) i(vs11) i(vs12) i(vs13) i(vs14) i(vs15) i(vs16) i(vs17) i(vs18) i(vs19)
print i(vs20) i(vs21) i(vs22) i(vs23) i(vs24) i(vs25) i(vs26) i(vs27) i(vs28) i(vs29)
print i(vs30) i(vs31) i(vs32) i(vs33) i(vs34) i(vs35) i(vs36) i(vs37) i(vs38) i(vs39)
print i(vs40) i(vs41)
.endc
.end
