controls oracle ac-0215
* Generated (plan F2.7, ADR 0012): do not edit; regenerate with `pnpm sim oracle regen`. ac seed 20261031 index 215 nodes 26 elements 44
.options sparse gmin=1e-12 noopac
RG1 1 0 1000000000000
RG2 2 0 1000000000000
RG3 3 0 1000000000000
RG4 4 0 1000000000000
RG5 5 0 1000000000000
RG6 6 0 1000000000000
RG7 7 0 1000000000000
RG8 8 0 1000000000000
RG9 9 0 1000000000000
RG10 10 0 1000000000000
RG11 11 0 1000000000000
RG12 12 0 1000000000000
RG13 13 0 1000000000000
RG14 14 0 1000000000000
RG15 15 0 1000000000000
RG16 16 0 1000000000000
RG17 17 0 1000000000000
RG18 18 0 1000000000000
RG19 19 0 1000000000000
RG20 20 0 1000000000000
RG21 21 0 1000000000000
RG22 22 0 1000000000000
RG23 23 0 1000000000000
RG24 24 0 1000000000000
RG25 25 0 1000000000000
VS0 5 s0 0
L0 s0 3 15e-5
VS1 6 s1 0
R1 s1 1 12e0
VS2 17 s2 0
R2 s2 0 82e3
VS3 12 s3 0
C3 s3 4 39e-4
VS4 18 s4 0
L4 s4 5 22e-2
VS5 13 s5 0
L5 s5 7 22e-3
VS6 14 s6 0
C6 s6 21 27e-6
VS7 10 s7 0
C7 s7 5 18e-6
VS8 0 s8 0
V8 e8 s8 DC 0 AC 12e1 -120
RI8 e8 12 56e-3
VS9 24 s9 0
R9 s9 16 15e1
VS10 11 s10 0
L10 s10 21 12e-2
VS11 8 s11 0
L11 s11 17 33e-5
VS12 21 s12 0
C12 s12 5 10e-7
VS13 23 s13 0
V13 e13 s13 DC 0 AC 39e0 180
RI13 e13 5 68e-2
VS14 7 s14 0
R14 s14 12 68e0
VS15 1 s15 0
L15 s15 11 47e-2
VS16 18 s16 0
V16 e16 s16 DC 0 AC 15e0 120
RI16 e16 19 10e-2
VS17 23 s17 0
R17 s17 25 27e-2
VS18 19 s18 0
V18 e18 s18 DC 0 AC 33e1 0
RI18 e18 15 22e-3
VS19 23 s19 0
L19 s19 3 68e-5
VS20 11 s20 0
L20 s20 12 47e-5
VS21 9 s21 0
R21 s21 4 15e2
VS22 6 s22 0
V22 e22 s22 DC 0 AC 10e1 -120
RI22 e22 14 10e-3
VS23 7 s23 0
C23 s23 4 33e-5
VS24 24 s24 0
L24 s24 17 22e-4
VS25 20 s25 0
R25 s25 6 82e3
VS26 12 s26 0
R26 s26 16 33e1
VS27 22 s27 0
R27 s27 8 27e1
VS28 24 s28 0
L28 s28 20 22e-5
VS29 16 s29 0
R29 s29 2 12e1
VS30 16 s30 0
L30 s30 1 47e-3
VS31 18 s31 0
L31 s31 11 15e-2
VS32 12 s32 0
R32 s32 9 18e-2
VS33 4 s33 0
L33 s33 15 27e-5
VS34 18 s34 0
C34 s34 21 56e-4
VS35 22 s35 0
V35 e35 s35 DC 0 AC 33e1 120
RI35 e35 20 27e-2
VS36 8 s36 0
L36 s36 13 33e-4
VS37 20 s37 0
R37 s37 3 39e1
VS38 1 s38 0
R38 s38 12 22e-1
VS39 16 s39 0
L39 s39 6 27e-3
VS40 2 s40 0
L40 s40 15 22e-4
VS41 7 s41 0
L41 s41 11 12e-4
VS42 6 s42 0
C42 s42 25 10e-4
VS43 10 s43 0
C43 s43 14 82e-6
.control
set numdgt=17
ac lin 1 60 60
print v(1) v(2) v(3) v(4) v(5) v(6) v(7) v(8) v(9) v(10)
print v(11) v(12) v(13) v(14) v(15) v(16) v(17) v(18) v(19) v(20)
print v(21) v(22) v(23) v(24) v(25)
print i(vs0) i(vs1) i(vs2) i(vs3) i(vs4) i(vs5) i(vs6) i(vs7) i(vs8) i(vs9)
print i(vs10) i(vs11) i(vs12) i(vs13) i(vs14) i(vs15) i(vs16) i(vs17) i(vs18) i(vs19)
print i(vs20) i(vs21) i(vs22) i(vs23) i(vs24) i(vs25) i(vs26) i(vs27) i(vs28) i(vs29)
print i(vs30) i(vs31) i(vs32) i(vs33) i(vs34) i(vs35) i(vs36) i(vs37) i(vs38) i(vs39)
print i(vs40) i(vs41) i(vs42) i(vs43)
.endc
.end
