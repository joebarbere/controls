controls oracle ac-0215
* Generated (plan F2.7, ADR 0012): do not edit; regenerate with `pnpm sim oracle regen`. ac seed 20261031 index 215 nodes 26 elements 35
.options sparse gmin=1e-12 noopac
RG1 1 0 1000000000000
RG2 2 0 1000000000000
RG3 3 0 1000000000000
RG4 4 0 1000000000000
RG5 5 0 1000000000000
RG6 6 0 1000000000000
RG7 7 0 1000000000000
RG8 8 0 1000000000000
RG9 9 0 1000000000000
RG10 10 0 1000000000000
RG11 11 0 1000000000000
RG12 12 0 1000000000000
RG13 13 0 1000000000000
RG14 14 0 1000000000000
RG15 15 0 1000000000000
RG16 16 0 1000000000000
RG17 17 0 1000000000000
RG18 18 0 1000000000000
RG19 19 0 1000000000000
RG20 20 0 1000000000000
RG21 21 0 1000000000000
RG22 22 0 1000000000000
RG23 23 0 1000000000000
RG24 24 0 1000000000000
RG25 25 0 1000000000000
VS0 24 s0 0
L0 s0 2 27e-3
VS1 1 s1 0
L1 s1 16 82e-4
VS2 23 s2 0
C2 s2 7 15e-4
VS3 5 s3 0
R3 s3 0 27e0
VS4 9 s4 0
R4 s4 13 18e3
VS5 21 s5 0
R5 s5 18 56e-2
VS6 19 s6 0
R6 s6 10 56e1
VS7 0 s7 0
R7 s7 6 12e0
VS8 7 s8 0
R8 s8 21 82e-1
VS9 6 s9 0
L9 s9 11 47e-2
VS10 9 s10 0
L10 s10 25 22e-5
VS11 1 s11 0
L11 s11 19 47e-5
VS12 5 s12 0
R12 s12 2 39e2
VS13 3 s13 0
R13 s13 18 33e-1
VS14 13 s14 0
L14 s14 24 12e-2
VS15 15 s15 0
R15 s15 10 15e2
VS16 20 s16 0
R16 s16 10 10e1
VS17 16 s17 0
L17 s17 6 47e-3
VS18 0 s18 0
V18 e18 s18 DC 0 AC 10e1 -120
RI18 e18 14 10e-3
VS19 25 s19 0
V19 e19 s19 DC 0 AC 33e1 0
RI19 e19 m19 22e-3
LI19 m19 18 15e-7
VS20 9 s20 0
C20 s20 21 18e-6
VS21 4 s21 0
L21 s21 8 22e-4
VS22 15 s22 0
C22 s22 22 15e-4
VS23 14 s23 0
R23 s23 17 10e-1
VS24 20 s24 0
V24 e24 s24 DC 0 AC 82e0 0
RI24 e24 4 12e-2
VS25 12 s25 0
V25 e25 s25 DC 0 AC 12e-1 0
RI25 e25 23 27e-3
VS26 13 s26 0
L26 s26 11 47e-4
VS27 21 s27 0
C27 s27 20 12e-7
VS28 11 s28 0
R28 s28 1 22e1
VS29 22 s29 0
C29 s29 8 68e-6
VS30 24 s30 0
R30 s30 21 27e1
VS31 11 s31 0
R31 s31 12 56e3
VS32 20 s32 0
R32 s32 11 27e-2
VS33 17 s33 0
V33 e33 s33 DC 0 AC 68e-1 120
RI33 e33 m33 68e-1
LI33 m33 22 33e-7
VS34 3 s34 0
V34 e34 s34 DC 0 AC 56e0 -120
RI34 e34 m34 39e-3
LI34 m34 14 22e-7
.control
set numdgt=17
ac lin 1 60 60
print v(1) v(2) v(3) v(4) v(5) v(6) v(7) v(8) v(9) v(10)
print v(11) v(12) v(13) v(14) v(15) v(16) v(17) v(18) v(19) v(20)
print v(21) v(22) v(23) v(24) v(25)
print i(vs0) i(vs1) i(vs2) i(vs3) i(vs4) i(vs5) i(vs6) i(vs7) i(vs8) i(vs9)
print i(vs10) i(vs11) i(vs12) i(vs13) i(vs14) i(vs15) i(vs16) i(vs17) i(vs18) i(vs19)
print i(vs20) i(vs21) i(vs22) i(vs23) i(vs24) i(vs25) i(vs26) i(vs27) i(vs28) i(vs29)
print i(vs30) i(vs31) i(vs32) i(vs33) i(vs34)
.endc
.end
