controls oracle ac-0050
* Generated (plan F2.7, ADR 0012): do not edit; regenerate with `pnpm sim oracle regen`. ac seed 20261031 index 50 nodes 16 elements 22
.options sparse gmin=1e-12 noopac
RG1 1 0 1000000000000
RG2 2 0 1000000000000
RG3 3 0 1000000000000
RG4 4 0 1000000000000
RG5 5 0 1000000000000
RG6 6 0 1000000000000
RG7 7 0 1000000000000
RG8 8 0 1000000000000
RG9 9 0 1000000000000
RG10 10 0 1000000000000
RG11 11 0 1000000000000
RG12 12 0 1000000000000
RG13 13 0 1000000000000
RG14 14 0 1000000000000
RG15 15 0 1000000000000
VS0 0 s0 0
V0 e0 s0 DC 0 AC 82e1 180
RI0 e0 m0 12e-2
LI0 m0 10 47e-5
VS1 11 s1 0
V1 e1 s1 DC 0 AC 68e1 180
RI1 e1 9 18e-1
VS2 7 s2 0
R2 s2 8 18e3
VS3 8 s3 0
C3 s3 5 56e-7
VS4 13 s4 0
V4 e4 s4 DC 0 AC 18e-1 120
RI4 e4 2 33e-2
VS5 12 s5 0
L5 s5 14 82e-5
VS6 2 s6 0
C6 s6 12 82e-6
VS7 9 s7 0
V7 e7 s7 DC 0 AC 27e0 -120
RI7 e7 m7 82e-2
LI7 m7 2 12e-7
VS8 12 s8 0
R8 s8 15 39e0
VS9 15 s9 0
R9 s9 5 33e3
VS10 0 s10 0
L10 s10 2 18e-2
VS11 14 s11 0
R11 s11 1 56e2
VS12 8 s12 0
R12 s12 9 33e-2
VS13 6 s13 0
R13 s13 4 15e2
VS14 3 s14 0
L14 s14 4 39e-4
VS15 13 s15 0
C15 s15 6 33e-4
VS16 7 s16 0
R16 s16 3 15e3
VS17 1 s17 0
R17 s17 2 10e2
VS18 5 s18 0
L18 s18 3 18e-4
VS19 7 s19 0
L19 s19 11 18e-5
VS20 3 s20 0
C20 s20 14 27e-4
VS21 10 s21 0
R21 s21 6 27e3
.control
set numdgt=17
ac lin 1 60 60
print v(1) v(2) v(3) v(4) v(5) v(6) v(7) v(8) v(9) v(10)
print v(11) v(12) v(13) v(14) v(15)
print i(vs0) i(vs1) i(vs2) i(vs3) i(vs4) i(vs5) i(vs6) i(vs7) i(vs8) i(vs9)
print i(vs10) i(vs11) i(vs12) i(vs13) i(vs14) i(vs15) i(vs16) i(vs17) i(vs18) i(vs19)
print i(vs20) i(vs21)
.endc
.end
