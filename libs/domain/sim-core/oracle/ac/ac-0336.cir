controls oracle ac-0336
* Generated (plan F2.7, ADR 0012): do not edit; regenerate with `pnpm sim oracle regen`. ac seed 20261031 index 336 nodes 13 elements 21
.options sparse gmin=1e-12 noopac
RG1 1 0 1000000000000
RG2 2 0 1000000000000
RG3 3 0 1000000000000
RG4 4 0 1000000000000
RG5 5 0 1000000000000
RG6 6 0 1000000000000
RG7 7 0 1000000000000
RG8 8 0 1000000000000
RG9 9 0 1000000000000
RG10 10 0 1000000000000
RG11 11 0 1000000000000
RG12 12 0 1000000000000
VS0 0 s0 0
V0 e0 s0 DC 0 AC 27e0 120
RI0 e0 11 68e-1
VS1 3 s1 0
V1 e1 s1 DC 0 AC 68e1 -120
RI1 e1 9 68e-2
VS2 5 s2 0
C2 s2 9 68e-7
VS3 11 s3 0
L3 s3 5 33e-2
VS4 11 s4 0
C4 s4 3 27e-7
VS5 12 s5 0
V5 e5 s5 DC 0 AC 12e0 120
RI5 e5 11 18e-3
VS6 3 s6 0
C6 s6 2 68e-6
VS7 1 s7 0
R7 s7 0 12e2
VS8 9 s8 0
L8 s8 3 15e-4
VS9 10 s9 0
C9 s9 4 39e-5
VS10 8 s10 0
V10 e10 s10 DC 0 AC 68e-1 0
RI10 e10 9 22e-3
VS11 0 s11 0
L11 s11 1 56e-5
VS12 8 s12 0
R12 s12 6 33e2
VS13 4 s13 0
R13 s13 9 56e3
VS14 6 s14 0
V14 e14 s14 DC 0 AC 39e1 180
RI14 e14 0 33e-3
VS15 2 s15 0
V15 e15 s15 DC 0 AC 33e1 -120
RI15 e15 3 10e-2
VS16 8 s16 0
R16 s16 10 39e2
VS17 11 s17 0
C17 s17 9 56e-6
VS18 10 s18 0
L18 s18 7 12e-2
VS19 2 s19 0
R19 s19 10 12e3
VS20 5 s20 0
L20 s20 10 39e-4
.control
set numdgt=17
ac lin 1 60 60
print v(1) v(2) v(3) v(4) v(5) v(6) v(7) v(8) v(9) v(10)
print v(11) v(12)
print i(vs0) i(vs1) i(vs2) i(vs3) i(vs4) i(vs5) i(vs6) i(vs7) i(vs8) i(vs9)
print i(vs10) i(vs11) i(vs12) i(vs13) i(vs14) i(vs15) i(vs16) i(vs17) i(vs18) i(vs19)
print i(vs20)
.endc
.end
