controls oracle ac-0336
* Generated (plan F2.7, ADR 0012): do not edit; regenerate with `pnpm sim oracle regen`. ac seed 20261031 index 336 nodes 13 elements 19
.options sparse gmin=1e-12 noopac
RG1 1 0 1000000000000
RG2 2 0 1000000000000
RG3 3 0 1000000000000
RG4 4 0 1000000000000
RG5 5 0 1000000000000
RG6 6 0 1000000000000
RG7 7 0 1000000000000
RG8 8 0 1000000000000
RG9 9 0 1000000000000
RG10 10 0 1000000000000
RG11 11 0 1000000000000
RG12 12 0 1000000000000
VS0 11 s0 0
C0 s0 3 27e-7
VS1 12 s1 0
R1 s1 0 47e-2
VS2 2 s2 0
L2 s2 7 56e-4
VS3 9 s3 0
C3 s3 12 68e-6
VS4 10 s4 0
C4 s4 4 39e-5
VS5 3 s5 0
C5 s5 2 68e-6
VS6 0 s6 0
V6 e6 s6 DC 0 AC 12e0 120
RI6 e6 m6 18e-3
LI6 m6 11 47e-7
VS7 1 s7 0
V7 e7 s7 DC 0 AC 10e0 180
RI7 e7 m7 39e-1
LI7 m7 8 12e-6
VS8 10 s8 0
L8 s8 7 12e-2
VS9 2 s9 0
R9 s9 10 12e3
VS10 12 s10 0
L10 s10 10 39e-4
VS11 10 s11 0
L11 s11 0 12e-4
VS12 11 s12 0
L12 s12 12 33e-2
VS13 8 s13 0
R13 s13 10 39e2
VS14 4 s14 0
R14 s14 9 22e1
VS15 5 s15 0
V15 e15 s15 DC 0 AC 27e0 120
RI15 e15 m15 68e-1
LI15 m15 11 82e-5
VS16 8 s16 0
R16 s16 6 33e2
VS17 6 s17 0
V17 e17 s17 DC 0 AC 39e1 180
RI17 e17 m17 33e-3
LI17 m17 5 15e-7
VS18 1 s18 0
R18 s18 4 82e3
.control
set numdgt=17
ac lin 1 60 60
print v(1) v(2) v(3) v(4) v(5) v(6) v(7) v(8) v(9) v(10)
print v(11) v(12)
print i(vs0) i(vs1) i(vs2) i(vs3) i(vs4) i(vs5) i(vs6) i(vs7) i(vs8) i(vs9)
print i(vs10) i(vs11) i(vs12) i(vs13) i(vs14) i(vs15) i(vs16) i(vs17) i(vs18)
.endc
.end
