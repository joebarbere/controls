controls oracle ac-0020
* Generated (plan F2.7, ADR 0012): do not edit; regenerate with `pnpm sim oracle regen`. ac seed 20261031 index 20 nodes 12 elements 16
.options sparse gmin=1e-12 noopac
RG1 1 0 1000000000000
RG2 2 0 1000000000000
RG3 3 0 1000000000000
RG4 4 0 1000000000000
RG5 5 0 1000000000000
RG6 6 0 1000000000000
RG7 7 0 1000000000000
RG8 8 0 1000000000000
RG9 9 0 1000000000000
RG10 10 0 1000000000000
RG11 11 0 1000000000000
VS0 8 s0 0
R0 s0 4 22e3
VS1 0 s1 0
V1 e1 s1 DC 0 AC 18e0 -120
RI1 e1 9 47e-3
VS2 0 s2 0
V2 e2 s2 DC 0 AC 82e1 180
RI2 e2 1 27e-1
VS3 11 s3 0
L3 s3 10 39e-4
VS4 11 s4 0
C4 s4 0 22e-6
VS5 8 s5 0
L5 s5 2 15e-2
VS6 6 s6 0
R6 s6 5 33e-2
VS7 8 s7 0
L7 s7 1 15e-4
VS8 3 s8 0
R8 s8 8 82e0
VS9 2 s9 0
L9 s9 9 10e-3
VS10 8 s10 0
L10 s10 3 39e-2
VS11 7 s11 0
L11 s11 9 12e-3
VS12 2 s12 0
R12 s12 5 68e2
VS13 9 s13 0
R13 s13 8 56e0
VS14 7 s14 0
R14 s14 11 12e1
VS15 6 s15 0
V15 e15 s15 DC 0 AC 68e0 -120
RI15 e15 0 47e-3
.control
set numdgt=17
ac lin 1 60 60
print v(1) v(2) v(3) v(4) v(5) v(6) v(7) v(8) v(9) v(10)
print v(11)
print i(vs0) i(vs1) i(vs2) i(vs3) i(vs4) i(vs5) i(vs6) i(vs7) i(vs8) i(vs9)
print i(vs10) i(vs11) i(vs12) i(vs13) i(vs14) i(vs15)
.endc
.end
