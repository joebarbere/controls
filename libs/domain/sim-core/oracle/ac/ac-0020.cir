controls oracle ac-0020
* Generated (plan F2.7, ADR 0012): do not edit; regenerate with `pnpm sim oracle regen`. ac seed 20261031 index 20 nodes 12 elements 19
.options sparse gmin=1e-12 noopac
RG1 1 0 1000000000000
RG2 2 0 1000000000000
RG3 3 0 1000000000000
RG4 4 0 1000000000000
RG5 5 0 1000000000000
RG6 6 0 1000000000000
RG7 7 0 1000000000000
RG8 8 0 1000000000000
RG9 9 0 1000000000000
RG10 10 0 1000000000000
RG11 11 0 1000000000000
VS0 7 s0 0
L0 s0 9 12e-3
VS1 9 s1 0
R1 s1 8 56e0
VS2 8 s2 0
L2 s2 1 15e-4
VS3 10 s3 0
R3 s3 6 39e0
VS4 8 s4 0
R4 s4 4 22e3
VS5 7 s5 0
R5 s5 11 12e1
VS6 6 s6 0
R6 s6 5 33e-2
VS7 0 s7 0
V7 e7 s7 DC 0 AC 18e0 -120
RI7 e7 n7 47e-3
H7 n7 h7 VS14 -15e-4
ED7 h7 9 d7 0 -10e-7
F7 0 d7 VS14 1
LD7 d7 0 1
VS8 11 s8 0
C8 s8 0 22e-6
VS9 8 s9 0
L9 s9 2 15e-2
VS10 8 s10 0
L10 s10 3 39e-2
VS11 9 s11 0
L11 s11 4 68e-5
VS12 2 s12 0
L12 s12 9 10e-3
VS13 3 s13 0
R13 s13 8 82e0
VS14 6 s14 0
V14 e14 s14 DC 0 AC 68e0 -120
RI14 e14 n14 47e-3
H14 n14 h14 VS7 -15e-4
ED14 h14 0 d14 0 -10e-7
F14 0 d14 VS7 1
LD14 d14 0 1
VS15 2 s15 0
R15 s15 5 68e2
VS16 11 s16 0
L16 s16 10 39e-4
VS17 0 s17 0
V17 e17 s17 DC 0 AC 82e1 180
RI17 e17 m17 27e-1
LI17 m17 1 33e-6
VS18 3 s18 0
R18 s18 11 33e-1
.control
set numdgt=17
ac lin 1 60 60
print v(1) v(2) v(3) v(4) v(5) v(6) v(7) v(8) v(9) v(10)
print v(11)
print i(vs0) i(vs1) i(vs2) i(vs3) i(vs4) i(vs5) i(vs6) i(vs7) i(vs8) i(vs9)
print i(vs10) i(vs11) i(vs12) i(vs13) i(vs14) i(vs15) i(vs16) i(vs17) i(vs18)
.endc
.end
