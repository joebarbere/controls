controls oracle ac-0282
* Generated (plan F2.7, ADR 0012): do not edit; regenerate with `pnpm sim oracle regen`. ac seed 20261031 index 282 nodes 27 elements 38
.options sparse gmin=1e-12 noopac
RG1 1 0 1000000000000
RG2 2 0 1000000000000
RG3 3 0 1000000000000
RG4 4 0 1000000000000
RG5 5 0 1000000000000
RG6 6 0 1000000000000
RG7 7 0 1000000000000
RG8 8 0 1000000000000
RG9 9 0 1000000000000
RG10 10 0 1000000000000
RG11 11 0 1000000000000
RG12 12 0 1000000000000
RG13 13 0 1000000000000
RG14 14 0 1000000000000
RG15 15 0 1000000000000
RG16 16 0 1000000000000
RG17 17 0 1000000000000
RG18 18 0 1000000000000
RG19 19 0 1000000000000
RG20 20 0 1000000000000
RG21 21 0 1000000000000
RG22 22 0 1000000000000
RG23 23 0 1000000000000
RG24 24 0 1000000000000
RG25 25 0 1000000000000
RG26 26 0 1000000000000
VS0 13 s0 0
L0 s0 14 18e-2
VS1 17 s1 0
R1 s1 18 68e-2
VS2 26 s2 0
C2 s2 17 12e-6
VS3 26 s3 0
L3 s3 20 22e-4
VS4 11 s4 0
R4 s4 1 10e-1
VS5 13 s5 0
R5 s5 17 15e0
VS6 0 s6 0
V6 e6 s6 DC 0 AC 68e0 -120
RI6 e6 m6 33e-2
LI6 m6 11 82e-5
VS7 19 s7 0
R7 s7 20 27e0
VS8 15 s8 0
V8 e8 s8 DC 0 AC 12e-1 0
RI8 e8 m8 22e-1
LI8 m8 7 12e-7
VS9 21 s9 0
C9 s9 19 82e-5
VS10 8 s10 0
L10 s10 0 39e-4
VS11 7 s11 0
V11 e11 s11 DC 0 AC 22e-1 120
RI11 e11 m11 39e-1
LI11 m11 25 15e-6
VS12 1 s12 0
R12 s12 24 39e1
VS13 25 s13 0
L13 s13 26 33e-4
VS14 2 s14 0
V14 e14 s14 DC 0 AC 10e1 0
RI14 e14 8 56e-1
VS15 10 s15 0
R15 s15 17 22e2
VS16 23 s16 0
R16 s16 9 47e1
VS17 4 s17 0
R17 s17 22 12e0
VS18 14 s18 0
L18 s18 11 39e-2
VS19 3 s19 0
L19 s19 16 47e-5
VS20 26 s20 0
L20 s20 8 82e-3
VS21 12 s21 0
C21 s21 17 47e-6
VS22 3 s22 0
L22 s22 8 12e-5
VS23 18 s23 0
R23 s23 23 22e0
VS24 23 s24 0
R24 s24 7 10e1
VS25 9 s25 0
V25 e25 s25 DC 0 AC 33e1 0
RI25 e25 1 56e-2
VS26 5 s26 0
R26 s26 12 12e0
VS27 11 s27 0
V27 e27 s27 DC 0 AC 68e0 0
RI27 e27 m27 39e-2
LI27 m27 21 27e-5
VS28 4 s28 0
L28 s28 10 47e-3
VS29 6 s29 0
L29 s29 19 39e-2
VS30 1 s30 0
V30 e30 s30 DC 0 AC 10e-1 -120
RI30 e30 m30 10e-3
LI30 m30 8 56e-5
VS31 18 s31 0
L31 s31 6 56e-2
VS32 10 s32 0
L32 s32 24 22e-2
VS33 4 s33 0
L33 s33 2 39e-3
VS34 19 s34 0
R34 s34 10 82e-2
VS35 5 s35 0
L35 s35 22 47e-4
VS36 25 s36 0
V36 e36 s36 DC 0 AC 39e1 120
RI36 e36 m36 47e-3
LI36 m36 15 10e-7
VS37 16 s37 0
R37 s37 5 10e0
.control
set numdgt=17
ac lin 1 60 60
print v(1) v(2) v(3) v(4) v(5) v(6) v(7) v(8) v(9) v(10)
print v(11) v(12) v(13) v(14) v(15) v(16) v(17) v(18) v(19) v(20)
print v(21) v(22) v(23) v(24) v(25) v(26)
print i(vs0) i(vs1) i(vs2) i(vs3) i(vs4) i(vs5) i(vs6) i(vs7) i(vs8) i(vs9)
print i(vs10) i(vs11) i(vs12) i(vs13) i(vs14) i(vs15) i(vs16) i(vs17) i(vs18) i(vs19)
print i(vs20) i(vs21) i(vs22) i(vs23) i(vs24) i(vs25) i(vs26) i(vs27) i(vs28) i(vs29)
print i(vs30) i(vs31) i(vs32) i(vs33) i(vs34) i(vs35) i(vs36) i(vs37)
.endc
.end
