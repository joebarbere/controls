controls oracle ac-0282
* Generated (plan F2.7, ADR 0012): do not edit; regenerate with `pnpm sim oracle regen`. ac seed 20261031 index 282 nodes 27 elements 50
.options sparse gmin=1e-12 noopac
RG1 1 0 1000000000000
RG2 2 0 1000000000000
RG3 3 0 1000000000000
RG4 4 0 1000000000000
RG5 5 0 1000000000000
RG6 6 0 1000000000000
RG7 7 0 1000000000000
RG8 8 0 1000000000000
RG9 9 0 1000000000000
RG10 10 0 1000000000000
RG11 11 0 1000000000000
RG12 12 0 1000000000000
RG13 13 0 1000000000000
RG14 14 0 1000000000000
RG15 15 0 1000000000000
RG16 16 0 1000000000000
RG17 17 0 1000000000000
RG18 18 0 1000000000000
RG19 19 0 1000000000000
RG20 20 0 1000000000000
RG21 21 0 1000000000000
RG22 22 0 1000000000000
RG23 23 0 1000000000000
RG24 24 0 1000000000000
RG25 25 0 1000000000000
RG26 26 0 1000000000000
VS0 0 s0 0
V0 e0 s0 DC 0 AC 82e1 0
RI0 e0 19 33e-3
VS1 9 s1 0
R1 s1 8 18e-1
VS2 2 s2 0
V2 e2 s2 DC 0 AC 10e1 0
RI2 e2 8 56e-1
VS3 5 s3 0
L3 s3 16 47e-2
VS4 7 s4 0
V4 e4 s4 DC 0 AC 22e-1 120
RI4 e4 0 39e-1
VS5 17 s5 0
L5 s5 14 47e-5
VS6 3 s6 0
C6 s6 1 18e-6
VS7 15 s7 0
L7 s7 5 10e-5
VS8 0 s8 0
L8 s8 25 33e-4
VS9 11 s9 0
R9 s9 0 12e0
VS10 24 s10 0
L10 s10 21 82e-5
VS11 5 s11 0
L11 s11 22 27e-2
VS12 21 s12 0
C12 s12 14 15e-4
VS13 10 s13 0
L13 s13 17 15e-4
VS14 19 s14 0
V14 e14 s14 DC 0 AC 47e1 180
RI14 e14 12 18e-2
VS15 22 s15 0
L15 s15 12 15e-2
VS16 9 s16 0
L16 s16 0 18e-5
VS17 4 s17 0
R17 s17 23 47e0
VS18 25 s18 0
C18 s18 17 12e-6
VS19 1 s19 0
V19 e19 s19 DC 0 AC 10e-1 -120
RI19 e19 8 10e-3
VS20 23 s20 0
R20 s20 18 22e1
VS21 23 s21 0
L21 s21 6 68e-5
VS22 26 s22 0
R22 s22 12 56e-1
VS23 24 s23 0
C23 s23 26 10e-5
VS24 8 s24 0
V24 e24 s24 DC 0 AC 18e-1 -120
RI24 e24 4 47e-2
VS25 0 s25 0
V25 e25 s25 DC 0 AC 15e-1 180
RI25 e25 4 56e-2
VS26 12 s26 0
L26 s26 7 68e-3
VS27 16 s27 0
L27 s27 26 39e-2
VS28 0 s28 0
V28 e28 s28 DC 0 AC 22e0 -120
RI28 e28 21 82e-1
VS29 13 s29 0
V29 e29 s29 DC 0 AC 18e-1 0
RI29 e29 5 18e-3
VS30 10 s30 0
C30 s30 23 39e-4
VS31 2 s31 0
V31 e31 s31 DC 0 AC 12e0 120
RI31 e31 7 10e-2
VS32 5 s32 0
C32 s32 6 82e-5
VS33 16 s33 0
L33 s33 15 47e-4
VS34 22 s34 0
V34 e34 s34 DC 0 AC 56e1 0
RI34 e34 26 12e-1
VS35 8 s35 0
L35 s35 26 39e-4
VS36 3 s36 0
C36 s36 4 10e-5
VS37 5 s37 0
L37 s37 24 82e-4
VS38 6 s38 0
L38 s38 1 27e-4
VS39 5 s39 0
L39 s39 10 15e-2
VS40 3 s40 0
R40 s40 9 15e0
VS41 7 s41 0
R41 s41 12 18e-1
VS42 18 s42 0
L42 s42 7 47e-5
VS43 25 s43 0
L43 s43 8 82e-3
VS44 25 s44 0
L44 s44 20 22e-4
VS45 12 s45 0
R45 s45 23 47e0
VS46 13 s46 0
C46 s46 25 56e-4
VS47 25 s47 0
L47 s47 18 47e-2
VS48 14 s48 0
L48 s48 6 18e-4
VS49 26 s49 0
V49 e49 s49 DC 0 AC 27e-1 120
RI49 e49 10 22e-2
.control
set numdgt=17
ac lin 1 60 60
print v(1) v(2) v(3) v(4) v(5) v(6) v(7) v(8) v(9) v(10)
print v(11) v(12) v(13) v(14) v(15) v(16) v(17) v(18) v(19) v(20)
print v(21) v(22) v(23) v(24) v(25) v(26)
print i(vs0) i(vs1) i(vs2) i(vs3) i(vs4) i(vs5) i(vs6) i(vs7) i(vs8) i(vs9)
print i(vs10) i(vs11) i(vs12) i(vs13) i(vs14) i(vs15) i(vs16) i(vs17) i(vs18) i(vs19)
print i(vs20) i(vs21) i(vs22) i(vs23) i(vs24) i(vs25) i(vs26) i(vs27) i(vs28) i(vs29)
print i(vs30) i(vs31) i(vs32) i(vs33) i(vs34) i(vs35) i(vs36) i(vs37) i(vs38) i(vs39)
print i(vs40) i(vs41) i(vs42) i(vs43) i(vs44) i(vs45) i(vs46) i(vs47) i(vs48) i(vs49)
.endc
.end
