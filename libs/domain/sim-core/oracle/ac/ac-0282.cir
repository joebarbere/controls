controls oracle ac-0282
* Generated (plan F2.7, ADR 0012): do not edit; regenerate with `pnpm sim oracle regen`. ac seed 20261031 index 282 nodes 27 elements 52
.options sparse gmin=1e-12 noopac
RG1 1 0 1000000000000
RG2 2 0 1000000000000
RG3 3 0 1000000000000
RG4 4 0 1000000000000
RG5 5 0 1000000000000
RG6 6 0 1000000000000
RG7 7 0 1000000000000
RG8 8 0 1000000000000
RG9 9 0 1000000000000
RG10 10 0 1000000000000
RG11 11 0 1000000000000
RG12 12 0 1000000000000
RG13 13 0 1000000000000
RG14 14 0 1000000000000
RG15 15 0 1000000000000
RG16 16 0 1000000000000
RG17 17 0 1000000000000
RG18 18 0 1000000000000
RG19 19 0 1000000000000
RG20 20 0 1000000000000
RG21 21 0 1000000000000
RG22 22 0 1000000000000
RG23 23 0 1000000000000
RG24 24 0 1000000000000
RG25 25 0 1000000000000
RG26 26 0 1000000000000
VS0 26 s0 0
R0 s0 12 56e-1
VS1 11 s1 0
R1 s1 25 12e0
VS2 0 s2 0
V2 e2 s2 DC 0 AC 22e-1 120
RI2 e2 n2 39e-1
H2 n2 h2 VS5 10e-3
ED2 h2 25 d2 0 18e-7
F2 0 d2 VS5 1
LD2 d2 0 1
VS3 7 s3 0
C3 s3 17 12e-6
VS4 3 s4 0
C4 s4 1 18e-6
VS5 19 s5 0
V5 e5 s5 DC 0 AC 47e1 180
RI5 e5 m5 18e-2
LI5 m5 n5 56e-7
H5 n5 h5 VS2 10e-3
ED5 h5 12 d5 0 18e-7
F5 0 d5 VS2 1
LD5 d5 0 1
VS6 0 s6 0
R6 s6 12 18e-1
VS7 25 s7 0
V7 e7 s7 DC 0 AC 15e-1 180
RI7 e7 4 56e-2
VS8 21 s8 0
C8 s8 14 15e-4
VS9 9 s9 0
L9 s9 25 18e-5
VS10 5 s10 0
L10 s10 24 82e-4
VS11 16 s11 0
L11 s11 15 47e-4
VS12 22 s12 0
L12 s12 12 15e-2
VS13 2 s13 0
V13 e13 s13 DC 0 AC 10e1 0
RI13 e13 8 56e-1
VS14 3 s14 0
R14 s14 9 15e0
VS15 8 s15 0
V15 e15 s15 DC 0 AC 18e-1 -120
RI15 e15 m15 47e-2
LI15 m15 4 47e-6
VS16 7 s16 0
L16 s16 8 82e-3
VS17 26 s17 0
V17 e17 s17 DC 0 AC 27e-1 120
RI17 e17 m17 22e-2
LI17 m17 10 68e-7
VS18 13 s18 0
V18 e18 s18 DC 0 AC 18e-1 0
RI18 e18 m18 18e-3
LI18 m18 5 15e-6
VS19 20 s19 0
C19 s19 10 82e-4
VS20 23 s20 0
L20 s20 6 68e-5
VS21 25 s21 0
L21 s21 7 33e-4
VS22 4 s22 0
R22 s22 23 47e0
VS23 17 s23 0
L23 s23 14 47e-5
VS24 5 s24 0
L24 s24 16 47e-2
VS25 12 s25 0
L25 s25 0 68e-3
VS26 6 s26 0
L26 s26 1 27e-4
VS27 5 s27 0
C27 s27 6 82e-5
VS28 24 s28 0
L28 s28 21 82e-5
VS29 10 s29 0
C29 s29 23 39e-4
VS30 22 s30 0
V30 e30 s30 DC 0 AC 56e1 0
RI30 e30 26 12e-1
VS31 25 s31 0
V31 e31 s31 DC 0 AC 82e1 0
RI31 e31 m31 33e-3
LI31 m31 19 27e-7
VS32 8 s32 0
L32 s32 26 39e-4
VS33 7 s33 0
L33 s33 18 47e-2
VS34 5 s34 0
V34 e34 s34 DC 0 AC 18e-1 180
RI34 e34 m34 33e-3
LI34 m34 11 10e-6
VS35 18 s35 0
L35 s35 0 47e-5
VS36 12 s36 0
R36 s36 23 47e0
VS37 3 s37 0
C37 s37 4 10e-5
VS38 5 s38 0
L38 s38 10 15e-2
VS39 7 s39 0
L39 s39 20 22e-4
VS40 23 s40 0
R40 s40 18 22e1
VS41 25 s41 0
V41 e41 s41 DC 0 AC 22e0 -120
RI41 e41 m41 82e-1
LI41 m41 21 47e-7
VS42 16 s42 0
L42 s42 26 39e-2
VS43 15 s43 0
L43 s43 5 10e-5
VS44 5 s44 0
L44 s44 22 27e-2
VS45 1 s45 0
V45 e45 s45 DC 0 AC 10e-1 -120
RI45 e45 8 10e-3
VS46 2 s46 0
V46 e46 s46 DC 0 AC 12e0 120
RI46 e46 0 10e-2
VS47 10 s47 0
L47 s47 17 15e-4
VS48 13 s48 0
C48 s48 7 56e-4
VS49 24 s49 0
C49 s49 26 10e-5
VS50 9 s50 0
R50 s50 8 18e-1
VS51 14 s51 0
L51 s51 6 18e-4
.control
set numdgt=17
ac lin 1 60 60
print v(1) v(2) v(3) v(4) v(5) v(6) v(7) v(8) v(9) v(10)
print v(11) v(12) v(13) v(14) v(15) v(16) v(17) v(18) v(19) v(20)
print v(21) v(22) v(23) v(24) v(25) v(26)
print i(vs0) i(vs1) i(vs2) i(vs3) i(vs4) i(vs5) i(vs6) i(vs7) i(vs8) i(vs9)
print i(vs10) i(vs11) i(vs12) i(vs13) i(vs14) i(vs15) i(vs16) i(vs17) i(vs18) i(vs19)
print i(vs20) i(vs21) i(vs22) i(vs23) i(vs24) i(vs25) i(vs26) i(vs27) i(vs28) i(vs29)
print i(vs30) i(vs31) i(vs32) i(vs33) i(vs34) i(vs35) i(vs36) i(vs37) i(vs38) i(vs39)
print i(vs40) i(vs41) i(vs42) i(vs43) i(vs44) i(vs45) i(vs46) i(vs47) i(vs48) i(vs49)
print i(vs50) i(vs51)
.endc
.end
