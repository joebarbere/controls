controls oracle ac-0017
* Generated (plan F2.7, ADR 0012): do not edit; regenerate with `pnpm sim oracle regen`. ac seed 20261031 index 17 nodes 27 elements 40
.options sparse gmin=1e-12 noopac
RG1 1 0 1000000000000
RG2 2 0 1000000000000
RG3 3 0 1000000000000
RG4 4 0 1000000000000
RG5 5 0 1000000000000
RG6 6 0 1000000000000
RG7 7 0 1000000000000
RG8 8 0 1000000000000
RG9 9 0 1000000000000
RG10 10 0 1000000000000
RG11 11 0 1000000000000
RG12 12 0 1000000000000
RG13 13 0 1000000000000
RG14 14 0 1000000000000
RG15 15 0 1000000000000
RG16 16 0 1000000000000
RG17 17 0 1000000000000
RG18 18 0 1000000000000
RG19 19 0 1000000000000
RG20 20 0 1000000000000
RG21 21 0 1000000000000
RG22 22 0 1000000000000
RG23 23 0 1000000000000
RG24 24 0 1000000000000
RG25 25 0 1000000000000
RG26 26 0 1000000000000
VS0 23 s0 0
L0 s0 0 33e-2
VS1 26 s1 0
C1 s1 11 18e-7
VS2 0 s2 0
V2 e2 s2 DC 0 AC 15e0 120
RI2 e2 20 47e-2
VS3 24 s3 0
R3 s3 19 10e-2
VS4 3 s4 0
R4 s4 6 15e-1
VS5 15 s5 0
R5 s5 25 18e1
VS6 13 s6 0
C6 s6 9 82e-6
VS7 24 s7 0
V7 e7 s7 DC 0 AC 39e-1 180
RI7 e7 14 56e-3
VS8 11 s8 0
R8 s8 12 15e-1
VS9 3 s9 0
C9 s9 24 56e-4
VS10 9 s10 0
R10 s10 1 39e0
VS11 0 s11 0
V11 e11 s11 DC 0 AC 39e-1 0
RI11 e11 1 82e-3
VS12 19 s12 0
C12 s12 16 10e-5
VS13 16 s13 0
L13 s13 22 18e-5
VS14 5 s14 0
C14 s14 26 10e-4
VS15 6 s15 0
V15 e15 s15 DC 0 AC 47e1 180
RI15 e15 5 33e-2
VS16 9 s16 0
L16 s16 4 15e-2
VS17 20 s17 0
V17 e17 s17 DC 0 AC 10e-1 -120
RI17 e17 6 12e-3
VS18 15 s18 0
C18 s18 11 12e-5
VS19 6 s19 0
R19 s19 20 68e3
VS20 10 s20 0
C20 s20 20 56e-4
VS21 14 s21 0
C21 s21 12 47e-7
VS22 25 s22 0
C22 s22 24 47e-6
VS23 8 s23 0
V23 e23 s23 DC 0 AC 12e1 -120
RI23 e23 4 39e-1
VS24 2 s24 0
V24 e24 s24 DC 0 AC 12e0 -120
RI24 e24 3 68e-2
VS25 21 s25 0
R25 s25 8 68e0
VS26 18 s26 0
R26 s26 10 82e-1
VS27 18 s27 0
C27 s27 17 27e-5
VS28 9 s28 0
R28 s28 3 56e0
VS29 13 s29 0
V29 e29 s29 DC 0 AC 15e1 120
RI29 e29 24 68e-1
VS30 21 s30 0
V30 e30 s30 DC 0 AC 68e0 -120
RI30 e30 23 33e-3
VS31 16 s31 0
V31 e31 s31 DC 0 AC 47e0 -120
RI31 e31 17 56e-2
VS32 24 s32 0
C32 s32 10 82e-4
VS33 24 s33 0
L33 s33 21 22e-2
VS34 7 s34 0
L34 s34 23 10e-2
VS35 20 s35 0
C35 s35 7 27e-6
VS36 19 s36 0
R36 s36 14 10e3
VS37 20 s37 0
L37 s37 22 22e-3
VS38 2 s38 0
R38 s38 7 18e2
VS39 1 s39 0
C39 s39 16 82e-7
.control
set numdgt=17
ac lin 1 60 60
print v(1) v(2) v(3) v(4) v(5) v(6) v(7) v(8) v(9) v(10)
print v(11) v(12) v(13) v(14) v(15) v(16) v(17) v(18) v(19) v(20)
print v(21) v(22) v(23) v(24) v(25) v(26)
print i(vs0) i(vs1) i(vs2) i(vs3) i(vs4) i(vs5) i(vs6) i(vs7) i(vs8) i(vs9)
print i(vs10) i(vs11) i(vs12) i(vs13) i(vs14) i(vs15) i(vs16) i(vs17) i(vs18) i(vs19)
print i(vs20) i(vs21) i(vs22) i(vs23) i(vs24) i(vs25) i(vs26) i(vs27) i(vs28) i(vs29)
print i(vs30) i(vs31) i(vs32) i(vs33) i(vs34) i(vs35) i(vs36) i(vs37) i(vs38) i(vs39)
.endc
.end
