controls oracle ac-0017
* Generated (plan F2.7, ADR 0012): do not edit; regenerate with `pnpm sim oracle regen`. ac seed 20261031 index 17 nodes 27 elements 38
.options sparse gmin=1e-12 noopac
RG1 1 0 1000000000000
RG2 2 0 1000000000000
RG3 3 0 1000000000000
RG4 4 0 1000000000000
RG5 5 0 1000000000000
RG6 6 0 1000000000000
RG7 7 0 1000000000000
RG8 8 0 1000000000000
RG9 9 0 1000000000000
RG10 10 0 1000000000000
RG11 11 0 1000000000000
RG12 12 0 1000000000000
RG13 13 0 1000000000000
RG14 14 0 1000000000000
RG15 15 0 1000000000000
RG16 16 0 1000000000000
RG17 17 0 1000000000000
RG18 18 0 1000000000000
RG19 19 0 1000000000000
RG20 20 0 1000000000000
RG21 21 0 1000000000000
RG22 22 0 1000000000000
RG23 23 0 1000000000000
RG24 24 0 1000000000000
RG25 25 0 1000000000000
RG26 26 0 1000000000000
VS0 18 s0 0
R0 s0 10 82e-1
VS1 19 s1 0
C1 s1 0 10e-5
VS2 16 s2 0
C2 s2 10 82e-4
VS3 2 s3 0
R3 s3 7 18e2
VS4 3 s4 0
R4 s4 6 15e-1
VS5 15 s5 0
C5 s5 11 12e-5
VS6 16 s6 0
L6 s6 21 22e-2
VS7 0 s7 0
V7 e7 s7 DC 0 AC 47e0 -120
RI7 e7 17 56e-2
VS8 20 s8 0
C8 s8 7 27e-6
VS9 20 s9 0
V9 e9 s9 DC 0 AC 10e-1 -120
RI9 e9 6 12e-3
VS10 20 s10 0
L10 s10 22 22e-3
VS11 16 s11 0
V11 e11 s11 DC 0 AC 39e-1 180
RI11 e11 14 56e-3
VS12 9 s12 0
R12 s12 3 56e0
VS13 6 s13 0
R13 s13 20 68e3
VS14 1 s14 0
C14 s14 0 82e-7
VS15 10 s15 0
C15 s15 20 56e-4
VS16 15 s16 0
R16 s16 25 18e1
VS17 21 s17 0
R17 s17 8 68e0
VS18 3 s18 0
C18 s18 16 56e-4
VS19 6 s19 0
V19 e19 s19 DC 0 AC 47e1 180
RI19 e19 5 33e-2
VS20 2 s20 0
V20 e20 s20 DC 0 AC 12e0 -120
RI20 e20 3 68e-2
VS21 25 s21 0
C21 s21 16 47e-6
VS22 9 s22 0
R22 s22 1 39e0
VS23 9 s23 0
L23 s23 4 15e-2
VS24 7 s24 0
L24 s24 23 10e-2
VS25 18 s25 0
C25 s25 17 27e-5
VS26 13 s26 0
V26 e26 s26 DC 0 AC 15e1 120
RI26 e26 16 68e-1
VS27 24 s27 0
V27 e27 s27 DC 0 AC 39e-1 0
RI27 e27 1 82e-3
VS28 24 s28 0
V28 e28 s28 DC 0 AC 15e0 120
RI28 e28 20 47e-2
VS29 19 s29 0
R29 s29 14 10e3
VS30 21 s30 0
V30 e30 s30 DC 0 AC 68e0 -120
RI30 e30 23 33e-3
VS31 8 s31 0
V31 e31 s31 DC 0 AC 12e1 -120
RI31 e31 4 39e-1
VS32 11 s32 0
R32 s32 12 15e-1
VS33 16 s33 0
R33 s33 19 10e-2
VS34 14 s34 0
C34 s34 12 47e-7
VS35 26 s35 0
C35 s35 11 18e-7
VS36 23 s36 0
L36 s36 24 33e-2
VS37 13 s37 0
C37 s37 9 82e-6
.control
set numdgt=17
ac lin 1 60 60
print v(1) v(2) v(3) v(4) v(5) v(6) v(7) v(8) v(9) v(10)
print v(11) v(12) v(13) v(14) v(15) v(16) v(17) v(18) v(19) v(20)
print v(21) v(22) v(23) v(24) v(25) v(26)
print i(vs0) i(vs1) i(vs2) i(vs3) i(vs4) i(vs5) i(vs6) i(vs7) i(vs8) i(vs9)
print i(vs10) i(vs11) i(vs12) i(vs13) i(vs14) i(vs15) i(vs16) i(vs17) i(vs18) i(vs19)
print i(vs20) i(vs21) i(vs22) i(vs23) i(vs24) i(vs25) i(vs26) i(vs27) i(vs28) i(vs29)
print i(vs30) i(vs31) i(vs32) i(vs33) i(vs34) i(vs35) i(vs36) i(vs37)
.endc
.end
