controls oracle ac-0017
* Generated (plan F2.7, ADR 0012): do not edit; regenerate with `pnpm sim oracle regen`. ac seed 20261031 index 17 nodes 27 elements 37
.options sparse gmin=1e-12 noopac
RG1 1 0 1000000000000
RG2 2 0 1000000000000
RG3 3 0 1000000000000
RG4 4 0 1000000000000
RG5 5 0 1000000000000
RG6 6 0 1000000000000
RG7 7 0 1000000000000
RG8 8 0 1000000000000
RG9 9 0 1000000000000
RG10 10 0 1000000000000
RG11 11 0 1000000000000
RG12 12 0 1000000000000
RG13 13 0 1000000000000
RG14 14 0 1000000000000
RG15 15 0 1000000000000
RG16 16 0 1000000000000
RG17 17 0 1000000000000
RG18 18 0 1000000000000
RG19 19 0 1000000000000
RG20 20 0 1000000000000
RG21 21 0 1000000000000
RG22 22 0 1000000000000
RG23 23 0 1000000000000
RG24 24 0 1000000000000
RG25 25 0 1000000000000
RG26 26 0 1000000000000
VS0 1 s0 0
R0 s0 2 39e-2
VS1 17 s1 0
R1 s1 8 68e2
VS2 0 s2 0
V2 e2 s2 DC 0 AC 82e0 -120
RI2 e2 m2 39e-2
LI2 m2 14 33e-5
VS3 15 s3 0
R3 s3 16 18e1
VS4 18 s4 0
R4 s4 19 10e-2
VS5 18 s5 0
C5 s5 4 47e-7
VS6 2 s6 0
V6 e6 s6 DC 0 AC 18e-1 -120
RI6 e6 13 68e-2
VS7 18 s7 0
L7 s7 11 47e-4
VS8 24 s8 0
L8 s8 18 82e-5
VS9 10 s9 0
L9 s9 23 18e-3
VS10 16 s10 0
L10 s10 12 82e-4
VS11 13 s11 0
R11 s11 3 47e2
VS12 1 s12 0
V12 e12 s12 DC 0 AC 47e0 -120
RI12 e12 22 56e-2
VS13 7 s13 0
L13 s13 6 18e-5
VS14 3 s14 0
V14 e14 s14 DC 0 AC 15e-1 120
RI14 e14 m14 12e-2
LI14 m14 21 82e-7
VS15 10 s15 0
L15 s15 11 10e-2
VS16 13 s16 0
R16 s16 1 68e3
VS17 9 s17 0
L17 s17 25 22e-3
VS18 5 s18 0
V18 e18 s18 DC 0 AC 39e-1 0
RI18 e18 m18 82e-3
LI18 m18 21 56e-5
VS19 12 s19 0
R19 s19 26 27e-2
VS20 17 s20 0
C20 s20 26 10e-4
VS21 9 s21 0
C21 s21 13 47e-7
VS22 11 s22 0
C22 s22 25 27e-6
VS23 15 s23 0
R23 s23 1 27e-1
VS24 12 s24 0
V24 e24 s24 DC 0 AC 10e-1 -120
RI24 e24 m24 12e-3
LI24 m24 22 47e-7
VS25 18 s25 0
V25 e25 s25 DC 0 AC 10e0 0
RI25 e25 m25 15e-1
LI25 m25 16 47e-7
VS26 24 s26 0
L26 s26 20 39e-4
VS27 0 s27 0
L27 s27 4 18e-5
VS28 13 s28 0
V28 e28 s28 DC 0 AC 15e1 120
RI28 e28 m28 68e-1
LI28 m28 18 10e-7
VS29 6 s29 0
L29 s29 19 68e-3
VS30 13 s30 0
R30 s30 7 82e3
VS31 9 s31 0
L31 s31 14 15e-2
VS32 5 s32 0
R32 s32 26 47e-1
VS33 0 s33 0
L33 s33 2 82e-4
VS34 5 s34 0
V34 e34 s34 DC 0 AC 39e-1 0
RI34 e34 23 27e-2
VS35 8 s35 0
R35 s35 18 47e-2
VS36 20 s36 0
R36 s36 8 18e1
.control
set numdgt=17
ac lin 1 60 60
print v(1) v(2) v(3) v(4) v(5) v(6) v(7) v(8) v(9) v(10)
print v(11) v(12) v(13) v(14) v(15) v(16) v(17) v(18) v(19) v(20)
print v(21) v(22) v(23) v(24) v(25) v(26)
print i(vs0) i(vs1) i(vs2) i(vs3) i(vs4) i(vs5) i(vs6) i(vs7) i(vs8) i(vs9)
print i(vs10) i(vs11) i(vs12) i(vs13) i(vs14) i(vs15) i(vs16) i(vs17) i(vs18) i(vs19)
print i(vs20) i(vs21) i(vs22) i(vs23) i(vs24) i(vs25) i(vs26) i(vs27) i(vs28) i(vs29)
print i(vs30) i(vs31) i(vs32) i(vs33) i(vs34) i(vs35) i(vs36)
.endc
.end
