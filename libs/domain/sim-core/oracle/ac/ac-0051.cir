controls oracle ac-0051
* Generated (plan F2.7, ADR 0012): do not edit; regenerate with `pnpm sim oracle regen`. ac seed 20261031 index 51 nodes 4 elements 5
.options sparse gmin=1e-12 noopac
RG1 1 0 1000000000000
RG2 2 0 1000000000000
RG3 3 0 1000000000000
VS0 2 s0 0
R0 s0 1 82e0
VS1 1 s1 0
C1 s1 2 18e-5
VS2 0 s2 0
L2 s2 1 39e-3
VS3 0 s3 0
V3 e3 s3 DC 0 AC 27e0 180
RI3 e3 2 56e-2
VS4 0 s4 0
C4 s4 3 39e-6
.control
set numdgt=17
ac lin 1 60 60
print v(1) v(2) v(3)
print i(vs0) i(vs1) i(vs2) i(vs3) i(vs4)
.endc
.end
