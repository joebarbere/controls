controls oracle ac-0051
* Generated (plan F2.7, ADR 0012): do not edit; regenerate with `pnpm sim oracle regen`. ac seed 20261031 index 51 nodes 4 elements 6
.options sparse gmin=1e-12 noopac
RG1 1 0 1000000000000
RG2 2 0 1000000000000
RG3 3 0 1000000000000
VS0 3 s0 0
L0 s0 1 27e-2
VS1 2 s1 0
R1 s1 1 82e0
VS2 0 s2 0
V2 e2 s2 DC 0 AC 27e0 180
RI2 e2 m2 56e-2
LI2 m2 2 82e-5
VS3 1 s3 0
L3 s3 3 56e-5
VS4 3 s4 0
R4 s4 1 68e2
VS5 3 s5 0
C5 s5 0 33e-7
.control
set numdgt=17
ac lin 1 60 60
print v(1) v(2) v(3)
print i(vs0) i(vs1) i(vs2) i(vs3) i(vs4) i(vs5)
.endc
.end
