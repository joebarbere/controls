controls oracle ac-0051
* Generated (plan F2.7, ADR 0012): do not edit; regenerate with `pnpm sim oracle regen`. ac seed 20261031 index 51 nodes 4 elements 6
.options sparse gmin=1e-12 noopac
RG1 1 0 1000000000000
RG2 2 0 1000000000000
RG3 3 0 1000000000000
VS0 0 s0 0
L0 s0 1 39e-3
VS1 1 s1 0
C1 s1 2 18e-5
VS2 0 s2 0
C2 s2 3 39e-6
VS3 2 s3 0
R3 s3 1 82e0
VS4 3 s4 0
R4 s4 1 56e3
VS5 0 s5 0
V5 e5 s5 DC 0 AC 27e0 180
RI5 e5 2 56e-2
.control
set numdgt=17
ac lin 1 60 60
print v(1) v(2) v(3)
print i(vs0) i(vs1) i(vs2) i(vs3) i(vs4) i(vs5)
.endc
.end
