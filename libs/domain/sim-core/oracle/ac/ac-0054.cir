controls oracle ac-0054
* Generated (plan F2.7, ADR 0012): do not edit; regenerate with `pnpm sim oracle regen`. ac seed 20261031 index 54 nodes 11 elements 17
.options sparse gmin=1e-12 noopac
RG1 1 0 1000000000000
RG2 2 0 1000000000000
RG3 3 0 1000000000000
RG4 4 0 1000000000000
RG5 5 0 1000000000000
RG6 6 0 1000000000000
RG7 7 0 1000000000000
RG8 8 0 1000000000000
RG9 9 0 1000000000000
RG10 10 0 1000000000000
VS0 8 s0 0
R0 s0 10 33e0
VS1 1 s1 0
C1 s1 5 12e-6
VS2 6 s2 0
R2 s2 2 47e2
VS3 6 s3 0
L3 s3 7 47e-5
VS4 10 s4 0
L4 s4 7 56e-4
VS5 7 s5 0
C5 s5 8 33e-5
VS6 5 s6 0
L6 s6 1 22e-2
VS7 4 s7 0
R7 s7 3 47e0
VS8 7 s8 0
C8 s8 9 47e-5
VS9 2 s9 0
L9 s9 1 82e-2
VS10 1 s10 0
R10 s10 7 39e1
VS11 5 s11 0
C11 s11 2 68e-7
VS12 0 s12 0
V12 e12 s12 DC 0 AC 18e-1 180
RI12 e12 3 47e-2
VS13 5 s13 0
C13 s13 7 10e-5
VS14 4 s14 0
R14 s14 0 12e1
VS15 7 s15 0
C15 s15 10 33e-6
VS16 0 s16 0
C16 s16 10 33e-5
.control
set numdgt=17
ac lin 1 60 60
print v(1) v(2) v(3) v(4) v(5) v(6) v(7) v(8) v(9) v(10)
print i(vs0) i(vs1) i(vs2) i(vs3) i(vs4) i(vs5) i(vs6) i(vs7) i(vs8) i(vs9)
print i(vs10) i(vs11) i(vs12) i(vs13) i(vs14) i(vs15) i(vs16)
.endc
.end
