controls oracle ac-0054
* Generated (plan F2.7, ADR 0012): do not edit; regenerate with `pnpm sim oracle regen`. ac seed 20261031 index 54 nodes 11 elements 19
.options sparse gmin=1e-12 noopac
RG1 1 0 1000000000000
RG2 2 0 1000000000000
RG3 3 0 1000000000000
RG4 4 0 1000000000000
RG5 5 0 1000000000000
RG6 6 0 1000000000000
RG7 7 0 1000000000000
RG8 8 0 1000000000000
RG9 9 0 1000000000000
RG10 10 0 1000000000000
VS0 1 s0 0
R0 s0 7 39e1
VS1 4 s1 0
R1 s1 0 12e1
VS2 0 s2 0
V2 e2 s2 DC 0 AC 18e-1 180
RI2 e2 m2 47e-2
LI2 m2 n2 56e-6
H2 n2 h2 VS9 -47e-3
ED2 h2 3 d2 0 27e-6
F2 0 d2 VS9 1
LD2 d2 0 1
VS3 10 s3 0
L3 s3 7 56e-4
VS4 4 s4 0
R4 s4 5 47e-1
VS5 1 s5 0
C5 s5 5 12e-6
VS6 8 s6 0
R6 s6 10 33e0
VS7 6 s7 0
R7 s7 2 47e2
VS8 2 s8 0
L8 s8 1 82e-2
VS9 8 s9 0
V9 e9 s9 DC 0 AC 68e1 180
RI9 e9 m9 10e-1
LI9 m9 n9 12e-6
H9 n9 h9 VS2 -47e-3
ED9 h9 9 d9 0 27e-6
F9 0 d9 VS2 1
LD9 d9 0 1
VS10 7 s10 0
C10 s10 10 33e-6
VS11 7 s11 0
C11 s11 8 33e-5
VS12 6 s12 0
L12 s12 7 47e-5
VS13 7 s13 0
C13 s13 9 47e-5
VS14 0 s14 0
C14 s14 10 33e-5
VS15 5 s15 0
L15 s15 1 22e-2
VS16 5 s16 0
C16 s16 2 68e-7
VS17 5 s17 0
C17 s17 7 10e-5
VS18 4 s18 0
R18 s18 3 47e0
.control
set numdgt=17
ac lin 1 60 60
print v(1) v(2) v(3) v(4) v(5) v(6) v(7) v(8) v(9) v(10)
print i(vs0) i(vs1) i(vs2) i(vs3) i(vs4) i(vs5) i(vs6) i(vs7) i(vs8) i(vs9)
print i(vs10) i(vs11) i(vs12) i(vs13) i(vs14) i(vs15) i(vs16) i(vs17) i(vs18)
.endc
.end
