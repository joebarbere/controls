controls oracle ac-0145
* Generated (plan F2.7, ADR 0012): do not edit; regenerate with `pnpm sim oracle regen`. ac seed 20261031 index 145 nodes 28 elements 56
.options sparse gmin=1e-12 noopac
RG1 1 0 1000000000000
RG2 2 0 1000000000000
RG3 3 0 1000000000000
RG4 4 0 1000000000000
RG5 5 0 1000000000000
RG6 6 0 1000000000000
RG7 7 0 1000000000000
RG8 8 0 1000000000000
RG9 9 0 1000000000000
RG10 10 0 1000000000000
RG11 11 0 1000000000000
RG12 12 0 1000000000000
RG13 13 0 1000000000000
RG14 14 0 1000000000000
RG15 15 0 1000000000000
RG16 16 0 1000000000000
RG17 17 0 1000000000000
RG18 18 0 1000000000000
RG19 19 0 1000000000000
RG20 20 0 1000000000000
RG21 21 0 1000000000000
RG22 22 0 1000000000000
RG23 23 0 1000000000000
RG24 24 0 1000000000000
RG25 25 0 1000000000000
RG26 26 0 1000000000000
RG27 27 0 1000000000000
VS0 13 s0 0
L0 s0 8 68e-3
VS1 7 s1 0
C1 s1 19 18e-5
VS2 5 s2 0
C2 s2 9 56e-7
VS3 0 s3 0
V3 e3 s3 DC 0 AC 10e0 180
RI3 e3 19 56e-2
VS4 17 s4 0
V4 e4 s4 DC 0 AC 22e1 120
RI4 e4 21 27e-1
VS5 17 s5 0
C5 s5 24 22e-6
VS6 7 s6 0
C6 s6 15 82e-4
VS7 8 s7 0
L7 s7 10 15e-2
VS8 6 s8 0
R8 s8 27 12e-1
VS9 16 s9 0
R9 s9 18 22e2
VS10 27 s10 0
C10 s10 16 39e-6
VS11 13 s11 0
V11 e11 s11 DC 0 AC 22e-1 -120
RI11 e11 26 39e-1
VS12 4 s12 0
R12 s12 27 56e2
VS13 7 s13 0
R13 s13 2 33e0
VS14 2 s14 0
C14 s14 16 56e-5
VS15 20 s15 0
R15 s15 22 68e1
VS16 1 s16 0
L16 s16 22 56e-5
VS17 24 s17 0
R17 s17 0 56e1
VS18 12 s18 0
L18 s18 22 18e-4
VS19 1 s19 0
V19 e19 s19 DC 0 AC 39e-1 120
RI19 e19 0 47e-3
VS20 10 s20 0
V20 e20 s20 DC 0 AC 15e0 0
RI20 e20 12 82e-1
VS21 17 s21 0
R21 s21 27 15e1
VS22 3 s22 0
L22 s22 17 47e-5
VS23 13 s23 0
V23 e23 s23 DC 0 AC 12e1 0
RI23 e23 10 56e-1
VS24 8 s24 0
L24 s24 6 18e-4
VS25 8 s25 0
L25 s25 26 22e-2
VS26 7 s26 0
C26 s26 26 33e-6
VS27 2 s27 0
V27 e27 s27 DC 0 AC 68e1 120
RI27 e27 4 15e-3
VS28 12 s28 0
C28 s28 3 47e-7
VS29 23 s29 0
R29 s29 10 10e-2
VS30 13 s30 0
C30 s30 11 68e-4
VS31 5 s31 0
L31 s31 20 47e-4
VS32 12 s32 0
C32 s32 5 18e-6
VS33 8 s33 0
L33 s33 5 68e-4
VS34 12 s34 0
C34 s34 4 82e-5
VS35 27 s35 0
L35 s35 12 56e-5
VS36 9 s36 0
L36 s36 21 47e-5
VS37 24 s37 0
R37 s37 23 18e2
VS38 0 s38 0
L38 s38 3 68e-4
VS39 12 s39 0
L39 s39 15 27e-5
VS40 20 s40 0
L40 s40 3 22e-2
VS41 0 s41 0
V41 e41 s41 DC 0 AC 68e0 120
RI41 e41 22 68e-2
VS42 22 s42 0
R42 s42 13 22e1
VS43 3 s43 0
C43 s43 2 68e-4
VS44 25 s44 0
L44 s44 23 39e-5
VS45 10 s45 0
C45 s45 14 12e-6
VS46 23 s46 0
V46 e46 s46 DC 0 AC 33e-1 180
RI46 e46 11 82e-3
VS47 24 s47 0
C47 s47 21 10e-4
VS48 18 s48 0
R48 s48 15 56e3
VS49 9 s49 0
L49 s49 27 27e-2
VS50 2 s50 0
L50 s50 25 18e-5
VS51 25 s51 0
R51 s51 8 47e1
VS52 12 s52 0
C52 s52 25 68e-7
VS53 21 s53 0
L53 s53 14 82e-5
VS54 25 s54 0
R54 s54 5 15e-2
VS55 10 s55 0
C55 s55 4 18e-5
.control
set numdgt=17
ac lin 1 60 60
print v(1) v(2) v(3) v(4) v(5) v(6) v(7) v(8) v(9) v(10)
print v(11) v(12) v(13) v(14) v(15) v(16) v(17) v(18) v(19) v(20)
print v(21) v(22) v(23) v(24) v(25) v(26) v(27)
print i(vs0) i(vs1) i(vs2) i(vs3) i(vs4) i(vs5) i(vs6) i(vs7) i(vs8) i(vs9)
print i(vs10) i(vs11) i(vs12) i(vs13) i(vs14) i(vs15) i(vs16) i(vs17) i(vs18) i(vs19)
print i(vs20) i(vs21) i(vs22) i(vs23) i(vs24) i(vs25) i(vs26) i(vs27) i(vs28) i(vs29)
print i(vs30) i(vs31) i(vs32) i(vs33) i(vs34) i(vs35) i(vs36) i(vs37) i(vs38) i(vs39)
print i(vs40) i(vs41) i(vs42) i(vs43) i(vs44) i(vs45) i(vs46) i(vs47) i(vs48) i(vs49)
print i(vs50) i(vs51) i(vs52) i(vs53) i(vs54) i(vs55)
.endc
.end
