controls oracle ac-0145
* Generated (plan F2.7, ADR 0012): do not edit; regenerate with `pnpm sim oracle regen`. ac seed 20261031 index 145 nodes 28 elements 53
.options sparse gmin=1e-12 noopac
RG1 1 0 1000000000000
RG2 2 0 1000000000000
RG3 3 0 1000000000000
RG4 4 0 1000000000000
RG5 5 0 1000000000000
RG6 6 0 1000000000000
RG7 7 0 1000000000000
RG8 8 0 1000000000000
RG9 9 0 1000000000000
RG10 10 0 1000000000000
RG11 11 0 1000000000000
RG12 12 0 1000000000000
RG13 13 0 1000000000000
RG14 14 0 1000000000000
RG15 15 0 1000000000000
RG16 16 0 1000000000000
RG17 17 0 1000000000000
RG18 18 0 1000000000000
RG19 19 0 1000000000000
RG20 20 0 1000000000000
RG21 21 0 1000000000000
RG22 22 0 1000000000000
RG23 23 0 1000000000000
RG24 24 0 1000000000000
RG25 25 0 1000000000000
RG26 26 0 1000000000000
RG27 27 0 1000000000000
VS0 0 s0 0
V0 e0 s0 DC 0 AC 15e0 0
RI0 e0 12 82e-1
VS1 27 s1 0
L1 s1 11 10e-3
VS2 1 s2 0
R2 s2 10 47e-2
VS3 18 s3 0
R3 s3 16 56e2
VS4 12 s4 0
L4 s4 7 39e-3
VS5 9 s5 0
V5 e5 s5 DC 0 AC 39e-1 120
RI5 e5 m5 47e-3
LI5 m5 5 68e-5
VS6 3 s6 0
C6 s6 2 68e-4
VS7 13 s7 0
L7 s7 3 68e-4
VS8 24 s8 0
V8 e8 s8 DC 0 AC 68e-1 120
RI8 e8 m8 39e-3
LI8 m8 5 22e-7
VS9 22 s9 0
L9 s9 6 47e-4
VS10 22 s10 0
R10 s10 0 15e1
VS11 20 s11 0
C11 s11 22 15e-4
VS12 8 s12 0
L12 s12 16 33e-5
VS13 7 s13 0
R13 s13 8 12e3
VS14 25 s14 0
R14 s14 6 12e1
VS15 7 s15 0
C15 s15 19 18e-5
VS16 14 s16 0
V16 e16 s16 DC 0 AC 18e1 -120
RI16 e16 m16 68e-2
LI16 m16 2 27e-6
VS17 24 s17 0
L17 s17 7 18e-2
VS18 23 s18 0
C18 s18 20 56e-7
VS19 23 s19 0
R19 s19 17 47e1
VS20 0 s20 0
V20 e20 s20 DC 0 AC 33e1 120
RI20 e20 m20 18e-2
LI20 m20 4 82e-7
VS21 24 s21 0
L21 s21 19 18e-4
VS22 27 s22 0
V22 e22 s22 DC 0 AC 82e0 0
RI22 e22 m22 33e-2
LI22 m22 19 18e-6
VS23 22 s23 0
V23 e23 s23 DC 0 AC 10e-1 180
RI23 e23 m23 47e-3
LI23 m23 3 39e-5
VS24 1 s24 0
C24 s24 6 12e-4
VS25 17 s25 0
L25 s25 7 39e-4
VS26 26 s26 0
V26 e26 s26 DC 0 AC 82e0 -120
RI26 e26 8 68e-3
VS27 12 s27 0
V27 e27 s27 DC 0 AC 18e-1 -120
RI27 e27 5 10e-3
VS28 21 s28 0
R28 s28 12 18e0
VS29 15 s29 0
V29 e29 s29 DC 0 AC 27e1 0
RI29 e29 m29 56e-2
LI29 m29 10 27e-6
VS30 14 s30 0
L30 s30 22 15e-2
VS31 27 s31 0
R31 s31 3 12e1
VS32 17 s32 0
V32 e32 s32 DC 0 AC 12e0 -120
RI32 e32 16 18e-3
VS33 15 s33 0
C33 s33 23 39e-7
VS34 9 s34 0
C34 s34 3 56e-4
VS35 24 s35 0
V35 e35 s35 DC 0 AC 18e1 -120
RI35 e35 12 47e-2
VS36 26 s36 0
L36 s36 0 56e-4
VS37 12 s37 0
R37 s37 10 82e0
VS38 26 s38 0
L38 s38 27 33e-4
VS39 25 s39 0
L39 s39 10 47e-5
VS40 27 s40 0
L40 s40 17 82e-3
VS41 18 s41 0
R41 s41 2 33e-1
VS42 11 s42 0
V42 e42 s42 DC 0 AC 47e1 0
RI42 e42 3 27e-1
VS43 27 s43 0
L43 s43 22 39e-3
VS44 13 s44 0
C44 s44 16 68e-4
VS45 2 s45 0
L45 s45 25 18e-5
VS46 4 s46 0
L46 s46 16 39e-5
VS47 10 s47 0
V47 e47 s47 DC 0 AC 12e1 0
RI47 e47 m47 56e-1
LI47 m47 0 22e-7
VS48 21 s48 0
C48 s48 0 27e-6
VS49 0 s49 0
R49 s49 8 10e2
VS50 25 s50 0
L50 s50 15 18e-2
VS51 0 s51 0
C51 s51 4 18e-5
VS52 17 s52 0
R52 s52 13 47e0
.control
set numdgt=17
ac lin 1 60 60
print v(1) v(2) v(3) v(4) v(5) v(6) v(7) v(8) v(9) v(10)
print v(11) v(12) v(13) v(14) v(15) v(16) v(17) v(18) v(19) v(20)
print v(21) v(22) v(23) v(24) v(25) v(26) v(27)
print i(vs0) i(vs1) i(vs2) i(vs3) i(vs4) i(vs5) i(vs6) i(vs7) i(vs8) i(vs9)
print i(vs10) i(vs11) i(vs12) i(vs13) i(vs14) i(vs15) i(vs16) i(vs17) i(vs18) i(vs19)
print i(vs20) i(vs21) i(vs22) i(vs23) i(vs24) i(vs25) i(vs26) i(vs27) i(vs28) i(vs29)
print i(vs30) i(vs31) i(vs32) i(vs33) i(vs34) i(vs35) i(vs36) i(vs37) i(vs38) i(vs39)
print i(vs40) i(vs41) i(vs42) i(vs43) i(vs44) i(vs45) i(vs46) i(vs47) i(vs48) i(vs49)
print i(vs50) i(vs51) i(vs52)
.endc
.end
