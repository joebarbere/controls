controls oracle ac-0145
* Generated (plan F2.7, ADR 0012): do not edit; regenerate with `pnpm sim oracle regen`. ac seed 20261031 index 145 nodes 28 elements 53
.options sparse gmin=1e-12 noopac
RG1 1 0 1000000000000
RG2 2 0 1000000000000
RG3 3 0 1000000000000
RG4 4 0 1000000000000
RG5 5 0 1000000000000
RG6 6 0 1000000000000
RG7 7 0 1000000000000
RG8 8 0 1000000000000
RG9 9 0 1000000000000
RG10 10 0 1000000000000
RG11 11 0 1000000000000
RG12 12 0 1000000000000
RG13 13 0 1000000000000
RG14 14 0 1000000000000
RG15 15 0 1000000000000
RG16 16 0 1000000000000
RG17 17 0 1000000000000
RG18 18 0 1000000000000
RG19 19 0 1000000000000
RG20 20 0 1000000000000
RG21 21 0 1000000000000
RG22 22 0 1000000000000
RG23 23 0 1000000000000
RG24 24 0 1000000000000
RG25 25 0 1000000000000
RG26 26 0 1000000000000
RG27 27 0 1000000000000
VS0 12 s0 0
C0 s0 25 68e-7
VS1 9 s1 0
L1 s1 21 47e-5
VS2 3 s2 0
C2 s2 2 68e-4
VS3 0 s3 0
V3 e3 s3 DC 0 AC 22e1 120
RI3 e3 21 27e-1
VS4 18 s4 0
R4 s4 15 56e3
VS5 7 s5 0
R5 s5 2 33e0
VS6 25 s6 0
R6 s6 8 47e1
VS7 8 s7 0
L7 s7 6 18e-4
VS8 12 s8 0
C8 s8 5 18e-6
VS9 21 s9 0
L9 s9 14 82e-5
VS10 24 s10 0
R10 s10 23 18e2
VS11 23 s11 0
V11 e11 s11 DC 0 AC 33e-1 180
RI11 e11 11 82e-3
VS12 3 s12 0
L12 s12 0 47e-5
VS13 17 s13 0
L13 s13 8 68e-3
VS14 2 s14 0
L14 s14 25 18e-5
VS15 0 s15 0
R15 s15 27 15e1
VS16 27 s16 0
C16 s16 16 39e-6
VS17 20 s17 0
L17 s17 3 22e-2
VS18 4 s18 0
R18 s18 27 56e2
VS19 7 s19 0
C19 s19 19 18e-5
VS20 13 s20 0
V20 e20 s20 DC 0 AC 68e0 120
RI20 e20 22 68e-2
VS21 5 s21 0
L21 s21 20 47e-4
VS22 2 s22 0
V22 e22 s22 DC 0 AC 68e1 120
RI22 e22 4 15e-3
VS23 12 s23 0
L23 s23 22 18e-4
VS24 12 s24 0
L24 s24 15 27e-5
VS25 25 s25 0
L25 s25 23 39e-5
VS26 7 s26 0
C26 s26 15 82e-4
VS27 12 s27 0
C27 s27 3 47e-7
VS28 10 s28 0
C28 s28 4 18e-5
VS29 27 s29 0
L29 s29 12 56e-5
VS30 8 s30 0
L30 s30 10 15e-2
VS31 17 s31 0
V31 e31 s31 DC 0 AC 22e-1 -120
RI31 e31 26 39e-1
VS32 6 s32 0
R32 s32 27 12e-1
VS33 13 s33 0
L33 s33 3 68e-4
VS34 8 s34 0
L34 s34 26 22e-2
VS35 23 s35 0
R35 s35 10 10e-2
VS36 7 s36 0
C36 s36 26 33e-6
VS37 24 s37 0
C37 s37 21 10e-4
VS38 13 s38 0
V38 e38 s38 DC 0 AC 10e0 180
RI38 e38 19 56e-2
VS39 2 s39 0
C39 s39 16 56e-5
VS40 0 s40 0
C40 s40 24 22e-6
VS41 22 s41 0
R41 s41 17 22e1
VS42 5 s42 0
C42 s42 9 56e-7
VS43 24 s43 0
R43 s43 13 56e1
VS44 20 s44 0
R44 s44 22 68e1
VS45 25 s45 0
R45 s45 5 15e-2
VS46 12 s46 0
C46 s46 4 82e-5
VS47 8 s47 0
L47 s47 5 68e-4
VS48 1 s48 0
V48 e48 s48 DC 0 AC 39e-1 120
RI48 e48 13 47e-3
VS49 9 s49 0
L49 s49 27 27e-2
VS50 10 s50 0
V50 e50 s50 DC 0 AC 15e0 0
RI50 e50 12 82e-1
VS51 17 s51 0
V51 e51 s51 DC 0 AC 12e1 0
RI51 e51 10 56e-1
VS52 16 s52 0
R52 s52 18 22e2
.control
set numdgt=17
ac lin 1 60 60
print v(1) v(2) v(3) v(4) v(5) v(6) v(7) v(8) v(9) v(10)
print v(11) v(12) v(13) v(14) v(15) v(16) v(17) v(18) v(19) v(20)
print v(21) v(22) v(23) v(24) v(25) v(26) v(27)
print i(vs0) i(vs1) i(vs2) i(vs3) i(vs4) i(vs5) i(vs6) i(vs7) i(vs8) i(vs9)
print i(vs10) i(vs11) i(vs12) i(vs13) i(vs14) i(vs15) i(vs16) i(vs17) i(vs18) i(vs19)
print i(vs20) i(vs21) i(vs22) i(vs23) i(vs24) i(vs25) i(vs26) i(vs27) i(vs28) i(vs29)
print i(vs30) i(vs31) i(vs32) i(vs33) i(vs34) i(vs35) i(vs36) i(vs37) i(vs38) i(vs39)
print i(vs40) i(vs41) i(vs42) i(vs43) i(vs44) i(vs45) i(vs46) i(vs47) i(vs48) i(vs49)
print i(vs50) i(vs51) i(vs52)
.endc
.end
