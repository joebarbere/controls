controls oracle ac-0028
* Generated (plan F2.7, ADR 0012): do not edit; regenerate with `pnpm sim oracle regen`. ac seed 20261031 index 28 nodes 24 elements 39
.options sparse gmin=1e-12 noopac
RG1 1 0 1000000000000
RG2 2 0 1000000000000
RG3 3 0 1000000000000
RG4 4 0 1000000000000
RG5 5 0 1000000000000
RG6 6 0 1000000000000
RG7 7 0 1000000000000
RG8 8 0 1000000000000
RG9 9 0 1000000000000
RG10 10 0 1000000000000
RG11 11 0 1000000000000
RG12 12 0 1000000000000
RG13 13 0 1000000000000
RG14 14 0 1000000000000
RG15 15 0 1000000000000
RG16 16 0 1000000000000
RG17 17 0 1000000000000
RG18 18 0 1000000000000
RG19 19 0 1000000000000
RG20 20 0 1000000000000
RG21 21 0 1000000000000
RG22 22 0 1000000000000
RG23 23 0 1000000000000
VS0 18 s0 0
R0 s0 14 10e-2
VS1 16 s1 0
R1 s1 22 27e2
VS2 23 s2 0
L2 s2 6 22e-3
VS3 2 s3 0
L3 s3 8 27e-4
VS4 3 s4 0
C4 s4 19 39e-5
VS5 7 s5 0
L5 s5 18 39e-5
VS6 21 s6 0
R6 s6 2 10e-2
VS7 18 s7 0
C7 s7 0 27e-6
VS8 17 s8 0
R8 s8 8 15e-1
VS9 0 s9 0
V9 e9 s9 DC 0 AC 56e1 -120
RI9 e9 14 10e-2
VS10 6 s10 0
C10 s10 20 27e-6
VS11 13 s11 0
R11 s11 1 10e1
VS12 9 s12 0
L12 s12 18 56e-3
VS13 12 s13 0
L13 s13 10 18e-4
VS14 19 s14 0
L14 s14 23 15e-5
VS15 2 s15 0
V15 e15 s15 DC 0 AC 10e0 120
RI15 e15 m15 12e-3
LI15 m15 15 15e-6
VS16 22 s16 0
L16 s16 15 82e-5
VS17 3 s17 0
C17 s17 2 68e-4
VS18 23 s18 0
C18 s18 17 10e-5
VS19 8 s19 0
R19 s19 5 47e1
VS20 20 s20 0
L20 s20 4 39e-5
VS21 14 s21 0
V21 e21 s21 DC 0 AC 27e0 0
RI21 e21 m21 68e-3
LI21 m21 5 56e-7
VS22 17 s22 0
C22 s22 23 33e-4
VS23 12 s23 0
C23 s23 2 47e-6
VS24 3 s24 0
R24 s24 4 33e3
VS25 17 s25 0
V25 e25 s25 DC 0 AC 15e-1 180
RI25 e25 23 22e-2
VS26 23 s26 0
R26 s26 8 68e0
VS27 16 s27 0
V27 e27 s27 DC 0 AC 39e1 180
RI27 e27 m27 12e-1
LI27 m27 21 27e-5
VS28 9 s28 0
R28 s28 11 18e-2
VS29 6 s29 0
L29 s29 1 47e-3
VS30 22 s30 0
L30 s30 5 82e-5
VS31 22 s31 0
R31 s31 3 15e1
VS32 4 s32 0
R32 s32 9 33e0
VS33 7 s33 0
V33 e33 s33 DC 0 AC 15e-1 -120
RI33 e33 13 33e-3
VS34 16 s34 0
R34 s34 10 22e1
VS35 4 s35 0
C35 s35 2 56e-7
VS36 1 s36 0
L36 s36 11 27e-4
VS37 4 s37 0
V37 e37 s37 DC 0 AC 12e-1 0
RI37 e37 5 18e-3
VS38 5 s38 0
V38 e38 s38 DC 0 AC 33e0 -120
RI38 e38 m38 39e-1
LI38 m38 16 82e-5
.control
set numdgt=17
ac lin 1 60 60
print v(1) v(2) v(3) v(4) v(5) v(6) v(7) v(8) v(9) v(10)
print v(11) v(12) v(13) v(14) v(15) v(16) v(17) v(18) v(19) v(20)
print v(21) v(22) v(23)
print i(vs0) i(vs1) i(vs2) i(vs3) i(vs4) i(vs5) i(vs6) i(vs7) i(vs8) i(vs9)
print i(vs10) i(vs11) i(vs12) i(vs13) i(vs14) i(vs15) i(vs16) i(vs17) i(vs18) i(vs19)
print i(vs20) i(vs21) i(vs22) i(vs23) i(vs24) i(vs25) i(vs26) i(vs27) i(vs28) i(vs29)
print i(vs30) i(vs31) i(vs32) i(vs33) i(vs34) i(vs35) i(vs36) i(vs37) i(vs38)
.endc
.end
