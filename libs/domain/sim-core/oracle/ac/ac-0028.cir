controls oracle ac-0028
* Generated (plan F2.7, ADR 0012): do not edit; regenerate with `pnpm sim oracle regen`. ac seed 20261031 index 28 nodes 24 elements 38
.options sparse gmin=1e-12 noopac
RG1 1 0 1000000000000
RG2 2 0 1000000000000
RG3 3 0 1000000000000
RG4 4 0 1000000000000
RG5 5 0 1000000000000
RG6 6 0 1000000000000
RG7 7 0 1000000000000
RG8 8 0 1000000000000
RG9 9 0 1000000000000
RG10 10 0 1000000000000
RG11 11 0 1000000000000
RG12 12 0 1000000000000
RG13 13 0 1000000000000
RG14 14 0 1000000000000
RG15 15 0 1000000000000
RG16 16 0 1000000000000
RG17 17 0 1000000000000
RG18 18 0 1000000000000
RG19 19 0 1000000000000
RG20 20 0 1000000000000
RG21 21 0 1000000000000
RG22 22 0 1000000000000
RG23 23 0 1000000000000
VS0 23 s0 0
R0 s0 8 68e0
VS1 21 s1 0
L1 s1 5 82e-3
VS2 15 s2 0
R2 s2 14 82e-2
VS3 18 s3 0
R3 s3 14 10e-2
VS4 2 s4 0
L4 s4 18 82e-3
VS5 12 s5 0
C5 s5 2 47e-6
VS6 7 s6 0
L6 s6 18 39e-5
VS7 1 s7 0
R7 s7 12 82e-1
VS8 0 s8 0
R8 s8 5 33e-2
VS9 4 s9 0
R9 s9 15 33e0
VS10 14 s10 0
L10 s10 11 82e-4
VS11 4 s11 0
R11 s11 17 27e0
VS12 13 s12 0
C12 s12 12 10e-6
VS13 6 s13 0
L13 s13 1 47e-3
VS14 17 s14 0
R14 s14 3 82e2
VS15 16 s15 0
R15 s15 10 22e1
VS16 14 s16 0
L16 s16 18 27e-4
VS17 0 s17 0
V17 e17 s17 DC 0 AC 39e1 120
RI17 e17 21 18e-3
VS18 2 s18 0
L18 s18 8 27e-4
VS19 19 s19 0
R19 s19 22 22e-2
VS20 15 s20 0
R20 s20 10 27e-2
VS21 23 s21 0
V21 e21 s21 DC 0 AC 39e-1 0
RI21 e21 18 56e-3
VS22 23 s22 0
L22 s22 6 22e-3
VS23 9 s23 0
C23 s23 19 33e-7
VS24 22 s24 0
L24 s24 2 33e-2
VS25 15 s25 0
R25 s25 11 18e-2
VS26 4 s26 0
C26 s26 2 56e-7
VS27 7 s27 0
R27 s27 19 10e-1
VS28 13 s28 0
L28 s28 16 27e-3
VS29 21 s29 0
R29 s29 2 10e-2
VS30 16 s30 0
R30 s30 22 27e0
VS31 18 s31 0
R31 s31 9 82e-1
VS32 20 s32 0
R32 s32 17 47e-1
VS33 16 s33 0
V33 e33 s33 DC 0 AC 39e1 180
RI33 e33 m33 12e-1
LI33 m33 21 56e-5
VS34 22 s34 0
R34 s34 16 47e0
VS35 4 s35 0
V35 e35 s35 DC 0 AC 12e-1 0
RI35 e35 5 18e-3
VS36 23 s36 0
L36 s36 20 22e-4
VS37 3 s37 0
R37 s37 8 27e-1
.control
set numdgt=17
ac lin 1 60 60
print v(1) v(2) v(3) v(4) v(5) v(6) v(7) v(8) v(9) v(10)
print v(11) v(12) v(13) v(14) v(15) v(16) v(17) v(18) v(19) v(20)
print v(21) v(22) v(23)
print i(vs0) i(vs1) i(vs2) i(vs3) i(vs4) i(vs5) i(vs6) i(vs7) i(vs8) i(vs9)
print i(vs10) i(vs11) i(vs12) i(vs13) i(vs14) i(vs15) i(vs16) i(vs17) i(vs18) i(vs19)
print i(vs20) i(vs21) i(vs22) i(vs23) i(vs24) i(vs25) i(vs26) i(vs27) i(vs28) i(vs29)
print i(vs30) i(vs31) i(vs32) i(vs33) i(vs34) i(vs35) i(vs36) i(vs37)
.endc
.end
