controls oracle ac-0028
* Generated (plan F2.7, ADR 0012): do not edit; regenerate with `pnpm sim oracle regen`. ac seed 20261031 index 28 nodes 24 elements 28
.options sparse gmin=1e-12 noopac
RG1 1 0 1000000000000
RG2 2 0 1000000000000
RG3 3 0 1000000000000
RG4 4 0 1000000000000
RG5 5 0 1000000000000
RG6 6 0 1000000000000
RG7 7 0 1000000000000
RG8 8 0 1000000000000
RG9 9 0 1000000000000
RG10 10 0 1000000000000
RG11 11 0 1000000000000
RG12 12 0 1000000000000
RG13 13 0 1000000000000
RG14 14 0 1000000000000
RG15 15 0 1000000000000
RG16 16 0 1000000000000
RG17 17 0 1000000000000
RG18 18 0 1000000000000
RG19 19 0 1000000000000
RG20 20 0 1000000000000
RG21 21 0 1000000000000
RG22 22 0 1000000000000
RG23 23 0 1000000000000
VS0 18 s0 0
R0 s0 9 82e-1
VS1 15 s1 0
R1 s1 5 33e-2
VS2 0 s2 0
V2 e2 s2 DC 0 AC 39e1 180
RI2 e2 21 12e-1
VS3 7 s3 0
R3 s3 19 10e-1
VS4 0 s4 0
R4 s4 10 22e1
VS5 18 s5 0
R5 s5 14 10e-2
VS6 4 s6 0
R6 s6 16 33e0
VS7 23 s7 0
L7 s7 6 22e-3
VS8 21 s8 0
L8 s8 5 82e-3
VS9 23 s9 0
V9 e9 s9 DC 0 AC 39e-1 0
RI9 e9 18 56e-3
VS10 23 s10 0
L10 s10 20 22e-4
VS11 13 s11 0
C11 s11 12 10e-6
VS12 21 s12 0
R12 s12 2 10e-2
VS13 4 s13 0
R13 s13 17 27e0
VS14 2 s14 0
L14 s14 8 27e-4
VS15 4 s15 0
C15 s15 2 56e-7
VS16 23 s16 0
R16 s16 8 68e0
VS17 0 s17 0
R17 s17 22 27e0
VS18 4 s18 0
V18 e18 s18 DC 0 AC 12e-1 0
RI18 e18 5 18e-3
VS19 16 s19 0
R19 s19 11 18e-2
VS20 12 s20 0
C20 s20 2 47e-6
VS21 17 s21 0
R21 s21 3 82e2
VS22 2 s22 0
L22 s22 18 82e-3
VS23 14 s23 0
L23 s23 18 27e-4
VS24 7 s24 0
L24 s24 18 39e-5
VS25 22 s25 0
R25 s25 0 47e0
VS26 22 s26 0
L26 s26 2 33e-2
VS27 6 s27 0
L27 s27 1 47e-3
.control
set numdgt=17
ac lin 1 60 60
print v(1) v(2) v(3) v(4) v(5) v(6) v(7) v(8) v(9) v(10)
print v(11) v(12) v(13) v(14) v(15) v(16) v(17) v(18) v(19) v(20)
print v(21) v(22) v(23)
print i(vs0) i(vs1) i(vs2) i(vs3) i(vs4) i(vs5) i(vs6) i(vs7) i(vs8) i(vs9)
print i(vs10) i(vs11) i(vs12) i(vs13) i(vs14) i(vs15) i(vs16) i(vs17) i(vs18) i(vs19)
print i(vs20) i(vs21) i(vs22) i(vs23) i(vs24) i(vs25) i(vs26) i(vs27)
.endc
.end
