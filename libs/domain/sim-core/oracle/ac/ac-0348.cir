controls oracle ac-0348
* Generated (plan F2.7, ADR 0012): do not edit; regenerate with `pnpm sim oracle regen`. ac seed 20261031 index 348 nodes 8 elements 10
.options sparse gmin=1e-12 noopac
RG1 1 0 1000000000000
RG2 2 0 1000000000000
RG3 3 0 1000000000000
RG4 4 0 1000000000000
RG5 5 0 1000000000000
RG6 6 0 1000000000000
RG7 7 0 1000000000000
VS0 0 s0 0
V0 e0 s0 DC 0 AC 12e-1 180
RI0 e0 1 39e-1
VS1 0 s1 0
L1 s1 1 82e-4
VS2 4 s2 0
C2 s2 0 56e-4
VS3 2 s3 0
L3 s3 7 82e-4
VS4 4 s4 0
L4 s4 3 47e-3
VS5 0 s5 0
L5 s5 6 82e-4
VS6 5 s6 0
R6 s6 0 18e0
VS7 3 s7 0
C7 s7 0 33e-6
VS8 7 s8 0
L8 s8 3 12e-2
VS9 4 s9 0
R9 s9 2 15e1
.control
set numdgt=17
ac lin 1 60 60
print v(1) v(2) v(3) v(4) v(5) v(6) v(7)
print i(vs0) i(vs1) i(vs2) i(vs3) i(vs4) i(vs5) i(vs6) i(vs7) i(vs8) i(vs9)
.endc
.end
