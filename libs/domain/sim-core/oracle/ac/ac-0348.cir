controls oracle ac-0348
* Generated (plan F2.7, ADR 0012): do not edit; regenerate with `pnpm sim oracle regen`. ac seed 20261031 index 348 nodes 8 elements 13
.options sparse gmin=1e-12 noopac
RG1 1 0 1000000000000
RG2 2 0 1000000000000
RG3 3 0 1000000000000
RG4 4 0 1000000000000
RG5 5 0 1000000000000
RG6 6 0 1000000000000
RG7 7 0 1000000000000
VS0 5 s0 0
R0 s0 3 18e0
VS1 4 s1 0
C1 s1 3 56e-4
VS2 0 s2 0
V2 e2 s2 DC 0 AC 18e1 -120
RI2 e2 6 27e-1
VS3 2 s3 0
L3 s3 7 82e-4
VS4 3 s4 0
V4 e4 s4 DC 0 AC 12e-1 180
RI4 e4 1 39e-1
VS5 3 s5 0
L5 s5 6 82e-4
VS6 0 s6 0
C6 s6 3 33e-6
VS7 7 s7 0
L7 s7 0 12e-2
VS8 1 s8 0
L8 s8 2 56e-5
VS9 3 s9 0
L9 s9 1 82e-4
VS10 4 s10 0
R10 s10 2 15e1
VS11 5 s11 0
R11 s11 4 47e1
VS12 4 s12 0
L12 s12 0 47e-3
.control
set numdgt=17
ac lin 1 60 60
print v(1) v(2) v(3) v(4) v(5) v(6) v(7)
print i(vs0) i(vs1) i(vs2) i(vs3) i(vs4) i(vs5) i(vs6) i(vs7) i(vs8) i(vs9)
print i(vs10) i(vs11) i(vs12)
.endc
.end
