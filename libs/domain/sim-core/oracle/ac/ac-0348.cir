controls oracle ac-0348
* Generated (plan F2.7, ADR 0012): do not edit; regenerate with `pnpm sim oracle regen`. ac seed 20261031 index 348 nodes 8 elements 13
.options sparse gmin=1e-12 noopac
RG1 1 0 1000000000000
RG2 2 0 1000000000000
RG3 3 0 1000000000000
RG4 4 0 1000000000000
RG5 5 0 1000000000000
RG6 6 0 1000000000000
RG7 7 0 1000000000000
VS0 4 s0 0
R0 s0 2 15e1
VS1 4 s1 0
C1 s1 0 56e-4
VS2 6 s2 0
C2 s2 4 47e-4
VS3 4 s3 0
L3 s3 3 47e-3
VS4 2 s4 0
L4 s4 7 82e-4
VS5 0 s5 0
L5 s5 1 82e-4
VS6 3 s6 0
C6 s6 1 15e-4
VS7 7 s7 0
L7 s7 3 12e-2
VS8 0 s8 0
L8 s8 6 82e-4
VS9 5 s9 0
R9 s9 0 18e0
VS10 3 s10 0
C10 s10 0 33e-6
VS11 0 s11 0
V11 e11 s11 DC 0 AC 12e-1 180
RI11 e11 1 39e-1
VS12 5 s12 0
R12 s12 3 82e3
.control
set numdgt=17
ac lin 1 60 60
print v(1) v(2) v(3) v(4) v(5) v(6) v(7)
print i(vs0) i(vs1) i(vs2) i(vs3) i(vs4) i(vs5) i(vs6) i(vs7) i(vs8) i(vs9)
print i(vs10) i(vs11) i(vs12)
.endc
.end
