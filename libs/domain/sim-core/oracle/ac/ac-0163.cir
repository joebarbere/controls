controls oracle ac-0163
* Generated (plan F2.7, ADR 0012): do not edit; regenerate with `pnpm sim oracle regen`. ac seed 20261031 index 163 nodes 16 elements 27
.options sparse gmin=1e-12 noopac
RG1 1 0 1000000000000
RG2 2 0 1000000000000
RG3 3 0 1000000000000
RG4 4 0 1000000000000
RG5 5 0 1000000000000
RG6 6 0 1000000000000
RG7 7 0 1000000000000
RG8 8 0 1000000000000
RG9 9 0 1000000000000
RG10 10 0 1000000000000
RG11 11 0 1000000000000
RG12 12 0 1000000000000
RG13 13 0 1000000000000
RG14 14 0 1000000000000
RG15 15 0 1000000000000
VS0 12 s0 0
L0 s0 14 27e-5
VS1 0 s1 0
V1 e1 s1 DC 0 AC 15e0 -120
RI1 e1 3 82e-3
VS2 13 s2 0
L2 s2 7 39e-5
VS3 13 s3 0
R3 s3 3 56e3
VS4 4 s4 0
C4 s4 0 33e-5
VS5 15 s5 0
C5 s5 4 82e-5
VS6 10 s6 0
L6 s6 0 10e-3
VS7 5 s7 0
L7 s7 14 18e-2
VS8 2 s8 0
V8 e8 s8 DC 0 AC 47e0 180
RI8 e8 11 33e-2
VS9 13 s9 0
V9 e9 s9 DC 0 AC 22e1 180
RI9 e9 9 18e-2
VS10 1 s10 0
V10 e10 s10 DC 0 AC 12e-1 -120
RI10 e10 12 12e-1
VS11 7 s11 0
R11 s11 0 68e2
VS12 10 s12 0
R12 s12 4 10e-1
VS13 6 s13 0
L13 s13 15 22e-3
VS14 9 s14 0
R14 s14 1 68e-1
VS15 7 s15 0
V15 e15 s15 DC 0 AC 18e1 180
RI15 e15 3 33e-3
VS16 6 s16 0
L16 s16 12 56e-5
VS17 0 s17 0
V17 e17 s17 DC 0 AC 27e-1 0
RI17 e17 8 68e-2
VS18 8 s18 0
R18 s18 13 15e-2
VS19 12 s19 0
V19 e19 s19 DC 0 AC 56e0 -120
RI19 e19 7 56e-3
VS20 4 s20 0
C20 s20 1 12e-6
VS21 4 s21 0
C21 s21 3 10e-4
VS22 3 s22 0
C22 s22 0 22e-4
VS23 11 s23 0
L23 s23 1 12e-5
VS24 3 s24 0
R24 s24 7 47e2
VS25 2 s25 0
C25 s25 13 27e-5
VS26 5 s26 0
R26 s26 10 82e3
.control
set numdgt=17
ac lin 1 60 60
print v(1) v(2) v(3) v(4) v(5) v(6) v(7) v(8) v(9) v(10)
print v(11) v(12) v(13) v(14) v(15)
print i(vs0) i(vs1) i(vs2) i(vs3) i(vs4) i(vs5) i(vs6) i(vs7) i(vs8) i(vs9)
print i(vs10) i(vs11) i(vs12) i(vs13) i(vs14) i(vs15) i(vs16) i(vs17) i(vs18) i(vs19)
print i(vs20) i(vs21) i(vs22) i(vs23) i(vs24) i(vs25) i(vs26)
.endc
.end
