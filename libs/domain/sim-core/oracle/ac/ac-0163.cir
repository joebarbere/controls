controls oracle ac-0163
* Generated (plan F2.7, ADR 0012): do not edit; regenerate with `pnpm sim oracle regen`. ac seed 20261031 index 163 nodes 16 elements 23
.options sparse gmin=1e-12 noopac
RG1 1 0 1000000000000
RG2 2 0 1000000000000
RG3 3 0 1000000000000
RG4 4 0 1000000000000
RG5 5 0 1000000000000
RG6 6 0 1000000000000
RG7 7 0 1000000000000
RG8 8 0 1000000000000
RG9 9 0 1000000000000
RG10 10 0 1000000000000
RG11 11 0 1000000000000
RG12 12 0 1000000000000
RG13 13 0 1000000000000
RG14 14 0 1000000000000
RG15 15 0 1000000000000
VS0 13 s0 0
C0 s0 15 22e-4
VS1 5 s1 0
R1 s1 12 10e-2
VS2 3 s2 0
L2 s2 13 47e-2
VS3 0 s3 0
V3 e3 s3 DC 0 AC 18e0 -120
RI3 e3 m3 33e-2
LI3 m3 2 68e-6
VS4 1 s4 0
R4 s4 15 10e2
VS5 12 s5 0
L5 s5 14 27e-5
VS6 11 s6 0
R6 s6 1 15e3
VS7 15 s7 0
C7 s7 9 15e-4
VS8 11 s8 0
C8 s8 3 33e-4
VS9 12 s9 0
V9 e9 s9 DC 0 AC 56e0 -120
RI9 e9 7 56e-3
VS10 1 s10 0
R10 s10 14 33e1
VS11 6 s11 0
R11 s11 7 47e3
VS12 1 s12 0
R12 s12 0 56e-2
VS13 6 s13 0
R13 s13 11 27e-1
VS14 9 s14 0
L14 s14 2 22e-2
VS15 12 s15 0
V15 e15 s15 DC 0 AC 12e1 120
RI15 e15 m15 12e-2
LI15 m15 8 39e-5
VS16 8 s16 0
R16 s16 2 15e1
VS17 12 s17 0
V17 e17 s17 DC 0 AC 10e1 120
RI17 e17 m17 12e-3
LI17 m17 9 47e-5
VS18 5 s18 0
L18 s18 14 18e-2
VS19 0 s19 0
L19 s19 11 33e-4
VS20 10 s20 0
L20 s20 2 22e-2
VS21 14 s21 0
V21 e21 s21 DC 0 AC 15e1 -120
RI21 e21 m21 27e-1
LI21 m21 4 18e-6
VS22 4 s22 0
C22 s22 10 68e-5
.control
set numdgt=17
ac lin 1 60 60
print v(1) v(2) v(3) v(4) v(5) v(6) v(7) v(8) v(9) v(10)
print v(11) v(12) v(13) v(14) v(15)
print i(vs0) i(vs1) i(vs2) i(vs3) i(vs4) i(vs5) i(vs6) i(vs7) i(vs8) i(vs9)
print i(vs10) i(vs11) i(vs12) i(vs13) i(vs14) i(vs15) i(vs16) i(vs17) i(vs18) i(vs19)
print i(vs20) i(vs21) i(vs22)
.endc
.end
