controls oracle ac-0163
* Generated (plan F2.7, ADR 0012): do not edit; regenerate with `pnpm sim oracle regen`. ac seed 20261031 index 163 nodes 16 elements 24
.options sparse gmin=1e-12 noopac
RG1 1 0 1000000000000
RG2 2 0 1000000000000
RG3 3 0 1000000000000
RG4 4 0 1000000000000
RG5 5 0 1000000000000
RG6 6 0 1000000000000
RG7 7 0 1000000000000
RG8 8 0 1000000000000
RG9 9 0 1000000000000
RG10 10 0 1000000000000
RG11 11 0 1000000000000
RG12 12 0 1000000000000
RG13 13 0 1000000000000
RG14 14 0 1000000000000
RG15 15 0 1000000000000
VS0 0 s0 0
V0 e0 s0 DC 0 AC 27e-1 0
RI0 e0 8 68e-2
VS1 2 s1 0
C1 s1 13 27e-5
VS2 4 s2 0
C2 s2 3 10e-4
VS3 6 s3 0
L3 s3 15 22e-3
VS4 11 s4 0
L4 s4 1 12e-5
VS5 15 s5 0
C5 s5 4 82e-5
VS6 4 s6 0
C6 s6 1 12e-6
VS7 7 s7 0
V7 e7 s7 DC 0 AC 18e1 180
RI7 e7 3 33e-3
VS8 7 s8 0
R8 s8 0 68e2
VS9 12 s9 0
V9 e9 s9 DC 0 AC 56e0 -120
RI9 e9 7 56e-3
VS10 13 s10 0
R10 s10 3 56e3
VS11 10 s11 0
L11 s11 0 10e-3
VS12 1 s12 0
V12 e12 s12 DC 0 AC 12e-1 -120
RI12 e12 12 12e-1
VS13 13 s13 0
L13 s13 7 39e-5
VS14 5 s14 0
R14 s14 10 82e3
VS15 9 s15 0
R15 s15 1 68e-1
VS16 10 s16 0
R16 s16 4 10e-1
VS17 3 s17 0
C17 s17 0 22e-4
VS18 0 s18 0
V18 e18 s18 DC 0 AC 15e0 -120
RI18 e18 3 82e-3
VS19 3 s19 0
R19 s19 7 47e2
VS20 6 s20 0
L20 s20 12 56e-5
VS21 12 s21 0
L21 s21 14 27e-5
VS22 5 s22 0
L22 s22 14 18e-2
VS23 4 s23 0
C23 s23 0 33e-5
.control
set numdgt=17
ac lin 1 60 60
print v(1) v(2) v(3) v(4) v(5) v(6) v(7) v(8) v(9) v(10)
print v(11) v(12) v(13) v(14) v(15)
print i(vs0) i(vs1) i(vs2) i(vs3) i(vs4) i(vs5) i(vs6) i(vs7) i(vs8) i(vs9)
print i(vs10) i(vs11) i(vs12) i(vs13) i(vs14) i(vs15) i(vs16) i(vs17) i(vs18) i(vs19)
print i(vs20) i(vs21) i(vs22) i(vs23)
.endc
.end
