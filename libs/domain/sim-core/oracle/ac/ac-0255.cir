controls oracle ac-0255
* Generated (plan F2.7, ADR 0012): do not edit; regenerate with `pnpm sim oracle regen`. ac seed 20261031 index 255 nodes 12 elements 17
.options sparse gmin=1e-12 noopac
RG1 1 0 1000000000000
RG2 2 0 1000000000000
RG3 3 0 1000000000000
RG4 4 0 1000000000000
RG5 5 0 1000000000000
RG6 6 0 1000000000000
RG7 7 0 1000000000000
RG8 8 0 1000000000000
RG9 9 0 1000000000000
RG10 10 0 1000000000000
RG11 11 0 1000000000000
VS0 8 s0 0
L0 s0 6 27e-4
VS1 8 s1 0
R1 s1 6 22e2
VS2 5 s2 0
C2 s2 11 56e-5
VS3 1 s3 0
R3 s3 4 12e1
VS4 3 s4 0
R4 s4 11 27e3
VS5 2 s5 0
R5 s5 0 47e-2
VS6 6 s6 0
C6 s6 5 68e-4
VS7 3 s7 0
C7 s7 7 12e-5
VS8 0 s8 0
V8 e8 s8 DC 0 AC 56e-1 0
RI8 e8 3 22e-3
VS9 9 s9 0
R9 s9 10 82e3
VS10 1 s10 0
V10 e10 s10 DC 0 AC 15e0 0
RI10 e10 m10 68e-1
LI10 m10 3 68e-6
VS11 11 s11 0
R11 s11 6 39e3
VS12 8 s12 0
C12 s12 5 12e-7
VS13 2 s13 0
R13 s13 7 15e-2
VS14 2 s14 0
C14 s14 4 56e-5
VS15 9 s15 0
L15 s15 1 18e-2
VS16 6 s16 0
R16 s16 10 22e2
.control
set numdgt=17
ac lin 1 60 60
print v(1) v(2) v(3) v(4) v(5) v(6) v(7) v(8) v(9) v(10)
print v(11)
print i(vs0) i(vs1) i(vs2) i(vs3) i(vs4) i(vs5) i(vs6) i(vs7) i(vs8) i(vs9)
print i(vs10) i(vs11) i(vs12) i(vs13) i(vs14) i(vs15) i(vs16)
.endc
.end
