controls oracle ac-0255
* Generated (plan F2.7, ADR 0012): do not edit; regenerate with `pnpm sim oracle regen`. ac seed 20261031 index 255 nodes 12 elements 17
.options sparse gmin=1e-12 noopac
RG1 1 0 1000000000000
RG2 2 0 1000000000000
RG3 3 0 1000000000000
RG4 4 0 1000000000000
RG5 5 0 1000000000000
RG6 6 0 1000000000000
RG7 7 0 1000000000000
RG8 8 0 1000000000000
RG9 9 0 1000000000000
RG10 10 0 1000000000000
RG11 11 0 1000000000000
VS0 3 s0 0
R0 s0 11 12e-2
VS1 7 s1 0
R1 s1 5 68e2
VS2 0 s2 0
V2 e2 s2 DC 0 AC 15e0 0
RI2 e2 m2 68e-1
LI2 m2 n2 82e-7
H2 n2 h2 VS3 33e-2
ED2 h2 3 d2 0 39e-5
F2 0 d2 VS3 1
LD2 d2 0 1
VS3 2 s3 0
V3 e3 s3 DC 0 AC 68e0 180
RI3 e3 m3 33e-1
LI3 m3 n3 18e-6
H3 n3 h3 VS2 33e-2
ED3 h3 7 d3 0 39e-5
F3 0 d3 VS2 1
LD3 d3 0 1
VS4 4 s4 0
R4 s4 5 68e-1
VS5 10 s5 0
V5 e5 s5 DC 0 AC 56e-1 -120
RI5 e5 3 82e-2
VS6 2 s6 0
C6 s6 10 18e-6
VS7 0 s7 0
C7 s7 4 22e-7
VS8 6 s8 0
L8 s8 1 15e-4
VS9 8 s9 0
V9 e9 s9 DC 0 AC 82e0 0
RI9 e9 9 10e-2
VS10 2 s10 0
V10 e10 s10 DC 0 AC 15e-1 180
RI10 e10 6 15e-1
VS11 1 s11 0
L11 s11 0 18e-2
VS12 2 s12 0
L12 s12 8 33e-2
VS13 6 s13 0
R13 s13 11 22e-1
VS14 0 s14 0
L14 s14 5 10e-3
VS15 9 s15 0
R15 s15 2 12e0
VS16 0 s16 0
R16 s16 9 27e0
.control
set numdgt=17
ac lin 1 60 60
print v(1) v(2) v(3) v(4) v(5) v(6) v(7) v(8) v(9) v(10)
print v(11)
print i(vs0) i(vs1) i(vs2) i(vs3) i(vs4) i(vs5) i(vs6) i(vs7) i(vs8) i(vs9)
print i(vs10) i(vs11) i(vs12) i(vs13) i(vs14) i(vs15) i(vs16)
.endc
.end
