controls oracle ac-0255
* Generated (plan F2.7, ADR 0012): do not edit; regenerate with `pnpm sim oracle regen`. ac seed 20261031 index 255 nodes 12 elements 13
.options sparse gmin=1e-12 noopac
RG1 1 0 1000000000000
RG2 2 0 1000000000000
RG3 3 0 1000000000000
RG4 4 0 1000000000000
RG5 5 0 1000000000000
RG6 6 0 1000000000000
RG7 7 0 1000000000000
RG8 8 0 1000000000000
RG9 9 0 1000000000000
RG10 10 0 1000000000000
RG11 11 0 1000000000000
VS0 0 s0 0
R0 s0 9 27e0
VS1 3 s1 0
R1 s1 11 12e-2
VS2 0 s2 0
V2 e2 s2 DC 0 AC 15e0 0
RI2 e2 3 68e-1
VS3 4 s3 0
R3 s3 5 68e-1
VS4 9 s4 0
R4 s4 2 12e0
VS5 8 s5 0
V5 e5 s5 DC 0 AC 82e0 0
RI5 e5 9 10e-2
VS6 2 s6 0
V6 e6 s6 DC 0 AC 68e0 180
RI6 e6 7 33e-1
VS7 10 s7 0
V7 e7 s7 DC 0 AC 56e-1 -120
RI7 e7 3 82e-2
VS8 2 s8 0
V8 e8 s8 DC 0 AC 15e-1 180
RI8 e8 6 15e-1
VS9 0 s9 0
L9 s9 5 10e-3
VS10 1 s10 0
L10 s10 0 18e-2
VS11 6 s11 0
R11 s11 11 22e-1
VS12 0 s12 0
C12 s12 4 22e-7
.control
set numdgt=17
ac lin 1 60 60
print v(1) v(2) v(3) v(4) v(5) v(6) v(7) v(8) v(9) v(10)
print v(11)
print i(vs0) i(vs1) i(vs2) i(vs3) i(vs4) i(vs5) i(vs6) i(vs7) i(vs8) i(vs9)
print i(vs10) i(vs11) i(vs12)
.endc
.end
