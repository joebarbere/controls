controls oracle ac-0170
* Generated (plan F2.7, ADR 0012): do not edit; regenerate with `pnpm sim oracle regen`. ac seed 20261031 index 170 nodes 6 elements 11
.options sparse gmin=1e-12 noopac
RG1 1 0 1000000000000
RG2 2 0 1000000000000
RG3 3 0 1000000000000
RG4 4 0 1000000000000
RG5 5 0 1000000000000
VS0 5 s0 0
L0 s0 2 15e-2
VS1 3 s1 0
L1 s1 0 39e-3
VS2 0 s2 0
V2 e2 s2 DC 0 AC 33e0 120
RI2 e2 1 12e-1
VS3 3 s3 0
R3 s3 2 22e3
VS4 4 s4 0
R4 s4 0 18e0
VS5 2 s5 0
R5 s5 1 10e-2
VS6 4 s6 0
R6 s6 3 10e-2
VS7 0 s7 0
L7 s7 5 68e-3
VS8 4 s8 0
R8 s8 2 47e-1
VS9 1 s9 0
L9 s9 2 18e-2
VS10 0 s10 0
L10 s10 5 68e-5
.control
set numdgt=17
ac lin 1 60 60
print v(1) v(2) v(3) v(4) v(5)
print i(vs0) i(vs1) i(vs2) i(vs3) i(vs4) i(vs5) i(vs6) i(vs7) i(vs8) i(vs9)
print i(vs10)
.endc
.end
