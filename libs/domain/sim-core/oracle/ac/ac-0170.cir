controls oracle ac-0170
* Generated (plan F2.7, ADR 0012): do not edit; regenerate with `pnpm sim oracle regen`. ac seed 20261031 index 170 nodes 6 elements 11
.options sparse gmin=1e-12 noopac
RG1 1 0 1000000000000
RG2 2 0 1000000000000
RG3 3 0 1000000000000
RG4 4 0 1000000000000
RG5 5 0 1000000000000
VS0 2 s0 0
R0 s0 1 10e-2
VS1 1 s1 0
L1 s1 2 18e-2
VS2 5 s2 0
L2 s2 2 15e-2
VS3 3 s3 0
L3 s3 0 39e-3
VS4 0 s4 0
L4 s4 5 68e-3
VS5 0 s5 0
V5 e5 s5 DC 0 AC 33e0 120
RI5 e5 1 12e-1
VS6 3 s6 0
R6 s6 2 22e3
VS7 4 s7 0
R7 s7 0 18e0
VS8 4 s8 0
R8 s8 3 10e-2
VS9 0 s9 0
L9 s9 5 68e-5
VS10 4 s10 0
R10 s10 2 47e-1
.control
set numdgt=17
ac lin 1 60 60
print v(1) v(2) v(3) v(4) v(5)
print i(vs0) i(vs1) i(vs2) i(vs3) i(vs4) i(vs5) i(vs6) i(vs7) i(vs8) i(vs9)
print i(vs10)
.endc
.end
