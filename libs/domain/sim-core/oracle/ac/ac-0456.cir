controls oracle ac-0456
* Generated (plan F2.7, ADR 0012): do not edit; regenerate with `pnpm sim oracle regen`. ac seed 20261031 index 456 nodes 23 elements 34
.options sparse gmin=1e-12 noopac
RG1 1 0 1000000000000
RG2 2 0 1000000000000
RG3 3 0 1000000000000
RG4 4 0 1000000000000
RG5 5 0 1000000000000
RG6 6 0 1000000000000
RG7 7 0 1000000000000
RG8 8 0 1000000000000
RG9 9 0 1000000000000
RG10 10 0 1000000000000
RG11 11 0 1000000000000
RG12 12 0 1000000000000
RG13 13 0 1000000000000
RG14 14 0 1000000000000
RG15 15 0 1000000000000
RG16 16 0 1000000000000
RG17 17 0 1000000000000
RG18 18 0 1000000000000
RG19 19 0 1000000000000
RG20 20 0 1000000000000
RG21 21 0 1000000000000
RG22 22 0 1000000000000
VS0 10 s0 0
R0 s0 1 68e-1
VS1 12 s1 0
L1 s1 14 27e-2
VS2 12 s2 0
R2 s2 1 22e0
VS3 6 s3 0
R3 s3 4 33e3
VS4 19 s4 0
C4 s4 21 33e-5
VS5 0 s5 0
V5 e5 s5 DC 0 AC 15e-1 180
RI5 e5 18 56e-1
VS6 15 s6 0
R6 s6 19 18e3
VS7 17 s7 0
R7 s7 16 27e3
VS8 17 s8 0
L8 s8 9 47e-2
VS9 1 s9 0
L9 s9 7 33e-2
VS10 18 s10 0
V10 e10 s10 DC 0 AC 82e1 -120
RI10 e10 m10 39e-2
LI10 m10 12 18e-5
VS11 2 s11 0
L11 s11 3 27e-4
VS12 12 s12 0
R12 s12 22 39e-2
VS13 2 s13 0
V13 e13 s13 DC 0 AC 82e-1 -120
RI13 e13 4 22e-1
VS14 17 s14 0
L14 s14 8 27e-3
VS15 20 s15 0
L15 s15 12 33e-4
VS16 4 s16 0
R16 s16 2 18e0
VS17 14 s17 0
C17 s17 21 68e-5
VS18 10 s18 0
C18 s18 5 47e-5
VS19 4 s19 0
C19 s19 21 56e-7
VS20 7 s20 0
R20 s20 16 33e2
VS21 6 s21 0
V21 e21 s21 DC 0 AC 12e1 120
RI21 e21 3 56e-1
VS22 5 s22 0
R22 s22 3 27e1
VS23 2 s23 0
C23 s23 22 15e-4
VS24 5 s24 0
R24 s24 12 68e0
VS25 8 s25 0
V25 e25 s25 DC 0 AC 33e-1 120
RI25 e25 0 56e-1
VS26 0 s26 0
V26 e26 s26 DC 0 AC 12e0 120
RI26 e26 9 82e-3
VS27 11 s27 0
V27 e27 s27 DC 0 AC 12e1 120
RI27 e27 21 39e-1
VS28 11 s28 0
V28 e28 s28 DC 0 AC 39e0 180
RI28 e28 13 18e-2
VS29 14 s29 0
R29 s29 13 56e-1
VS30 22 s30 0
L30 s30 17 22e-3
VS31 19 s31 0
R31 s31 16 56e0
VS32 15 s32 0
V32 e32 s32 DC 0 AC 18e1 -120
RI32 e32 m32 15e-1
LI32 m32 2 12e-6
VS33 20 s33 0
R33 s33 17 47e-2
.control
set numdgt=17
ac lin 1 60 60
print v(1) v(2) v(3) v(4) v(5) v(6) v(7) v(8) v(9) v(10)
print v(11) v(12) v(13) v(14) v(15) v(16) v(17) v(18) v(19) v(20)
print v(21) v(22)
print i(vs0) i(vs1) i(vs2) i(vs3) i(vs4) i(vs5) i(vs6) i(vs7) i(vs8) i(vs9)
print i(vs10) i(vs11) i(vs12) i(vs13) i(vs14) i(vs15) i(vs16) i(vs17) i(vs18) i(vs19)
print i(vs20) i(vs21) i(vs22) i(vs23) i(vs24) i(vs25) i(vs26) i(vs27) i(vs28) i(vs29)
print i(vs30) i(vs31) i(vs32) i(vs33)
.endc
.end
