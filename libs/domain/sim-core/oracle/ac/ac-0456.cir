controls oracle ac-0456
* Generated (plan F2.7, ADR 0012): do not edit; regenerate with `pnpm sim oracle regen`. ac seed 20261031 index 456 nodes 23 elements 31
.options sparse gmin=1e-12 noopac
RG1 1 0 1000000000000
RG2 2 0 1000000000000
RG3 3 0 1000000000000
RG4 4 0 1000000000000
RG5 5 0 1000000000000
RG6 6 0 1000000000000
RG7 7 0 1000000000000
RG8 8 0 1000000000000
RG9 9 0 1000000000000
RG10 10 0 1000000000000
RG11 11 0 1000000000000
RG12 12 0 1000000000000
RG13 13 0 1000000000000
RG14 14 0 1000000000000
RG15 15 0 1000000000000
RG16 16 0 1000000000000
RG17 17 0 1000000000000
RG18 18 0 1000000000000
RG19 19 0 1000000000000
RG20 20 0 1000000000000
RG21 21 0 1000000000000
RG22 22 0 1000000000000
VS0 0 s0 0
V0 e0 s0 DC 0 AC 82e1 -120
RI0 e0 n0 39e-2
H0 n0 h0 VS1 -33e-3
ED0 h0 18 d0 0 68e-6
F0 0 d0 VS1 1
LD0 d0 0 1
VS1 14 s1 0
V1 e1 s1 DC 0 AC 27e1 120
RI1 e1 m1 68e-2
LI1 m1 n1 68e-7
H1 n1 h1 VS0 -33e-3
ED1 h1 9 d1 0 68e-6
F1 0 d1 VS0 1
LD1 d1 0 1
VS2 17 s2 0
C2 s2 6 15e-4
VS3 0 s3 0
L3 s3 14 15e-4
VS4 11 s4 0
C4 s4 8 27e-6
VS5 13 s5 0
L5 s5 3 39e-3
VS6 14 s6 0
V6 e6 s6 DC 0 AC 12e-1 -120
RI6 e6 m6 10e-1
LI6 m6 7 27e-5
VS7 5 s7 0
R7 s7 18 68e0
VS8 9 s8 0
L8 s8 15 15e-3
VS9 20 s9 0
L9 s9 18 33e-4
VS10 8 s10 0
R10 s10 2 56e0
VS11 18 s11 0
R11 s11 22 39e-2
VS12 6 s12 0
L12 s12 13 39e-4
VS13 1 s13 0
L13 s13 7 33e-2
VS14 13 s14 0
L14 s14 16 39e-4
VS15 22 s15 0
V15 e15 s15 DC 0 AC 47e-1 120
RI15 e15 7 56e-1
VS16 17 s16 0
R16 s16 9 10e-2
VS17 4 s17 0
C17 s17 19 15e-6
VS18 2 s18 0
L18 s18 20 27e-3
VS19 12 s19 0
R19 s19 11 18e1
VS20 21 s20 0
L20 s20 6 33e-2
VS21 7 s21 0
R21 s21 16 33e2
VS22 18 s22 0
R22 s22 1 22e0
VS23 21 s23 0
V23 e23 s23 DC 0 AC 12e-1 -120
RI23 e23 16 10e-2
VS24 10 s24 0
L24 s24 12 27e-4
VS25 7 s25 0
R25 s25 15 33e-1
VS26 19 s26 0
R26 s26 20 27e3
VS27 10 s27 0
C27 s27 5 47e-5
VS28 5 s28 0
R28 s28 3 27e1
VS29 4 s29 0
V29 e29 s29 DC 0 AC 39e0 180
RI29 e29 0 18e-2
VS30 0 s30 0
L30 s30 11 27e-3
.control
set numdgt=17
ac lin 1 60 60
print v(1) v(2) v(3) v(4) v(5) v(6) v(7) v(8) v(9) v(10)
print v(11) v(12) v(13) v(14) v(15) v(16) v(17) v(18) v(19) v(20)
print v(21) v(22)
print i(vs0) i(vs1) i(vs2) i(vs3) i(vs4) i(vs5) i(vs6) i(vs7) i(vs8) i(vs9)
print i(vs10) i(vs11) i(vs12) i(vs13) i(vs14) i(vs15) i(vs16) i(vs17) i(vs18) i(vs19)
print i(vs20) i(vs21) i(vs22) i(vs23) i(vs24) i(vs25) i(vs26) i(vs27) i(vs28) i(vs29)
print i(vs30)
.endc
.end
