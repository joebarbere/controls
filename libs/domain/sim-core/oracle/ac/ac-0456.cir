controls oracle ac-0456
* Generated (plan F2.7, ADR 0012): do not edit; regenerate with `pnpm sim oracle regen`. ac seed 20261031 index 456 nodes 23 elements 23
.options sparse gmin=1e-12 noopac
RG1 1 0 1000000000000
RG2 2 0 1000000000000
RG3 3 0 1000000000000
RG4 4 0 1000000000000
RG5 5 0 1000000000000
RG6 6 0 1000000000000
RG7 7 0 1000000000000
RG8 8 0 1000000000000
RG9 9 0 1000000000000
RG10 10 0 1000000000000
RG11 11 0 1000000000000
RG12 12 0 1000000000000
RG13 13 0 1000000000000
RG14 14 0 1000000000000
RG15 15 0 1000000000000
RG16 16 0 1000000000000
RG17 17 0 1000000000000
RG18 18 0 1000000000000
RG19 19 0 1000000000000
RG20 20 0 1000000000000
RG21 21 0 1000000000000
RG22 22 0 1000000000000
VS0 0 s0 0
V0 e0 s0 DC 0 AC 12e-1 -120
RI0 e0 7 10e-1
VS1 10 s1 0
C1 s1 5 47e-5
VS2 5 s2 0
R2 s2 14 68e0
VS3 18 s3 0
L3 s3 11 27e-3
VS4 6 s4 0
L4 s4 13 39e-4
VS5 13 s5 0
L5 s5 16 39e-4
VS6 2 s6 0
L6 s6 20 27e-3
VS7 1 s7 0
L7 s7 7 33e-2
VS8 14 s8 0
R8 s8 1 22e0
VS9 5 s9 0
R9 s9 3 27e1
VS10 18 s10 0
L10 s10 0 15e-4
VS11 7 s11 0
R11 s11 15 33e-1
VS12 4 s12 0
V12 e12 s12 DC 0 AC 39e0 180
RI12 e12 18 18e-2
VS13 7 s13 0
R13 s13 16 33e2
VS14 21 s14 0
V14 e14 s14 DC 0 AC 12e-1 -120
RI14 e14 16 10e-2
VS15 14 s15 0
R15 s15 22 39e-2
VS16 20 s16 0
L16 s16 14 33e-4
VS17 8 s17 0
R17 s17 2 56e0
VS18 17 s18 0
C18 s18 6 15e-4
VS19 18 s19 0
V19 e19 s19 DC 0 AC 82e1 -120
RI19 e19 14 39e-2
VS20 17 s20 0
R20 s20 9 10e-2
VS21 10 s21 0
L21 s21 12 27e-4
VS22 19 s22 0
R22 s22 20 27e3
.control
set numdgt=17
ac lin 1 60 60
print v(1) v(2) v(3) v(4) v(5) v(6) v(7) v(8) v(9) v(10)
print v(11) v(12) v(13) v(14) v(15) v(16) v(17) v(18) v(19) v(20)
print v(21) v(22)
print i(vs0) i(vs1) i(vs2) i(vs3) i(vs4) i(vs5) i(vs6) i(vs7) i(vs8) i(vs9)
print i(vs10) i(vs11) i(vs12) i(vs13) i(vs14) i(vs15) i(vs16) i(vs17) i(vs18) i(vs19)
print i(vs20) i(vs21) i(vs22)
.endc
.end
