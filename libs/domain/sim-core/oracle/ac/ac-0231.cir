controls oracle ac-0231
* Generated (plan F2.7, ADR 0012): do not edit; regenerate with `pnpm sim oracle regen`. ac seed 20261031 index 231 nodes 22 elements 43
.options sparse gmin=1e-12 noopac
RG1 1 0 1000000000000
RG2 2 0 1000000000000
RG3 3 0 1000000000000
RG4 4 0 1000000000000
RG5 5 0 1000000000000
RG6 6 0 1000000000000
RG7 7 0 1000000000000
RG8 8 0 1000000000000
RG9 9 0 1000000000000
RG10 10 0 1000000000000
RG11 11 0 1000000000000
RG12 12 0 1000000000000
RG13 13 0 1000000000000
RG14 14 0 1000000000000
RG15 15 0 1000000000000
RG16 16 0 1000000000000
RG17 17 0 1000000000000
RG18 18 0 1000000000000
RG19 19 0 1000000000000
RG20 20 0 1000000000000
RG21 21 0 1000000000000
VS0 10 s0 0
L0 s0 21 68e-4
VS1 13 s1 0
L1 s1 2 18e-4
VS2 17 s2 0
C2 s2 5 56e-4
VS3 1 s3 0
R3 s3 18 12e2
VS4 10 s4 0
C4 s4 7 10e-5
VS5 17 s5 0
L5 s5 3 56e-2
VS6 12 s6 0
L6 s6 16 68e-4
VS7 0 s7 0
V7 e7 s7 DC 0 AC 27e-1 120
RI7 e7 m7 15e-2
LI7 m7 n7 82e-7
H7 n7 h7 VS8 -56e-3
ED7 h7 17 d7 0 56e-7
F7 0 d7 VS8 1
LD7 d7 0 1
VS8 14 s8 0
V8 e8 s8 DC 0 AC 12e1 0
RI8 e8 n8 39e-2
H8 n8 h8 VS7 -56e-3
ED8 h8 20 d8 0 56e-7
F8 0 d8 VS7 1
LD8 d8 0 1
VS9 2 s9 0
V9 e9 s9 DC 0 AC 82e0 180
RI9 e9 m9 22e-3
LI9 m9 1 68e-6
VS10 14 s10 0
L10 s10 1 27e-5
VS11 21 s11 0
C11 s11 18 56e-7
VS12 18 s12 0
R12 s12 13 10e-2
VS13 2 s13 0
R13 s13 20 39e0
VS14 10 s14 0
L14 s14 8 82e-5
VS15 3 s15 0
R15 s15 6 56e1
VS16 18 s16 0
V16 e16 s16 DC 0 AC 47e-1 0
RI16 e16 2 27e-3
VS17 17 s17 0
C17 s17 1 22e-7
VS18 12 s18 0
R18 s18 2 33e2
VS19 6 s19 0
R19 s19 4 56e-2
VS20 14 s20 0
V20 e20 s20 DC 0 AC 27e0 180
RI20 e20 15 82e-2
VS21 7 s21 0
L21 s21 9 10e-5
VS22 14 s22 0
V22 e22 s22 DC 0 AC 33e1 180
RI22 e22 16 22e-2
VS23 18 s23 0
V23 e23 s23 DC 0 AC 39e0 120
RI23 e23 10 47e-3
VS24 8 s24 0
R24 s24 1 82e0
VS25 2 s25 0
C25 s25 6 68e-5
VS26 20 s26 0
R26 s26 0 10e-2
VS27 19 s27 0
V27 e27 s27 DC 0 AC 12e-1 180
RI27 e27 m27 18e-3
LI27 m27 2 82e-5
VS28 4 s28 0
L28 s28 21 22e-5
VS29 2 s29 0
R29 s29 10 22e1
VS30 12 s30 0
V30 e30 s30 DC 0 AC 39e-1 120
RI30 e30 18 27e-2
VS31 18 s31 0
R31 s31 0 82e3
VS32 19 s32 0
R32 s32 11 33e0
VS33 9 s33 0
L33 s33 8 39e-5
VS34 5 s34 0
L34 s34 14 15e-2
VS35 19 s35 0
L35 s35 17 56e-2
VS36 8 s36 0
L36 s36 7 39e-3
VS37 15 s37 0
V37 e37 s37 DC 0 AC 39e1 0
RI37 e37 m37 22e-3
LI37 m37 21 39e-5
VS38 10 s38 0
R38 s38 3 56e-1
VS39 6 s39 0
L39 s39 21 27e-5
VS40 13 s40 0
C40 s40 11 12e-7
VS41 6 s41 0
L41 s41 20 15e-5
VS42 19 s42 0
R42 s42 12 47e1
.control
set numdgt=17
ac lin 1 60 60
print v(1) v(2) v(3) v(4) v(5) v(6) v(7) v(8) v(9) v(10)
print v(11) v(12) v(13) v(14) v(15) v(16) v(17) v(18) v(19) v(20)
print v(21)
print i(vs0) i(vs1) i(vs2) i(vs3) i(vs4) i(vs5) i(vs6) i(vs7) i(vs8) i(vs9)
print i(vs10) i(vs11) i(vs12) i(vs13) i(vs14) i(vs15) i(vs16) i(vs17) i(vs18) i(vs19)
print i(vs20) i(vs21) i(vs22) i(vs23) i(vs24) i(vs25) i(vs26) i(vs27) i(vs28) i(vs29)
print i(vs30) i(vs31) i(vs32) i(vs33) i(vs34) i(vs35) i(vs36) i(vs37) i(vs38) i(vs39)
print i(vs40) i(vs41) i(vs42)
.endc
.end
