controls oracle ac-0231
* Generated (plan F2.7, ADR 0012): do not edit; regenerate with `pnpm sim oracle regen`. ac seed 20261031 index 231 nodes 22 elements 31
.options sparse gmin=1e-12 noopac
RG1 1 0 1000000000000
RG2 2 0 1000000000000
RG3 3 0 1000000000000
RG4 4 0 1000000000000
RG5 5 0 1000000000000
RG6 6 0 1000000000000
RG7 7 0 1000000000000
RG8 8 0 1000000000000
RG9 9 0 1000000000000
RG10 10 0 1000000000000
RG11 11 0 1000000000000
RG12 12 0 1000000000000
RG13 13 0 1000000000000
RG14 14 0 1000000000000
RG15 15 0 1000000000000
RG16 16 0 1000000000000
RG17 17 0 1000000000000
RG18 18 0 1000000000000
RG19 19 0 1000000000000
RG20 20 0 1000000000000
RG21 21 0 1000000000000
VS0 17 s0 0
C0 s0 6 12e-7
VS1 10 s1 0
L1 s1 2 22e-5
VS2 0 s2 0
V2 e2 s2 DC 0 AC 47e0 -120
RI2 e2 m2 68e-1
LI2 m2 21 33e-7
VS3 12 s3 0
R3 s3 11 22e1
VS4 9 s4 0
R4 s4 0 12e2
VS5 10 s5 0
L5 s5 3 12e-4
VS6 4 s6 0
V6 e6 s6 DC 0 AC 39e-1 -120
RI6 e6 m6 22e-1
LI6 m6 8 68e-7
VS7 8 s7 0
V7 e7 s7 DC 0 AC 56e-1 -120
RI7 e7 3 82e-1
VS8 12 s8 0
V8 e8 s8 DC 0 AC 39e-1 120
RI8 e8 18 27e-2
VS9 6 s9 0
L9 s9 16 22e-2
VS10 2 s10 0
R10 s10 0 33e-1
VS11 18 s11 0
C11 s11 17 15e-4
VS12 3 s12 0
L12 s12 13 27e-5
VS13 17 s13 0
V13 e13 s13 DC 0 AC 18e-1 0
RI13 e13 5 39e-2
VS14 12 s14 0
L14 s14 0 68e-4
VS15 14 s15 0
V15 e15 s15 DC 0 AC 22e0 -120
RI15 e15 13 56e-2
VS16 4 s16 0
L16 s16 9 22e-3
VS17 20 s17 0
V17 e17 s17 DC 0 AC 56e0 0
RI17 e17 18 18e-1
VS18 4 s18 0
R18 s18 19 68e2
VS19 17 s19 0
L19 s19 5 12e-2
VS20 16 s20 0
C20 s20 20 10e-6
VS21 21 s21 0
L21 s21 7 47e-3
VS22 10 s22 0
L22 s22 18 39e-3
VS23 8 s23 0
V23 e23 s23 DC 0 AC 47e-1 0
RI23 e23 m23 56e-1
LI23 m23 1 56e-6
VS24 7 s24 0
V24 e24 s24 DC 0 AC 12e-1 180
RI24 e24 10 18e-3
VS25 14 s25 0
L25 s25 15 82e-5
VS26 1 s26 0
R26 s26 12 22e-2
VS27 19 s27 0
R27 s27 6 56e1
VS28 11 s28 0
R28 s28 20 12e0
VS29 20 s29 0
V29 e29 s29 DC 0 AC 47e-1 0
RI29 e29 15 10e-3
VS30 5 s30 0
L30 s30 13 15e-5
.control
set numdgt=17
ac lin 1 60 60
print v(1) v(2) v(3) v(4) v(5) v(6) v(7) v(8) v(9) v(10)
print v(11) v(12) v(13) v(14) v(15) v(16) v(17) v(18) v(19) v(20)
print v(21)
print i(vs0) i(vs1) i(vs2) i(vs3) i(vs4) i(vs5) i(vs6) i(vs7) i(vs8) i(vs9)
print i(vs10) i(vs11) i(vs12) i(vs13) i(vs14) i(vs15) i(vs16) i(vs17) i(vs18) i(vs19)
print i(vs20) i(vs21) i(vs22) i(vs23) i(vs24) i(vs25) i(vs26) i(vs27) i(vs28) i(vs29)
print i(vs30)
.endc
.end
