controls oracle ac-0479
* Generated (plan F2.7, ADR 0012): do not edit; regenerate with `pnpm sim oracle regen`. ac seed 20261031 index 479 nodes 9 elements 17
.options sparse gmin=1e-12 noopac
RG1 1 0 1000000000000
RG2 2 0 1000000000000
RG3 3 0 1000000000000
RG4 4 0 1000000000000
RG5 5 0 1000000000000
RG6 6 0 1000000000000
RG7 7 0 1000000000000
RG8 8 0 1000000000000
VS0 6 s0 0
C0 s0 3 56e-6
VS1 5 s1 0
L1 s1 8 12e-2
VS2 0 s2 0
V2 e2 s2 DC 0 AC 33e-1 120
RI2 e2 m2 56e-3
LI2 m2 8 15e-6
VS3 7 s3 0
C3 s3 1 56e-4
VS4 3 s4 0
L4 s4 7 39e-5
VS5 2 s5 0
V5 e5 s5 DC 0 AC 47e1 120
RI5 e5 m5 82e-3
LI5 m5 0 10e-6
VS6 6 s6 0
L6 s6 4 68e-5
VS7 0 s7 0
V7 e7 s7 DC 0 AC 33e1 -120
RI7 e7 5 15e-1
VS8 4 s8 0
R8 s8 3 33e3
VS9 8 s9 0
R9 s9 7 68e0
VS10 1 s10 0
C10 s10 5 10e-6
VS11 3 s11 0
R11 s11 2 56e0
VS12 2 s12 0
R12 s12 3 22e-1
VS13 7 s13 0
C13 s13 4 39e-4
VS14 1 s14 0
R14 s14 4 33e-1
VS15 5 s15 0
R15 s15 8 33e2
VS16 4 s16 0
R16 s16 0 27e3
.control
set numdgt=17
ac lin 1 60 60
print v(1) v(2) v(3) v(4) v(5) v(6) v(7) v(8)
print i(vs0) i(vs1) i(vs2) i(vs3) i(vs4) i(vs5) i(vs6) i(vs7) i(vs8) i(vs9)
print i(vs10) i(vs11) i(vs12) i(vs13) i(vs14) i(vs15) i(vs16)
.endc
.end
