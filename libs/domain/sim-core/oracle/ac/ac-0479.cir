controls oracle ac-0479
* Generated (plan F2.7, ADR 0012): do not edit; regenerate with `pnpm sim oracle regen`. ac seed 20261031 index 479 nodes 9 elements 13
.options sparse gmin=1e-12 noopac
RG1 1 0 1000000000000
RG2 2 0 1000000000000
RG3 3 0 1000000000000
RG4 4 0 1000000000000
RG5 5 0 1000000000000
RG6 6 0 1000000000000
RG7 7 0 1000000000000
RG8 8 0 1000000000000
VS0 0 s0 0
V0 e0 s0 DC 0 AC 47e1 120
RI0 e0 3 82e-3
VS1 4 s1 0
R1 s1 8 12e2
VS2 5 s2 0
L2 s2 3 39e-2
VS3 6 s3 0
L3 s3 0 10e-3
VS4 2 s4 0
C4 s4 1 10e-7
VS5 8 s5 0
R5 s5 7 68e0
VS6 2 s6 0
L6 s6 7 39e-5
VS7 4 s7 0
R7 s7 2 33e3
VS8 5 s8 0
R8 s8 2 12e-1
VS9 2 s9 0
R9 s9 0 56e0
VS10 7 s10 0
C10 s10 1 56e-4
VS11 6 s11 0
V11 e11 s11 DC 0 AC 15e1 0
RI11 e11 8 33e-3
VS12 3 s12 0
L12 s12 7 68e-5
.control
set numdgt=17
ac lin 1 60 60
print v(1) v(2) v(3) v(4) v(5) v(6) v(7) v(8)
print i(vs0) i(vs1) i(vs2) i(vs3) i(vs4) i(vs5) i(vs6) i(vs7) i(vs8) i(vs9)
print i(vs10) i(vs11) i(vs12)
.endc
.end
