controls oracle ac-0479
* Generated (plan F2.7, ADR 0012): do not edit; regenerate with `pnpm sim oracle regen`. ac seed 20261031 index 479 nodes 9 elements 10
.options sparse gmin=1e-12 noopac
RG1 1 0 1000000000000
RG2 2 0 1000000000000
RG3 3 0 1000000000000
RG4 4 0 1000000000000
RG5 5 0 1000000000000
RG6 6 0 1000000000000
RG7 7 0 1000000000000
RG8 8 0 1000000000000
VS0 6 s0 0
L0 s0 0 10e-3
VS1 2 s1 0
L1 s1 7 39e-5
VS2 0 s2 0
V2 e2 s2 DC 0 AC 47e1 120
RI2 e2 3 82e-3
VS3 4 s3 0
R3 s3 2 33e3
VS4 8 s4 0
R4 s4 7 68e0
VS5 0 s5 0
R5 s5 3 39e1
VS6 7 s6 0
C6 s6 1 56e-4
VS7 2 s7 0
C7 s7 1 10e-7
VS8 2 s8 0
R8 s8 0 56e0
VS9 5 s9 0
R9 s9 2 12e-1
.control
set numdgt=17
ac lin 1 60 60
print v(1) v(2) v(3) v(4) v(5) v(6) v(7) v(8)
print i(vs0) i(vs1) i(vs2) i(vs3) i(vs4) i(vs5) i(vs6) i(vs7) i(vs8) i(vs9)
.endc
.end
