controls oracle ac-0099
* Generated (plan F2.7, ADR 0012): do not edit; regenerate with `pnpm sim oracle regen`. ac seed 20261031 index 99 nodes 13 elements 21
.options sparse gmin=1e-12 noopac
RG1 1 0 1000000000000
RG2 2 0 1000000000000
RG3 3 0 1000000000000
RG4 4 0 1000000000000
RG5 5 0 1000000000000
RG6 6 0 1000000000000
RG7 7 0 1000000000000
RG8 8 0 1000000000000
RG9 9 0 1000000000000
RG10 10 0 1000000000000
RG11 11 0 1000000000000
RG12 12 0 1000000000000
VS0 6 s0 0
R0 s0 4 56e-2
VS1 3 s1 0
R1 s1 6 47e3
VS2 9 s2 0
C2 s2 7 56e-4
VS3 3 s3 0
R3 s3 5 22e-2
VS4 0 s4 0
V4 e4 s4 DC 0 AC 39e-1 120
RI4 e4 10 47e-1
VS5 12 s5 0
R5 s5 4 15e0
VS6 8 s6 0
R6 s6 9 15e-1
VS7 1 s7 0
C7 s7 11 33e-4
VS8 9 s8 0
R8 s8 0 18e2
VS9 9 s9 0
R9 s9 5 68e-2
VS10 2 s10 0
C10 s10 12 56e-6
VS11 11 s11 0
C11 s11 1 22e-6
VS12 11 s12 0
L12 s12 2 18e-4
VS13 9 s13 0
L13 s13 11 39e-3
VS14 1 s14 0
R14 s14 0 56e2
VS15 8 s15 0
C15 s15 4 82e-4
VS16 1 s16 0
L16 s16 6 82e-5
VS17 4 s17 0
C17 s17 9 12e-6
VS18 4 s18 0
V18 e18 s18 DC 0 AC 39e-1 180
RI18 e18 10 68e-3
VS19 1 s19 0
C19 s19 7 12e-6
VS20 12 s20 0
L20 s20 1 27e-5
.control
set numdgt=17
ac lin 1 60 60
print v(1) v(2) v(3) v(4) v(5) v(6) v(7) v(8) v(9) v(10)
print v(11) v(12)
print i(vs0) i(vs1) i(vs2) i(vs3) i(vs4) i(vs5) i(vs6) i(vs7) i(vs8) i(vs9)
print i(vs10) i(vs11) i(vs12) i(vs13) i(vs14) i(vs15) i(vs16) i(vs17) i(vs18) i(vs19)
print i(vs20)
.endc
.end
