controls oracle ac-0099
* Generated (plan F2.7, ADR 0012): do not edit; regenerate with `pnpm sim oracle regen`. ac seed 20261031 index 99 nodes 13 elements 23
.options sparse gmin=1e-12 noopac
RG1 1 0 1000000000000
RG2 2 0 1000000000000
RG3 3 0 1000000000000
RG4 4 0 1000000000000
RG5 5 0 1000000000000
RG6 6 0 1000000000000
RG7 7 0 1000000000000
RG8 8 0 1000000000000
RG9 9 0 1000000000000
RG10 10 0 1000000000000
RG11 11 0 1000000000000
RG12 12 0 1000000000000
VS0 6 s0 0
R0 s0 4 56e-2
VS1 0 s1 0
V1 e1 s1 DC 0 AC 12e1 0
RI1 e1 8 56e-3
VS2 4 s2 0
C2 s2 9 12e-6
VS3 9 s3 0
R3 s3 3 18e1
VS4 8 s4 0
R4 s4 9 15e-1
VS5 11 s5 0
R5 s5 9 10e-1
VS6 9 s6 0
C6 s6 7 56e-4
VS7 3 s7 0
V7 e7 s7 DC 0 AC 39e-1 0
RI7 e7 6 47e-1
VS8 9 s8 0
L8 s8 11 39e-3
VS9 3 s9 0
R9 s9 5 22e-2
VS10 12 s10 0
V10 e10 s10 DC 0 AC 82e1 180
RI10 e10 11 39e-1
VS11 9 s11 0
R11 s11 5 68e-2
VS12 0 s12 0
C12 s12 5 12e-6
VS13 6 s13 0
R13 s13 0 47e-1
VS14 4 s14 0
V14 e14 s14 DC 0 AC 39e-1 180
RI14 e14 10 68e-3
VS15 1 s15 0
R15 s15 0 56e2
VS16 12 s16 0
L16 s16 1 27e-5
VS17 4 s17 0
V17 e17 s17 DC 0 AC 15e1 -120
RI17 e17 2 33e-3
VS18 1 s18 0
C18 s18 11 33e-4
VS19 2 s19 0
V19 e19 s19 DC 0 AC 15e-1 0
RI19 e19 3 18e-2
VS20 11 s20 0
L20 s20 2 18e-4
VS21 7 s21 0
V21 e21 s21 DC 0 AC 39e1 180
RI21 e21 11 68e-3
VS22 10 s22 0
V22 e22 s22 DC 0 AC 56e1 -120
RI22 e22 12 10e-2
.control
set numdgt=17
ac lin 1 60 60
print v(1) v(2) v(3) v(4) v(5) v(6) v(7) v(8) v(9) v(10)
print v(11) v(12)
print i(vs0) i(vs1) i(vs2) i(vs3) i(vs4) i(vs5) i(vs6) i(vs7) i(vs8) i(vs9)
print i(vs10) i(vs11) i(vs12) i(vs13) i(vs14) i(vs15) i(vs16) i(vs17) i(vs18) i(vs19)
print i(vs20) i(vs21) i(vs22)
.endc
.end
