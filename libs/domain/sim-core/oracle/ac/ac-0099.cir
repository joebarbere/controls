controls oracle ac-0099
* Generated (plan F2.7, ADR 0012): do not edit; regenerate with `pnpm sim oracle regen`. ac seed 20261031 index 99 nodes 13 elements 22
.options sparse gmin=1e-12 noopac
RG1 1 0 1000000000000
RG2 2 0 1000000000000
RG3 3 0 1000000000000
RG4 4 0 1000000000000
RG5 5 0 1000000000000
RG6 6 0 1000000000000
RG7 7 0 1000000000000
RG8 8 0 1000000000000
RG9 9 0 1000000000000
RG10 10 0 1000000000000
RG11 11 0 1000000000000
RG12 12 0 1000000000000
VS0 1 s0 0
R0 s0 11 56e2
VS1 11 s1 0
C1 s1 5 12e-6
VS2 4 s2 0
R2 s2 9 10e-1
VS3 6 s3 0
R3 s3 11 47e-1
VS4 6 s4 0
R4 s4 0 56e-2
VS5 0 s5 0
V5 e5 s5 DC 0 AC 39e-1 180
RI5 e5 10 68e-3
VS6 9 s6 0
L6 s6 4 39e-3
VS7 3 s7 0
V7 e7 s7 DC 0 AC 39e-1 0
RI7 e7 6 47e-1
VS8 12 s8 0
V8 e8 s8 DC 0 AC 82e1 180
RI8 e8 4 39e-1
VS9 2 s9 0
V9 e9 s9 DC 0 AC 15e-1 0
RI9 e9 3 18e-2
VS10 9 s10 0
R10 s10 5 68e-2
VS11 0 s11 0
C11 s11 9 12e-6
VS12 11 s12 0
V12 e12 s12 DC 0 AC 12e1 0
RI12 e12 8 56e-3
VS13 8 s13 0
R13 s13 9 15e-1
VS14 12 s14 0
L14 s14 1 27e-5
VS15 10 s15 0
V15 e15 s15 DC 0 AC 56e1 -120
RI15 e15 12 10e-2
VS16 9 s16 0
C16 s16 7 56e-4
VS17 0 s17 0
V17 e17 s17 DC 0 AC 15e1 -120
RI17 e17 2 33e-3
VS18 3 s18 0
R18 s18 5 22e-2
VS19 1 s19 0
C19 s19 4 33e-4
VS20 4 s20 0
L20 s20 2 18e-4
VS21 9 s21 0
R21 s21 3 18e1
.control
set numdgt=17
ac lin 1 60 60
print v(1) v(2) v(3) v(4) v(5) v(6) v(7) v(8) v(9) v(10)
print v(11) v(12)
print i(vs0) i(vs1) i(vs2) i(vs3) i(vs4) i(vs5) i(vs6) i(vs7) i(vs8) i(vs9)
print i(vs10) i(vs11) i(vs12) i(vs13) i(vs14) i(vs15) i(vs16) i(vs17) i(vs18) i(vs19)
print i(vs20) i(vs21)
.endc
.end
