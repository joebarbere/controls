controls oracle ac-0308
* Generated (plan F2.7, ADR 0012): do not edit; regenerate with `pnpm sim oracle regen`. ac seed 20261031 index 308 nodes 7 elements 12
.options sparse gmin=1e-12 noopac
RG1 1 0 1000000000000
RG2 2 0 1000000000000
RG3 3 0 1000000000000
RG4 4 0 1000000000000
RG5 5 0 1000000000000
RG6 6 0 1000000000000
VS0 4 s0 0
C0 s0 0 10e-6
VS1 4 s1 0
R1 s1 0 15e-1
VS2 0 s2 0
V2 e2 s2 DC 0 AC 27e0 180
RI2 e2 m2 47e-1
LI2 m2 5 18e-6
VS3 2 s3 0
C3 s3 1 15e-6
VS4 0 s4 0
R4 s4 1 27e2
VS5 2 s5 0
R5 s5 0 68e1
VS6 6 s6 0
C6 s6 0 33e-6
VS7 0 s7 0
R7 s7 3 39e1
VS8 4 s8 0
R8 s8 6 47e1
VS9 3 s9 0
L9 s9 2 12e-5
VS10 5 s10 0
R10 s10 4 39e3
VS11 5 s11 0
V11 e11 s11 DC 0 AC 82e1 0
RI11 e11 1 56e-2
.control
set numdgt=17
ac lin 1 60 60
print v(1) v(2) v(3) v(4) v(5) v(6)
print i(vs0) i(vs1) i(vs2) i(vs3) i(vs4) i(vs5) i(vs6) i(vs7) i(vs8) i(vs9)
print i(vs10) i(vs11)
.endc
.end
