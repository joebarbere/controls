controls oracle ac-0308
* Generated (plan F2.7, ADR 0012): do not edit; regenerate with `pnpm sim oracle regen`. ac seed 20261031 index 308 nodes 7 elements 11
.options sparse gmin=1e-12 noopac
RG1 1 0 1000000000000
RG2 2 0 1000000000000
RG3 3 0 1000000000000
RG4 4 0 1000000000000
RG5 5 0 1000000000000
RG6 6 0 1000000000000
VS0 1 s0 0
C0 s0 6 22e-6
VS1 5 s1 0
R1 s1 4 39e3
VS2 2 s2 0
R2 s2 1 33e1
VS3 0 s3 0
R3 s3 1 27e2
VS4 0 s4 0
V4 e4 s4 DC 0 AC 27e0 180
RI4 e4 5 47e-1
VS5 0 s5 0
V5 e5 s5 DC 0 AC 56e0 120
RI5 e5 m5 12e-2
LI5 m5 2 12e-6
VS6 1 s6 0
R6 s6 0 15e-2
VS7 3 s7 0
L7 s7 2 12e-5
VS8 4 s8 0
R8 s8 6 47e1
VS9 0 s9 0
R9 s9 3 39e1
VS10 4 s10 0
C10 s10 0 10e-6
.control
set numdgt=17
ac lin 1 60 60
print v(1) v(2) v(3) v(4) v(5) v(6)
print i(vs0) i(vs1) i(vs2) i(vs3) i(vs4) i(vs5) i(vs6) i(vs7) i(vs8) i(vs9)
print i(vs10)
.endc
.end
