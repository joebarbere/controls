controls oracle ac-0308
* Generated (plan F2.7, ADR 0012): do not edit; regenerate with `pnpm sim oracle regen`. ac seed 20261031 index 308 nodes 7 elements 8
.options sparse gmin=1e-12 noopac
RG1 1 0 1000000000000
RG2 2 0 1000000000000
RG3 3 0 1000000000000
RG4 4 0 1000000000000
RG5 5 0 1000000000000
RG6 6 0 1000000000000
VS0 3 s0 0
L0 s0 2 12e-5
VS1 0 s1 0
V1 e1 s1 DC 0 AC 27e0 180
RI1 e1 5 47e-1
VS2 5 s2 0
R2 s2 4 39e3
VS3 4 s3 0
C3 s3 0 10e-6
VS4 4 s4 0
R4 s4 6 47e1
VS5 1 s5 0
R5 s5 0 15e-2
VS6 0 s6 0
R6 s6 3 39e1
VS7 0 s7 0
R7 s7 1 27e2
.control
set numdgt=17
ac lin 1 60 60
print v(1) v(2) v(3) v(4) v(5) v(6)
print i(vs0) i(vs1) i(vs2) i(vs3) i(vs4) i(vs5) i(vs6) i(vs7)
.endc
.end
