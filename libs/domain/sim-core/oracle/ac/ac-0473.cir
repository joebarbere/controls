controls oracle ac-0473
* Generated (plan F2.7, ADR 0012): do not edit; regenerate with `pnpm sim oracle regen`. ac seed 20261031 index 473 nodes 28 elements 48
.options sparse gmin=1e-12 noopac
RG1 1 0 1000000000000
RG2 2 0 1000000000000
RG3 3 0 1000000000000
RG4 4 0 1000000000000
RG5 5 0 1000000000000
RG6 6 0 1000000000000
RG7 7 0 1000000000000
RG8 8 0 1000000000000
RG9 9 0 1000000000000
RG10 10 0 1000000000000
RG11 11 0 1000000000000
RG12 12 0 1000000000000
RG13 13 0 1000000000000
RG14 14 0 1000000000000
RG15 15 0 1000000000000
RG16 16 0 1000000000000
RG17 17 0 1000000000000
RG18 18 0 1000000000000
RG19 19 0 1000000000000
RG20 20 0 1000000000000
RG21 21 0 1000000000000
RG22 22 0 1000000000000
RG23 23 0 1000000000000
RG24 24 0 1000000000000
RG25 25 0 1000000000000
RG26 26 0 1000000000000
RG27 27 0 1000000000000
VS0 24 s0 0
C0 s0 18 18e-4
VS1 0 s1 0
V1 e1 s1 DC 0 AC 12e-1 120
RI1 e1 19 82e-3
VS2 23 s2 0
R2 s2 19 18e0
VS3 21 s3 0
L3 s3 1 39e-2
VS4 25 s4 0
R4 s4 5 18e0
VS5 26 s5 0
R5 s5 5 22e-2
VS6 25 s6 0
L6 s6 12 22e-4
VS7 20 s7 0
L7 s7 11 10e-2
VS8 9 s8 0
R8 s8 0 15e-1
VS9 6 s9 0
R9 s9 25 27e0
VS10 2 s10 0
L10 s10 9 56e-2
VS11 10 s11 0
R11 s11 12 18e2
VS12 12 s12 0
V12 e12 s12 DC 0 AC 15e-1 -120
RI12 e12 m12 18e-1
LI12 m12 4 47e-6
VS13 18 s13 0
R13 s13 4 12e1
VS14 9 s14 0
V14 e14 s14 DC 0 AC 47e-1 -120
RI14 e14 m14 27e-1
LI14 m14 1 39e-7
VS15 8 s15 0
R15 s15 16 10e0
VS16 23 s16 0
L16 s16 6 82e-3
VS17 21 s17 0
C17 s17 5 33e-5
VS18 3 s18 0
V18 e18 s18 DC 0 AC 12e1 180
RI18 e18 m18 82e-1
LI18 m18 15 47e-7
VS19 15 s19 0
C19 s19 1 18e-6
VS20 15 s20 0
V20 e20 s20 DC 0 AC 56e1 -120
RI20 e20 m20 15e-3
LI20 m20 11 68e-6
VS21 3 s21 0
R21 s21 7 68e-1
VS22 5 s22 0
R22 s22 13 47e-1
VS23 22 s23 0
R23 s23 19 33e1
VS24 24 s24 0
L24 s24 4 27e-4
VS25 16 s25 0
C25 s25 10 15e-6
VS26 15 s26 0
C26 s26 17 82e-4
VS27 25 s27 0
V27 e27 s27 DC 0 AC 39e-1 180
RI27 e27 m27 12e-2
LI27 m27 14 82e-6
VS28 20 s28 0
V28 e28 s28 DC 0 AC 56e-1 -120
RI28 e28 m28 15e-1
LI28 m28 24 33e-7
VS29 4 s29 0
C29 s29 25 22e-5
VS30 26 s30 0
L30 s30 17 10e-2
VS31 17 s31 0
L31 s31 2 39e-3
VS32 13 s32 0
V32 e32 s32 DC 0 AC 12e0 -120
RI32 e32 19 47e-2
VS33 23 s33 0
R33 s33 2 27e1
VS34 13 s34 0
V34 e34 s34 DC 0 AC 15e0 120
RI34 e34 10 47e-1
VS35 14 s35 0
L35 s35 22 10e-2
VS36 18 s36 0
R36 s36 16 56e2
VS37 11 s37 0
C37 s37 24 39e-5
VS38 13 s38 0
L38 s38 27 33e-3
VS39 19 s39 0
R39 s39 11 22e-2
VS40 23 s40 0
V40 e40 s40 DC 0 AC 68e-1 120
RI40 e40 m40 12e-3
LI40 m40 27 27e-7
VS41 8 s41 0
C41 s41 7 27e-7
VS42 18 s42 0
C42 s42 11 68e-5
VS43 16 s43 0
C43 s43 1 82e-4
VS44 21 s44 0
R44 s44 3 39e0
VS45 12 s45 0
L45 s45 5 56e-3
VS46 19 s46 0
C46 s46 1 82e-7
VS47 26 s47 0
R47 s47 18 68e0
.control
set numdgt=17
ac lin 1 60 60
print v(1) v(2) v(3) v(4) v(5) v(6) v(7) v(8) v(9) v(10)
print v(11) v(12) v(13) v(14) v(15) v(16) v(17) v(18) v(19) v(20)
print v(21) v(22) v(23) v(24) v(25) v(26) v(27)
print i(vs0) i(vs1) i(vs2) i(vs3) i(vs4) i(vs5) i(vs6) i(vs7) i(vs8) i(vs9)
print i(vs10) i(vs11) i(vs12) i(vs13) i(vs14) i(vs15) i(vs16) i(vs17) i(vs18) i(vs19)
print i(vs20) i(vs21) i(vs22) i(vs23) i(vs24) i(vs25) i(vs26) i(vs27) i(vs28) i(vs29)
print i(vs30) i(vs31) i(vs32) i(vs33) i(vs34) i(vs35) i(vs36) i(vs37) i(vs38) i(vs39)
print i(vs40) i(vs41) i(vs42) i(vs43) i(vs44) i(vs45) i(vs46) i(vs47)
.endc
.end
