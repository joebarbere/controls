controls oracle ac-0473
* Generated (plan F2.7, ADR 0012): do not edit; regenerate with `pnpm sim oracle regen`. ac seed 20261031 index 473 nodes 28 elements 57
.options sparse gmin=1e-12 noopac
RG1 1 0 1000000000000
RG2 2 0 1000000000000
RG3 3 0 1000000000000
RG4 4 0 1000000000000
RG5 5 0 1000000000000
RG6 6 0 1000000000000
RG7 7 0 1000000000000
RG8 8 0 1000000000000
RG9 9 0 1000000000000
RG10 10 0 1000000000000
RG11 11 0 1000000000000
RG12 12 0 1000000000000
RG13 13 0 1000000000000
RG14 14 0 1000000000000
RG15 15 0 1000000000000
RG16 16 0 1000000000000
RG17 17 0 1000000000000
RG18 18 0 1000000000000
RG19 19 0 1000000000000
RG20 20 0 1000000000000
RG21 21 0 1000000000000
RG22 22 0 1000000000000
RG23 23 0 1000000000000
RG24 24 0 1000000000000
RG25 25 0 1000000000000
RG26 26 0 1000000000000
RG27 27 0 1000000000000
VS0 25 s0 0
L0 s0 4 10e-2
VS1 7 s1 0
L1 s1 9 33e-5
VS2 0 s2 0
V2 e2 s2 DC 0 AC 68e1 120
RI2 e2 n2 47e-3
H2 n2 h2 VS5 -68e-4
ED2 h2 13 d2 0 -18e-5
F2 0 d2 VS5 1
LD2 d2 0 1
VS3 17 s3 0
L3 s3 12 12e-2
VS4 20 s4 0
R4 s4 25 12e0
VS5 24 s5 0
V5 e5 s5 DC 0 AC 12e-1 -120
RI5 e5 m5 18e-1
LI5 m5 n5 12e-7
H5 n5 h5 VS2 -68e-4
ED5 h5 19 d5 0 -18e-5
F5 0 d5 VS2 1
LD5 d5 0 1
VS6 21 s6 0
C6 s6 5 33e-5
VS7 13 s7 0
C7 s7 9 39e-5
VS8 20 s8 0
V8 e8 s8 DC 0 AC 10e0 0
RI8 e8 m8 82e-1
LI8 m8 5 39e-6
VS9 7 s9 0
V9 e9 s9 DC 0 AC 47e-1 -120
RI9 e9 m9 27e-1
LI9 m9 9 27e-6
VS10 17 s10 0
V10 e10 s10 DC 0 AC 33e-1 180
RI10 e10 m10 56e-1
LI10 m10 25 39e-6
VS11 13 s11 0
L11 s11 0 15e-5
VS12 26 s12 0
R12 s12 18 68e0
VS13 15 s13 0
R13 s13 12 18e-1
VS14 21 s14 0
C14 s14 0 39e-6
VS15 15 s15 0
C15 s15 17 82e-4
VS16 5 s16 0
R16 s16 13 47e-1
VS17 23 s17 0
L17 s17 12 82e-4
VS18 13 s18 0
V18 e18 s18 DC 0 AC 12e0 -120
RI18 e18 m18 47e-2
LI18 m18 19 27e-7
VS19 5 s19 0
R19 s19 15 27e0
VS20 22 s20 0
R20 s20 18 18e-2
VS21 11 s21 0
R21 s21 4 47e2
VS22 23 s22 0
R22 s22 2 27e1
VS23 15 s23 0
L23 s23 13 18e-4
VS24 27 s24 0
V24 e24 s24 DC 0 AC 12e-1 120
RI24 e24 7 82e-3
VS25 21 s25 0
R25 s25 3 39e0
VS26 6 s26 0
C26 s26 27 15e-5
VS27 17 s27 0
L27 s27 7 10e-2
VS28 22 s28 0
R28 s28 5 56e-2
VS29 12 s29 0
R29 s29 1 56e0
VS30 11 s30 0
L30 s30 25 10e-4
VS31 2 s31 0
V31 e31 s31 DC 0 AC 56e-1 0
RI31 e31 m31 68e-2
LI31 m31 12 47e-7
VS32 24 s32 0
C32 s32 18 18e-4
VS33 19 s33 0
C33 s33 2 18e-5
VS34 16 s34 0
R34 s34 17 15e-2
VS35 18 s35 0
R35 s35 14 27e0
VS36 20 s36 0
R36 s36 6 18e-1
VS37 6 s37 0
R37 s37 2 68e-1
VS38 4 s38 0
R38 s38 5 18e0
VS39 8 s39 0
C39 s39 23 18e-4
VS40 3 s40 0
C40 s40 26 12e-6
VS41 26 s41 0
R41 s41 4 56e2
VS42 10 s42 0
C42 s42 2 68e-6
VS43 24 s43 0
L43 s43 16 18e-4
VS44 14 s44 0
V44 e44 s44 DC 0 AC 39e-1 180
RI44 e44 m44 12e-2
LI44 m44 26 56e-7
VS45 16 s45 0
R45 s45 18 47e2
VS46 20 s46 0
L46 s46 24 15e-3
VS47 17 s47 0
R47 s47 1 10e0
VS48 6 s48 0
C48 s48 27 33e-4
VS49 0 s49 0
R49 s49 12 18e2
VS50 6 s50 0
L50 s50 23 56e-2
VS51 17 s51 0
L51 s51 2 39e-3
VS52 10 s52 0
C52 s52 7 82e-7
VS53 3 s53 0
L53 s53 8 10e-3
VS54 14 s54 0
C54 s54 16 15e-6
VS55 24 s55 0
C55 s55 10 82e-7
VS56 25 s56 0
R56 s56 13 22e2
.control
set numdgt=17
ac lin 1 60 60
print v(1) v(2) v(3) v(4) v(5) v(6) v(7) v(8) v(9) v(10)
print v(11) v(12) v(13) v(14) v(15) v(16) v(17) v(18) v(19) v(20)
print v(21) v(22) v(23) v(24) v(25) v(26) v(27)
print i(vs0) i(vs1) i(vs2) i(vs3) i(vs4) i(vs5) i(vs6) i(vs7) i(vs8) i(vs9)
print i(vs10) i(vs11) i(vs12) i(vs13) i(vs14) i(vs15) i(vs16) i(vs17) i(vs18) i(vs19)
print i(vs20) i(vs21) i(vs22) i(vs23) i(vs24) i(vs25) i(vs26) i(vs27) i(vs28) i(vs29)
print i(vs30) i(vs31) i(vs32) i(vs33) i(vs34) i(vs35) i(vs36) i(vs37) i(vs38) i(vs39)
print i(vs40) i(vs41) i(vs42) i(vs43) i(vs44) i(vs45) i(vs46) i(vs47) i(vs48) i(vs49)
print i(vs50) i(vs51) i(vs52) i(vs53) i(vs54) i(vs55) i(vs56)
.endc
.end
