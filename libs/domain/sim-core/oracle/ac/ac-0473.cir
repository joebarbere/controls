controls oracle ac-0473
* Generated (plan F2.7, ADR 0012): do not edit; regenerate with `pnpm sim oracle regen`. ac seed 20261031 index 473 nodes 28 elements 55
.options sparse gmin=1e-12 noopac
RG1 1 0 1000000000000
RG2 2 0 1000000000000
RG3 3 0 1000000000000
RG4 4 0 1000000000000
RG5 5 0 1000000000000
RG6 6 0 1000000000000
RG7 7 0 1000000000000
RG8 8 0 1000000000000
RG9 9 0 1000000000000
RG10 10 0 1000000000000
RG11 11 0 1000000000000
RG12 12 0 1000000000000
RG13 13 0 1000000000000
RG14 14 0 1000000000000
RG15 15 0 1000000000000
RG16 16 0 1000000000000
RG17 17 0 1000000000000
RG18 18 0 1000000000000
RG19 19 0 1000000000000
RG20 20 0 1000000000000
RG21 21 0 1000000000000
RG22 22 0 1000000000000
RG23 23 0 1000000000000
RG24 24 0 1000000000000
RG25 25 0 1000000000000
RG26 26 0 1000000000000
RG27 27 0 1000000000000
VS0 8 s0 0
C0 s0 23 18e-4
VS1 16 s1 0
R1 s1 17 15e-2
VS2 17 s2 0
L2 s2 2 39e-3
VS3 26 s3 0
R3 s3 18 68e0
VS4 24 s4 0
L4 s4 16 18e-4
VS5 20 s5 0
R5 s5 6 18e-1
VS6 17 s6 0
L6 s6 7 10e-2
VS7 10 s7 0
C7 s7 2 68e-6
VS8 0 s8 0
C8 s8 9 39e-5
VS9 11 s9 0
R9 s9 13 47e2
VS10 0 s10 0
V10 e10 s10 DC 0 AC 12e0 -120
RI10 e10 19 47e-2
VS11 6 s11 0
L11 s11 23 56e-2
VS12 14 s12 0
V12 e12 s12 DC 0 AC 39e-1 180
RI12 e12 26 12e-2
VS13 25 s13 0
R13 s13 0 22e2
VS14 22 s14 0
R14 s14 5 56e-2
VS15 24 s15 0
C15 s15 10 82e-7
VS16 0 s16 0
L16 s16 4 15e-5
VS17 18 s17 0
R17 s17 14 27e0
VS18 15 s18 0
L18 s18 0 18e-4
VS19 6 s19 0
C19 s19 27 33e-4
VS20 21 s20 0
R20 s20 3 39e0
VS21 23 s21 0
L21 s21 12 82e-4
VS22 19 s22 0
C22 s22 2 18e-5
VS23 15 s23 0
C23 s23 17 82e-4
VS24 21 s24 0
C24 s24 4 39e-6
VS25 12 s25 0
R25 s25 1 56e0
VS26 17 s26 0
L26 s26 12 12e-2
VS27 26 s27 0
R27 s27 13 56e2
VS28 21 s28 0
C28 s28 5 33e-5
VS29 5 s29 0
R29 s29 0 47e-1
VS30 3 s30 0
C30 s30 26 12e-6
VS31 17 s31 0
V31 e31 s31 DC 0 AC 33e-1 180
RI31 e31 25 56e-1
VS32 14 s32 0
C32 s32 16 15e-6
VS33 6 s33 0
C33 s33 27 15e-5
VS34 6 s34 0
R34 s34 2 68e-1
VS35 3 s35 0
L35 s35 8 10e-3
VS36 24 s36 0
V36 e36 s36 DC 0 AC 12e-1 -120
RI36 e36 19 18e-1
VS37 15 s37 0
R37 s37 12 18e-1
VS38 20 s38 0
V38 e38 s38 DC 0 AC 10e0 0
RI38 e38 5 82e-1
VS39 4 s39 0
R39 s39 12 18e2
VS40 7 s40 0
V40 e40 s40 DC 0 AC 47e-1 -120
RI40 e40 9 27e-1
VS41 4 s41 0
V41 e41 s41 DC 0 AC 68e1 120
RI41 e41 0 47e-3
VS42 25 s42 0
L42 s42 13 10e-2
VS43 5 s43 0
R43 s43 15 27e0
VS44 2 s44 0
V44 e44 s44 DC 0 AC 56e-1 0
RI44 e44 12 68e-2
VS45 11 s45 0
L45 s45 25 10e-4
VS46 27 s46 0
V46 e46 s46 DC 0 AC 12e-1 120
RI46 e46 7 82e-3
VS47 23 s47 0
R47 s47 2 27e1
VS48 20 s48 0
L48 s48 24 15e-3
VS49 16 s49 0
R49 s49 18 47e2
VS50 20 s50 0
R50 s50 25 12e0
VS51 13 s51 0
R51 s51 5 18e0
VS52 10 s52 0
C52 s52 7 82e-7
VS53 7 s53 0
L53 s53 9 33e-5
VS54 24 s54 0
C54 s54 18 18e-4
.control
set numdgt=17
ac lin 1 60 60
print v(1) v(2) v(3) v(4) v(5) v(6) v(7) v(8) v(9) v(10)
print v(11) v(12) v(13) v(14) v(15) v(16) v(17) v(18) v(19) v(20)
print v(21) v(22) v(23) v(24) v(25) v(26) v(27)
print i(vs0) i(vs1) i(vs2) i(vs3) i(vs4) i(vs5) i(vs6) i(vs7) i(vs8) i(vs9)
print i(vs10) i(vs11) i(vs12) i(vs13) i(vs14) i(vs15) i(vs16) i(vs17) i(vs18) i(vs19)
print i(vs20) i(vs21) i(vs22) i(vs23) i(vs24) i(vs25) i(vs26) i(vs27) i(vs28) i(vs29)
print i(vs30) i(vs31) i(vs32) i(vs33) i(vs34) i(vs35) i(vs36) i(vs37) i(vs38) i(vs39)
print i(vs40) i(vs41) i(vs42) i(vs43) i(vs44) i(vs45) i(vs46) i(vs47) i(vs48) i(vs49)
print i(vs50) i(vs51) i(vs52) i(vs53) i(vs54)
.endc
.end
