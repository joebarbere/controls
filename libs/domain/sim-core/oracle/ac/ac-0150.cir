controls oracle ac-0150
* Generated (plan F2.7, ADR 0012): do not edit; regenerate with `pnpm sim oracle regen`. ac seed 20261031 index 150 nodes 16 elements 30
.options sparse gmin=1e-12 noopac
RG1 1 0 1000000000000
RG2 2 0 1000000000000
RG3 3 0 1000000000000
RG4 4 0 1000000000000
RG5 5 0 1000000000000
RG6 6 0 1000000000000
RG7 7 0 1000000000000
RG8 8 0 1000000000000
RG9 9 0 1000000000000
RG10 10 0 1000000000000
RG11 11 0 1000000000000
RG12 12 0 1000000000000
RG13 13 0 1000000000000
RG14 14 0 1000000000000
RG15 15 0 1000000000000
VS0 0 s0 0
V0 e0 s0 DC 0 AC 56e-1 180
RI0 e0 14 82e-1
VS1 4 s1 0
L1 s1 5 12e-2
VS2 6 s2 0
C2 s2 5 18e-5
VS3 0 s3 0
L3 s3 13 33e-2
VS4 15 s4 0
R4 s4 9 10e0
VS5 8 s5 0
C5 s5 7 27e-7
VS6 8 s6 0
L6 s6 0 82e-5
VS7 3 s7 0
L7 s7 6 10e-2
VS8 5 s8 0
L8 s8 1 12e-5
VS9 14 s9 0
V9 e9 s9 DC 0 AC 27e-1 0
RI9 e9 m9 18e-3
LI9 m9 11 33e-5
VS10 1 s10 0
L10 s10 6 82e-4
VS11 0 s11 0
R11 s11 6 10e2
VS12 11 s12 0
R12 s12 12 27e3
VS13 1 s13 0
C13 s13 10 82e-4
VS14 14 s14 0
L14 s14 7 33e-5
VS15 1 s15 0
R15 s15 2 22e-1
VS16 7 s16 0
L16 s16 6 12e-2
VS17 4 s17 0
V17 e17 s17 DC 0 AC 47e0 0
RI17 e17 m17 18e-1
LI17 m17 0 82e-6
VS18 12 s18 0
L18 s18 9 22e-5
VS19 15 s19 0
R19 s19 10 33e2
VS20 0 s20 0
L20 s20 4 82e-3
VS21 7 s21 0
L21 s21 8 10e-3
VS22 2 s22 0
C22 s22 10 27e-4
VS23 0 s23 0
L23 s23 7 56e-5
VS24 12 s24 0
R24 s24 13 15e3
VS25 2 s25 0
R25 s25 7 47e-2
VS26 9 s26 0
L26 s26 0 12e-4
VS27 0 s27 0
V27 e27 s27 DC 0 AC 12e1 120
RI27 e27 m27 27e-1
LI27 m27 5 47e-5
VS28 11 s28 0
V28 e28 s28 DC 0 AC 27e0 180
RI28 e28 m28 47e-2
LI28 m28 3 47e-5
VS29 0 s29 0
L29 s29 13 33e-2
.control
set numdgt=17
ac lin 1 60 60
print v(1) v(2) v(3) v(4) v(5) v(6) v(7) v(8) v(9) v(10)
print v(11) v(12) v(13) v(14) v(15)
print i(vs0) i(vs1) i(vs2) i(vs3) i(vs4) i(vs5) i(vs6) i(vs7) i(vs8) i(vs9)
print i(vs10) i(vs11) i(vs12) i(vs13) i(vs14) i(vs15) i(vs16) i(vs17) i(vs18) i(vs19)
print i(vs20) i(vs21) i(vs22) i(vs23) i(vs24) i(vs25) i(vs26) i(vs27) i(vs28) i(vs29)
.endc
.end
