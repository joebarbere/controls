controls oracle ac-0150
* Generated (plan F2.7, ADR 0012): do not edit; regenerate with `pnpm sim oracle regen`. ac seed 20261031 index 150 nodes 16 elements 25
.options sparse gmin=1e-12 noopac
RG1 1 0 1000000000000
RG2 2 0 1000000000000
RG3 3 0 1000000000000
RG4 4 0 1000000000000
RG5 5 0 1000000000000
RG6 6 0 1000000000000
RG7 7 0 1000000000000
RG8 8 0 1000000000000
RG9 9 0 1000000000000
RG10 10 0 1000000000000
RG11 11 0 1000000000000
RG12 12 0 1000000000000
RG13 13 0 1000000000000
RG14 14 0 1000000000000
RG15 15 0 1000000000000
VS0 6 s0 0
R0 s0 1 12e3
VS1 7 s1 0
L1 s1 12 15e-4
VS2 10 s2 0
C2 s2 7 10e-4
VS3 0 s3 0
V3 e3 s3 DC 0 AC 27e0 -120
RI3 e3 9 12e-2
VS4 13 s4 0
R4 s4 6 10e2
VS5 15 s5 0
R5 s5 9 10e0
VS6 2 s6 0
L6 s6 14 39e-5
VS7 10 s7 0
V7 e7 s7 DC 0 AC 10e0 120
RI7 e7 3 82e-1
VS8 13 s8 0
V8 e8 s8 DC 0 AC 12e1 120
RI8 e8 5 27e-1
VS9 0 s9 0
R9 s9 3 22e0
VS10 11 s10 0
R10 s10 8 22e1
VS11 13 s11 0
L11 s11 0 33e-2
VS12 9 s12 0
V12 e12 s12 DC 0 AC 12e0 180
RI12 e12 7 82e-2
VS13 8 s13 0
V13 e13 s13 DC 0 AC 39e0 120
RI13 e13 5 22e-3
VS14 15 s14 0
C14 s14 11 39e-6
VS15 7 s15 0
L15 s15 6 12e-2
VS16 3 s16 0
C16 s16 8 15e-7
VS17 0 s17 0
L17 s17 2 68e-4
VS18 13 s18 0
R18 s18 12 27e3
VS19 0 s19 0
L19 s19 9 27e-4
VS20 4 s20 0
V20 e20 s20 DC 0 AC 10e-1 180
RI20 e20 0 82e-1
VS21 9 s21 0
L21 s21 13 12e-4
VS22 0 s22 0
R22 s22 1 18e-2
VS23 10 s23 0
L23 s23 8 56e-2
VS24 8 s24 0
L24 s24 13 82e-5
.control
set numdgt=17
ac lin 1 60 60
print v(1) v(2) v(3) v(4) v(5) v(6) v(7) v(8) v(9) v(10)
print v(11) v(12) v(13) v(14) v(15)
print i(vs0) i(vs1) i(vs2) i(vs3) i(vs4) i(vs5) i(vs6) i(vs7) i(vs8) i(vs9)
print i(vs10) i(vs11) i(vs12) i(vs13) i(vs14) i(vs15) i(vs16) i(vs17) i(vs18) i(vs19)
print i(vs20) i(vs21) i(vs22) i(vs23) i(vs24)
.endc
.end
