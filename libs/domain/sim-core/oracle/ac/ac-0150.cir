controls oracle ac-0150
* Generated (plan F2.7, ADR 0012): do not edit; regenerate with `pnpm sim oracle regen`. ac seed 20261031 index 150 nodes 16 elements 27
.options sparse gmin=1e-12 noopac
RG1 1 0 1000000000000
RG2 2 0 1000000000000
RG3 3 0 1000000000000
RG4 4 0 1000000000000
RG5 5 0 1000000000000
RG6 6 0 1000000000000
RG7 7 0 1000000000000
RG8 8 0 1000000000000
RG9 9 0 1000000000000
RG10 10 0 1000000000000
RG11 11 0 1000000000000
RG12 12 0 1000000000000
RG13 13 0 1000000000000
RG14 14 0 1000000000000
RG15 15 0 1000000000000
VS0 0 s0 0
V0 e0 s0 DC 0 AC 12e1 120
RI0 e0 5 27e-1
VS1 13 s1 0
L1 s1 9 27e-4
VS2 10 s2 0
V2 e2 s2 DC 0 AC 10e0 120
RI2 e2 3 82e-1
VS3 10 s3 0
C3 s3 7 10e-4
VS4 15 s4 0
R4 s4 9 10e0
VS5 0 s5 0
R5 s5 12 27e3
VS6 4 s6 0
V6 e6 s6 DC 0 AC 10e-1 180
RI6 e6 13 82e-1
VS7 0 s7 0
R7 s7 6 10e2
VS8 10 s8 0
L8 s8 8 56e-2
VS9 13 s9 0
R9 s9 3 22e0
VS10 11 s10 0
L10 s10 4 10e-2
VS11 2 s11 0
L11 s11 14 39e-5
VS12 7 s12 0
L12 s12 6 12e-2
VS13 9 s13 0
V13 e13 s13 DC 0 AC 12e0 180
RI13 e13 m13 82e-2
LI13 m13 7 82e-6
VS14 8 s14 0
V14 e14 s14 DC 0 AC 39e0 120
RI14 e14 m14 22e-3
LI14 m14 5 15e-6
VS15 0 s15 0
L15 s15 13 33e-2
VS16 13 s16 0
V16 e16 s16 DC 0 AC 27e0 -120
RI16 e16 9 12e-2
VS17 9 s17 0
L17 s17 0 12e-4
VS18 14 s18 0
C18 s18 6 82e-6
VS19 13 s19 0
L19 s19 2 68e-4
VS20 3 s20 0
C20 s20 8 15e-7
VS21 6 s21 0
R21 s21 1 12e3
VS22 8 s22 0
L22 s22 0 82e-5
VS23 15 s23 0
C23 s23 11 39e-6
VS24 11 s24 0
R24 s24 8 22e1
VS25 13 s25 0
R25 s25 1 18e-2
VS26 7 s26 0
L26 s26 12 15e-4
.control
set numdgt=17
ac lin 1 60 60
print v(1) v(2) v(3) v(4) v(5) v(6) v(7) v(8) v(9) v(10)
print v(11) v(12) v(13) v(14) v(15)
print i(vs0) i(vs1) i(vs2) i(vs3) i(vs4) i(vs5) i(vs6) i(vs7) i(vs8) i(vs9)
print i(vs10) i(vs11) i(vs12) i(vs13) i(vs14) i(vs15) i(vs16) i(vs17) i(vs18) i(vs19)
print i(vs20) i(vs21) i(vs22) i(vs23) i(vs24) i(vs25) i(vs26)
.endc
.end
