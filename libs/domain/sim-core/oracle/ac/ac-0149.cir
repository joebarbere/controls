controls oracle ac-0149
* Generated (plan F2.7, ADR 0012): do not edit; regenerate with `pnpm sim oracle regen`. ac seed 20261031 index 149 nodes 27 elements 41
.options sparse gmin=1e-12 noopac
RG1 1 0 1000000000000
RG2 2 0 1000000000000
RG3 3 0 1000000000000
RG4 4 0 1000000000000
RG5 5 0 1000000000000
RG6 6 0 1000000000000
RG7 7 0 1000000000000
RG8 8 0 1000000000000
RG9 9 0 1000000000000
RG10 10 0 1000000000000
RG11 11 0 1000000000000
RG12 12 0 1000000000000
RG13 13 0 1000000000000
RG14 14 0 1000000000000
RG15 15 0 1000000000000
RG16 16 0 1000000000000
RG17 17 0 1000000000000
RG18 18 0 1000000000000
RG19 19 0 1000000000000
RG20 20 0 1000000000000
RG21 21 0 1000000000000
RG22 22 0 1000000000000
RG23 23 0 1000000000000
RG24 24 0 1000000000000
RG25 25 0 1000000000000
RG26 26 0 1000000000000
VS0 0 s0 0
V0 e0 s0 DC 0 AC 82e1 0
RI0 e0 19 15e-2
VS1 7 s1 0
R1 s1 0 47e-1
VS2 7 s2 0
V2 e2 s2 DC 0 AC 22e1 -120
RI2 e2 16 33e-1
VS3 6 s3 0
R3 s3 9 27e1
VS4 25 s4 0
C4 s4 3 27e-4
VS5 15 s5 0
R5 s5 23 47e1
VS6 14 s6 0
V6 e6 s6 DC 0 AC 27e0 180
RI6 e6 26 33e-3
VS7 11 s7 0
R7 s7 16 18e-1
VS8 24 s8 0
L8 s8 15 82e-5
VS9 16 s9 0
V9 e9 s9 DC 0 AC 39e1 120
RI9 e9 24 56e-2
VS10 13 s10 0
R10 s10 3 39e1
VS11 18 s11 0
R11 s11 26 10e1
VS12 1 s12 0
C12 s12 11 39e-6
VS13 18 s13 0
C13 s13 6 39e-4
VS14 2 s14 0
R14 s14 10 56e3
VS15 21 s15 0
R15 s15 10 56e3
VS16 8 s16 0
C16 s16 26 68e-7
VS17 9 s17 0
R17 s17 12 10e3
VS18 26 s18 0
L18 s18 24 12e-2
VS19 13 s19 0
R19 s19 22 12e-2
VS20 19 s20 0
R20 s20 25 39e1
VS21 3 s21 0
C21 s21 22 18e-5
VS22 23 s22 0
C22 s22 21 15e-4
VS23 1 s23 0
R23 s23 25 15e2
VS24 15 s24 0
R24 s24 21 22e3
VS25 17 s25 0
C25 s25 19 68e-6
VS26 22 s26 0
R26 s26 1 39e3
VS27 10 s27 0
C27 s27 1 12e-5
VS28 7 s28 0
C28 s28 5 27e-6
VS29 14 s29 0
L29 s29 12 39e-2
VS30 4 s30 0
V30 e30 s30 DC 0 AC 39e1 180
RI30 e30 12 10e-2
VS31 3 s31 0
R31 s31 18 18e-2
VS32 11 s32 0
C32 s32 22 22e-5
VS33 7 s33 0
V33 e33 s33 DC 0 AC 33e1 0
RI33 e33 20 18e-1
VS34 19 s34 0
L34 s34 16 10e-3
VS35 14 s35 0
L35 s35 21 22e-2
VS36 18 s36 0
R36 s36 6 47e0
VS37 25 s37 0
V37 e37 s37 DC 0 AC 18e0 180
RI37 e37 14 18e-1
VS38 23 s38 0
L38 s38 9 27e-4
VS39 6 s39 0
C39 s39 25 15e-7
VS40 22 s40 0
C40 s40 0 82e-6
.control
set numdgt=17
ac lin 1 60 60
print v(1) v(2) v(3) v(4) v(5) v(6) v(7) v(8) v(9) v(10)
print v(11) v(12) v(13) v(14) v(15) v(16) v(17) v(18) v(19) v(20)
print v(21) v(22) v(23) v(24) v(25) v(26)
print i(vs0) i(vs1) i(vs2) i(vs3) i(vs4) i(vs5) i(vs6) i(vs7) i(vs8) i(vs9)
print i(vs10) i(vs11) i(vs12) i(vs13) i(vs14) i(vs15) i(vs16) i(vs17) i(vs18) i(vs19)
print i(vs20) i(vs21) i(vs22) i(vs23) i(vs24) i(vs25) i(vs26) i(vs27) i(vs28) i(vs29)
print i(vs30) i(vs31) i(vs32) i(vs33) i(vs34) i(vs35) i(vs36) i(vs37) i(vs38) i(vs39)
print i(vs40)
.endc
.end
