controls oracle ac-0149
* Generated (plan F2.7, ADR 0012): do not edit; regenerate with `pnpm sim oracle regen`. ac seed 20261031 index 149 nodes 27 elements 51
.options sparse gmin=1e-12 noopac
RG1 1 0 1000000000000
RG2 2 0 1000000000000
RG3 3 0 1000000000000
RG4 4 0 1000000000000
RG5 5 0 1000000000000
RG6 6 0 1000000000000
RG7 7 0 1000000000000
RG8 8 0 1000000000000
RG9 9 0 1000000000000
RG10 10 0 1000000000000
RG11 11 0 1000000000000
RG12 12 0 1000000000000
RG13 13 0 1000000000000
RG14 14 0 1000000000000
RG15 15 0 1000000000000
RG16 16 0 1000000000000
RG17 17 0 1000000000000
RG18 18 0 1000000000000
RG19 19 0 1000000000000
RG20 20 0 1000000000000
RG21 21 0 1000000000000
RG22 22 0 1000000000000
RG23 23 0 1000000000000
RG24 24 0 1000000000000
RG25 25 0 1000000000000
RG26 26 0 1000000000000
VS0 16 s0 0
L0 s0 25 68e-2
VS1 19 s1 0
L1 s1 1 82e-4
VS2 18 s2 0
R2 s2 6 27e1
VS3 8 s3 0
L3 s3 5 18e-3
VS4 0 s4 0
V4 e4 s4 DC 0 AC 12e-1 -120
RI4 e4 m4 68e-2
LI4 m4 5 56e-5
VS5 17 s5 0
C5 s5 16 56e-6
VS6 23 s6 0
V6 e6 s6 DC 0 AC 10e0 120
RI6 e6 14 39e-2
VS7 11 s7 0
V7 e7 s7 DC 0 AC 56e0 0
RI7 e7 8 82e-3
VS8 4 s8 0
L8 s8 24 10e-2
VS9 23 s9 0
R9 s9 3 10e2
VS10 4 s10 0
L10 s10 17 33e-3
VS11 22 s11 0
R11 s11 2 22e-1
VS12 6 s12 0
R12 s12 2 68e3
VS13 24 s13 0
R13 s13 18 12e1
VS14 8 s14 0
V14 e14 s14 DC 0 AC 47e1 0
RI14 e14 12 39e-2
VS15 2 s15 0
R15 s15 18 22e3
VS16 13 s16 0
L16 s16 2 82e-2
VS17 16 s17 0
V17 e17 s17 DC 0 AC 39e1 120
RI17 e17 m17 56e-2
LI17 m17 24 47e-7
VS18 13 s18 0
C18 s18 21 33e-4
VS19 1 s19 0
R19 s19 5 39e2
VS20 20 s20 0
V20 e20 s20 DC 0 AC 47e-1 120
RI20 e20 1 82e-3
VS21 14 s21 0
C21 s21 9 22e-5
VS22 8 s22 0
C22 s22 0 15e-6
VS23 25 s23 0
C23 s23 22 27e-7
VS24 14 s24 0
V24 e24 s24 DC 0 AC 27e0 180
RI24 e24 m24 33e-3
LI24 m24 7 56e-7
VS25 0 s25 0
R25 s25 23 39e3
VS26 25 s26 0
R26 s26 23 27e-1
VS27 13 s27 0
L27 s27 24 39e-2
VS28 17 s28 0
C28 s28 20 39e-7
VS29 6 s29 0
R29 s29 23 56e-1
VS30 15 s30 0
V30 e30 s30 DC 0 AC 82e-1 120
RI30 e30 m30 10e-1
LI30 m30 13 27e-7
VS31 7 s31 0
R31 s31 21 22e3
VS32 1 s32 0
C32 s32 22 18e-4
VS33 11 s33 0
R33 s33 24 22e1
VS34 26 s34 0
R34 s34 9 27e0
VS35 3 s35 0
L35 s35 18 82e-2
VS36 18 s36 0
R36 s36 0 15e0
VS37 26 s37 0
V37 e37 s37 DC 0 AC 39e0 120
RI37 e37 1 22e-3
VS38 14 s38 0
R38 s38 12 56e2
VS39 20 s39 0
C39 s39 11 22e-7
VS40 22 s40 0
L40 s40 1 27e-4
VS41 10 s41 0
V41 e41 s41 DC 0 AC 18e-1 180
RI41 e41 m41 15e-2
LI41 m41 4 82e-5
VS42 6 s42 0
R42 s42 25 27e-2
VS43 5 s43 0
R43 s43 3 27e1
VS44 22 s44 0
C44 s44 20 22e-6
VS45 20 s45 0
C45 s45 10 82e-5
VS46 15 s46 0
L46 s46 8 22e-4
VS47 13 s47 0
C47 s47 2 82e-5
VS48 18 s48 0
C48 s48 23 22e-6
VS49 23 s49 0
V49 e49 s49 DC 0 AC 39e-1 0
RI49 e49 m49 68e-2
LI49 m49 19 39e-5
VS50 14 s50 0
L50 s50 24 22e-4
.control
set numdgt=17
ac lin 1 60 60
print v(1) v(2) v(3) v(4) v(5) v(6) v(7) v(8) v(9) v(10)
print v(11) v(12) v(13) v(14) v(15) v(16) v(17) v(18) v(19) v(20)
print v(21) v(22) v(23) v(24) v(25) v(26)
print i(vs0) i(vs1) i(vs2) i(vs3) i(vs4) i(vs5) i(vs6) i(vs7) i(vs8) i(vs9)
print i(vs10) i(vs11) i(vs12) i(vs13) i(vs14) i(vs15) i(vs16) i(vs17) i(vs18) i(vs19)
print i(vs20) i(vs21) i(vs22) i(vs23) i(vs24) i(vs25) i(vs26) i(vs27) i(vs28) i(vs29)
print i(vs30) i(vs31) i(vs32) i(vs33) i(vs34) i(vs35) i(vs36) i(vs37) i(vs38) i(vs39)
print i(vs40) i(vs41) i(vs42) i(vs43) i(vs44) i(vs45) i(vs46) i(vs47) i(vs48) i(vs49)
print i(vs50)
.endc
.end
