controls oracle ac-0149
* Generated (plan F2.7, ADR 0012): do not edit; regenerate with `pnpm sim oracle regen`. ac seed 20261031 index 149 nodes 27 elements 47
.options sparse gmin=1e-12 noopac
RG1 1 0 1000000000000
RG2 2 0 1000000000000
RG3 3 0 1000000000000
RG4 4 0 1000000000000
RG5 5 0 1000000000000
RG6 6 0 1000000000000
RG7 7 0 1000000000000
RG8 8 0 1000000000000
RG9 9 0 1000000000000
RG10 10 0 1000000000000
RG11 11 0 1000000000000
RG12 12 0 1000000000000
RG13 13 0 1000000000000
RG14 14 0 1000000000000
RG15 15 0 1000000000000
RG16 16 0 1000000000000
RG17 17 0 1000000000000
RG18 18 0 1000000000000
RG19 19 0 1000000000000
RG20 20 0 1000000000000
RG21 21 0 1000000000000
RG22 22 0 1000000000000
RG23 23 0 1000000000000
RG24 24 0 1000000000000
RG25 25 0 1000000000000
RG26 26 0 1000000000000
VS0 10 s0 0
C0 s0 1 12e-5
VS1 4 s1 0
L1 s1 2 82e-3
VS2 13 s2 0
R2 s2 22 12e-2
VS3 0 s3 0
R3 s3 10 56e3
VS4 14 s4 0
L4 s4 12 39e-2
VS5 9 s5 0
R5 s5 12 10e3
VS6 17 s6 0
C6 s6 6 18e-7
VS7 0 s7 0
V7 e7 s7 DC 0 AC 56e-1 180
RI7 e7 22 56e-2
VS8 19 s8 0
R8 s8 25 39e1
VS9 22 s9 0
R9 s9 1 39e3
VS10 18 s10 0
R10 s10 6 47e0
VS11 6 s11 0
R11 s11 9 27e1
VS12 7 s12 0
V12 e12 s12 DC 0 AC 22e1 -120
RI12 e12 16 33e-1
VS13 26 s13 0
V13 e13 s13 DC 0 AC 82e1 0
RI13 e13 19 15e-2
VS14 11 s14 0
C14 s14 22 22e-5
VS15 14 s15 0
V15 e15 s15 DC 0 AC 27e0 180
RI15 e15 2 33e-3
VS16 22 s16 0
C16 s16 26 82e-6
VS17 15 s17 0
R17 s17 23 47e1
VS18 20 s18 0
L18 s18 22 15e-4
VS19 1 s19 0
C19 s19 11 39e-6
VS20 7 s20 0
C20 s20 5 27e-6
VS21 21 s21 0
R21 s21 10 56e3
VS22 25 s22 0
V22 e22 s22 DC 0 AC 18e0 180
RI22 e22 14 18e-1
VS23 19 s23 0
L23 s23 16 10e-3
VS24 16 s24 0
V24 e24 s24 DC 0 AC 39e1 120
RI24 e24 24 56e-2
VS25 3 s25 0
C25 s25 22 18e-5
VS26 17 s26 0
C26 s26 19 68e-6
VS27 1 s27 0
R27 s27 25 15e2
VS28 15 s28 0
R28 s28 21 22e3
VS29 23 s29 0
L29 s29 9 27e-4
VS30 14 s30 0
L30 s30 21 22e-2
VS31 24 s31 0
L31 s31 15 82e-5
VS32 18 s32 0
R32 s32 2 10e1
VS33 2 s33 0
L33 s33 24 12e-2
VS34 4 s34 0
V34 e34 s34 DC 0 AC 39e1 180
RI34 e34 12 10e-2
VS35 18 s35 0
C35 s35 6 39e-4
VS36 25 s36 0
C36 s36 3 27e-4
VS37 3 s37 0
R37 s37 18 18e-2
VS38 8 s38 0
C38 s38 23 82e-6
VS39 7 s39 0
R39 s39 26 47e-1
VS40 11 s40 0
R40 s40 16 18e-1
VS41 23 s41 0
C41 s41 21 15e-4
VS42 13 s42 0
R42 s42 3 39e1
VS43 8 s43 0
C43 s43 2 68e-7
VS44 5 s44 0
C44 s44 12 22e-5
VS45 6 s45 0
C45 s45 25 15e-7
VS46 7 s46 0
V46 e46 s46 DC 0 AC 33e1 0
RI46 e46 20 18e-1
.control
set numdgt=17
ac lin 1 60 60
print v(1) v(2) v(3) v(4) v(5) v(6) v(7) v(8) v(9) v(10)
print v(11) v(12) v(13) v(14) v(15) v(16) v(17) v(18) v(19) v(20)
print v(21) v(22) v(23) v(24) v(25) v(26)
print i(vs0) i(vs1) i(vs2) i(vs3) i(vs4) i(vs5) i(vs6) i(vs7) i(vs8) i(vs9)
print i(vs10) i(vs11) i(vs12) i(vs13) i(vs14) i(vs15) i(vs16) i(vs17) i(vs18) i(vs19)
print i(vs20) i(vs21) i(vs22) i(vs23) i(vs24) i(vs25) i(vs26) i(vs27) i(vs28) i(vs29)
print i(vs30) i(vs31) i(vs32) i(vs33) i(vs34) i(vs35) i(vs36) i(vs37) i(vs38) i(vs39)
print i(vs40) i(vs41) i(vs42) i(vs43) i(vs44) i(vs45) i(vs46)
.endc
.end
