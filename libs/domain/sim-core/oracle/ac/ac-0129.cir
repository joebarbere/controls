controls oracle ac-0129
* Generated (plan F2.7, ADR 0012): do not edit; regenerate with `pnpm sim oracle regen`. ac seed 20261031 index 129 nodes 10 elements 15
.options sparse gmin=1e-12 noopac
RG1 1 0 1000000000000
RG2 2 0 1000000000000
RG3 3 0 1000000000000
RG4 4 0 1000000000000
RG5 5 0 1000000000000
RG6 6 0 1000000000000
RG7 7 0 1000000000000
RG8 8 0 1000000000000
RG9 9 0 1000000000000
VS0 1 s0 0
L0 s0 9 27e-2
VS1 0 s1 0
C1 s1 5 10e-6
VS2 4 s2 0
R2 s2 7 68e0
VS3 3 s3 0
L3 s3 0 27e-4
VS4 6 s4 0
C4 s4 5 56e-5
VS5 0 s5 0
V5 e5 s5 DC 0 AC 33e0 180
RI5 e5 2 68e-2
VS6 8 s6 0
R6 s6 0 56e1
VS7 2 s7 0
R7 s7 9 82e2
VS8 1 s8 0
C8 s8 8 33e-6
VS9 2 s9 0
R9 s9 8 47e-1
VS10 8 s10 0
L10 s10 5 47e-4
VS11 3 s11 0
L11 s11 5 12e-3
VS12 1 s12 0
V12 e12 s12 DC 0 AC 18e-1 0
RI12 e12 7 33e-2
VS13 1 s13 0
L13 s13 2 22e-4
VS14 1 s14 0
L14 s14 9 22e-2
.control
set numdgt=17
ac lin 1 60 60
print v(1) v(2) v(3) v(4) v(5) v(6) v(7) v(8) v(9)
print i(vs0) i(vs1) i(vs2) i(vs3) i(vs4) i(vs5) i(vs6) i(vs7) i(vs8) i(vs9)
print i(vs10) i(vs11) i(vs12) i(vs13) i(vs14)
.endc
.end
