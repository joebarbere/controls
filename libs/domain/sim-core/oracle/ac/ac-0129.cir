controls oracle ac-0129
* Generated (plan F2.7, ADR 0012): do not edit; regenerate with `pnpm sim oracle regen`. ac seed 20261031 index 129 nodes 10 elements 15
.options sparse gmin=1e-12 noopac
RG1 1 0 1000000000000
RG2 2 0 1000000000000
RG3 3 0 1000000000000
RG4 4 0 1000000000000
RG5 5 0 1000000000000
RG6 6 0 1000000000000
RG7 7 0 1000000000000
RG8 8 0 1000000000000
RG9 9 0 1000000000000
VS0 0 s0 0
R0 s0 6 18e0
VS1 0 s1 0
V1 e1 s1 DC 0 AC 68e-1 -120
RI1 e1 9 39e-2
VS2 1 s2 0
C2 s2 8 56e-5
VS3 1 s3 0
V3 e3 s3 DC 0 AC 33e0 180
RI3 e3 2 68e-2
VS4 6 s4 0
V4 e4 s4 DC 0 AC 39e-1 180
RI4 e4 3 33e-1
VS5 2 s5 0
R5 s5 4 27e0
VS6 2 s6 0
R6 s6 5 56e-1
VS7 6 s7 0
R7 s7 2 15e-1
VS8 8 s8 0
L8 s8 4 68e-4
VS9 7 s9 0
V9 e9 s9 DC 0 AC 47e1 -120
RI9 e9 m9 47e-1
LI9 m9 9 68e-5
VS10 7 s10 0
L10 s10 2 22e-4
VS11 3 s11 0
R11 s11 8 27e-1
VS12 7 s12 0
R12 s12 4 10e0
VS13 5 s13 0
R13 s13 1 47e3
VS14 6 s14 0
R14 s14 9 15e2
.control
set numdgt=17
ac lin 1 60 60
print v(1) v(2) v(3) v(4) v(5) v(6) v(7) v(8) v(9)
print i(vs0) i(vs1) i(vs2) i(vs3) i(vs4) i(vs5) i(vs6) i(vs7) i(vs8) i(vs9)
print i(vs10) i(vs11) i(vs12) i(vs13) i(vs14)
.endc
.end
