controls oracle ac-0094
* Generated (plan F2.7, ADR 0012): do not edit; regenerate with `pnpm sim oracle regen`. ac seed 20261031 index 94 nodes 30 elements 48
.options sparse gmin=1e-12 noopac
RG1 1 0 1000000000000
RG2 2 0 1000000000000
RG3 3 0 1000000000000
RG4 4 0 1000000000000
RG5 5 0 1000000000000
RG6 6 0 1000000000000
RG7 7 0 1000000000000
RG8 8 0 1000000000000
RG9 9 0 1000000000000
RG10 10 0 1000000000000
RG11 11 0 1000000000000
RG12 12 0 1000000000000
RG13 13 0 1000000000000
RG14 14 0 1000000000000
RG15 15 0 1000000000000
RG16 16 0 1000000000000
RG17 17 0 1000000000000
RG18 18 0 1000000000000
RG19 19 0 1000000000000
RG20 20 0 1000000000000
RG21 21 0 1000000000000
RG22 22 0 1000000000000
RG23 23 0 1000000000000
RG24 24 0 1000000000000
RG25 25 0 1000000000000
RG26 26 0 1000000000000
RG27 27 0 1000000000000
RG28 28 0 1000000000000
RG29 29 0 1000000000000
VS0 0 s0 0
V0 e0 s0 DC 0 AC 15e-1 -120
RI0 e0 12 18e-1
VS1 28 s1 0
R1 s1 29 68e0
VS2 2 s2 0
L2 s2 21 10e-2
VS3 8 s3 0
R3 s3 25 27e2
VS4 29 s4 0
L4 s4 23 22e-4
VS5 24 s5 0
R5 s5 29 12e-1
VS6 12 s6 0
C6 s6 23 68e-4
VS7 23 s7 0
R7 s7 5 68e-2
VS8 7 s8 0
L8 s8 6 47e-2
VS9 16 s9 0
R9 s9 27 39e-2
VS10 7 s10 0
R10 s10 29 27e2
VS11 10 s11 0
R11 s11 3 56e1
VS12 15 s12 0
R12 s12 13 22e2
VS13 10 s13 0
R13 s13 11 27e1
VS14 11 s14 0
R14 s14 19 39e2
VS15 28 s15 0
V15 e15 s15 DC 0 AC 56e1 0
RI15 e15 10 39e-1
VS16 24 s16 0
R16 s16 10 47e-1
VS17 8 s17 0
R17 s17 15 27e0
VS18 26 s18 0
L18 s18 17 39e-4
VS19 25 s19 0
L19 s19 4 39e-4
VS20 22 s20 0
C20 s20 29 39e-5
VS21 6 s21 0
L21 s21 7 15e-5
VS22 10 s22 0
C22 s22 5 22e-6
VS23 7 s23 0
V23 e23 s23 DC 0 AC 68e0 0
RI23 e23 29 68e-3
VS24 27 s24 0
R24 s24 11 68e1
VS25 19 s25 0
R25 s25 3 10e1
VS26 11 s26 0
V26 e26 s26 DC 0 AC 15e0 120
RI26 e26 29 27e-1
VS27 4 s27 0
L27 s27 15 47e-4
VS28 12 s28 0
V28 e28 s28 DC 0 AC 33e-1 180
RI28 e28 10 68e-3
VS29 14 s29 0
R29 s29 3 47e2
VS30 13 s30 0
L30 s30 24 68e-2
VS31 1 s31 0
V31 e31 s31 DC 0 AC 82e0 -120
RI31 e31 27 39e-3
VS32 1 s32 0
R32 s32 10 47e3
VS33 1 s33 0
L33 s33 11 68e-3
VS34 21 s34 0
L34 s34 3 18e-5
VS35 17 s35 0
L35 s35 20 39e-2
VS36 24 s36 0
C36 s36 9 39e-4
VS37 26 s37 0
C37 s37 6 18e-4
VS38 29 s38 0
R38 s38 13 12e0
VS39 10 s39 0
V39 e39 s39 DC 0 AC 47e1 -120
RI39 e39 20 27e-3
VS40 2 s40 0
R40 s40 21 22e-1
VS41 8 s41 0
R41 s41 10 47e-1
VS42 29 s42 0
R42 s42 18 27e0
VS43 2 s43 0
R43 s43 28 56e-1
VS44 4 s44 0
R44 s44 0 68e3
VS45 2 s45 0
R45 s45 8 22e3
VS46 9 s46 0
L46 s46 21 56e-5
VS47 15 s47 0
R47 s47 17 82e0
.control
set numdgt=17
ac lin 1 60 60
print v(1) v(2) v(3) v(4) v(5) v(6) v(7) v(8) v(9) v(10)
print v(11) v(12) v(13) v(14) v(15) v(16) v(17) v(18) v(19) v(20)
print v(21) v(22) v(23) v(24) v(25) v(26) v(27) v(28) v(29)
print i(vs0) i(vs1) i(vs2) i(vs3) i(vs4) i(vs5) i(vs6) i(vs7) i(vs8) i(vs9)
print i(vs10) i(vs11) i(vs12) i(vs13) i(vs14) i(vs15) i(vs16) i(vs17) i(vs18) i(vs19)
print i(vs20) i(vs21) i(vs22) i(vs23) i(vs24) i(vs25) i(vs26) i(vs27) i(vs28) i(vs29)
print i(vs30) i(vs31) i(vs32) i(vs33) i(vs34) i(vs35) i(vs36) i(vs37) i(vs38) i(vs39)
print i(vs40) i(vs41) i(vs42) i(vs43) i(vs44) i(vs45) i(vs46) i(vs47)
.endc
.end
