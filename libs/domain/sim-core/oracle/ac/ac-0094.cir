controls oracle ac-0094
* Generated (plan F2.7, ADR 0012): do not edit; regenerate with `pnpm sim oracle regen`. ac seed 20261031 index 94 nodes 30 elements 52
.options sparse gmin=1e-12 noopac
RG1 1 0 1000000000000
RG2 2 0 1000000000000
RG3 3 0 1000000000000
RG4 4 0 1000000000000
RG5 5 0 1000000000000
RG6 6 0 1000000000000
RG7 7 0 1000000000000
RG8 8 0 1000000000000
RG9 9 0 1000000000000
RG10 10 0 1000000000000
RG11 11 0 1000000000000
RG12 12 0 1000000000000
RG13 13 0 1000000000000
RG14 14 0 1000000000000
RG15 15 0 1000000000000
RG16 16 0 1000000000000
RG17 17 0 1000000000000
RG18 18 0 1000000000000
RG19 19 0 1000000000000
RG20 20 0 1000000000000
RG21 21 0 1000000000000
RG22 22 0 1000000000000
RG23 23 0 1000000000000
RG24 24 0 1000000000000
RG25 25 0 1000000000000
RG26 26 0 1000000000000
RG27 27 0 1000000000000
RG28 28 0 1000000000000
RG29 29 0 1000000000000
VS0 7 s0 0
L0 s0 6 47e-2
VS1 14 s1 0
R1 s1 3 47e2
VS2 12 s2 0
C2 s2 16 10e-6
VS3 9 s3 0
L3 s3 21 56e-5
VS4 8 s4 0
R4 s4 10 47e-1
VS5 0 s5 0
V5 e5 s5 DC 0 AC 15e0 120
RI5 e5 m5 27e-1
LI5 m5 11 15e-7
VS6 28 s6 0
V6 e6 s6 DC 0 AC 56e1 0
RI6 e6 m6 39e-1
LI6 m6 10 47e-6
VS7 24 s7 0
C7 s7 9 39e-4
VS8 6 s8 0
L8 s8 7 15e-5
VS9 7 s9 0
R9 s9 11 27e2
VS10 24 s10 0
R10 s10 10 47e-1
VS11 22 s11 0
C11 s11 11 39e-5
VS12 1 s12 0
V12 e12 s12 DC 0 AC 82e0 -120
RI12 e12 27 39e-3
VS13 7 s13 0
V13 e13 s13 DC 0 AC 68e0 0
RI13 e13 11 68e-3
VS14 9 s14 0
V14 e14 s14 DC 0 AC 18e1 0
RI14 e14 14 33e-1
VS15 12 s15 0
V15 e15 s15 DC 0 AC 33e-1 180
RI15 e15 m15 68e-3
LI15 m15 10 39e-7
VS16 4 s16 0
L16 s16 15 47e-4
VS17 21 s17 0
L17 s17 3 18e-5
VS18 2 s18 0
R18 s18 8 22e3
VS19 1 s19 0
R19 s19 10 47e3
VS20 26 s20 0
L20 s20 17 39e-4
VS21 28 s21 0
R21 s21 11 68e0
VS22 2 s22 0
L22 s22 21 10e-2
VS23 12 s23 0
C23 s23 23 68e-4
VS24 0 s24 0
R24 s24 19 39e2
VS25 10 s25 0
C25 s25 5 22e-6
VS26 25 s26 0
L26 s26 4 39e-4
VS27 4 s27 0
R27 s27 18 18e2
VS28 23 s28 0
R28 s28 5 68e-2
VS29 11 s29 0
L29 s29 23 22e-4
VS30 8 s30 0
R30 s30 15 27e0
VS31 10 s31 0
R31 s31 3 56e1
VS32 16 s32 0
R32 s32 27 39e-2
VS33 27 s33 0
R33 s33 0 68e1
VS34 17 s34 0
L34 s34 20 39e-2
VS35 13 s35 0
L35 s35 24 68e-2
VS36 1 s36 0
L36 s36 0 68e-3
VS37 4 s37 0
R37 s37 29 68e3
VS38 29 s38 0
V38 e38 s38 DC 0 AC 15e-1 -120
RI38 e38 12 18e-1
VS39 26 s39 0
C39 s39 6 18e-4
VS40 24 s40 0
R40 s40 11 12e-1
VS41 15 s41 0
R41 s41 17 82e0
VS42 11 s42 0
R42 s42 13 12e0
VS43 19 s43 0
R43 s43 3 10e1
VS44 11 s44 0
R44 s44 18 27e0
VS45 15 s45 0
R45 s45 13 22e2
VS46 2 s46 0
R46 s46 21 22e-1
VS47 8 s47 0
R47 s47 25 27e2
VS48 10 s48 0
R48 s48 0 27e1
VS49 15 s49 0
V49 e49 s49 DC 0 AC 82e-1 -120
RI49 e49 22 22e-3
VS50 2 s50 0
R50 s50 28 56e-1
VS51 10 s51 0
V51 e51 s51 DC 0 AC 47e1 -120
RI51 e51 20 27e-3
.control
set numdgt=17
ac lin 1 60 60
print v(1) v(2) v(3) v(4) v(5) v(6) v(7) v(8) v(9) v(10)
print v(11) v(12) v(13) v(14) v(15) v(16) v(17) v(18) v(19) v(20)
print v(21) v(22) v(23) v(24) v(25) v(26) v(27) v(28) v(29)
print i(vs0) i(vs1) i(vs2) i(vs3) i(vs4) i(vs5) i(vs6) i(vs7) i(vs8) i(vs9)
print i(vs10) i(vs11) i(vs12) i(vs13) i(vs14) i(vs15) i(vs16) i(vs17) i(vs18) i(vs19)
print i(vs20) i(vs21) i(vs22) i(vs23) i(vs24) i(vs25) i(vs26) i(vs27) i(vs28) i(vs29)
print i(vs30) i(vs31) i(vs32) i(vs33) i(vs34) i(vs35) i(vs36) i(vs37) i(vs38) i(vs39)
print i(vs40) i(vs41) i(vs42) i(vs43) i(vs44) i(vs45) i(vs46) i(vs47) i(vs48) i(vs49)
print i(vs50) i(vs51)
.endc
.end
