controls oracle ac-0094
* Generated (plan F2.7, ADR 0012): do not edit; regenerate with `pnpm sim oracle regen`. ac seed 20261031 index 94 nodes 30 elements 47
.options sparse gmin=1e-12 noopac
RG1 1 0 1000000000000
RG2 2 0 1000000000000
RG3 3 0 1000000000000
RG4 4 0 1000000000000
RG5 5 0 1000000000000
RG6 6 0 1000000000000
RG7 7 0 1000000000000
RG8 8 0 1000000000000
RG9 9 0 1000000000000
RG10 10 0 1000000000000
RG11 11 0 1000000000000
RG12 12 0 1000000000000
RG13 13 0 1000000000000
RG14 14 0 1000000000000
RG15 15 0 1000000000000
RG16 16 0 1000000000000
RG17 17 0 1000000000000
RG18 18 0 1000000000000
RG19 19 0 1000000000000
RG20 20 0 1000000000000
RG21 21 0 1000000000000
RG22 22 0 1000000000000
RG23 23 0 1000000000000
RG24 24 0 1000000000000
RG25 25 0 1000000000000
RG26 26 0 1000000000000
RG27 27 0 1000000000000
RG28 28 0 1000000000000
RG29 29 0 1000000000000
VS0 22 s0 0
R0 s0 16 68e0
VS1 5 s1 0
R1 s1 26 12e2
VS2 0 s2 0
V2 e2 s2 DC 0 AC 15e-1 -120
RI2 e2 12 18e-1
VS3 10 s3 0
C3 s3 5 22e-6
VS4 10 s4 0
R4 s4 3 56e1
VS5 3 s5 0
R5 s5 2 22e-1
VS6 24 s6 0
R6 s6 10 47e-1
VS7 7 s7 0
R7 s7 29 27e2
VS8 0 s8 0
L8 s8 28 47e-3
VS9 20 s9 0
R9 s9 19 27e-1
VS10 8 s10 0
R10 s10 15 27e0
VS11 19 s11 0
R11 s11 0 18e1
VS12 17 s12 0
V12 e12 s12 DC 0 AC 27e-1 0
RI12 e12 8 56e-3
VS13 4 s13 0
C13 s13 23 10e-5
VS14 29 s14 0
R14 s14 18 27e0
VS15 6 s15 0
R15 s15 4 22e1
VS16 15 s16 0
R16 s16 17 82e0
VS17 12 s17 0
C17 s17 23 68e-4
VS18 25 s18 0
L18 s18 13 82e-3
VS19 0 s19 0
R19 s19 9 22e2
VS20 27 s20 0
C20 s20 1 68e-6
VS21 20 s21 0
V21 e21 s21 DC 0 AC 27e1 180
RI21 e21 1 56e-2
VS22 3 s22 0
L22 s22 5 68e-3
VS23 22 s23 0
R23 s23 18 22e3
VS24 10 s24 0
R24 s24 8 68e0
VS25 26 s25 0
C25 s25 21 39e-4
VS26 14 s26 0
R26 s26 23 22e2
VS27 9 s27 0
L27 s27 21 56e-5
VS28 26 s28 0
L28 s28 17 39e-4
VS29 17 s29 0
L29 s29 20 39e-2
VS30 2 s30 0
R30 s30 13 27e2
VS31 23 s31 0
R31 s31 16 18e-2
VS32 10 s32 0
L32 s32 9 18e-5
VS33 8 s33 0
R33 s33 20 12e3
VS34 4 s34 0
R34 s34 0 68e3
VS35 6 s35 0
L35 s35 7 15e-5
VS36 8 s36 0
R36 s36 10 47e-1
VS37 0 s37 0
V37 e37 s37 DC 0 AC 33e0 0
RI37 e37 18 68e-2
VS38 29 s38 0
L38 s38 23 22e-4
VS39 14 s39 0
L39 s39 17 10e-5
VS40 24 s40 0
R40 s40 29 12e-1
VS41 25 s41 0
V41 e41 s41 DC 0 AC 18e1 0
RI41 e41 m41 47e-1
LI41 m41 11 18e-5
VS42 21 s42 0
R42 s42 25 68e-2
VS43 1 s43 0
V43 e43 s43 DC 0 AC 82e0 -120
RI43 e43 11 39e-3
VS44 28 s44 0
V44 e44 s44 DC 0 AC 56e1 0
RI44 e44 m44 39e-1
LI44 m44 10 18e-7
VS45 29 s45 0
R45 s45 13 12e0
VS46 27 s46 0
C46 s46 17 27e-5
.control
set numdgt=17
ac lin 1 60 60
print v(1) v(2) v(3) v(4) v(5) v(6) v(7) v(8) v(9) v(10)
print v(11) v(12) v(13) v(14) v(15) v(16) v(17) v(18) v(19) v(20)
print v(21) v(22) v(23) v(24) v(25) v(26) v(27) v(28) v(29)
print i(vs0) i(vs1) i(vs2) i(vs3) i(vs4) i(vs5) i(vs6) i(vs7) i(vs8) i(vs9)
print i(vs10) i(vs11) i(vs12) i(vs13) i(vs14) i(vs15) i(vs16) i(vs17) i(vs18) i(vs19)
print i(vs20) i(vs21) i(vs22) i(vs23) i(vs24) i(vs25) i(vs26) i(vs27) i(vs28) i(vs29)
print i(vs30) i(vs31) i(vs32) i(vs33) i(vs34) i(vs35) i(vs36) i(vs37) i(vs38) i(vs39)
print i(vs40) i(vs41) i(vs42) i(vs43) i(vs44) i(vs45) i(vs46)
.endc
.end
