controls oracle ac-0319
* Generated (plan F2.7, ADR 0012): do not edit; regenerate with `pnpm sim oracle regen`. ac seed 20261031 index 319 nodes 15 elements 27
.options sparse gmin=1e-12 noopac
RG1 1 0 1000000000000
RG2 2 0 1000000000000
RG3 3 0 1000000000000
RG4 4 0 1000000000000
RG5 5 0 1000000000000
RG6 6 0 1000000000000
RG7 7 0 1000000000000
RG8 8 0 1000000000000
RG9 9 0 1000000000000
RG10 10 0 1000000000000
RG11 11 0 1000000000000
RG12 12 0 1000000000000
RG13 13 0 1000000000000
RG14 14 0 1000000000000
VS0 0 s0 0
V0 e0 s0 DC 0 AC 33e-1 -120
RI0 e0 n0 15e-2
H0 n0 h0 VS4 -18e-4
ED0 h0 13 d0 0 39e-5
F0 0 d0 VS4 1
LD0 d0 0 1
VS1 6 s1 0
L1 s1 7 39e-2
VS2 8 s2 0
L2 s2 6 82e-3
VS3 5 s3 0
R3 s3 7 27e-2
VS4 10 s4 0
V4 e4 s4 DC 0 AC 68e1 180
RI4 e4 n4 27e-3
H4 n4 h4 VS0 -18e-4
ED4 h4 1 d4 0 39e-5
F4 0 d4 VS0 1
LD4 d4 0 1
VS5 14 s5 0
V5 e5 s5 DC 0 AC 18e0 120
RI5 e5 13 39e-2
VS6 13 s6 0
R6 s6 0 68e-2
VS7 4 s7 0
C7 s7 3 39e-6
VS8 1 s8 0
L8 s8 2 56e-5
VS9 1 s9 0
R9 s9 9 27e1
VS10 7 s10 0
L10 s10 12 10e-4
VS11 8 s11 0
V11 e11 s11 DC 0 AC 47e-1 180
RI11 e11 10 12e-1
VS12 9 s12 0
R12 s12 8 27e2
VS13 14 s13 0
R13 s13 11 15e-1
VS14 4 s14 0
R14 s14 9 82e2
VS15 11 s15 0
L15 s15 13 47e-2
VS16 4 s16 0
R16 s16 14 27e-2
VS17 5 s17 0
V17 e17 s17 DC 0 AC 39e0 -120
RI17 e17 m17 39e-3
LI17 m17 10 12e-7
VS18 12 s18 0
V18 e18 s18 DC 0 AC 82e1 -120
RI18 e18 m18 18e-3
LI18 m18 8 33e-6
VS19 12 s19 0
R19 s19 0 22e3
VS20 13 s20 0
R20 s20 2 12e-1
VS21 11 s21 0
C21 s21 1 12e-4
VS22 3 s22 0
R22 s22 2 22e-2
VS23 6 s23 0
R23 s23 10 12e-2
VS24 9 s24 0
L24 s24 14 22e-5
VS25 6 s25 0
R25 s25 8 82e3
VS26 14 s26 0
R26 s26 7 68e3
.control
set numdgt=17
ac lin 1 60 60
print v(1) v(2) v(3) v(4) v(5) v(6) v(7) v(8) v(9) v(10)
print v(11) v(12) v(13) v(14)
print i(vs0) i(vs1) i(vs2) i(vs3) i(vs4) i(vs5) i(vs6) i(vs7) i(vs8) i(vs9)
print i(vs10) i(vs11) i(vs12) i(vs13) i(vs14) i(vs15) i(vs16) i(vs17) i(vs18) i(vs19)
print i(vs20) i(vs21) i(vs22) i(vs23) i(vs24) i(vs25) i(vs26)
.endc
.end
