controls oracle ac-0319
* Generated (plan F2.7, ADR 0012): do not edit; regenerate with `pnpm sim oracle regen`. ac seed 20261031 index 319 nodes 15 elements 26
.options sparse gmin=1e-12 noopac
RG1 1 0 1000000000000
RG2 2 0 1000000000000
RG3 3 0 1000000000000
RG4 4 0 1000000000000
RG5 5 0 1000000000000
RG6 6 0 1000000000000
RG7 7 0 1000000000000
RG8 8 0 1000000000000
RG9 9 0 1000000000000
RG10 10 0 1000000000000
RG11 11 0 1000000000000
RG12 12 0 1000000000000
RG13 13 0 1000000000000
RG14 14 0 1000000000000
VS0 6 s0 0
L0 s0 7 39e-2
VS1 1 s1 0
L1 s1 2 56e-5
VS2 0 s2 0
V2 e2 s2 DC 0 AC 47e-1 180
RI2 e2 8 12e-1
VS3 0 s3 0
L3 s3 6 82e-3
VS4 11 s4 0
C4 s4 1 12e-4
VS5 1 s5 0
R5 s5 9 27e1
VS6 9 s6 0
R6 s6 0 27e2
VS7 4 s7 0
R7 s7 9 82e2
VS8 14 s8 0
R8 s8 11 15e-1
VS9 6 s9 0
R9 s9 8 12e-2
VS10 6 s10 0
R10 s10 0 82e3
VS11 3 s11 0
R11 s11 2 22e-2
VS12 4 s12 0
C12 s12 3 39e-6
VS13 13 s13 0
R13 s13 10 68e-2
VS14 13 s14 0
R14 s14 2 12e-1
VS15 14 s15 0
V15 e15 s15 DC 0 AC 18e0 120
RI15 e15 13 39e-2
VS16 5 s16 0
V16 e16 s16 DC 0 AC 39e0 -120
RI16 e16 8 39e-3
VS17 14 s17 0
R17 s17 7 68e3
VS18 12 s18 0
V18 e18 s18 DC 0 AC 82e1 -120
RI18 e18 0 18e-3
VS19 4 s19 0
R19 s19 14 27e-2
VS20 11 s20 0
L20 s20 13 47e-2
VS21 7 s21 0
L21 s21 12 10e-4
VS22 9 s22 0
L22 s22 14 22e-5
VS23 5 s23 0
R23 s23 7 27e-2
VS24 8 s24 0
V24 e24 s24 DC 0 AC 68e1 180
RI24 e24 1 27e-3
VS25 10 s25 0
V25 e25 s25 DC 0 AC 33e-1 -120
RI25 e25 13 15e-2
.control
set numdgt=17
ac lin 1 60 60
print v(1) v(2) v(3) v(4) v(5) v(6) v(7) v(8) v(9) v(10)
print v(11) v(12) v(13) v(14)
print i(vs0) i(vs1) i(vs2) i(vs3) i(vs4) i(vs5) i(vs6) i(vs7) i(vs8) i(vs9)
print i(vs10) i(vs11) i(vs12) i(vs13) i(vs14) i(vs15) i(vs16) i(vs17) i(vs18) i(vs19)
print i(vs20) i(vs21) i(vs22) i(vs23) i(vs24) i(vs25)
.endc
.end
