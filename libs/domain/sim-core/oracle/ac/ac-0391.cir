controls oracle ac-0391
* Generated (plan F2.7, ADR 0012): do not edit; regenerate with `pnpm sim oracle regen`. ac seed 20261031 index 391 nodes 19 elements 25
.options sparse gmin=1e-12 noopac
RG1 1 0 1000000000000
RG2 2 0 1000000000000
RG3 3 0 1000000000000
RG4 4 0 1000000000000
RG5 5 0 1000000000000
RG6 6 0 1000000000000
RG7 7 0 1000000000000
RG8 8 0 1000000000000
RG9 9 0 1000000000000
RG10 10 0 1000000000000
RG11 11 0 1000000000000
RG12 12 0 1000000000000
RG13 13 0 1000000000000
RG14 14 0 1000000000000
RG15 15 0 1000000000000
RG16 16 0 1000000000000
RG17 17 0 1000000000000
RG18 18 0 1000000000000
VS0 3 s0 0
R0 s0 13 56e2
VS1 12 s1 0
C1 s1 6 10e-5
VS2 1 s2 0
L2 s2 12 27e-3
VS3 7 s3 0
L3 s3 1 18e-5
VS4 13 s4 0
R4 s4 11 39e0
VS5 16 s5 0
R5 s5 18 18e0
VS6 8 s6 0
C6 s6 4 68e-7
VS7 0 s7 0
V7 e7 s7 DC 0 AC 47e1 180
RI7 e7 m7 18e-3
LI7 m7 n7 68e-7
H7 n7 h7 VS8 27e-4
ED7 h7 8 d7 0 47e-6
F7 0 d7 VS8 1
LD7 d7 0 1
VS8 3 s8 0
V8 e8 s8 DC 0 AC 33e-1 0
RI8 e8 m8 15e-2
LI8 m8 n8 18e-7
H8 n8 h8 VS7 27e-4
ED8 h8 5 d8 0 47e-6
F8 0 d8 VS7 1
LD8 d8 0 1
VS9 17 s9 0
C9 s9 14 27e-5
VS10 2 s10 0
L10 s10 5 15e-2
VS11 16 s11 0
V11 e11 s11 DC 0 AC 56e0 0
RI11 e11 m11 68e-2
LI11 m11 0 68e-6
VS12 15 s12 0
R12 s12 18 12e-2
VS13 4 s13 0
R13 s13 17 18e-2
VS14 1 s14 0
R14 s14 15 68e0
VS15 4 s15 0
R15 s15 10 82e-1
VS16 4 s16 0
V16 e16 s16 DC 0 AC 56e1 -120
RI16 e16 m16 18e-1
LI16 m16 9 10e-7
VS17 2 s17 0
C17 s17 6 82e-5
VS18 12 s18 0
R18 s18 16 27e1
VS19 11 s19 0
L19 s19 9 10e-5
VS20 7 s20 0
V20 e20 s20 DC 0 AC 15e-1 180
RI20 e20 m20 39e-2
LI20 m20 6 22e-6
VS21 0 s21 0
R21 s21 14 56e2
VS22 5 s22 0
R22 s22 10 56e1
VS23 15 s23 0
L23 s23 16 22e-5
VS24 13 s24 0
V24 e24 s24 DC 0 AC 56e1 120
RI24 e24 5 56e-1
.control
set numdgt=17
ac lin 1 60 60
print v(1) v(2) v(3) v(4) v(5) v(6) v(7) v(8) v(9) v(10)
print v(11) v(12) v(13) v(14) v(15) v(16) v(17) v(18)
print i(vs0) i(vs1) i(vs2) i(vs3) i(vs4) i(vs5) i(vs6) i(vs7) i(vs8) i(vs9)
print i(vs10) i(vs11) i(vs12) i(vs13) i(vs14) i(vs15) i(vs16) i(vs17) i(vs18) i(vs19)
print i(vs20) i(vs21) i(vs22) i(vs23) i(vs24)
.endc
.end
