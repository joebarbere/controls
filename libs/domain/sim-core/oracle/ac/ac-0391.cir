controls oracle ac-0391
* Generated (plan F2.7, ADR 0012): do not edit; regenerate with `pnpm sim oracle regen`. ac seed 20261031 index 391 nodes 19 elements 19
.options sparse gmin=1e-12 noopac
RG1 1 0 1000000000000
RG2 2 0 1000000000000
RG3 3 0 1000000000000
RG4 4 0 1000000000000
RG5 5 0 1000000000000
RG6 6 0 1000000000000
RG7 7 0 1000000000000
RG8 8 0 1000000000000
RG9 9 0 1000000000000
RG10 10 0 1000000000000
RG11 11 0 1000000000000
RG12 12 0 1000000000000
RG13 13 0 1000000000000
RG14 14 0 1000000000000
RG15 15 0 1000000000000
RG16 16 0 1000000000000
RG17 17 0 1000000000000
RG18 18 0 1000000000000
VS0 0 s0 0
C0 s0 16 56e-5
VS1 2 s1 0
C1 s1 6 82e-5
VS2 2 s2 0
L2 s2 5 15e-2
VS3 5 s3 0
R3 s3 10 56e1
VS4 3 s4 0
R4 s4 13 56e2
VS5 8 s5 0
C5 s5 4 68e-7
VS6 12 s6 0
R6 s6 16 27e1
VS7 15 s7 0
L7 s7 16 22e-5
VS8 0 s8 0
V8 e8 s8 DC 0 AC 47e1 180
RI8 e8 8 18e-3
VS9 16 s9 0
R9 s9 18 18e0
VS10 13 s10 0
R10 s10 11 39e0
VS11 1 s11 0
L11 s11 12 27e-3
VS12 4 s12 0
V12 e12 s12 DC 0 AC 56e1 -120
RI12 e12 9 18e-1
VS13 16 s13 0
V13 e13 s13 DC 0 AC 56e0 0
RI13 e13 0 68e-2
VS14 13 s14 0
V14 e14 s14 DC 0 AC 56e1 120
RI14 e14 5 56e-1
VS15 7 s15 0
V15 e15 s15 DC 0 AC 15e-1 180
RI15 e15 6 39e-2
VS16 17 s16 0
C16 s16 14 27e-5
VS17 12 s17 0
C17 s17 6 10e-5
VS18 0 s18 0
R18 s18 14 56e2
.control
set numdgt=17
ac lin 1 60 60
print v(1) v(2) v(3) v(4) v(5) v(6) v(7) v(8) v(9) v(10)
print v(11) v(12) v(13) v(14) v(15) v(16) v(17) v(18)
print i(vs0) i(vs1) i(vs2) i(vs3) i(vs4) i(vs5) i(vs6) i(vs7) i(vs8) i(vs9)
print i(vs10) i(vs11) i(vs12) i(vs13) i(vs14) i(vs15) i(vs16) i(vs17) i(vs18)
.endc
.end
