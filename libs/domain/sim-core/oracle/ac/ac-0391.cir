controls oracle ac-0391
* Generated (plan F2.7, ADR 0012): do not edit; regenerate with `pnpm sim oracle regen`. ac seed 20261031 index 391 nodes 19 elements 33
.options sparse gmin=1e-12 noopac
RG1 1 0 1000000000000
RG2 2 0 1000000000000
RG3 3 0 1000000000000
RG4 4 0 1000000000000
RG5 5 0 1000000000000
RG6 6 0 1000000000000
RG7 7 0 1000000000000
RG8 8 0 1000000000000
RG9 9 0 1000000000000
RG10 10 0 1000000000000
RG11 11 0 1000000000000
RG12 12 0 1000000000000
RG13 13 0 1000000000000
RG14 14 0 1000000000000
RG15 15 0 1000000000000
RG16 16 0 1000000000000
RG17 17 0 1000000000000
RG18 18 0 1000000000000
VS0 0 s0 0
V0 e0 s0 DC 0 AC 18e-1 120
RI0 e0 m0 47e-1
LI0 m0 12 15e-5
VS1 10 s1 0
V1 e1 s1 DC 0 AC 47e0 -120
RI1 e1 9 33e-2
VS2 12 s2 0
C2 s2 6 10e-5
VS3 5 s3 0
V3 e3 s3 DC 0 AC 68e1 0
RI3 e3 2 22e-2
VS4 4 s4 0
C4 s4 1 12e-7
VS5 1 s5 0
R5 s5 12 82e1
VS6 9 s6 0
R6 s6 0 15e-2
VS7 10 s7 0
R7 s7 1 68e0
VS8 4 s8 0
V8 e8 s8 DC 0 AC 22e0 180
RI8 e8 15 22e-1
VS9 12 s9 0
R9 s9 8 27e1
VS10 4 s10 0
C10 s10 0 39e-5
VS11 8 s11 0
V11 e11 s11 DC 0 AC 56e0 0
RI11 e11 m11 68e-2
LI11 m11 16 39e-5
VS12 3 s12 0
V12 e12 s12 DC 0 AC 47e0 120
RI12 e12 m12 10e-3
LI12 m12 5 22e-5
VS13 0 s13 0
L13 s13 2 39e-4
VS14 12 s14 0
V14 e14 s14 DC 0 AC 68e1 120
RI14 e14 7 10e-2
VS15 11 s15 0
V15 e15 s15 DC 0 AC 10e-1 -120
RI15 e15 13 82e-2
VS16 14 s16 0
C16 s16 16 27e-6
VS17 13 s17 0
L17 s17 15 10e-5
VS18 0 s18 0
R18 s18 18 68e1
VS19 4 s19 0
V19 e19 s19 DC 0 AC 56e1 120
RI19 e19 m19 56e-1
LI19 m19 6 39e-6
VS20 0 s20 0
L20 s20 14 22e-3
VS21 9 s21 0
V21 e21 s21 DC 0 AC 15e-1 180
RI21 e21 m21 39e-2
LI21 m21 8 15e-7
VS22 2 s22 0
R22 s22 1 56e1
VS23 11 s23 0
C23 s23 4 18e-5
VS24 0 s24 0
V24 e24 s24 DC 0 AC 18e-1 0
RI24 e24 m24 82e-3
LI24 m24 7 47e-6
VS25 6 s25 0
R25 s25 17 12e-2
VS26 13 s26 0
R26 s26 0 10e1
VS27 1 s27 0
V27 e27 s27 DC 0 AC 18e0 -120
RI27 e27 8 22e-1
VS28 12 s28 0
R28 s28 14 22e2
VS29 12 s29 0
R29 s29 3 10e-2
VS30 12 s30 0
L30 s30 7 82e-4
VS31 18 s31 0
C31 s31 13 47e-6
VS32 17 s32 0
L32 s32 11 22e-5
.control
set numdgt=17
ac lin 1 60 60
print v(1) v(2) v(3) v(4) v(5) v(6) v(7) v(8) v(9) v(10)
print v(11) v(12) v(13) v(14) v(15) v(16) v(17) v(18)
print i(vs0) i(vs1) i(vs2) i(vs3) i(vs4) i(vs5) i(vs6) i(vs7) i(vs8) i(vs9)
print i(vs10) i(vs11) i(vs12) i(vs13) i(vs14) i(vs15) i(vs16) i(vs17) i(vs18) i(vs19)
print i(vs20) i(vs21) i(vs22) i(vs23) i(vs24) i(vs25) i(vs26) i(vs27) i(vs28) i(vs29)
print i(vs30) i(vs31) i(vs32)
.endc
.end
