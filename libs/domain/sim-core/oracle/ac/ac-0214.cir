controls oracle ac-0214
* Generated (plan F2.7, ADR 0012): do not edit; regenerate with `pnpm sim oracle regen`. ac seed 20261031 index 214 nodes 22 elements 22
.options sparse gmin=1e-12 noopac
RG1 1 0 1000000000000
RG2 2 0 1000000000000
RG3 3 0 1000000000000
RG4 4 0 1000000000000
RG5 5 0 1000000000000
RG6 6 0 1000000000000
RG7 7 0 1000000000000
RG8 8 0 1000000000000
RG9 9 0 1000000000000
RG10 10 0 1000000000000
RG11 11 0 1000000000000
RG12 12 0 1000000000000
RG13 13 0 1000000000000
RG14 14 0 1000000000000
RG15 15 0 1000000000000
RG16 16 0 1000000000000
RG17 17 0 1000000000000
RG18 18 0 1000000000000
RG19 19 0 1000000000000
RG20 20 0 1000000000000
RG21 21 0 1000000000000
VS0 16 s0 0
R0 s0 13 22e0
VS1 1 s1 0
C1 s1 0 15e-7
VS2 1 s2 0
L2 s2 7 68e-5
VS3 9 s3 0
C3 s3 20 47e-4
VS4 20 s4 0
L4 s4 11 39e-5
VS5 0 s5 0
V5 e5 s5 DC 0 AC 47e0 -120
RI5 e5 16 18e-1
VS6 6 s6 0
R6 s6 11 47e3
VS7 15 s7 0
V7 e7 s7 DC 0 AC 12e1 120
RI7 e7 9 12e-3
VS8 15 s8 0
R8 s8 17 68e3
VS9 2 s9 0
R9 s9 9 15e-2
VS10 12 s10 0
R10 s10 8 12e2
VS11 14 s11 0
L11 s11 0 39e-3
VS12 19 s12 0
C12 s12 21 82e-4
VS13 7 s13 0
V13 e13 s13 DC 0 AC 27e1 -120
RI13 e13 18 47e-3
VS14 21 s14 0
R14 s14 5 10e-1
VS15 14 s15 0
C15 s15 3 68e-7
VS16 10 s16 0
R16 s16 16 15e3
VS17 14 s17 0
L17 s17 5 47e-2
VS18 1 s18 0
C18 s18 12 56e-7
VS19 4 s19 0
C19 s19 10 22e-7
VS20 14 s20 0
L20 s20 20 47e-2
VS21 14 s21 0
L21 s21 4 18e-4
.control
set numdgt=17
ac lin 1 60 60
print v(1) v(2) v(3) v(4) v(5) v(6) v(7) v(8) v(9) v(10)
print v(11) v(12) v(13) v(14) v(15) v(16) v(17) v(18) v(19) v(20)
print v(21)
print i(vs0) i(vs1) i(vs2) i(vs3) i(vs4) i(vs5) i(vs6) i(vs7) i(vs8) i(vs9)
print i(vs10) i(vs11) i(vs12) i(vs13) i(vs14) i(vs15) i(vs16) i(vs17) i(vs18) i(vs19)
print i(vs20) i(vs21)
.endc
.end
