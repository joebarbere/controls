controls oracle ac-0450
* Generated (plan F2.7, ADR 0012): do not edit; regenerate with `pnpm sim oracle regen`. ac seed 20261031 index 450 nodes 27 elements 34
.options sparse gmin=1e-12 noopac
RG1 1 0 1000000000000
RG2 2 0 1000000000000
RG3 3 0 1000000000000
RG4 4 0 1000000000000
RG5 5 0 1000000000000
RG6 6 0 1000000000000
RG7 7 0 1000000000000
RG8 8 0 1000000000000
RG9 9 0 1000000000000
RG10 10 0 1000000000000
RG11 11 0 1000000000000
RG12 12 0 1000000000000
RG13 13 0 1000000000000
RG14 14 0 1000000000000
RG15 15 0 1000000000000
RG16 16 0 1000000000000
RG17 17 0 1000000000000
RG18 18 0 1000000000000
RG19 19 0 1000000000000
RG20 20 0 1000000000000
RG21 21 0 1000000000000
RG22 22 0 1000000000000
RG23 23 0 1000000000000
RG24 24 0 1000000000000
RG25 25 0 1000000000000
RG26 26 0 1000000000000
VS0 11 s0 0
R0 s0 13 10e1
VS1 4 s1 0
L1 s1 10 18e-4
VS2 0 s2 0
V2 e2 s2 DC 0 AC 56e1 -120
RI2 e2 7 39e-3
VS3 12 s3 0
R3 s3 18 27e-1
VS4 21 s4 0
R4 s4 4 33e-1
VS5 24 s5 0
L5 s5 5 10e-3
VS6 17 s6 0
R6 s6 14 68e3
VS7 1 s7 0
L7 s7 17 33e-2
VS8 9 s8 0
L8 s8 20 22e-2
VS9 8 s9 0
V9 e9 s9 DC 0 AC 12e0 120
RI9 e9 m9 12e-3
LI9 m9 4 18e-6
VS10 24 s10 0
L10 s10 1 56e-3
VS11 21 s11 0
R11 s11 13 22e0
VS12 25 s12 0
R12 s12 5 33e-1
VS13 9 s13 0
R13 s13 16 82e2
VS14 26 s14 0
C14 s14 6 56e-6
VS15 22 s15 0
C15 s15 3 27e-6
VS16 22 s16 0
C16 s16 4 82e-6
VS17 10 s17 0
C17 s17 2 39e-4
VS18 20 s18 0
C18 s18 26 33e-5
VS19 5 s19 0
L19 s19 18 10e-4
VS20 23 s20 0
V20 e20 s20 DC 0 AC 33e0 0
RI20 e20 3 18e-3
VS21 16 s21 0
R21 s21 15 82e1
VS22 20 s22 0
R22 s22 7 68e-2
VS23 20 s23 0
R23 s23 25 39e3
VS24 6 s24 0
V24 e24 s24 DC 0 AC 22e1 120
RI24 e24 m24 33e-2
LI24 m24 22 10e-7
VS25 19 s25 0
L25 s25 18 56e-2
VS26 0 s26 0
R26 s26 2 39e1
VS27 4 s27 0
L27 s27 11 10e-5
VS28 20 s28 0
V28 e28 s28 DC 0 AC 82e1 120
RI28 e28 m28 39e-3
LI28 m28 22 27e-7
VS29 20 s29 0
V29 e29 s29 DC 0 AC 82e1 120
RI29 e29 8 39e-2
VS30 20 s30 0
R30 s30 19 33e-2
VS31 14 s31 0
V31 e31 s31 DC 0 AC 39e1 180
RI31 e31 13 56e-1
VS32 15 s32 0
L32 s32 12 47e-5
VS33 17 s33 0
V33 e33 s33 DC 0 AC 33e1 180
RI33 e33 m33 27e-3
LI33 m33 23 47e-7
.control
set numdgt=17
ac lin 1 60 60
print v(1) v(2) v(3) v(4) v(5) v(6) v(7) v(8) v(9) v(10)
print v(11) v(12) v(13) v(14) v(15) v(16) v(17) v(18) v(19) v(20)
print v(21) v(22) v(23) v(24) v(25) v(26)
print i(vs0) i(vs1) i(vs2) i(vs3) i(vs4) i(vs5) i(vs6) i(vs7) i(vs8) i(vs9)
print i(vs10) i(vs11) i(vs12) i(vs13) i(vs14) i(vs15) i(vs16) i(vs17) i(vs18) i(vs19)
print i(vs20) i(vs21) i(vs22) i(vs23) i(vs24) i(vs25) i(vs26) i(vs27) i(vs28) i(vs29)
print i(vs30) i(vs31) i(vs32) i(vs33)
.endc
.end
