controls oracle ac-0450
* Generated (plan F2.7, ADR 0012): do not edit; regenerate with `pnpm sim oracle regen`. ac seed 20261031 index 450 nodes 27 elements 53
.options sparse gmin=1e-12 noopac
RG1 1 0 1000000000000
RG2 2 0 1000000000000
RG3 3 0 1000000000000
RG4 4 0 1000000000000
RG5 5 0 1000000000000
RG6 6 0 1000000000000
RG7 7 0 1000000000000
RG8 8 0 1000000000000
RG9 9 0 1000000000000
RG10 10 0 1000000000000
RG11 11 0 1000000000000
RG12 12 0 1000000000000
RG13 13 0 1000000000000
RG14 14 0 1000000000000
RG15 15 0 1000000000000
RG16 16 0 1000000000000
RG17 17 0 1000000000000
RG18 18 0 1000000000000
RG19 19 0 1000000000000
RG20 20 0 1000000000000
RG21 21 0 1000000000000
RG22 22 0 1000000000000
RG23 23 0 1000000000000
RG24 24 0 1000000000000
RG25 25 0 1000000000000
RG26 26 0 1000000000000
VS0 0 s0 0
V0 e0 s0 DC 0 AC 47e-1 120
RI0 e0 1 10e-2
VS1 10 s1 0
C1 s1 26 27e-6
VS2 19 s2 0
L2 s2 12 47e-5
VS3 22 s3 0
R3 s3 6 10e-1
VS4 6 s4 0
L4 s4 7 82e-4
VS5 14 s5 0
R5 s5 17 39e-1
VS6 7 s6 0
V6 e6 s6 DC 0 AC 12e-1 120
RI6 e6 26 68e-3
VS7 5 s7 0
R7 s7 6 18e0
VS8 1 s8 0
L8 s8 16 39e-4
VS9 1 s9 0
V9 e9 s9 DC 0 AC 10e-1 -120
RI9 e9 14 39e-1
VS10 0 s10 0
L10 s10 17 56e-4
VS11 6 s11 0
R11 s11 24 47e1
VS12 16 s12 0
L12 s12 12 12e-4
VS13 25 s13 0
L13 s13 1 15e-3
VS14 0 s14 0
R14 s14 6 12e-2
VS15 21 s15 0
R15 s15 0 27e1
VS16 4 s16 0
L16 s16 20 33e-3
VS17 24 s17 0
L17 s17 25 12e-2
VS18 1 s18 0
R18 s18 13 56e1
VS19 7 s19 0
C19 s19 19 39e-5
VS20 0 s20 0
R20 s20 3 27e0
VS21 4 s21 0
C21 s21 8 56e-7
VS22 9 s22 0
C22 s22 5 27e-6
VS23 20 s23 0
V23 e23 s23 DC 0 AC 82e1 120
RI23 e23 22 39e-3
VS24 25 s24 0
V24 e24 s24 DC 0 AC 56e-1 120
RI24 e24 23 22e-3
VS25 4 s25 0
L25 s25 5 47e-3
VS26 19 s26 0
C26 s26 3 82e-5
VS27 23 s27 0
R27 s27 0 68e2
VS28 25 s28 0
V28 e28 s28 DC 0 AC 56e1 -120
RI28 e28 7 39e-3
VS29 26 s29 0
R29 s29 20 22e3
VS30 11 s30 0
V30 e30 s30 DC 0 AC 15e-1 -120
RI30 e30 5 15e-2
VS31 8 s31 0
C31 s31 10 22e-5
VS32 22 s32 0
L32 s32 3 22e-2
VS33 25 s33 0
R33 s33 24 47e0
VS34 3 s34 0
L34 s34 24 27e-2
VS35 9 s35 0
C35 s35 0 33e-6
VS36 17 s36 0
C36 s36 20 68e-7
VS37 19 s37 0
R37 s37 21 22e-2
VS38 3 s38 0
L38 s38 12 10e-3
VS39 20 s39 0
R39 s39 26 39e3
VS40 14 s40 0
R40 s40 9 18e1
VS41 8 s41 0
V41 e41 s41 DC 0 AC 12e0 120
RI41 e41 4 12e-3
VS42 0 s42 0
C42 s42 18 22e-4
VS43 2 s43 0
C43 s43 22 27e-4
VS44 11 s44 0
C44 s44 9 47e-5
VS45 15 s45 0
L45 s45 7 27e-3
VS46 0 s46 0
V46 e46 s46 DC 0 AC 22e-1 120
RI46 e46 13 82e-2
VS47 23 s47 0
R47 s47 11 22e1
VS48 4 s48 0
R48 s48 1 15e-2
VS49 12 s49 0
C49 s49 10 12e-6
VS50 17 s50 0
L50 s50 11 18e-4
VS51 17 s51 0
L51 s51 1 18e-5
VS52 21 s52 0
R52 s52 20 18e1
.control
set numdgt=17
ac lin 1 60 60
print v(1) v(2) v(3) v(4) v(5) v(6) v(7) v(8) v(9) v(10)
print v(11) v(12) v(13) v(14) v(15) v(16) v(17) v(18) v(19) v(20)
print v(21) v(22) v(23) v(24) v(25) v(26)
print i(vs0) i(vs1) i(vs2) i(vs3) i(vs4) i(vs5) i(vs6) i(vs7) i(vs8) i(vs9)
print i(vs10) i(vs11) i(vs12) i(vs13) i(vs14) i(vs15) i(vs16) i(vs17) i(vs18) i(vs19)
print i(vs20) i(vs21) i(vs22) i(vs23) i(vs24) i(vs25) i(vs26) i(vs27) i(vs28) i(vs29)
print i(vs30) i(vs31) i(vs32) i(vs33) i(vs34) i(vs35) i(vs36) i(vs37) i(vs38) i(vs39)
print i(vs40) i(vs41) i(vs42) i(vs43) i(vs44) i(vs45) i(vs46) i(vs47) i(vs48) i(vs49)
print i(vs50) i(vs51) i(vs52)
.endc
.end
