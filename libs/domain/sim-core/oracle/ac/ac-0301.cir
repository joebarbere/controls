controls oracle ac-0301
* Generated (plan F2.7, ADR 0012): do not edit; regenerate with `pnpm sim oracle regen`. ac seed 20261031 index 301 nodes 17 elements 31
.options sparse gmin=1e-12 noopac
RG1 1 0 1000000000000
RG2 2 0 1000000000000
RG3 3 0 1000000000000
RG4 4 0 1000000000000
RG5 5 0 1000000000000
RG6 6 0 1000000000000
RG7 7 0 1000000000000
RG8 8 0 1000000000000
RG9 9 0 1000000000000
RG10 10 0 1000000000000
RG11 11 0 1000000000000
RG12 12 0 1000000000000
RG13 13 0 1000000000000
RG14 14 0 1000000000000
RG15 15 0 1000000000000
RG16 16 0 1000000000000
VS0 0 s0 0
V0 e0 s0 DC 0 AC 82e-1 120
RI0 e0 14 10e-3
VS1 5 s1 0
R1 s1 7 15e3
VS2 15 s2 0
L2 s2 11 15e-2
VS3 1 s3 0
C3 s3 14 27e-6
VS4 1 s4 0
V4 e4 s4 DC 0 AC 10e1 -120
RI4 e4 9 22e-3
VS5 14 s5 0
C5 s5 15 56e-5
VS6 1 s6 0
R6 s6 12 47e2
VS7 10 s7 0
R7 s7 5 12e-1
VS8 6 s8 0
V8 e8 s8 DC 0 AC 56e1 120
RI8 e8 0 33e-3
VS9 12 s9 0
L9 s9 0 56e-2
VS10 16 s10 0
C10 s10 5 12e-7
VS11 12 s11 0
V11 e11 s11 DC 0 AC 68e1 -120
RI11 e11 10 33e-2
VS12 0 s12 0
V12 e12 s12 DC 0 AC 15e0 120
RI12 e12 2 12e-3
VS13 10 s13 0
C13 s13 15 56e-5
VS14 13 s14 0
V14 e14 s14 DC 0 AC 33e-1 0
RI14 e14 1 27e-1
VS15 10 s15 0
V15 e15 s15 DC 0 AC 56e1 120
RI15 e15 9 68e-2
VS16 5 s16 0
R16 s16 11 18e3
VS17 2 s17 0
L17 s17 13 82e-4
VS18 3 s18 0
V18 e18 s18 DC 0 AC 68e0 180
RI18 e18 9 33e-1
VS19 0 s19 0
R19 s19 2 47e0
VS20 16 s20 0
V20 e20 s20 DC 0 AC 10e-1 180
RI20 e20 14 47e-3
VS21 15 s21 0
C21 s21 3 82e-6
VS22 4 s22 0
V22 e22 s22 DC 0 AC 27e-1 180
RI22 e22 2 12e-1
VS23 12 s23 0
C23 s23 6 39e-4
VS24 8 s24 0
V24 e24 s24 DC 0 AC 22e-1 -120
RI24 e24 9 68e-1
VS25 14 s25 0
C25 s25 8 22e-7
VS26 4 s26 0
V26 e26 s26 DC 0 AC 56e-1 120
RI26 e26 11 22e-3
VS27 16 s27 0
L27 s27 11 47e-2
VS28 0 s28 0
V28 e28 s28 DC 0 AC 15e0 -120
RI28 e28 11 68e-2
VS29 7 s29 0
C29 s29 16 12e-7
VS30 5 s30 0
C30 s30 12 22e-7
.control
set numdgt=17
ac lin 1 60 60
print v(1) v(2) v(3) v(4) v(5) v(6) v(7) v(8) v(9) v(10)
print v(11) v(12) v(13) v(14) v(15) v(16)
print i(vs0) i(vs1) i(vs2) i(vs3) i(vs4) i(vs5) i(vs6) i(vs7) i(vs8) i(vs9)
print i(vs10) i(vs11) i(vs12) i(vs13) i(vs14) i(vs15) i(vs16) i(vs17) i(vs18) i(vs19)
print i(vs20) i(vs21) i(vs22) i(vs23) i(vs24) i(vs25) i(vs26) i(vs27) i(vs28) i(vs29)
print i(vs30)
.endc
.end
