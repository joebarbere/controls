controls oracle ac-0301
* Generated (plan F2.7, ADR 0012): do not edit; regenerate with `pnpm sim oracle regen`. ac seed 20261031 index 301 nodes 17 elements 27
.options sparse gmin=1e-12 noopac
RG1 1 0 1000000000000
RG2 2 0 1000000000000
RG3 3 0 1000000000000
RG4 4 0 1000000000000
RG5 5 0 1000000000000
RG6 6 0 1000000000000
RG7 7 0 1000000000000
RG8 8 0 1000000000000
RG9 9 0 1000000000000
RG10 10 0 1000000000000
RG11 11 0 1000000000000
RG12 12 0 1000000000000
RG13 13 0 1000000000000
RG14 14 0 1000000000000
RG15 15 0 1000000000000
RG16 16 0 1000000000000
VS0 5 s0 0
R0 s0 8 10e1
VS1 13 s1 0
R1 s1 2 12e-2
VS2 0 s2 0
V2 e2 s2 DC 0 AC 56e1 120
RI2 e2 11 33e-3
VS3 10 s3 0
L3 s3 0 18e-3
VS4 14 s4 0
C4 s4 5 27e-6
VS5 9 s5 0
R5 s5 10 39e2
VS6 1 s6 0
R6 s6 12 47e2
VS7 11 s7 0
V7 e7 s7 DC 0 AC 15e0 -120
RI7 e7 m7 68e-2
LI7 m7 6 82e-7
VS8 16 s8 0
L8 s8 6 47e-2
VS9 1 s9 0
C9 s9 14 27e-6
VS10 3 s10 0
L10 s10 7 18e-3
VS11 15 s11 0
L11 s11 1 68e-2
VS12 6 s12 0
R12 s12 4 22e-2
VS13 13 s13 0
C13 s13 8 56e-5
VS14 2 s14 0
L14 s14 7 10e-4
VS15 16 s15 0
V15 e15 s15 DC 0 AC 33e1 120
RI15 e15 m15 15e-1
LI15 m15 6 10e-6
VS16 6 s16 0
R16 s16 7 27e1
VS17 15 s17 0
L17 s17 2 82e-3
VS18 14 s18 0
L18 s18 1 47e-3
VS19 10 s19 0
V19 e19 s19 DC 0 AC 68e0 -120
RI19 e19 m19 15e-3
LI19 m19 5 68e-6
VS20 3 s20 0
R20 s20 6 12e-2
VS21 5 s21 0
R21 s21 6 18e3
VS22 7 s22 0
C22 s22 16 12e-7
VS23 5 s23 0
C23 s23 12 22e-7
VS24 1 s24 0
C24 s24 9 18e-6
VS25 6 s25 0
R25 s25 2 39e-1
VS26 4 s26 0
L26 s26 0 56e-3
.control
set numdgt=17
ac lin 1 60 60
print v(1) v(2) v(3) v(4) v(5) v(6) v(7) v(8) v(9) v(10)
print v(11) v(12) v(13) v(14) v(15) v(16)
print i(vs0) i(vs1) i(vs2) i(vs3) i(vs4) i(vs5) i(vs6) i(vs7) i(vs8) i(vs9)
print i(vs10) i(vs11) i(vs12) i(vs13) i(vs14) i(vs15) i(vs16) i(vs17) i(vs18) i(vs19)
print i(vs20) i(vs21) i(vs22) i(vs23) i(vs24) i(vs25) i(vs26)
.endc
.end
