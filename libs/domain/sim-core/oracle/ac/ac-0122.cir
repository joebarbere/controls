controls oracle ac-0122
* Generated (plan F2.7, ADR 0012): do not edit; regenerate with `pnpm sim oracle regen`. ac seed 20261031 index 122 nodes 28 elements 41
.options sparse gmin=1e-12 noopac
RG1 1 0 1000000000000
RG2 2 0 1000000000000
RG3 3 0 1000000000000
RG4 4 0 1000000000000
RG5 5 0 1000000000000
RG6 6 0 1000000000000
RG7 7 0 1000000000000
RG8 8 0 1000000000000
RG9 9 0 1000000000000
RG10 10 0 1000000000000
RG11 11 0 1000000000000
RG12 12 0 1000000000000
RG13 13 0 1000000000000
RG14 14 0 1000000000000
RG15 15 0 1000000000000
RG16 16 0 1000000000000
RG17 17 0 1000000000000
RG18 18 0 1000000000000
RG19 19 0 1000000000000
RG20 20 0 1000000000000
RG21 21 0 1000000000000
RG22 22 0 1000000000000
RG23 23 0 1000000000000
RG24 24 0 1000000000000
RG25 25 0 1000000000000
RG26 26 0 1000000000000
RG27 27 0 1000000000000
VS0 27 s0 0
R0 s0 25 15e-2
VS1 19 s1 0
R1 s1 22 15e3
VS2 7 s2 0
L2 s2 0 68e-5
VS3 26 s3 0
C3 s3 9 68e-7
VS4 23 s4 0
L4 s4 20 27e-5
VS5 18 s5 0
L5 s5 20 18e-3
VS6 0 s6 0
V6 e6 s6 DC 0 AC 39e0 -120
RI6 e6 24 39e-3
VS7 0 s7 0
V7 e7 s7 DC 0 AC 10e-1 -120
RI7 e7 1 18e-1
VS8 13 s8 0
L8 s8 10 22e-3
VS9 25 s9 0
L9 s9 10 15e-3
VS10 26 s10 0
C10 s10 24 18e-5
VS11 2 s11 0
V11 e11 s11 DC 0 AC 68e-1 0
RI11 e11 15 82e-1
VS12 21 s12 0
V12 e12 s12 DC 0 AC 22e0 -120
RI12 e12 17 15e-3
VS13 1 s13 0
C13 s13 3 12e-6
VS14 25 s14 0
C14 s14 18 27e-6
VS15 8 s15 0
R15 s15 13 18e-2
VS16 4 s16 0
R16 s16 10 22e-2
VS17 15 s17 0
R17 s17 21 12e-1
VS18 14 s18 0
R18 s18 6 82e3
VS19 19 s19 0
L19 s19 13 15e-5
VS20 5 s20 0
C20 s20 0 10e-5
VS21 11 s21 0
R21 s21 6 27e-2
VS22 18 s22 0
V22 e22 s22 DC 0 AC 33e-1 0
RI22 e22 0 47e-1
VS23 2 s23 0
C23 s23 24 56e-6
VS24 4 s24 0
V24 e24 s24 DC 0 AC 12e0 0
RI24 e24 8 18e-1
VS25 22 s25 0
L25 s25 25 56e-3
VS26 22 s26 0
V26 e26 s26 DC 0 AC 27e1 120
RI26 e26 12 47e-1
VS27 7 s27 0
C27 s27 1 47e-6
VS28 25 s28 0
C28 s28 0 22e-4
VS29 0 s29 0
R29 s29 26 22e0
VS30 25 s30 0
L30 s30 17 12e-3
VS31 15 s31 0
V31 e31 s31 DC 0 AC 22e1 120
RI31 e31 21 18e-3
VS32 24 s32 0
C32 s32 2 39e-6
VS33 25 s33 0
V33 e33 s33 DC 0 AC 22e1 180
RI33 e33 16 22e-2
VS34 2 s34 0
C34 s34 19 10e-4
VS35 16 s35 0
V35 e35 s35 DC 0 AC 82e-1 120
RI35 e35 6 33e-2
VS36 14 s36 0
V36 e36 s36 DC 0 AC 39e-1 0
RI36 e36 4 33e-3
VS37 11 s37 0
R37 s37 24 27e1
VS38 3 s38 0
R38 s38 11 10e2
VS39 15 s39 0
C39 s39 11 68e-6
VS40 11 s40 0
L40 s40 0 15e-5
.control
set numdgt=17
ac lin 1 60 60
print v(1) v(2) v(3) v(4) v(5) v(6) v(7) v(8) v(9) v(10)
print v(11) v(12) v(13) v(14) v(15) v(16) v(17) v(18) v(19) v(20)
print v(21) v(22) v(23) v(24) v(25) v(26) v(27)
print i(vs0) i(vs1) i(vs2) i(vs3) i(vs4) i(vs5) i(vs6) i(vs7) i(vs8) i(vs9)
print i(vs10) i(vs11) i(vs12) i(vs13) i(vs14) i(vs15) i(vs16) i(vs17) i(vs18) i(vs19)
print i(vs20) i(vs21) i(vs22) i(vs23) i(vs24) i(vs25) i(vs26) i(vs27) i(vs28) i(vs29)
print i(vs30) i(vs31) i(vs32) i(vs33) i(vs34) i(vs35) i(vs36) i(vs37) i(vs38) i(vs39)
print i(vs40)
.endc
.end
