controls oracle ac-0122
* Generated (plan F2.7, ADR 0012): do not edit; regenerate with `pnpm sim oracle regen`. ac seed 20261031 index 122 nodes 28 elements 45
.options sparse gmin=1e-12 noopac
RG1 1 0 1000000000000
RG2 2 0 1000000000000
RG3 3 0 1000000000000
RG4 4 0 1000000000000
RG5 5 0 1000000000000
RG6 6 0 1000000000000
RG7 7 0 1000000000000
RG8 8 0 1000000000000
RG9 9 0 1000000000000
RG10 10 0 1000000000000
RG11 11 0 1000000000000
RG12 12 0 1000000000000
RG13 13 0 1000000000000
RG14 14 0 1000000000000
RG15 15 0 1000000000000
RG16 16 0 1000000000000
RG17 17 0 1000000000000
RG18 18 0 1000000000000
RG19 19 0 1000000000000
RG20 20 0 1000000000000
RG21 21 0 1000000000000
RG22 22 0 1000000000000
RG23 23 0 1000000000000
RG24 24 0 1000000000000
RG25 25 0 1000000000000
RG26 26 0 1000000000000
RG27 27 0 1000000000000
VS0 19 s0 0
L0 s0 13 15e-5
VS1 11 s1 0
L1 s1 25 15e-5
VS2 5 s2 0
C2 s2 25 10e-5
VS3 18 s3 0
L3 s3 10 15e-3
VS4 23 s4 0
L4 s4 20 27e-5
VS5 2 s5 0
C5 s5 24 56e-6
VS6 27 s6 0
R6 s6 18 15e-2
VS7 4 s7 0
R7 s7 10 22e-2
VS8 0 s8 0
V8 e8 s8 DC 0 AC 33e-1 0
RI8 e8 n8 47e-1
H8 n8 h8 VS13 12e-2
ED8 h8 25 d8 0 -56e-5
F8 0 d8 VS13 1
LD8 d8 0 1
VS9 4 s9 0
R9 s9 5 39e-2
VS10 15 s10 0
C10 s10 11 68e-6
VS11 15 s11 0
R11 s11 21 12e-1
VS12 7 s12 0
C12 s12 1 47e-6
VS13 4 s13 0
V13 e13 s13 DC 0 AC 12e0 0
RI13 e13 n13 18e-1
H13 n13 h13 VS8 12e-2
ED13 h13 8 d13 0 -56e-5
F13 0 d13 VS8 1
LD13 d13 0 1
VS14 24 s14 0
C14 s14 2 39e-6
VS15 12 s15 0
R15 s15 10 56e2
VS16 18 s16 0
C16 s16 25 22e-4
VS17 25 s17 0
V17 e17 s17 DC 0 AC 39e0 -120
RI17 e17 m17 39e-3
LI17 m17 24 10e-7
VS18 0 s18 0
L18 s18 20 18e-3
VS19 21 s19 0
V19 e19 s19 DC 0 AC 22e0 -120
RI19 e19 17 15e-3
VS20 16 s20 0
V20 e20 s20 DC 0 AC 82e-1 120
RI20 e20 6 33e-2
VS21 18 s21 0
C21 s21 0 27e-6
VS22 9 s22 0
L22 s22 19 82e-5
VS23 14 s23 0
V23 e23 s23 DC 0 AC 39e-1 0
RI23 e23 4 33e-3
VS24 11 s24 0
R24 s24 6 27e-2
VS25 18 s25 0
L25 s25 17 12e-3
VS26 22 s26 0
L26 s26 18 56e-3
VS27 18 s27 0
V27 e27 s27 DC 0 AC 22e1 180
RI27 e27 m27 22e-2
LI27 m27 16 27e-5
VS28 26 s28 0
C28 s28 24 18e-5
VS29 15 s29 0
V29 e29 s29 DC 0 AC 22e1 120
RI29 e29 m29 18e-3
LI29 m29 21 18e-5
VS30 7 s30 0
L30 s30 25 68e-5
VS31 3 s31 0
R31 s31 11 10e2
VS32 13 s32 0
L32 s32 10 22e-3
VS33 11 s33 0
R33 s33 24 27e1
VS34 2 s34 0
C34 s34 19 10e-4
VS35 25 s35 0
R35 s35 26 22e0
VS36 19 s36 0
R36 s36 22 15e3
VS37 22 s37 0
V37 e37 s37 DC 0 AC 27e1 120
RI37 e37 12 47e-1
VS38 2 s38 0
V38 e38 s38 DC 0 AC 68e-1 0
RI38 e38 15 82e-1
VS39 14 s39 0
R39 s39 6 82e3
VS40 25 s40 0
V40 e40 s40 DC 0 AC 10e-1 -120
RI40 e40 m40 18e-1
LI40 m40 1 33e-5
VS41 26 s41 0
C41 s41 9 68e-7
VS42 8 s42 0
R42 s42 13 18e-2
VS43 27 s43 0
L43 s43 23 22e-5
VS44 1 s44 0
C44 s44 3 12e-6
.control
set numdgt=17
ac lin 1 60 60
print v(1) v(2) v(3) v(4) v(5) v(6) v(7) v(8) v(9) v(10)
print v(11) v(12) v(13) v(14) v(15) v(16) v(17) v(18) v(19) v(20)
print v(21) v(22) v(23) v(24) v(25) v(26) v(27)
print i(vs0) i(vs1) i(vs2) i(vs3) i(vs4) i(vs5) i(vs6) i(vs7) i(vs8) i(vs9)
print i(vs10) i(vs11) i(vs12) i(vs13) i(vs14) i(vs15) i(vs16) i(vs17) i(vs18) i(vs19)
print i(vs20) i(vs21) i(vs22) i(vs23) i(vs24) i(vs25) i(vs26) i(vs27) i(vs28) i(vs29)
print i(vs30) i(vs31) i(vs32) i(vs33) i(vs34) i(vs35) i(vs36) i(vs37) i(vs38) i(vs39)
print i(vs40) i(vs41) i(vs42) i(vs43) i(vs44)
.endc
.end
