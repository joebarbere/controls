controls oracle ac-0122
* Generated (plan F2.7, ADR 0012): do not edit; regenerate with `pnpm sim oracle regen`. ac seed 20261031 index 122 nodes 28 elements 49
.options sparse gmin=1e-12 noopac
RG1 1 0 1000000000000
RG2 2 0 1000000000000
RG3 3 0 1000000000000
RG4 4 0 1000000000000
RG5 5 0 1000000000000
RG6 6 0 1000000000000
RG7 7 0 1000000000000
RG8 8 0 1000000000000
RG9 9 0 1000000000000
RG10 10 0 1000000000000
RG11 11 0 1000000000000
RG12 12 0 1000000000000
RG13 13 0 1000000000000
RG14 14 0 1000000000000
RG15 15 0 1000000000000
RG16 16 0 1000000000000
RG17 17 0 1000000000000
RG18 18 0 1000000000000
RG19 19 0 1000000000000
RG20 20 0 1000000000000
RG21 21 0 1000000000000
RG22 22 0 1000000000000
RG23 23 0 1000000000000
RG24 24 0 1000000000000
RG25 25 0 1000000000000
RG26 26 0 1000000000000
RG27 27 0 1000000000000
VS0 21 s0 0
R0 s0 24 56e1
VS1 0 s1 0
V1 e1 s1 DC 0 AC 82e1 0
RI1 e1 25 47e-1
VS2 1 s2 0
R2 s2 16 68e1
VS3 7 s3 0
L3 s3 1 33e-3
VS4 20 s4 0
R4 s4 10 18e2
VS5 15 s5 0
L5 s5 27 15e-5
VS6 6 s6 0
R6 s6 4 27e2
VS7 25 s7 0
R7 s7 13 39e1
VS8 4 s8 0
C8 s8 24 33e-6
VS9 26 s9 0
C9 s9 8 68e-5
VS10 7 s10 0
L10 s10 22 82e-2
VS11 14 s11 0
C11 s11 26 22e-5
VS12 25 s12 0
R12 s12 20 22e-2
VS13 9 s13 0
C13 s13 21 68e-4
VS14 16 s14 0
R14 s14 0 39e-2
VS15 16 s15 0
R15 s15 11 82e-2
VS16 6 s16 0
V16 e16 s16 DC 0 AC 33e0 180
RI16 e16 m16 15e-1
LI16 m16 20 18e-6
VS17 1 s17 0
L17 s17 9 56e-5
VS18 2 s18 0
V18 e18 s18 DC 0 AC 82e0 120
RI18 e18 m18 39e-1
LI18 m18 1 15e-7
VS19 18 s19 0
L19 s19 16 12e-4
VS20 16 s20 0
L20 s20 13 22e-5
VS21 5 s21 0
V21 e21 s21 DC 0 AC 18e0 -120
RI21 e21 25 15e-3
VS22 5 s22 0
C22 s22 6 47e-7
VS23 7 s23 0
V23 e23 s23 DC 0 AC 10e-1 -120
RI23 e23 m23 18e-1
LI23 m23 17 12e-6
VS24 25 s24 0
V24 e24 s24 DC 0 AC 27e-1 0
RI24 e24 m24 33e-3
LI24 m24 21 82e-5
VS25 2 s25 0
R25 s25 22 10e-2
VS26 0 s26 0
C26 s26 4 39e-4
VS27 19 s27 0
R27 s27 6 56e-2
VS28 17 s28 0
V28 e28 s28 DC 0 AC 39e1 120
RI28 e28 m28 56e-1
LI28 m28 15 22e-6
VS29 17 s29 0
L29 s29 8 47e-4
VS30 15 s30 0
V30 e30 s30 DC 0 AC 39e-1 0
RI30 e30 m30 33e-3
LI30 m30 10 15e-6
VS31 20 s31 0
V31 e31 s31 DC 0 AC 22e1 180
RI31 e31 m31 22e-2
LI31 m31 16 15e-6
VS32 27 s32 0
V32 e32 s32 DC 0 AC 18e1 0
RI32 e32 26 56e-2
VS33 11 s33 0
C33 s33 3 47e-7
VS34 18 s34 0
V34 e34 s34 DC 0 AC 33e-1 0
RI34 e34 m34 47e-1
LI34 m34 25 68e-5
VS35 18 s35 0
V35 e35 s35 DC 0 AC 39e0 180
RI35 e35 4 18e-2
VS36 12 s36 0
C36 s36 0 56e-6
VS37 0 s37 0
V37 e37 s37 DC 0 AC 82e1 180
RI37 e37 2 68e-2
VS38 23 s38 0
R38 s38 18 12e1
VS39 15 s39 0
R39 s39 21 47e2
VS40 23 s40 0
L40 s40 16 82e-2
VS41 7 s41 0
C41 s41 18 56e-7
VS42 12 s42 0
L42 s42 3 33e-3
VS43 18 s43 0
C43 s43 22 12e-7
VS44 4 s44 0
C44 s44 17 56e-4
VS45 24 s45 0
L45 s45 2 10e-4
VS46 14 s46 0
L46 s46 25 39e-5
VS47 26 s47 0
C47 s47 24 18e-5
VS48 13 s48 0
V48 e48 s48 DC 0 AC 10e0 180
RI48 e48 19 18e-2
.control
set numdgt=17
ac lin 1 60 60
print v(1) v(2) v(3) v(4) v(5) v(6) v(7) v(8) v(9) v(10)
print v(11) v(12) v(13) v(14) v(15) v(16) v(17) v(18) v(19) v(20)
print v(21) v(22) v(23) v(24) v(25) v(26) v(27)
print i(vs0) i(vs1) i(vs2) i(vs3) i(vs4) i(vs5) i(vs6) i(vs7) i(vs8) i(vs9)
print i(vs10) i(vs11) i(vs12) i(vs13) i(vs14) i(vs15) i(vs16) i(vs17) i(vs18) i(vs19)
print i(vs20) i(vs21) i(vs22) i(vs23) i(vs24) i(vs25) i(vs26) i(vs27) i(vs28) i(vs29)
print i(vs30) i(vs31) i(vs32) i(vs33) i(vs34) i(vs35) i(vs36) i(vs37) i(vs38) i(vs39)
print i(vs40) i(vs41) i(vs42) i(vs43) i(vs44) i(vs45) i(vs46) i(vs47) i(vs48)
.endc
.end
