controls oracle ac-0175
* Generated (plan F2.7, ADR 0012): do not edit; regenerate with `pnpm sim oracle regen`. ac seed 20261031 index 175 nodes 19 elements 33
.options sparse gmin=1e-12 noopac
RG1 1 0 1000000000000
RG2 2 0 1000000000000
RG3 3 0 1000000000000
RG4 4 0 1000000000000
RG5 5 0 1000000000000
RG6 6 0 1000000000000
RG7 7 0 1000000000000
RG8 8 0 1000000000000
RG9 9 0 1000000000000
RG10 10 0 1000000000000
RG11 11 0 1000000000000
RG12 12 0 1000000000000
RG13 13 0 1000000000000
RG14 14 0 1000000000000
RG15 15 0 1000000000000
RG16 16 0 1000000000000
RG17 17 0 1000000000000
RG18 18 0 1000000000000
VS0 10 s0 0
C0 s0 18 22e-4
VS1 18 s1 0
R1 s1 1 12e-2
VS2 0 s2 0
V2 e2 s2 DC 0 AC 27e-1 -120
RI2 e2 n2 82e-1
H2 n2 h2 VS4 -33e-3
ED2 h2 5 d2 0 56e-5
F2 0 d2 VS4 1
LD2 d2 0 1
VS3 7 s3 0
C3 s3 4 10e-4
VS4 15 s4 0
V4 e4 s4 DC 0 AC 27e-1 120
RI4 e4 m4 12e-2
LI4 m4 n4 18e-7
H4 n4 h4 VS2 -33e-3
ED4 h4 17 d4 0 56e-5
F4 0 d4 VS2 1
LD4 d4 0 1
VS5 6 s5 0
L5 s5 5 18e-3
VS6 6 s6 0
R6 s6 12 12e2
VS7 8 s7 0
R7 s7 4 47e1
VS8 16 s8 0
R8 s8 1 82e3
VS9 2 s9 0
L9 s9 10 39e-2
VS10 8 s10 0
V10 e10 s10 DC 0 AC 47e1 120
RI10 e10 m10 15e-3
LI10 m10 14 27e-7
VS11 15 s11 0
V11 e11 s11 DC 0 AC 22e0 120
RI11 e11 2 47e-2
VS12 7 s12 0
L12 s12 12 27e-4
VS13 0 s13 0
V13 e13 s13 DC 0 AC 47e-1 0
RI13 e13 m13 33e-3
LI13 m13 3 47e-5
VS14 16 s14 0
C14 s14 11 15e-4
VS15 13 s15 0
R15 s15 16 82e3
VS16 16 s16 0
C16 s16 13 33e-6
VS17 6 s17 0
C17 s17 13 18e-6
VS18 14 s18 0
L18 s18 8 27e-5
VS19 2 s19 0
R19 s19 1 27e0
VS20 6 s20 0
R20 s20 5 82e1
VS21 17 s21 0
V21 e21 s21 DC 0 AC 27e1 180
RI21 e21 m21 22e-2
LI21 m21 7 39e-6
VS22 6 s22 0
R22 s22 9 22e0
VS23 3 s23 0
C23 s23 18 12e-5
VS24 16 s24 0
V24 e24 s24 DC 0 AC 18e-1 180
RI24 e24 5 47e-1
VS25 8 s25 0
V25 e25 s25 DC 0 AC 33e0 180
RI25 e25 m25 39e-3
LI25 m25 11 82e-5
VS26 18 s26 0
L26 s26 9 68e-5
VS27 18 s27 0
V27 e27 s27 DC 0 AC 10e-1 180
RI27 e27 0 15e-2
VS28 5 s28 0
C28 s28 2 12e-5
VS29 8 s29 0
C29 s29 3 10e-6
VS30 0 s30 0
V30 e30 s30 DC 0 AC 22e0 120
RI30 e30 m30 12e-2
LI30 m30 6 47e-7
VS31 8 s31 0
R31 s31 5 18e1
VS32 14 s32 0
C32 s32 16 33e-4
.control
set numdgt=17
ac lin 1 60 60
print v(1) v(2) v(3) v(4) v(5) v(6) v(7) v(8) v(9) v(10)
print v(11) v(12) v(13) v(14) v(15) v(16) v(17) v(18)
print i(vs0) i(vs1) i(vs2) i(vs3) i(vs4) i(vs5) i(vs6) i(vs7) i(vs8) i(vs9)
print i(vs10) i(vs11) i(vs12) i(vs13) i(vs14) i(vs15) i(vs16) i(vs17) i(vs18) i(vs19)
print i(vs20) i(vs21) i(vs22) i(vs23) i(vs24) i(vs25) i(vs26) i(vs27) i(vs28) i(vs29)
print i(vs30) i(vs31) i(vs32)
.endc
.end
