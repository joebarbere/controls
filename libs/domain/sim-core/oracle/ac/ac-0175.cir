controls oracle ac-0175
* Generated (plan F2.7, ADR 0012): do not edit; regenerate with `pnpm sim oracle regen`. ac seed 20261031 index 175 nodes 19 elements 28
.options sparse gmin=1e-12 noopac
RG1 1 0 1000000000000
RG2 2 0 1000000000000
RG3 3 0 1000000000000
RG4 4 0 1000000000000
RG5 5 0 1000000000000
RG6 6 0 1000000000000
RG7 7 0 1000000000000
RG8 8 0 1000000000000
RG9 9 0 1000000000000
RG10 10 0 1000000000000
RG11 11 0 1000000000000
RG12 12 0 1000000000000
RG13 13 0 1000000000000
RG14 14 0 1000000000000
RG15 15 0 1000000000000
RG16 16 0 1000000000000
RG17 17 0 1000000000000
RG18 18 0 1000000000000
VS0 8 s0 0
R0 s0 4 47e1
VS1 8 s1 0
R1 s1 5 18e1
VS2 0 s2 0
V2 e2 s2 DC 0 AC 27e-1 -120
RI2 e2 5 82e-1
VS3 0 s3 0
V3 e3 s3 DC 0 AC 47e-1 0
RI3 e3 3 33e-3
VS4 14 s4 0
C4 s4 16 33e-4
VS5 14 s5 0
L5 s5 8 27e-5
VS6 7 s6 0
L6 s6 12 27e-4
VS7 16 s7 0
C7 s7 13 33e-6
VS8 2 s8 0
L8 s8 10 39e-2
VS9 8 s9 0
V9 e9 s9 DC 0 AC 33e0 180
RI9 e9 11 39e-3
VS10 18 s10 0
R10 s10 1 12e-2
VS11 16 s11 0
R11 s11 1 82e3
VS12 6 s12 0
R12 s12 12 12e2
VS13 6 s13 0
R13 s13 9 22e0
VS14 3 s14 0
C14 s14 18 12e-5
VS15 5 s15 0
C15 s15 2 12e-5
VS16 13 s16 0
R16 s16 16 82e3
VS17 17 s17 0
V17 e17 s17 DC 0 AC 27e1 180
RI17 e17 7 22e-2
VS18 8 s18 0
V18 e18 s18 DC 0 AC 47e1 120
RI18 e18 14 15e-3
VS19 16 s19 0
V19 e19 s19 DC 0 AC 18e-1 180
RI19 e19 5 47e-1
VS20 6 s20 0
L20 s20 5 18e-3
VS21 8 s21 0
C21 s21 3 10e-6
VS22 0 s22 0
V22 e22 s22 DC 0 AC 22e0 120
RI22 e22 6 12e-2
VS23 10 s23 0
C23 s23 18 22e-4
VS24 6 s24 0
R24 s24 5 82e1
VS25 2 s25 0
R25 s25 1 27e0
VS26 15 s26 0
V26 e26 s26 DC 0 AC 22e0 120
RI26 e26 2 47e-2
VS27 18 s27 0
V27 e27 s27 DC 0 AC 10e-1 180
RI27 e27 0 15e-2
.control
set numdgt=17
ac lin 1 60 60
print v(1) v(2) v(3) v(4) v(5) v(6) v(7) v(8) v(9) v(10)
print v(11) v(12) v(13) v(14) v(15) v(16) v(17) v(18)
print i(vs0) i(vs1) i(vs2) i(vs3) i(vs4) i(vs5) i(vs6) i(vs7) i(vs8) i(vs9)
print i(vs10) i(vs11) i(vs12) i(vs13) i(vs14) i(vs15) i(vs16) i(vs17) i(vs18) i(vs19)
print i(vs20) i(vs21) i(vs22) i(vs23) i(vs24) i(vs25) i(vs26) i(vs27)
.endc
.end
