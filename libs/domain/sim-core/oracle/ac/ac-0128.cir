controls oracle ac-0128
* Generated (plan F2.7, ADR 0012): do not edit; regenerate with `pnpm sim oracle regen`. ac seed 20261031 index 128 nodes 29 elements 37
.options sparse gmin=1e-12 noopac
RG1 1 0 1000000000000
RG2 2 0 1000000000000
RG3 3 0 1000000000000
RG4 4 0 1000000000000
RG5 5 0 1000000000000
RG6 6 0 1000000000000
RG7 7 0 1000000000000
RG8 8 0 1000000000000
RG9 9 0 1000000000000
RG10 10 0 1000000000000
RG11 11 0 1000000000000
RG12 12 0 1000000000000
RG13 13 0 1000000000000
RG14 14 0 1000000000000
RG15 15 0 1000000000000
RG16 16 0 1000000000000
RG17 17 0 1000000000000
RG18 18 0 1000000000000
RG19 19 0 1000000000000
RG20 20 0 1000000000000
RG21 21 0 1000000000000
RG22 22 0 1000000000000
RG23 23 0 1000000000000
RG24 24 0 1000000000000
RG25 25 0 1000000000000
RG26 26 0 1000000000000
RG27 27 0 1000000000000
RG28 28 0 1000000000000
VS0 10 s0 0
R0 s0 17 47e1
VS1 5 s1 0
C1 s1 26 47e-7
VS2 28 s2 0
C2 s2 24 47e-7
VS3 4 s3 0
R3 s3 2 33e-2
VS4 19 s4 0
L4 s4 15 27e-2
VS5 2 s5 0
C5 s5 0 39e-4
VS6 21 s6 0
L6 s6 20 10e-2
VS7 28 s7 0
L7 s7 12 22e-5
VS8 14 s8 0
R8 s8 13 47e-1
VS9 8 s9 0
L9 s9 4 47e-3
VS10 24 s10 0
C10 s10 19 27e-5
VS11 0 s11 0
V11 e11 s11 DC 0 AC 47e-1 0
RI11 e11 8 22e-2
VS12 17 s12 0
C12 s12 11 82e-4
VS13 11 s13 0
L13 s13 21 12e-5
VS14 11 s14 0
R14 s14 4 15e1
VS15 9 s15 0
C15 s15 21 47e-4
VS16 13 s16 0
R16 s16 11 56e3
VS17 11 s17 0
R17 s17 19 82e-1
VS18 6 s18 0
R18 s18 4 33e1
VS19 9 s19 0
V19 e19 s19 DC 0 AC 68e1 180
RI19 e19 3 68e-3
VS20 7 s20 0
L20 s20 4 47e-2
VS21 18 s21 0
V21 e21 s21 DC 0 AC 18e1 180
RI21 e21 5 12e-3
VS22 24 s22 0
L22 s22 0 22e-2
VS23 8 s23 0
V23 e23 s23 DC 0 AC 56e0 0
RI23 e23 27 56e-2
VS24 21 s24 0
R24 s24 10 10e-1
VS25 1 s25 0
R25 s25 8 12e0
VS26 26 s26 0
C26 s26 19 10e-4
VS27 28 s27 0
V27 e27 s27 DC 0 AC 12e-1 -120
RI27 e27 26 47e-2
VS28 6 s28 0
C28 s28 17 82e-4
VS29 2 s29 0
R29 s29 13 18e3
VS30 5 s30 0
R30 s30 22 33e-2
VS31 23 s31 0
R31 s31 15 82e-2
VS32 15 s32 0
R32 s32 19 47e3
VS33 5 s33 0
R33 s33 12 56e3
VS34 4 s34 0
V34 e34 s34 DC 0 AC 18e0 -120
RI34 e34 25 27e-2
VS35 13 s35 0
L35 s35 0 10e-3
VS36 16 s36 0
R36 s36 12 82e3
.control
set numdgt=17
ac lin 1 60 60
print v(1) v(2) v(3) v(4) v(5) v(6) v(7) v(8) v(9) v(10)
print v(11) v(12) v(13) v(14) v(15) v(16) v(17) v(18) v(19) v(20)
print v(21) v(22) v(23) v(24) v(25) v(26) v(27) v(28)
print i(vs0) i(vs1) i(vs2) i(vs3) i(vs4) i(vs5) i(vs6) i(vs7) i(vs8) i(vs9)
print i(vs10) i(vs11) i(vs12) i(vs13) i(vs14) i(vs15) i(vs16) i(vs17) i(vs18) i(vs19)
print i(vs20) i(vs21) i(vs22) i(vs23) i(vs24) i(vs25) i(vs26) i(vs27) i(vs28) i(vs29)
print i(vs30) i(vs31) i(vs32) i(vs33) i(vs34) i(vs35) i(vs36)
.endc
.end
