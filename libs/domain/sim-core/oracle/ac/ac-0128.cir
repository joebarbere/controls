controls oracle ac-0128
* Generated (plan F2.7, ADR 0012): do not edit; regenerate with `pnpm sim oracle regen`. ac seed 20261031 index 128 nodes 29 elements 43
.options sparse gmin=1e-12 noopac
RG1 1 0 1000000000000
RG2 2 0 1000000000000
RG3 3 0 1000000000000
RG4 4 0 1000000000000
RG5 5 0 1000000000000
RG6 6 0 1000000000000
RG7 7 0 1000000000000
RG8 8 0 1000000000000
RG9 9 0 1000000000000
RG10 10 0 1000000000000
RG11 11 0 1000000000000
RG12 12 0 1000000000000
RG13 13 0 1000000000000
RG14 14 0 1000000000000
RG15 15 0 1000000000000
RG16 16 0 1000000000000
RG17 17 0 1000000000000
RG18 18 0 1000000000000
RG19 19 0 1000000000000
RG20 20 0 1000000000000
RG21 21 0 1000000000000
RG22 22 0 1000000000000
RG23 23 0 1000000000000
RG24 24 0 1000000000000
RG25 25 0 1000000000000
RG26 26 0 1000000000000
RG27 27 0 1000000000000
RG28 28 0 1000000000000
VS0 0 s0 0
V0 e0 s0 DC 0 AC 68e1 180
RI0 e0 m0 68e-3
LI0 m0 7 18e-7
VS1 26 s1 0
R1 s1 2 33e-1
VS2 4 s2 0
C2 s2 27 82e-5
VS3 6 s3 0
C3 s3 7 27e-5
VS4 15 s4 0
R4 s4 18 47e3
VS5 11 s5 0
L5 s5 21 12e-5
VS6 13 s6 0
R6 s6 10 39e0
VS7 1 s7 0
L7 s7 23 33e-5
VS8 9 s8 0
C8 s8 21 47e-4
VS9 11 s9 0
R9 s9 4 15e1
VS10 17 s10 0
L10 s10 28 10e-2
VS11 1 s11 0
R11 s11 18 47e-1
VS12 13 s12 0
R12 s12 14 56e-1
VS13 17 s13 0
R13 s13 23 12e0
VS14 24 s14 0
L14 s14 0 82e-3
VS15 4 s15 0
V15 e15 s15 DC 0 AC 18e0 -120
RI15 e15 25 27e-2
VS16 11 s16 0
R16 s16 18 82e-1
VS17 20 s17 0
L17 s17 28 56e-2
VS18 6 s18 0
R18 s18 21 56e1
VS19 25 s19 0
L19 s19 16 18e-2
VS20 3 s20 0
C20 s20 5 82e-4
VS21 23 s21 0
R21 s21 15 82e-2
VS22 13 s22 0
R22 s22 24 33e-2
VS23 5 s23 0
V23 e23 s23 DC 0 AC 68e1 -120
RI23 e23 19 10e-2
VS24 17 s24 0
V24 e24 s24 DC 0 AC 10e-1 0
RI24 e24 m24 68e-3
LI24 m24 12 47e-7
VS25 1 s25 0
C25 s25 2 22e-7
VS26 27 s26 0
C26 s26 0 12e-7
VS27 21 s27 0
L27 s27 20 10e-2
VS28 25 s28 0
L28 s28 19 39e-2
VS29 4 s29 0
C29 s29 10 10e-6
VS30 3 s30 0
L30 s30 14 18e-2
VS31 8 s31 0
L31 s31 4 47e-3
VS32 18 s32 0
L32 s32 8 27e-4
VS33 16 s33 0
R33 s33 21 10e3
VS34 0 s34 0
C34 s34 25 15e-6
VS35 26 s35 0
C35 s35 18 10e-4
VS36 5 s36 0
C36 s36 26 47e-7
VS37 13 s37 0
L37 s37 25 27e-5
VS38 21 s38 0
R38 s38 22 18e1
VS39 5 s39 0
C39 s39 9 82e-5
VS40 13 s40 0
R40 s40 12 33e0
VS41 4 s41 0
R41 s41 22 33e-2
VS42 24 s42 0
R42 s42 4 10e-1
.control
set numdgt=17
ac lin 1 60 60
print v(1) v(2) v(3) v(4) v(5) v(6) v(7) v(8) v(9) v(10)
print v(11) v(12) v(13) v(14) v(15) v(16) v(17) v(18) v(19) v(20)
print v(21) v(22) v(23) v(24) v(25) v(26) v(27) v(28)
print i(vs0) i(vs1) i(vs2) i(vs3) i(vs4) i(vs5) i(vs6) i(vs7) i(vs8) i(vs9)
print i(vs10) i(vs11) i(vs12) i(vs13) i(vs14) i(vs15) i(vs16) i(vs17) i(vs18) i(vs19)
print i(vs20) i(vs21) i(vs22) i(vs23) i(vs24) i(vs25) i(vs26) i(vs27) i(vs28) i(vs29)
print i(vs30) i(vs31) i(vs32) i(vs33) i(vs34) i(vs35) i(vs36) i(vs37) i(vs38) i(vs39)
print i(vs40) i(vs41) i(vs42)
.endc
.end
