controls oracle ac-0128
* Generated (plan F2.7, ADR 0012): do not edit; regenerate with `pnpm sim oracle regen`. ac seed 20261031 index 128 nodes 29 elements 47
.options sparse gmin=1e-12 noopac
RG1 1 0 1000000000000
RG2 2 0 1000000000000
RG3 3 0 1000000000000
RG4 4 0 1000000000000
RG5 5 0 1000000000000
RG6 6 0 1000000000000
RG7 7 0 1000000000000
RG8 8 0 1000000000000
RG9 9 0 1000000000000
RG10 10 0 1000000000000
RG11 11 0 1000000000000
RG12 12 0 1000000000000
RG13 13 0 1000000000000
RG14 14 0 1000000000000
RG15 15 0 1000000000000
RG16 16 0 1000000000000
RG17 17 0 1000000000000
RG18 18 0 1000000000000
RG19 19 0 1000000000000
RG20 20 0 1000000000000
RG21 21 0 1000000000000
RG22 22 0 1000000000000
RG23 23 0 1000000000000
RG24 24 0 1000000000000
RG25 25 0 1000000000000
RG26 26 0 1000000000000
RG27 27 0 1000000000000
RG28 28 0 1000000000000
VS0 4 s0 0
R0 s0 2 33e-2
VS1 2 s1 0
C1 s1 19 39e-4
VS2 1 s2 0
R2 s2 8 12e0
VS3 21 s3 0
L3 s3 20 10e-2
VS4 1 s4 0
R4 s4 19 47e0
VS5 23 s5 0
R5 s5 15 82e-2
VS6 5 s6 0
R6 s6 22 33e-2
VS7 11 s7 0
R7 s7 9 82e-1
VS8 7 s8 0
C8 s8 2 22e-6
VS9 0 s9 0
V9 e9 s9 DC 0 AC 68e1 180
RI9 e9 3 68e-3
VS10 16 s10 0
R10 s10 12 82e3
VS11 6 s11 0
R11 s11 4 33e1
VS12 7 s12 0
L12 s12 4 47e-2
VS13 8 s13 0
V13 e13 s13 DC 0 AC 56e0 0
RI13 e13 27 56e-2
VS14 9 s14 0
L14 s14 15 27e-2
VS15 6 s15 0
C15 s15 17 82e-4
VS16 25 s16 0
R16 s16 11 12e3
VS17 22 s17 0
L17 s17 16 39e-5
VS18 23 s18 0
C18 s18 18 18e-7
VS19 5 s19 0
C19 s19 26 47e-7
VS20 28 s20 0
L20 s20 12 22e-5
VS21 14 s21 0
R21 s21 13 47e-1
VS22 18 s22 0
V22 e22 s22 DC 0 AC 18e1 180
RI22 e22 5 12e-3
VS23 5 s23 0
R23 s23 12 56e3
VS24 2 s24 0
R24 s24 13 18e3
VS25 14 s25 0
V25 e25 s25 DC 0 AC 18e-1 0
RI25 e25 9 10e-1
VS26 11 s26 0
R26 s26 4 15e1
VS27 8 s27 0
V27 e27 s27 DC 0 AC 27e-1 180
RI27 e27 18 33e-1
VS28 15 s28 0
R28 s28 9 47e3
VS29 10 s29 0
R29 s29 17 47e1
VS30 13 s30 0
L30 s30 19 10e-3
VS31 21 s31 0
R31 s31 10 10e-1
VS32 28 s32 0
C32 s32 24 47e-7
VS33 27 s33 0
V33 e33 s33 DC 0 AC 18e-1 0
RI33 e33 0 18e-1
VS34 17 s34 0
C34 s34 11 82e-4
VS35 13 s35 0
R35 s35 11 56e3
VS36 8 s36 0
L36 s36 4 47e-3
VS37 0 s37 0
C37 s37 21 47e-4
VS38 24 s38 0
C38 s38 9 27e-5
VS39 27 s39 0
L39 s39 20 15e-2
VS40 4 s40 0
V40 e40 s40 DC 0 AC 18e0 -120
RI40 e40 25 27e-2
VS41 26 s41 0
C41 s41 9 10e-4
VS42 28 s42 0
V42 e42 s42 DC 0 AC 12e-1 -120
RI42 e42 26 47e-2
VS43 24 s43 0
L43 s43 19 22e-2
VS44 19 s44 0
V44 e44 s44 DC 0 AC 47e-1 0
RI44 e44 8 22e-2
VS45 3 s45 0
L45 s45 21 22e-5
VS46 11 s46 0
L46 s46 21 12e-5
.control
set numdgt=17
ac lin 1 60 60
print v(1) v(2) v(3) v(4) v(5) v(6) v(7) v(8) v(9) v(10)
print v(11) v(12) v(13) v(14) v(15) v(16) v(17) v(18) v(19) v(20)
print v(21) v(22) v(23) v(24) v(25) v(26) v(27) v(28)
print i(vs0) i(vs1) i(vs2) i(vs3) i(vs4) i(vs5) i(vs6) i(vs7) i(vs8) i(vs9)
print i(vs10) i(vs11) i(vs12) i(vs13) i(vs14) i(vs15) i(vs16) i(vs17) i(vs18) i(vs19)
print i(vs20) i(vs21) i(vs22) i(vs23) i(vs24) i(vs25) i(vs26) i(vs27) i(vs28) i(vs29)
print i(vs30) i(vs31) i(vs32) i(vs33) i(vs34) i(vs35) i(vs36) i(vs37) i(vs38) i(vs39)
print i(vs40) i(vs41) i(vs42) i(vs43) i(vs44) i(vs45) i(vs46)
.endc
.end
