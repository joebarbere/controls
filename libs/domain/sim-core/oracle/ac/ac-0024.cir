controls oracle ac-0024
* Generated (plan F2.7, ADR 0012): do not edit; regenerate with `pnpm sim oracle regen`. ac seed 20261031 index 24 nodes 28 elements 57
.options sparse gmin=1e-12 noopac
RG1 1 0 1000000000000
RG2 2 0 1000000000000
RG3 3 0 1000000000000
RG4 4 0 1000000000000
RG5 5 0 1000000000000
RG6 6 0 1000000000000
RG7 7 0 1000000000000
RG8 8 0 1000000000000
RG9 9 0 1000000000000
RG10 10 0 1000000000000
RG11 11 0 1000000000000
RG12 12 0 1000000000000
RG13 13 0 1000000000000
RG14 14 0 1000000000000
RG15 15 0 1000000000000
RG16 16 0 1000000000000
RG17 17 0 1000000000000
RG18 18 0 1000000000000
RG19 19 0 1000000000000
RG20 20 0 1000000000000
RG21 21 0 1000000000000
RG22 22 0 1000000000000
RG23 23 0 1000000000000
RG24 24 0 1000000000000
RG25 25 0 1000000000000
RG26 26 0 1000000000000
RG27 27 0 1000000000000
VS0 24 s0 0
L0 s0 10 22e-2
VS1 6 s1 0
R1 s1 0 10e-1
VS2 13 s2 0
R2 s2 16 27e-2
VS3 19 s3 0
R3 s3 1 18e-2
VS4 24 s4 0
L4 s4 6 18e-2
VS5 20 s5 0
C5 s5 24 47e-7
VS6 14 s6 0
R6 s6 5 39e1
VS7 6 s7 0
C7 s7 19 10e-6
VS8 6 s8 0
L8 s8 25 10e-4
VS9 2 s9 0
L9 s9 11 56e-5
VS10 11 s10 0
L10 s10 10 10e-3
VS11 21 s11 0
L11 s11 12 68e-3
VS12 0 s12 0
V12 e12 s12 DC 0 AC 39e1 -120
RI12 e12 20 12e-2
VS13 1 s13 0
L13 s13 10 12e-5
VS14 5 s14 0
L14 s14 6 22e-2
VS15 22 s15 0
R15 s15 11 33e3
VS16 12 s16 0
L16 s16 23 10e-2
VS17 24 s17 0
V17 e17 s17 DC 0 AC 68e1 120
RI17 e17 m17 22e-2
LI17 m17 12 12e-6
VS18 11 s18 0
L18 s18 22 47e-4
VS19 27 s19 0
C19 s19 26 27e-5
VS20 2 s20 0
L20 s20 18 22e-4
VS21 16 s21 0
R21 s21 10 47e1
VS22 24 s22 0
R22 s22 3 33e-2
VS23 13 s23 0
C23 s23 18 39e-4
VS24 2 s24 0
L24 s24 1 10e-4
VS25 27 s25 0
R25 s25 25 39e3
VS26 15 s26 0
R26 s26 6 68e1
VS27 10 s27 0
R27 s27 16 47e-1
VS28 17 s28 0
R28 s28 22 10e2
VS29 27 s29 0
V29 e29 s29 DC 0 AC 39e1 -120
RI29 e29 m29 10e-1
LI29 m29 24 47e-7
VS30 0 s30 0
R30 s30 10 15e-1
VS31 14 s31 0
R31 s31 12 22e0
VS32 8 s32 0
C32 s32 21 10e-5
VS33 3 s33 0
L33 s33 6 68e-3
VS34 12 s34 0
R34 s34 20 15e0
VS35 13 s35 0
C35 s35 21 15e-4
VS36 11 s36 0
V36 e36 s36 DC 0 AC 33e-1 -120
RI36 e36 m36 27e-3
LI36 m36 26 12e-7
VS37 15 s37 0
R37 s37 3 39e3
VS38 7 s38 0
V38 e38 s38 DC 0 AC 12e1 180
RI38 e38 23 27e-3
VS39 13 s39 0
R39 s39 3 47e-2
VS40 3 s40 0
V40 e40 s40 DC 0 AC 18e-1 180
RI40 e40 22 56e-1
VS41 8 s41 0
R41 s41 3 18e3
VS42 10 s42 0
L42 s42 27 12e-3
VS43 24 s43 0
V43 e43 s43 DC 0 AC 56e-1 120
RI43 e43 7 27e-1
VS44 9 s44 0
L44 s44 16 27e-4
VS45 10 s45 0
C45 s45 8 47e-6
VS46 11 s46 0
C46 s46 27 27e-6
VS47 17 s47 0
L47 s47 8 82e-5
VS48 4 s48 0
R48 s48 22 18e-1
VS49 20 s49 0
R49 s49 21 33e1
VS50 17 s50 0
C50 s50 10 39e-5
VS51 4 s51 0
V51 e51 s51 DC 0 AC 22e0 120
RI51 e51 26 18e-1
VS52 6 s52 0
C52 s52 9 33e-4
VS53 7 s53 0
L53 s53 2 18e-5
VS54 11 s54 0
R54 s54 8 15e-1
VS55 20 s55 0
L55 s55 5 15e-5
VS56 16 s56 0
C56 s56 24 82e-6
.control
set numdgt=17
ac lin 1 60 60
print v(1) v(2) v(3) v(4) v(5) v(6) v(7) v(8) v(9) v(10)
print v(11) v(12) v(13) v(14) v(15) v(16) v(17) v(18) v(19) v(20)
print v(21) v(22) v(23) v(24) v(25) v(26) v(27)
print i(vs0) i(vs1) i(vs2) i(vs3) i(vs4) i(vs5) i(vs6) i(vs7) i(vs8) i(vs9)
print i(vs10) i(vs11) i(vs12) i(vs13) i(vs14) i(vs15) i(vs16) i(vs17) i(vs18) i(vs19)
print i(vs20) i(vs21) i(vs22) i(vs23) i(vs24) i(vs25) i(vs26) i(vs27) i(vs28) i(vs29)
print i(vs30) i(vs31) i(vs32) i(vs33) i(vs34) i(vs35) i(vs36) i(vs37) i(vs38) i(vs39)
print i(vs40) i(vs41) i(vs42) i(vs43) i(vs44) i(vs45) i(vs46) i(vs47) i(vs48) i(vs49)
print i(vs50) i(vs51) i(vs52) i(vs53) i(vs54) i(vs55) i(vs56)
.endc
.end
