controls oracle ac-0024
* Generated (plan F2.7, ADR 0012): do not edit; regenerate with `pnpm sim oracle regen`. ac seed 20261031 index 24 nodes 28 elements 54
.options sparse gmin=1e-12 noopac
RG1 1 0 1000000000000
RG2 2 0 1000000000000
RG3 3 0 1000000000000
RG4 4 0 1000000000000
RG5 5 0 1000000000000
RG6 6 0 1000000000000
RG7 7 0 1000000000000
RG8 8 0 1000000000000
RG9 9 0 1000000000000
RG10 10 0 1000000000000
RG11 11 0 1000000000000
RG12 12 0 1000000000000
RG13 13 0 1000000000000
RG14 14 0 1000000000000
RG15 15 0 1000000000000
RG16 16 0 1000000000000
RG17 17 0 1000000000000
RG18 18 0 1000000000000
RG19 19 0 1000000000000
RG20 20 0 1000000000000
RG21 21 0 1000000000000
RG22 22 0 1000000000000
RG23 23 0 1000000000000
RG24 24 0 1000000000000
RG25 25 0 1000000000000
RG26 26 0 1000000000000
RG27 27 0 1000000000000
VS0 2 s0 0
L0 s0 11 56e-5
VS1 1 s1 0
L1 s1 10 12e-5
VS2 0 s2 0
V2 e2 s2 DC 0 AC 18e-1 180
RI2 e2 22 56e-1
VS3 11 s3 0
C3 s3 27 27e-6
VS4 11 s4 0
R4 s4 8 15e-1
VS5 15 s5 0
R5 s5 0 39e3
VS6 4 s6 0
R6 s6 22 18e-1
VS7 27 s7 0
V7 e7 s7 DC 0 AC 39e1 -120
RI7 e7 3 10e-1
VS8 10 s8 0
L8 s8 27 12e-3
VS9 3 s9 0
V9 e9 s9 DC 0 AC 68e1 120
RI9 e9 12 22e-2
VS10 17 s10 0
R10 s10 22 10e2
VS11 5 s11 0
L11 s11 6 22e-2
VS12 3 s12 0
V12 e12 s12 DC 0 AC 56e-1 120
RI12 e12 7 27e-1
VS13 14 s13 0
R13 s13 12 22e0
VS14 15 s14 0
R14 s14 6 68e1
VS15 13 s15 0
R15 s15 0 47e-2
VS16 20 s16 0
R16 s16 21 33e1
VS17 4 s17 0
V17 e17 s17 DC 0 AC 22e0 120
RI17 e17 26 18e-1
VS18 3 s18 0
R18 s18 0 33e-2
VS19 10 s19 0
R19 s19 16 47e-1
VS20 8 s20 0
C20 s20 21 10e-5
VS21 20 s21 0
C21 s21 3 47e-7
VS22 13 s22 0
C22 s22 21 15e-4
VS23 6 s23 0
C23 s23 19 10e-6
VS24 2 s24 0
L24 s24 18 22e-4
VS25 8 s25 0
R25 s25 0 18e3
VS26 6 s26 0
R26 s26 24 10e-1
VS27 16 s27 0
R27 s27 10 47e1
VS28 0 s28 0
L28 s28 6 68e-3
VS29 24 s29 0
V29 e29 s29 DC 0 AC 39e1 -120
RI29 e29 20 12e-2
VS30 14 s30 0
R30 s30 5 39e1
VS31 20 s31 0
L31 s31 5 15e-5
VS32 17 s32 0
C32 s32 10 39e-5
VS33 11 s33 0
L33 s33 10 10e-3
VS34 27 s34 0
C34 s34 26 27e-5
VS35 12 s35 0
L35 s35 23 10e-2
VS36 11 s36 0
L36 s36 22 47e-4
VS37 9 s37 0
L37 s37 16 27e-4
VS38 11 s38 0
V38 e38 s38 DC 0 AC 33e-1 -120
RI38 e38 26 27e-3
VS39 13 s39 0
R39 s39 16 27e-2
VS40 17 s40 0
L40 s40 8 82e-5
VS41 21 s41 0
L41 s41 12 68e-3
VS42 7 s42 0
L42 s42 2 18e-5
VS43 16 s43 0
C43 s43 3 82e-6
VS44 27 s44 0
R44 s44 25 39e3
VS45 10 s45 0
C45 s45 8 47e-6
VS46 22 s46 0
R46 s46 11 33e3
VS47 12 s47 0
R47 s47 20 15e0
VS48 24 s48 0
R48 s48 10 15e-1
VS49 2 s49 0
L49 s49 1 10e-4
VS50 3 s50 0
L50 s50 6 18e-2
VS51 3 s51 0
L51 s51 10 22e-2
VS52 6 s52 0
C52 s52 9 33e-4
VS53 7 s53 0
V53 e53 s53 DC 0 AC 12e1 180
RI53 e53 23 27e-3
.control
set numdgt=17
ac lin 1 60 60
print v(1) v(2) v(3) v(4) v(5) v(6) v(7) v(8) v(9) v(10)
print v(11) v(12) v(13) v(14) v(15) v(16) v(17) v(18) v(19) v(20)
print v(21) v(22) v(23) v(24) v(25) v(26) v(27)
print i(vs0) i(vs1) i(vs2) i(vs3) i(vs4) i(vs5) i(vs6) i(vs7) i(vs8) i(vs9)
print i(vs10) i(vs11) i(vs12) i(vs13) i(vs14) i(vs15) i(vs16) i(vs17) i(vs18) i(vs19)
print i(vs20) i(vs21) i(vs22) i(vs23) i(vs24) i(vs25) i(vs26) i(vs27) i(vs28) i(vs29)
print i(vs30) i(vs31) i(vs32) i(vs33) i(vs34) i(vs35) i(vs36) i(vs37) i(vs38) i(vs39)
print i(vs40) i(vs41) i(vs42) i(vs43) i(vs44) i(vs45) i(vs46) i(vs47) i(vs48) i(vs49)
print i(vs50) i(vs51) i(vs52) i(vs53)
.endc
.end
