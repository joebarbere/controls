controls oracle ac-0024
* Generated (plan F2.7, ADR 0012): do not edit; regenerate with `pnpm sim oracle regen`. ac seed 20261031 index 24 nodes 28 elements 52
.options sparse gmin=1e-12 noopac
RG1 1 0 1000000000000
RG2 2 0 1000000000000
RG3 3 0 1000000000000
RG4 4 0 1000000000000
RG5 5 0 1000000000000
RG6 6 0 1000000000000
RG7 7 0 1000000000000
RG8 8 0 1000000000000
RG9 9 0 1000000000000
RG10 10 0 1000000000000
RG11 11 0 1000000000000
RG12 12 0 1000000000000
RG13 13 0 1000000000000
RG14 14 0 1000000000000
RG15 15 0 1000000000000
RG16 16 0 1000000000000
RG17 17 0 1000000000000
RG18 18 0 1000000000000
RG19 19 0 1000000000000
RG20 20 0 1000000000000
RG21 21 0 1000000000000
RG22 22 0 1000000000000
RG23 23 0 1000000000000
RG24 24 0 1000000000000
RG25 25 0 1000000000000
RG26 26 0 1000000000000
RG27 27 0 1000000000000
VS0 14 s0 0
R0 s0 18 82e-1
VS1 1 s1 0
C1 s1 16 39e-5
VS2 24 s2 0
R2 s2 23 33e0
VS3 16 s3 0
L3 s3 10 22e-2
VS4 1 s4 0
L4 s4 13 12e-5
VS5 16 s5 0
L5 s5 6 18e-2
VS6 8 s6 0
C6 s6 21 10e-5
VS7 14 s7 0
C7 s7 26 39e-7
VS8 0 s8 0
V8 e8 s8 DC 0 AC 10e1 0
RI8 e8 27 15e-3
VS9 11 s9 0
C9 s9 12 22e-5
VS10 11 s10 0
V10 e10 s10 DC 0 AC 33e-1 -120
RI10 e10 26 27e-3
VS11 18 s11 0
R11 s11 1 39e1
VS12 2 s12 0
L12 s12 11 56e-5
VS13 11 s13 0
R13 s13 8 15e-1
VS14 6 s14 0
V14 e14 s14 DC 0 AC 82e0 0
RI14 e14 m14 27e-1
LI14 m14 5 82e-6
VS15 27 s15 0
L15 s15 12 15e-3
VS16 21 s16 0
L16 s16 20 18e-2
VS17 17 s17 0
C17 s17 10 39e-5
VS18 25 s18 0
R18 s18 22 33e0
VS19 6 s19 0
L19 s19 26 10e-2
VS20 12 s20 0
R20 s20 20 15e0
VS21 10 s21 0
V21 e21 s21 DC 0 AC 33e0 120
RI21 e21 m21 33e-3
LI21 m21 26 27e-5
VS22 9 s22 0
V22 e22 s22 DC 0 AC 12e0 -120
RI22 e22 m22 33e-1
LI22 m22 5 12e-7
VS23 23 s23 0
C23 s23 10 10e-7
VS24 17 s24 0
R24 s24 22 10e2
VS25 20 s25 0
L25 s25 6 15e-3
VS26 2 s26 0
C26 s26 27 15e-4
VS27 17 s27 0
L27 s27 24 39e-4
VS28 1 s28 0
R28 s28 8 12e0
VS29 15 s29 0
R29 s29 21 27e1
VS30 27 s30 0
V30 e30 s30 DC 0 AC 39e1 -120
RI30 e30 16 10e-1
VS31 0 s31 0
C31 s31 1 56e-4
VS32 15 s32 0
L32 s32 4 27e-2
VS33 3 s33 0
V33 e33 s33 DC 0 AC 12e1 -120
RI33 e33 m33 10e-3
LI33 m33 7 15e-7
VS34 0 s34 0
R34 s34 10 47e1
VS35 20 s35 0
R35 s35 21 33e1
VS36 0 s36 0
R36 s36 24 27e2
VS37 3 s37 0
L37 s37 6 68e-3
VS38 0 s38 0
C38 s38 9 22e-6
VS39 16 s39 0
R39 s39 12 27e-2
VS40 0 s40 0
L40 s40 22 12e-5
VS41 8 s41 0
V41 e41 s41 DC 0 AC 33e-1 120
RI41 e41 14 22e-2
VS42 17 s42 0
V42 e42 s42 DC 0 AC 82e-1 120
RI42 e42 m42 22e-2
LI42 m42 15 68e-7
VS43 13 s43 0
R43 s43 19 39e-2
VS44 25 s44 0
L44 s44 17 15e-5
VS45 7 s45 0
R45 s45 16 33e-2
VS46 19 s46 0
R46 s46 10 39e0
VS47 8 s47 0
C47 s47 15 27e-5
VS48 26 s48 0
V48 e48 s48 DC 0 AC 33e-1 180
RI48 e48 m48 15e-2
LI48 m48 27 33e-7
VS49 4 s49 0
R49 s49 0 47e3
VS50 23 s50 0
R50 s50 17 18e1
VS51 20 s51 0
C51 s51 26 10e-6
.control
set numdgt=17
ac lin 1 60 60
print v(1) v(2) v(3) v(4) v(5) v(6) v(7) v(8) v(9) v(10)
print v(11) v(12) v(13) v(14) v(15) v(16) v(17) v(18) v(19) v(20)
print v(21) v(22) v(23) v(24) v(25) v(26) v(27)
print i(vs0) i(vs1) i(vs2) i(vs3) i(vs4) i(vs5) i(vs6) i(vs7) i(vs8) i(vs9)
print i(vs10) i(vs11) i(vs12) i(vs13) i(vs14) i(vs15) i(vs16) i(vs17) i(vs18) i(vs19)
print i(vs20) i(vs21) i(vs22) i(vs23) i(vs24) i(vs25) i(vs26) i(vs27) i(vs28) i(vs29)
print i(vs30) i(vs31) i(vs32) i(vs33) i(vs34) i(vs35) i(vs36) i(vs37) i(vs38) i(vs39)
print i(vs40) i(vs41) i(vs42) i(vs43) i(vs44) i(vs45) i(vs46) i(vs47) i(vs48) i(vs49)
print i(vs50) i(vs51)
.endc
.end
