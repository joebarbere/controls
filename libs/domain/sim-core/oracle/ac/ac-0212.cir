controls oracle ac-0212
* Generated (plan F2.7, ADR 0012): do not edit; regenerate with `pnpm sim oracle regen`. ac seed 20261031 index 212 nodes 9 elements 19
.options sparse gmin=1e-12 noopac
RG1 1 0 1000000000000
RG2 2 0 1000000000000
RG3 3 0 1000000000000
RG4 4 0 1000000000000
RG5 5 0 1000000000000
RG6 6 0 1000000000000
RG7 7 0 1000000000000
RG8 8 0 1000000000000
VS0 0 s0 0
V0 e0 s0 DC 0 AC 39e0 0
RI0 e0 7 12e-3
VS1 4 s1 0
C1 s1 1 10e-6
VS2 3 s2 0
L2 s2 1 33e-4
VS3 4 s3 0
R3 s3 0 33e3
VS4 4 s4 0
V4 e4 s4 DC 0 AC 27e-1 -120
RI4 e4 m4 10e-2
LI4 m4 8 12e-6
VS5 5 s5 0
C5 s5 1 47e-4
VS6 6 s6 0
V6 e6 s6 DC 0 AC 27e-1 120
RI6 e6 m6 82e-3
LI6 m6 8 10e-6
VS7 0 s7 0
C7 s7 8 22e-4
VS8 2 s8 0
R8 s8 0 33e-1
VS9 2 s9 0
L9 s9 0 22e-5
VS10 2 s10 0
C10 s10 5 10e-5
VS11 7 s11 0
V11 e11 s11 DC 0 AC 27e1 0
RI11 e11 0 15e-2
VS12 5 s12 0
R12 s12 2 82e2
VS13 4 s13 0
L13 s13 1 33e-3
VS14 5 s14 0
L14 s14 3 68e-2
VS15 1 s15 0
R15 s15 4 82e3
VS16 0 s16 0
R16 s16 5 18e3
VS17 7 s17 0
C17 s17 4 18e-5
VS18 0 s18 0
V18 e18 s18 DC 0 AC 15e0 120
RI18 e18 m18 82e-3
LI18 m18 6 39e-7
.control
set numdgt=17
ac lin 1 60 60
print v(1) v(2) v(3) v(4) v(5) v(6) v(7) v(8)
print i(vs0) i(vs1) i(vs2) i(vs3) i(vs4) i(vs5) i(vs6) i(vs7) i(vs8) i(vs9)
print i(vs10) i(vs11) i(vs12) i(vs13) i(vs14) i(vs15) i(vs16) i(vs17) i(vs18)
.endc
.end
