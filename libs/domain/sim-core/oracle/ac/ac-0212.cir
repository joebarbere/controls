controls oracle ac-0212
* Generated (plan F2.7, ADR 0012): do not edit; regenerate with `pnpm sim oracle regen`. ac seed 20261031 index 212 nodes 9 elements 12
.options sparse gmin=1e-12 noopac
RG1 1 0 1000000000000
RG2 2 0 1000000000000
RG3 3 0 1000000000000
RG4 4 0 1000000000000
RG5 5 0 1000000000000
RG6 6 0 1000000000000
RG7 7 0 1000000000000
RG8 8 0 1000000000000
VS0 0 s0 0
V0 e0 s0 DC 0 AC 39e-1 -120
RI0 e0 2 39e-2
VS1 5 s1 0
R1 s1 8 82e-1
VS2 0 s2 0
V2 e2 s2 DC 0 AC 39e0 0
RI2 e2 7 12e-3
VS3 5 s3 0
C3 s3 8 68e-5
VS4 3 s4 0
R4 s4 4 82e-2
VS5 3 s5 0
L5 s5 7 68e-3
VS6 1 s6 0
R6 s6 4 82e3
VS7 0 s7 0
C7 s7 8 18e-7
VS8 6 s8 0
L8 s8 7 22e-5
VS9 4 s9 0
R9 s9 0 33e3
VS10 4 s10 0
R10 s10 1 68e3
VS11 0 s11 0
C11 s11 5 15e-4
.control
set numdgt=17
ac lin 1 60 60
print v(1) v(2) v(3) v(4) v(5) v(6) v(7) v(8)
print i(vs0) i(vs1) i(vs2) i(vs3) i(vs4) i(vs5) i(vs6) i(vs7) i(vs8) i(vs9)
print i(vs10) i(vs11)
.endc
.end
