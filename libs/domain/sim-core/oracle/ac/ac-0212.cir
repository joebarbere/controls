controls oracle ac-0212
* Generated (plan F2.7, ADR 0012): do not edit; regenerate with `pnpm sim oracle regen`. ac seed 20261031 index 212 nodes 9 elements 15
.options sparse gmin=1e-12 noopac
RG1 1 0 1000000000000
RG2 2 0 1000000000000
RG3 3 0 1000000000000
RG4 4 0 1000000000000
RG5 5 0 1000000000000
RG6 6 0 1000000000000
RG7 7 0 1000000000000
RG8 8 0 1000000000000
VS0 0 s0 0
C0 s0 8 18e-7
VS1 0 s1 0
V1 e1 s1 DC 0 AC 39e0 0
RI1 e1 m1 12e-3
LI1 m1 7 15e-5
VS2 4 s2 0
R2 s2 0 33e3
VS3 1 s3 0
V3 e3 s3 DC 0 AC 15e1 180
RI3 e3 2 10e-1
VS4 0 s4 0
V4 e4 s4 DC 0 AC 39e-1 -120
RI4 e4 2 39e-2
VS5 1 s5 0
R5 s5 4 82e3
VS6 4 s6 0
R6 s6 1 68e3
VS7 0 s7 0
C7 s7 5 15e-4
VS8 5 s8 0
C8 s8 8 68e-5
VS9 6 s9 0
L9 s9 7 22e-5
VS10 1 s10 0
V10 e10 s10 DC 0 AC 33e-1 0
RI10 e10 8 68e-3
VS11 3 s11 0
L11 s11 7 68e-3
VS12 5 s12 0
R12 s12 6 27e3
VS13 3 s13 0
R13 s13 4 82e-2
VS14 5 s14 0
R14 s14 8 82e-1
.control
set numdgt=17
ac lin 1 60 60
print v(1) v(2) v(3) v(4) v(5) v(6) v(7) v(8)
print i(vs0) i(vs1) i(vs2) i(vs3) i(vs4) i(vs5) i(vs6) i(vs7) i(vs8) i(vs9)
print i(vs10) i(vs11) i(vs12) i(vs13) i(vs14)
.endc
.end
