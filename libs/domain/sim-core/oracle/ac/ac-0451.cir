controls oracle ac-0451
* Generated (plan F2.7, ADR 0012): do not edit; regenerate with `pnpm sim oracle regen`. ac seed 20261031 index 451 nodes 16 elements 21
.options sparse gmin=1e-12 noopac
RG1 1 0 1000000000000
RG2 2 0 1000000000000
RG3 3 0 1000000000000
RG4 4 0 1000000000000
RG5 5 0 1000000000000
RG6 6 0 1000000000000
RG7 7 0 1000000000000
RG8 8 0 1000000000000
RG9 9 0 1000000000000
RG10 10 0 1000000000000
RG11 11 0 1000000000000
RG12 12 0 1000000000000
RG13 13 0 1000000000000
RG14 14 0 1000000000000
RG15 15 0 1000000000000
VS0 7 s0 0
L0 s0 5 22e-3
VS1 2 s1 0
L1 s1 7 10e-5
VS2 12 s2 0
R2 s2 5 47e3
VS3 0 s3 0
V3 e3 s3 DC 0 AC 22e0 0
RI3 e3 5 22e-3
VS4 0 s4 0
L4 s4 5 10e-4
VS5 13 s5 0
R5 s5 8 56e1
VS6 13 s6 0
V6 e6 s6 DC 0 AC 56e1 120
RI6 e6 3 27e-2
VS7 15 s7 0
R7 s7 11 68e2
VS8 11 s8 0
R8 s8 13 18e0
VS9 6 s9 0
C9 s9 12 15e-7
VS10 5 s10 0
L10 s10 4 33e-2
VS11 2 s11 0
L11 s11 5 27e-4
VS12 3 s12 0
R12 s12 7 12e3
VS13 4 s13 0
R13 s13 8 33e3
VS14 0 s14 0
R14 s14 10 15e-1
VS15 1 s15 0
C15 s15 14 33e-6
VS16 13 s16 0
V16 e16 s16 DC 0 AC 18e-1 -120
RI16 e16 9 15e-2
VS17 4 s17 0
L17 s17 12 18e-2
VS18 3 s18 0
V18 e18 s18 DC 0 AC 18e0 180
RI18 e18 5 56e-1
VS19 1 s19 0
R19 s19 7 47e3
VS20 7 s20 0
V20 e20 s20 DC 0 AC 33e0 0
RI20 e20 4 18e-2
.control
set numdgt=17
ac lin 1 60 60
print v(1) v(2) v(3) v(4) v(5) v(6) v(7) v(8) v(9) v(10)
print v(11) v(12) v(13) v(14) v(15)
print i(vs0) i(vs1) i(vs2) i(vs3) i(vs4) i(vs5) i(vs6) i(vs7) i(vs8) i(vs9)
print i(vs10) i(vs11) i(vs12) i(vs13) i(vs14) i(vs15) i(vs16) i(vs17) i(vs18) i(vs19)
print i(vs20)
.endc
.end
