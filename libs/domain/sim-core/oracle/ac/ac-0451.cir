controls oracle ac-0451
* Generated (plan F2.7, ADR 0012): do not edit; regenerate with `pnpm sim oracle regen`. ac seed 20261031 index 451 nodes 16 elements 24
.options sparse gmin=1e-12 noopac
RG1 1 0 1000000000000
RG2 2 0 1000000000000
RG3 3 0 1000000000000
RG4 4 0 1000000000000
RG5 5 0 1000000000000
RG6 6 0 1000000000000
RG7 7 0 1000000000000
RG8 8 0 1000000000000
RG9 9 0 1000000000000
RG10 10 0 1000000000000
RG11 11 0 1000000000000
RG12 12 0 1000000000000
RG13 13 0 1000000000000
RG14 14 0 1000000000000
RG15 15 0 1000000000000
VS0 12 s0 0
C0 s0 3 39e-5
VS1 0 s1 0
L1 s1 9 18e-4
VS2 5 s2 0
R2 s2 4 47e2
VS3 0 s3 0
V3 e3 s3 DC 0 AC 68e-1 -120
RI3 e3 m3 10e-1
LI3 m3 4 15e-7
VS4 6 s4 0
L4 s4 13 33e-2
VS5 4 s5 0
R5 s5 9 33e3
VS6 2 s6 0
R6 s6 15 39e0
VS7 3 s7 0
L7 s7 4 82e-5
VS8 14 s8 0
R8 s8 1 22e2
VS9 8 s9 0
L9 s9 7 33e-4
VS10 0 s10 0
C10 s10 1 56e-6
VS11 10 s11 0
R11 s11 6 10e-2
VS12 7 s12 0
V12 e12 s12 DC 0 AC 33e0 0
RI12 e12 4 18e-2
VS13 13 s13 0
V13 e13 s13 DC 0 AC 27e-1 180
RI13 e13 m13 12e-1
LI13 m13 4 10e-7
VS14 14 s14 0
R14 s14 2 68e-2
VS15 13 s15 0
V15 e15 s15 DC 0 AC 27e-1 0
RI15 e15 m15 22e-1
LI15 m15 2 22e-6
VS16 15 s16 0
C16 s16 12 27e-6
VS17 3 s17 0
V17 e17 s17 DC 0 AC 82e0 0
RI17 e17 m17 47e-3
LI17 m17 1 15e-5
VS18 3 s18 0
L18 s18 10 47e-4
VS19 13 s19 0
L19 s19 11 18e-4
VS20 2 s20 0
R20 s20 8 47e2
VS21 5 s21 0
R21 s21 12 39e3
VS22 11 s22 0
R22 s22 1 18e3
VS23 6 s23 0
V23 e23 s23 DC 0 AC 56e0 180
RI23 e23 m23 22e-2
LI23 m23 1 33e-7
.control
set numdgt=17
ac lin 1 60 60
print v(1) v(2) v(3) v(4) v(5) v(6) v(7) v(8) v(9) v(10)
print v(11) v(12) v(13) v(14) v(15)
print i(vs0) i(vs1) i(vs2) i(vs3) i(vs4) i(vs5) i(vs6) i(vs7) i(vs8) i(vs9)
print i(vs10) i(vs11) i(vs12) i(vs13) i(vs14) i(vs15) i(vs16) i(vs17) i(vs18) i(vs19)
print i(vs20) i(vs21) i(vs22) i(vs23)
.endc
.end
