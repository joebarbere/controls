controls oracle ac-0451
* Generated (plan F2.7, ADR 0012): do not edit; regenerate with `pnpm sim oracle regen`. ac seed 20261031 index 451 nodes 16 elements 25
.options sparse gmin=1e-12 noopac
RG1 1 0 1000000000000
RG2 2 0 1000000000000
RG3 3 0 1000000000000
RG4 4 0 1000000000000
RG5 5 0 1000000000000
RG6 6 0 1000000000000
RG7 7 0 1000000000000
RG8 8 0 1000000000000
RG9 9 0 1000000000000
RG10 10 0 1000000000000
RG11 11 0 1000000000000
RG12 12 0 1000000000000
RG13 13 0 1000000000000
RG14 14 0 1000000000000
RG15 15 0 1000000000000
VS0 8 s0 0
L0 s0 5 10e-4
VS1 0 s1 0
V1 e1 s1 DC 0 AC 56e1 120
RI1 e1 n1 27e-2
H1 n1 h1 VS3 68e-3
ED1 h1 3 d1 0 12e-6
F1 0 d1 VS3 1
LD1 d1 0 1
VS2 6 s2 0
C2 s2 12 15e-7
VS3 7 s3 0
V3 e3 s3 DC 0 AC 33e0 0
RI3 e3 m3 18e-2
LI3 m3 n3 10e-7
H3 n3 h3 VS1 68e-3
ED3 h3 4 d3 0 12e-6
F3 0 d3 VS1 1
LD3 d3 0 1
VS4 3 s4 0
V4 e4 s4 DC 0 AC 18e0 180
RI4 e4 5 56e-1
VS5 0 s5 0
V5 e5 s5 DC 0 AC 18e-1 -120
RI5 e5 m5 15e-2
LI5 m5 9 18e-5
VS6 4 s6 0
L6 s6 12 18e-2
VS7 8 s7 0
V7 e7 s7 DC 0 AC 22e0 0
RI7 e7 5 22e-3
VS8 11 s8 0
R8 s8 0 18e0
VS9 0 s9 0
R9 s9 13 56e1
VS10 15 s10 0
C10 s10 10 82e-5
VS11 12 s11 0
R11 s11 5 47e3
VS12 1 s12 0
R12 s12 7 47e3
VS13 15 s13 0
R13 s13 11 68e2
VS14 3 s14 0
R14 s14 7 12e3
VS15 1 s15 0
C15 s15 14 33e-6
VS16 10 s16 0
L16 s16 9 82e-3
VS17 6 s17 0
R17 s17 13 56e-2
VS18 2 s18 0
L18 s18 7 10e-5
VS19 5 s19 0
L19 s19 4 33e-2
VS20 2 s20 0
L20 s20 5 27e-4
VS21 8 s21 0
R21 s21 10 15e-1
VS22 4 s22 0
R22 s22 13 33e3
VS23 7 s23 0
L23 s23 5 22e-3
VS24 10 s24 0
L24 s24 14 27e-3
.control
set numdgt=17
ac lin 1 60 60
print v(1) v(2) v(3) v(4) v(5) v(6) v(7) v(8) v(9) v(10)
print v(11) v(12) v(13) v(14) v(15)
print i(vs0) i(vs1) i(vs2) i(vs3) i(vs4) i(vs5) i(vs6) i(vs7) i(vs8) i(vs9)
print i(vs10) i(vs11) i(vs12) i(vs13) i(vs14) i(vs15) i(vs16) i(vs17) i(vs18) i(vs19)
print i(vs20) i(vs21) i(vs22) i(vs23) i(vs24)
.endc
.end
