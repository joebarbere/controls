controls oracle ac-0187
* Generated (plan F2.7, ADR 0012): do not edit; regenerate with `pnpm sim oracle regen`. ac seed 20261031 index 187 nodes 30 elements 46
.options sparse gmin=1e-12 noopac
RG1 1 0 1000000000000
RG2 2 0 1000000000000
RG3 3 0 1000000000000
RG4 4 0 1000000000000
RG5 5 0 1000000000000
RG6 6 0 1000000000000
RG7 7 0 1000000000000
RG8 8 0 1000000000000
RG9 9 0 1000000000000
RG10 10 0 1000000000000
RG11 11 0 1000000000000
RG12 12 0 1000000000000
RG13 13 0 1000000000000
RG14 14 0 1000000000000
RG15 15 0 1000000000000
RG16 16 0 1000000000000
RG17 17 0 1000000000000
RG18 18 0 1000000000000
RG19 19 0 1000000000000
RG20 20 0 1000000000000
RG21 21 0 1000000000000
RG22 22 0 1000000000000
RG23 23 0 1000000000000
RG24 24 0 1000000000000
RG25 25 0 1000000000000
RG26 26 0 1000000000000
RG27 27 0 1000000000000
RG28 28 0 1000000000000
RG29 29 0 1000000000000
VS0 22 s0 0
C0 s0 28 68e-7
VS1 7 s1 0
C1 s1 21 22e-4
VS2 1 s2 0
L2 s2 15 12e-3
VS3 21 s3 0
L3 s3 15 82e-3
VS4 0 s4 0
V4 e4 s4 DC 0 AC 33e-1 0
RI4 e4 24 47e-1
VS5 17 s5 0
V5 e5 s5 DC 0 AC 47e0 120
RI5 e5 28 15e-2
VS6 18 s6 0
V6 e6 s6 DC 0 AC 39e-1 120
RI6 e6 2 18e-3
VS7 27 s7 0
V7 e7 s7 DC 0 AC 10e1 120
RI7 e7 25 18e-3
VS8 3 s8 0
C8 s8 22 82e-6
VS9 1 s9 0
R9 s9 28 27e0
VS10 13 s10 0
V10 e10 s10 DC 0 AC 10e0 180
RI10 e10 25 27e-3
VS11 2 s11 0
R11 s11 1 33e2
VS12 2 s12 0
C12 s12 10 12e-4
VS13 29 s13 0
L13 s13 16 47e-4
VS14 28 s14 0
V14 e14 s14 DC 0 AC 12e-1 -120
RI14 e14 17 39e-2
VS15 14 s15 0
R15 s15 28 47e-2
VS16 19 s16 0
V16 e16 s16 DC 0 AC 56e1 0
RI16 e16 13 33e-3
VS17 19 s17 0
R17 s17 2 47e1
VS18 23 s18 0
L18 s18 26 82e-2
VS19 23 s19 0
R19 s19 7 12e1
VS20 6 s20 0
R20 s20 8 82e3
VS21 2 s21 0
C21 s21 6 47e-6
VS22 6 s22 0
R22 s22 25 10e3
VS23 1 s23 0
C23 s23 26 10e-6
VS24 14 s24 0
C24 s24 12 39e-7
VS25 12 s25 0
C25 s25 2 33e-6
VS26 16 s26 0
L26 s26 10 18e-5
VS27 1 s27 0
C27 s27 26 39e-5
VS28 18 s28 0
C28 s28 20 82e-5
VS29 1 s29 0
V29 e29 s29 DC 0 AC 12e-1 120
RI29 e29 19 22e-2
VS30 7 s30 0
R30 s30 23 47e0
VS31 10 s31 0
R31 s31 29 22e0
VS32 2 s32 0
C32 s32 5 68e-5
VS33 26 s33 0
L33 s33 14 15e-3
VS34 26 s34 0
V34 e34 s34 DC 0 AC 12e-1 120
RI34 e34 4 56e-3
VS35 0 s35 0
V35 e35 s35 DC 0 AC 56e0 180
RI35 e35 12 12e-1
VS36 8 s36 0
R36 s36 26 56e1
VS37 23 s37 0
L37 s37 6 39e-2
VS38 1 s38 0
R38 s38 22 47e-1
VS39 13 s39 0
R39 s39 27 10e1
VS40 27 s40 0
V40 e40 s40 DC 0 AC 82e1 120
RI40 e40 11 68e-3
VS41 6 s41 0
L41 s41 11 56e-4
VS42 8 s42 0
L42 s42 0 12e-3
VS43 16 s43 0
C43 s43 14 33e-4
VS44 21 s44 0
L44 s44 14 22e-4
VS45 9 s45 0
R45 s45 20 15e3
.control
set numdgt=17
ac lin 1 60 60
print v(1) v(2) v(3) v(4) v(5) v(6) v(7) v(8) v(9) v(10)
print v(11) v(12) v(13) v(14) v(15) v(16) v(17) v(18) v(19) v(20)
print v(21) v(22) v(23) v(24) v(25) v(26) v(27) v(28) v(29)
print i(vs0) i(vs1) i(vs2) i(vs3) i(vs4) i(vs5) i(vs6) i(vs7) i(vs8) i(vs9)
print i(vs10) i(vs11) i(vs12) i(vs13) i(vs14) i(vs15) i(vs16) i(vs17) i(vs18) i(vs19)
print i(vs20) i(vs21) i(vs22) i(vs23) i(vs24) i(vs25) i(vs26) i(vs27) i(vs28) i(vs29)
print i(vs30) i(vs31) i(vs32) i(vs33) i(vs34) i(vs35) i(vs36) i(vs37) i(vs38) i(vs39)
print i(vs40) i(vs41) i(vs42) i(vs43) i(vs44) i(vs45)
.endc
.end
