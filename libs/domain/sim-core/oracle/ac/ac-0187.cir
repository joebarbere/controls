controls oracle ac-0187
* Generated (plan F2.7, ADR 0012): do not edit; regenerate with `pnpm sim oracle regen`. ac seed 20261031 index 187 nodes 30 elements 61
.options sparse gmin=1e-12 noopac
RG1 1 0 1000000000000
RG2 2 0 1000000000000
RG3 3 0 1000000000000
RG4 4 0 1000000000000
RG5 5 0 1000000000000
RG6 6 0 1000000000000
RG7 7 0 1000000000000
RG8 8 0 1000000000000
RG9 9 0 1000000000000
RG10 10 0 1000000000000
RG11 11 0 1000000000000
RG12 12 0 1000000000000
RG13 13 0 1000000000000
RG14 14 0 1000000000000
RG15 15 0 1000000000000
RG16 16 0 1000000000000
RG17 17 0 1000000000000
RG18 18 0 1000000000000
RG19 19 0 1000000000000
RG20 20 0 1000000000000
RG21 21 0 1000000000000
RG22 22 0 1000000000000
RG23 23 0 1000000000000
RG24 24 0 1000000000000
RG25 25 0 1000000000000
RG26 26 0 1000000000000
RG27 27 0 1000000000000
RG28 28 0 1000000000000
RG29 29 0 1000000000000
VS0 28 s0 0
L0 s0 26 27e-4
VS1 3 s1 0
L1 s1 4 68e-4
VS2 3 s2 0
C2 s2 6 47e-6
VS3 12 s3 0
C3 s3 4 56e-4
VS4 26 s4 0
R4 s4 16 22e-1
VS5 13 s5 0
C5 s5 9 47e-6
VS6 1 s6 0
R6 s6 26 18e-1
VS7 0 s7 0
V7 e7 s7 DC 0 AC 33e-1 180
RI7 e7 m7 18e-1
LI7 m7 11 15e-6
VS8 8 s8 0
R8 s8 17 68e0
VS9 4 s9 0
V9 e9 s9 DC 0 AC 33e-1 120
RI9 e9 m9 82e-1
LI9 m9 8 18e-6
VS10 14 s10 0
R10 s10 15 56e-2
VS11 4 s11 0
L11 s11 3 18e-2
VS12 27 s12 0
V12 e12 s12 DC 0 AC 82e1 120
RI12 e12 m12 68e-3
LI12 m12 11 39e-6
VS13 22 s13 0
C13 s13 16 82e-5
VS14 1 s14 0
C14 s14 7 15e-4
VS15 3 s15 0
C15 s15 5 68e-5
VS16 0 s16 0
C16 s16 22 27e-4
VS17 19 s17 0
C17 s17 7 15e-5
VS18 28 s18 0
C18 s18 23 47e-6
VS19 24 s19 0
V19 e19 s19 DC 0 AC 33e0 -120
RI19 e19 m19 39e-3
LI19 m19 20 27e-6
VS20 13 s20 0
R20 s20 28 56e3
VS21 12 s21 0
C21 s21 3 33e-6
VS22 18 s22 0
R22 s22 27 68e2
VS23 19 s23 0
L23 s23 9 47e-2
VS24 3 s24 0
R24 s24 1 33e2
VS25 19 s25 0
R25 s25 12 27e2
VS26 23 s26 0
R26 s26 12 82e0
VS27 21 s27 0
R27 s27 28 15e3
VS28 23 s28 0
L28 s28 24 82e-3
VS29 0 s29 0
L29 s29 15 56e-4
VS30 12 s30 0
V30 e30 s30 DC 0 AC 33e-1 120
RI30 e30 m30 12e-3
LI30 m30 2 10e-5
VS31 12 s31 0
L31 s31 22 10e-5
VS32 6 s32 0
R32 s32 8 82e3
VS33 9 s33 0
R33 s33 24 47e0
VS34 15 s34 0
R34 s34 23 12e-1
VS35 20 s35 0
L35 s35 15 39e-2
VS36 18 s36 0
C36 s36 10 47e-5
VS37 14 s37 0
C37 s37 12 39e-7
VS38 18 s38 0
R38 s38 20 39e-2
VS39 29 s39 0
C39 s39 5 33e-6
VS40 14 s40 0
C40 s40 9 47e-6
VS41 18 s41 0
L41 s41 1 10e-4
VS42 21 s42 0
C42 s42 15 27e-5
VS43 3 s43 0
L43 s43 20 82e-4
VS44 17 s44 0
R44 s44 19 10e1
VS45 1 s45 0
R45 s45 28 27e0
VS46 17 s46 0
C46 s46 4 33e-7
VS47 24 s47 0
V47 e47 s47 DC 0 AC 56e0 180
RI47 e47 m47 22e-3
LI47 m47 2 33e-7
VS48 1 s48 0
V48 e48 s48 DC 0 AC 12e-1 120
RI48 e48 19 22e-2
VS49 10 s49 0
L49 s49 22 47e-5
VS50 13 s50 0
L50 s50 22 82e-5
VS51 8 s51 0
R51 s51 26 56e1
VS52 25 s52 0
L52 s52 29 27e-5
VS53 6 s53 0
L53 s53 11 56e-4
VS54 26 s54 0
L54 s54 24 12e-5
VS55 22 s55 0
R55 s55 3 68e1
VS56 16 s56 0
V56 e56 s56 DC 0 AC 18e-1 180
RI56 e56 25 10e-3
VS57 28 s57 0
C57 s57 24 82e-5
VS58 6 s58 0
C58 s58 29 82e-5
VS59 7 s59 0
R59 s59 29 33e2
VS60 8 s60 0
C60 s60 9 10e-6
.control
set numdgt=17
ac lin 1 60 60
print v(1) v(2) v(3) v(4) v(5) v(6) v(7) v(8) v(9) v(10)
print v(11) v(12) v(13) v(14) v(15) v(16) v(17) v(18) v(19) v(20)
print v(21) v(22) v(23) v(24) v(25) v(26) v(27) v(28) v(29)
print i(vs0) i(vs1) i(vs2) i(vs3) i(vs4) i(vs5) i(vs6) i(vs7) i(vs8) i(vs9)
print i(vs10) i(vs11) i(vs12) i(vs13) i(vs14) i(vs15) i(vs16) i(vs17) i(vs18) i(vs19)
print i(vs20) i(vs21) i(vs22) i(vs23) i(vs24) i(vs25) i(vs26) i(vs27) i(vs28) i(vs29)
print i(vs30) i(vs31) i(vs32) i(vs33) i(vs34) i(vs35) i(vs36) i(vs37) i(vs38) i(vs39)
print i(vs40) i(vs41) i(vs42) i(vs43) i(vs44) i(vs45) i(vs46) i(vs47) i(vs48) i(vs49)
print i(vs50) i(vs51) i(vs52) i(vs53) i(vs54) i(vs55) i(vs56) i(vs57) i(vs58) i(vs59)
print i(vs60)
.endc
.end
