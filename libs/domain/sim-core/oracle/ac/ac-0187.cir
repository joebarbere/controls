controls oracle ac-0187
* Generated (plan F2.7, ADR 0012): do not edit; regenerate with `pnpm sim oracle regen`. ac seed 20261031 index 187 nodes 30 elements 52
.options sparse gmin=1e-12 noopac
RG1 1 0 1000000000000
RG2 2 0 1000000000000
RG3 3 0 1000000000000
RG4 4 0 1000000000000
RG5 5 0 1000000000000
RG6 6 0 1000000000000
RG7 7 0 1000000000000
RG8 8 0 1000000000000
RG9 9 0 1000000000000
RG10 10 0 1000000000000
RG11 11 0 1000000000000
RG12 12 0 1000000000000
RG13 13 0 1000000000000
RG14 14 0 1000000000000
RG15 15 0 1000000000000
RG16 16 0 1000000000000
RG17 17 0 1000000000000
RG18 18 0 1000000000000
RG19 19 0 1000000000000
RG20 20 0 1000000000000
RG21 21 0 1000000000000
RG22 22 0 1000000000000
RG23 23 0 1000000000000
RG24 24 0 1000000000000
RG25 25 0 1000000000000
RG26 26 0 1000000000000
RG27 27 0 1000000000000
RG28 28 0 1000000000000
RG29 29 0 1000000000000
VS0 22 s0 0
C0 s0 0 68e-7
VS1 1 s1 0
C1 s1 26 39e-5
VS2 0 s2 0
V2 e2 s2 DC 0 AC 12e-1 -120
RI2 e2 n2 39e-2
H2 n2 h2 VS9 33e-4
ED2 h2 17 d2 0 33e-7
F2 0 d2 VS9 1
LD2 d2 0 1
VS3 28 s3 0
C3 s3 10 12e-4
VS4 14 s4 0
R4 s4 0 47e-2
VS5 6 s5 0
R5 s5 25 10e3
VS6 29 s6 0
R6 s6 3 68e2
VS7 16 s7 0
L7 s7 10 18e-5
VS8 1 s8 0
L8 s8 15 12e-3
VS9 27 s9 0
V9 e9 s9 DC 0 AC 10e1 120
RI9 e9 m9 18e-3
LI9 m9 n9 82e-5
H9 n9 h9 VS2 33e-4
ED9 h9 25 d9 0 33e-7
F9 0 d9 VS2 1
LD9 d9 0 1
VS10 28 s10 0
C10 s10 6 47e-6
VS11 8 s11 0
R11 s11 26 56e1
VS12 26 s12 0
L12 s12 14 15e-3
VS13 2 s13 0
V13 e13 s13 DC 0 AC 56e0 180
RI13 e13 12 12e-1
VS14 19 s14 0
R14 s14 28 47e1
VS15 13 s15 0
V15 e15 s15 DC 0 AC 10e0 180
RI15 e15 m15 27e-3
LI15 m15 25 15e-5
VS16 8 s16 0
L16 s16 2 12e-3
VS17 21 s17 0
R17 s17 9 27e3
VS18 23 s18 0
L18 s18 26 82e-2
VS19 6 s19 0
L19 s19 11 56e-4
VS20 13 s20 0
R20 s20 27 10e1
VS21 5 s21 0
V21 e21 s21 DC 0 AC 27e0 -120
RI21 e21 7 56e-1
VS22 1 s22 0
R22 s22 0 27e0
VS23 29 s23 0
L23 s23 16 47e-4
VS24 16 s24 0
C24 s24 14 33e-4
VS25 1 s25 0
R25 s25 22 47e-1
VS26 26 s26 0
V26 e26 s26 DC 0 AC 12e-1 120
RI26 e26 4 56e-3
VS27 10 s27 0
R27 s27 29 22e0
VS28 21 s28 0
L28 s28 14 22e-4
VS29 1 s29 0
C29 s29 26 10e-6
VS30 14 s30 0
R30 s30 17 56e2
VS31 23 s31 0
R31 s31 7 12e1
VS32 9 s32 0
R32 s32 20 15e3
VS33 21 s33 0
L33 s33 15 82e-3
VS34 24 s34 0
R34 s34 6 27e2
VS35 28 s35 0
R35 s35 1 33e2
VS36 17 s36 0
V36 e36 s36 DC 0 AC 47e0 120
RI36 e36 m36 15e-2
LI36 m36 0 15e-5
VS37 2 s37 0
V37 e37 s37 DC 0 AC 33e-1 0
RI37 e37 24 47e-1
VS38 7 s38 0
C38 s38 21 22e-4
VS39 23 s39 0
L39 s39 6 39e-2
VS40 18 s40 0
V40 e40 s40 DC 0 AC 39e-1 120
RI40 e40 m40 18e-3
LI40 m40 28 68e-6
VS41 28 s41 0
C41 s41 5 68e-5
VS42 4 s42 0
V42 e42 s42 DC 0 AC 15e1 0
RI42 e42 m42 47e-3
LI42 m42 0 27e-7
VS43 12 s43 0
C43 s43 28 33e-6
VS44 3 s44 0
C44 s44 22 82e-6
VS45 7 s45 0
R45 s45 23 47e0
VS46 18 s46 0
C46 s46 20 82e-5
VS47 1 s47 0
V47 e47 s47 DC 0 AC 12e-1 120
RI47 e47 19 22e-2
VS48 6 s48 0
R48 s48 8 82e3
VS49 19 s49 0
V49 e49 s49 DC 0 AC 56e1 0
RI49 e49 m49 33e-3
LI49 m49 13 10e-7
VS50 27 s50 0
V50 e50 s50 DC 0 AC 82e1 120
RI50 e50 11 68e-3
VS51 14 s51 0
C51 s51 12 39e-7
.control
set numdgt=17
ac lin 1 60 60
print v(1) v(2) v(3) v(4) v(5) v(6) v(7) v(8) v(9) v(10)
print v(11) v(12) v(13) v(14) v(15) v(16) v(17) v(18) v(19) v(20)
print v(21) v(22) v(23) v(24) v(25) v(26) v(27) v(28) v(29)
print i(vs0) i(vs1) i(vs2) i(vs3) i(vs4) i(vs5) i(vs6) i(vs7) i(vs8) i(vs9)
print i(vs10) i(vs11) i(vs12) i(vs13) i(vs14) i(vs15) i(vs16) i(vs17) i(vs18) i(vs19)
print i(vs20) i(vs21) i(vs22) i(vs23) i(vs24) i(vs25) i(vs26) i(vs27) i(vs28) i(vs29)
print i(vs30) i(vs31) i(vs32) i(vs33) i(vs34) i(vs35) i(vs36) i(vs37) i(vs38) i(vs39)
print i(vs40) i(vs41) i(vs42) i(vs43) i(vs44) i(vs45) i(vs46) i(vs47) i(vs48) i(vs49)
print i(vs50) i(vs51)
.endc
.end
