controls oracle ac-0326
* Generated (plan F2.7, ADR 0012): do not edit; regenerate with `pnpm sim oracle regen`. ac seed 20261031 index 326 nodes 16 elements 22
.options sparse gmin=1e-12 noopac
RG1 1 0 1000000000000
RG2 2 0 1000000000000
RG3 3 0 1000000000000
RG4 4 0 1000000000000
RG5 5 0 1000000000000
RG6 6 0 1000000000000
RG7 7 0 1000000000000
RG8 8 0 1000000000000
RG9 9 0 1000000000000
RG10 10 0 1000000000000
RG11 11 0 1000000000000
RG12 12 0 1000000000000
RG13 13 0 1000000000000
RG14 14 0 1000000000000
RG15 15 0 1000000000000
VS0 4 s0 0
R0 s0 12 10e-2
VS1 0 s1 0
V1 e1 s1 DC 0 AC 68e0 120
RI1 e1 14 39e-2
VS2 15 s2 0
V2 e2 s2 DC 0 AC 22e0 180
RI2 e2 1 27e-1
VS3 5 s3 0
R3 s3 13 56e3
VS4 9 s4 0
R4 s4 8 12e0
VS5 10 s5 0
L5 s5 2 47e-3
VS6 4 s6 0
L6 s6 14 22e-3
VS7 7 s7 0
R7 s7 2 47e1
VS8 11 s8 0
R8 s8 9 82e1
VS9 14 s9 0
C9 s9 5 68e-5
VS10 13 s10 0
R10 s10 10 22e-1
VS11 14 s11 0
L11 s11 9 18e-2
VS12 6 s12 0
C12 s12 3 22e-7
VS13 0 s13 0
L13 s13 8 10e-3
VS14 3 s14 0
V14 e14 s14 DC 0 AC 56e1 0
RI14 e14 5 39e-1
VS15 1 s15 0
R15 s15 7 15e-2
VS16 10 s16 0
C16 s16 1 68e-6
VS17 9 s17 0
V17 e17 s17 DC 0 AC 10e-1 0
RI17 e17 6 18e-1
VS18 11 s18 0
C18 s18 5 18e-4
VS19 7 s19 0
C19 s19 5 56e-7
VS20 0 s20 0
R20 s20 12 68e0
VS21 15 s21 0
V21 e21 s21 DC 0 AC 22e0 0
RI21 e21 14 33e-2
.control
set numdgt=17
ac lin 1 60 60
print v(1) v(2) v(3) v(4) v(5) v(6) v(7) v(8) v(9) v(10)
print v(11) v(12) v(13) v(14) v(15)
print i(vs0) i(vs1) i(vs2) i(vs3) i(vs4) i(vs5) i(vs6) i(vs7) i(vs8) i(vs9)
print i(vs10) i(vs11) i(vs12) i(vs13) i(vs14) i(vs15) i(vs16) i(vs17) i(vs18) i(vs19)
print i(vs20) i(vs21)
.endc
.end
