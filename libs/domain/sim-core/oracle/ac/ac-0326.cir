controls oracle ac-0326
* Generated (plan F2.7, ADR 0012): do not edit; regenerate with `pnpm sim oracle regen`. ac seed 20261031 index 326 nodes 16 elements 18
.options sparse gmin=1e-12 noopac
RG1 1 0 1000000000000
RG2 2 0 1000000000000
RG3 3 0 1000000000000
RG4 4 0 1000000000000
RG5 5 0 1000000000000
RG6 6 0 1000000000000
RG7 7 0 1000000000000
RG8 8 0 1000000000000
RG9 9 0 1000000000000
RG10 10 0 1000000000000
RG11 11 0 1000000000000
RG12 12 0 1000000000000
RG13 13 0 1000000000000
RG14 14 0 1000000000000
RG15 15 0 1000000000000
VS0 6 s0 0
C0 s0 3 22e-7
VS1 14 s1 0
L1 s1 8 10e-3
VS2 7 s2 0
C2 s2 5 56e-7
VS3 0 s3 0
V3 e3 s3 DC 0 AC 22e0 0
RI3 e3 15 33e-2
VS4 4 s4 0
R4 s4 12 10e-2
VS5 11 s5 0
R5 s5 9 82e1
VS6 10 s6 0
L6 s6 2 47e-3
VS7 0 s7 0
V7 e7 s7 DC 0 AC 22e0 180
RI7 e7 1 27e-1
VS8 10 s8 0
C8 s8 1 68e-6
VS9 15 s9 0
L9 s9 9 18e-2
VS10 15 s10 0
C10 s10 5 68e-5
VS11 9 s11 0
V11 e11 s11 DC 0 AC 10e-1 0
RI11 e11 6 18e-1
VS12 13 s12 0
R12 s12 10 22e-1
VS13 4 s13 0
L13 s13 15 22e-3
VS14 11 s14 0
C14 s14 5 18e-4
VS15 3 s15 0
V15 e15 s15 DC 0 AC 56e1 0
RI15 e15 5 39e-1
VS16 9 s16 0
R16 s16 8 12e0
VS17 14 s17 0
V17 e17 s17 DC 0 AC 68e0 120
RI17 e17 15 39e-2
.control
set numdgt=17
ac lin 1 60 60
print v(1) v(2) v(3) v(4) v(5) v(6) v(7) v(8) v(9) v(10)
print v(11) v(12) v(13) v(14) v(15)
print i(vs0) i(vs1) i(vs2) i(vs3) i(vs4) i(vs5) i(vs6) i(vs7) i(vs8) i(vs9)
print i(vs10) i(vs11) i(vs12) i(vs13) i(vs14) i(vs15) i(vs16) i(vs17)
.endc
.end
