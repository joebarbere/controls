controls oracle ac-0326
* Generated (plan F2.7, ADR 0012): do not edit; regenerate with `pnpm sim oracle regen`. ac seed 20261031 index 326 nodes 16 elements 29
.options sparse gmin=1e-12 noopac
RG1 1 0 1000000000000
RG2 2 0 1000000000000
RG3 3 0 1000000000000
RG4 4 0 1000000000000
RG5 5 0 1000000000000
RG6 6 0 1000000000000
RG7 7 0 1000000000000
RG8 8 0 1000000000000
RG9 9 0 1000000000000
RG10 10 0 1000000000000
RG11 11 0 1000000000000
RG12 12 0 1000000000000
RG13 13 0 1000000000000
RG14 14 0 1000000000000
RG15 15 0 1000000000000
VS0 15 s0 0
L0 s0 9 18e-2
VS1 10 s1 0
C1 s1 1 22e-6
VS2 0 s2 0
V2 e2 s2 DC 0 AC 39e1 180
RI2 e2 13 27e-2
VS3 1 s3 0
L3 s3 12 10e-3
VS4 5 s4 0
L4 s4 14 15e-3
VS5 15 s5 0
V5 e5 s5 DC 0 AC 56e-1 -120
RI5 e5 m5 18e-3
LI5 m5 2 27e-7
VS6 2 s6 0
C6 s6 7 27e-6
VS7 5 s7 0
R7 s7 10 15e2
VS8 3 s8 0
V8 e8 s8 DC 0 AC 56e1 0
RI8 e8 5 39e-1
VS9 4 s9 0
L9 s9 10 22e-3
VS10 0 s10 0
L10 s10 14 56e-4
VS11 10 s11 0
R11 s11 2 12e2
VS12 10 s12 0
C12 s12 2 27e-4
VS13 6 s13 0
C13 s13 3 10e-4
VS14 10 s14 0
R14 s14 14 39e-1
VS15 5 s15 0
L15 s15 8 33e-4
VS16 0 s16 0
V16 e16 s16 DC 0 AC 33e-1 180
RI16 e16 2 27e-2
VS17 1 s17 0
V17 e17 s17 DC 0 AC 56e1 -120
RI17 e17 m17 47e-3
LI17 m17 5 27e-5
VS18 11 s18 0
L18 s18 9 12e-4
VS19 7 s19 0
V19 e19 s19 DC 0 AC 82e-1 180
RI19 e19 14 10e-3
VS20 15 s20 0
V20 e20 s20 DC 0 AC 22e0 0
RI20 e20 m20 33e-2
LI20 m20 10 33e-6
VS21 11 s21 0
C21 s21 5 18e-4
VS22 3 s22 0
C22 s22 10 12e-6
VS23 0 s23 0
V23 e23 s23 DC 0 AC 82e1 0
RI23 e23 1 47e-1
VS24 11 s24 0
V24 e24 s24 DC 0 AC 10e1 -120
RI24 e24 13 39e-2
VS25 8 s25 0
R25 s25 4 33e1
VS26 12 s26 0
R26 s26 10 56e-1
VS27 9 s27 0
L27 s27 6 22e-2
VS28 10 s28 0
V28 e28 s28 DC 0 AC 18e1 0
RI28 e28 m28 68e-3
LI28 m28 12 68e-6
.control
set numdgt=17
ac lin 1 60 60
print v(1) v(2) v(3) v(4) v(5) v(6) v(7) v(8) v(9) v(10)
print v(11) v(12) v(13) v(14) v(15)
print i(vs0) i(vs1) i(vs2) i(vs3) i(vs4) i(vs5) i(vs6) i(vs7) i(vs8) i(vs9)
print i(vs10) i(vs11) i(vs12) i(vs13) i(vs14) i(vs15) i(vs16) i(vs17) i(vs18) i(vs19)
print i(vs20) i(vs21) i(vs22) i(vs23) i(vs24) i(vs25) i(vs26) i(vs27) i(vs28)
.endc
.end
