controls oracle ac-0156
* Generated (plan F2.7, ADR 0012): do not edit; regenerate with `pnpm sim oracle regen`. ac seed 20261031 index 156 nodes 22 elements 39
.options sparse gmin=1e-12 noopac
RG1 1 0 1000000000000
RG2 2 0 1000000000000
RG3 3 0 1000000000000
RG4 4 0 1000000000000
RG5 5 0 1000000000000
RG6 6 0 1000000000000
RG7 7 0 1000000000000
RG8 8 0 1000000000000
RG9 9 0 1000000000000
RG10 10 0 1000000000000
RG11 11 0 1000000000000
RG12 12 0 1000000000000
RG13 13 0 1000000000000
RG14 14 0 1000000000000
RG15 15 0 1000000000000
RG16 16 0 1000000000000
RG17 17 0 1000000000000
RG18 18 0 1000000000000
RG19 19 0 1000000000000
RG20 20 0 1000000000000
RG21 21 0 1000000000000
VS0 17 s0 0
C0 s0 4 22e-5
VS1 1 s1 0
L1 s1 18 56e-4
VS2 0 s2 0
V2 e2 s2 DC 0 AC 27e-1 0
RI2 e2 2 22e-2
VS3 4 s3 0
C3 s3 2 18e-6
VS4 13 s4 0
L4 s4 7 27e-3
VS5 8 s5 0
L5 s5 15 68e-3
VS6 8 s6 0
R6 s6 20 10e-2
VS7 14 s7 0
L7 s7 11 39e-4
VS8 12 s8 0
V8 e8 s8 DC 0 AC 68e0 0
RI8 e8 19 10e-3
VS9 6 s9 0
C9 s9 15 18e-7
VS10 5 s10 0
C10 s10 10 68e-4
VS11 21 s11 0
R11 s11 18 68e0
VS12 4 s12 0
R12 s12 15 39e2
VS13 0 s13 0
R13 s13 2 22e-1
VS14 0 s14 0
C14 s14 2 33e-6
VS15 9 s15 0
V15 e15 s15 DC 0 AC 10e1 0
RI15 e15 2 27e-2
VS16 12 s16 0
R16 s16 9 39e2
VS17 17 s17 0
V17 e17 s17 DC 0 AC 22e-1 -120
RI17 e17 15 27e-1
VS18 9 s18 0
C18 s18 5 39e-4
VS19 8 s19 0
C19 s19 2 39e-7
VS20 4 s20 0
L20 s20 0 22e-2
VS21 0 s21 0
L21 s21 6 82e-4
VS22 19 s22 0
R22 s22 10 27e0
VS23 16 s23 0
R23 s23 2 18e-2
VS24 18 s24 0
V24 e24 s24 DC 0 AC 18e0 120
RI24 e24 1 33e-1
VS25 10 s25 0
C25 s25 20 39e-7
VS26 5 s26 0
C26 s26 1 68e-4
VS27 14 s27 0
L27 s27 13 27e-5
VS28 3 s28 0
R28 s28 11 22e1
VS29 5 s29 0
R29 s29 11 12e-2
VS30 11 s30 0
V30 e30 s30 DC 0 AC 10e1 0
RI30 e30 7 10e-1
VS31 18 s31 0
V31 e31 s31 DC 0 AC 56e-1 180
RI31 e31 10 82e-2
VS32 8 s32 0
R32 s32 18 27e2
VS33 11 s33 0
R33 s33 4 27e0
VS34 1 s34 0
L34 s34 15 56e-4
VS35 21 s35 0
L35 s35 13 12e-5
VS36 5 s36 0
R36 s36 11 22e1
VS37 21 s37 0
R37 s37 10 12e1
VS38 0 s38 0
R38 s38 21 10e-2
.control
set numdgt=17
ac lin 1 60 60
print v(1) v(2) v(3) v(4) v(5) v(6) v(7) v(8) v(9) v(10)
print v(11) v(12) v(13) v(14) v(15) v(16) v(17) v(18) v(19) v(20)
print v(21)
print i(vs0) i(vs1) i(vs2) i(vs3) i(vs4) i(vs5) i(vs6) i(vs7) i(vs8) i(vs9)
print i(vs10) i(vs11) i(vs12) i(vs13) i(vs14) i(vs15) i(vs16) i(vs17) i(vs18) i(vs19)
print i(vs20) i(vs21) i(vs22) i(vs23) i(vs24) i(vs25) i(vs26) i(vs27) i(vs28) i(vs29)
print i(vs30) i(vs31) i(vs32) i(vs33) i(vs34) i(vs35) i(vs36) i(vs37) i(vs38)
.endc
.end
