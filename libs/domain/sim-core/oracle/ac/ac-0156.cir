controls oracle ac-0156
* Generated (plan F2.7, ADR 0012): do not edit; regenerate with `pnpm sim oracle regen`. ac seed 20261031 index 156 nodes 22 elements 33
.options sparse gmin=1e-12 noopac
RG1 1 0 1000000000000
RG2 2 0 1000000000000
RG3 3 0 1000000000000
RG4 4 0 1000000000000
RG5 5 0 1000000000000
RG6 6 0 1000000000000
RG7 7 0 1000000000000
RG8 8 0 1000000000000
RG9 9 0 1000000000000
RG10 10 0 1000000000000
RG11 11 0 1000000000000
RG12 12 0 1000000000000
RG13 13 0 1000000000000
RG14 14 0 1000000000000
RG15 15 0 1000000000000
RG16 16 0 1000000000000
RG17 17 0 1000000000000
RG18 18 0 1000000000000
RG19 19 0 1000000000000
RG20 20 0 1000000000000
RG21 21 0 1000000000000
VS0 17 s0 0
C0 s0 0 10e-4
VS1 6 s1 0
C1 s1 15 18e-7
VS2 5 s2 0
C2 s2 21 56e-7
VS3 21 s3 0
L3 s3 13 12e-5
VS4 0 s4 0
V4 e4 s4 DC 0 AC 22e-1 -120
RI4 e4 m4 27e-1
LI4 m4 15 47e-6
VS5 1 s5 0
L5 s5 18 56e-4
VS6 4 s6 0
L6 s6 14 22e-2
VS7 4 s7 0
R7 s7 15 39e2
VS8 20 s8 0
L8 s8 18 22e-5
VS9 9 s9 0
C9 s9 5 39e-4
VS10 20 s10 0
R10 s10 10 27e-1
VS11 8 s11 0
C11 s11 7 33e-6
VS12 8 s12 0
C12 s12 2 39e-7
VS13 5 s13 0
R13 s13 11 22e1
VS14 14 s14 0
V14 e14 s14 DC 0 AC 10e1 0
RI14 e14 m14 27e-2
LI14 m14 16 82e-5
VS15 5 s15 0
C15 s15 10 68e-4
VS16 8 s16 0
R16 s16 15 33e0
VS17 17 s17 0
L17 s17 11 39e-4
VS18 14 s18 0
R18 s18 3 68e3
VS19 16 s19 0
R19 s19 2 18e-2
VS20 4 s20 0
C20 s20 2 18e-6
VS21 11 s21 0
V21 e21 s21 DC 0 AC 10e1 0
RI21 e21 m21 10e-1
LI21 m21 7 10e-6
VS22 3 s22 0
R22 s22 11 22e1
VS23 5 s23 0
R23 s23 11 12e-2
VS24 4 s24 0
R24 s24 19 10e-2
VS25 5 s25 0
R25 s25 19 33e2
VS26 11 s26 0
R26 s26 4 27e0
VS27 20 s27 0
R27 s27 12 18e3
VS28 4 s28 0
C28 s28 12 82e-6
VS29 13 s29 0
L29 s29 6 18e-4
VS30 13 s30 0
R30 s30 9 27e1
VS31 1 s31 0
L31 s31 15 56e-4
VS32 17 s32 0
L32 s32 13 27e-5
.control
set numdgt=17
ac lin 1 60 60
print v(1) v(2) v(3) v(4) v(5) v(6) v(7) v(8) v(9) v(10)
print v(11) v(12) v(13) v(14) v(15) v(16) v(17) v(18) v(19) v(20)
print v(21)
print i(vs0) i(vs1) i(vs2) i(vs3) i(vs4) i(vs5) i(vs6) i(vs7) i(vs8) i(vs9)
print i(vs10) i(vs11) i(vs12) i(vs13) i(vs14) i(vs15) i(vs16) i(vs17) i(vs18) i(vs19)
print i(vs20) i(vs21) i(vs22) i(vs23) i(vs24) i(vs25) i(vs26) i(vs27) i(vs28) i(vs29)
print i(vs30) i(vs31) i(vs32)
.endc
.end
