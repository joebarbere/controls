controls oracle ac-0156
* Generated (plan F2.7, ADR 0012): do not edit; regenerate with `pnpm sim oracle regen`. ac seed 20261031 index 156 nodes 22 elements 41
.options sparse gmin=1e-12 noopac
RG1 1 0 1000000000000
RG2 2 0 1000000000000
RG3 3 0 1000000000000
RG4 4 0 1000000000000
RG5 5 0 1000000000000
RG6 6 0 1000000000000
RG7 7 0 1000000000000
RG8 8 0 1000000000000
RG9 9 0 1000000000000
RG10 10 0 1000000000000
RG11 11 0 1000000000000
RG12 12 0 1000000000000
RG13 13 0 1000000000000
RG14 14 0 1000000000000
RG15 15 0 1000000000000
RG16 16 0 1000000000000
RG17 17 0 1000000000000
RG18 18 0 1000000000000
RG19 19 0 1000000000000
RG20 20 0 1000000000000
RG21 21 0 1000000000000
VS0 6 s0 0
C0 s0 15 18e-7
VS1 5 s1 0
C1 s1 10 68e-4
VS2 19 s2 0
R2 s2 10 27e0
VS3 10 s3 0
C3 s3 20 39e-7
VS4 5 s4 0
C4 s4 1 68e-4
VS5 4 s5 0
C5 s5 2 18e-6
VS6 0 s6 0
V6 e6 s6 DC 0 AC 27e-1 0
RI6 e6 m6 22e-2
LI6 m6 2 39e-6
VS7 13 s7 0
L7 s7 7 27e-3
VS8 0 s8 0
R8 s8 21 10e-2
VS9 1 s9 0
L9 s9 15 56e-4
VS10 18 s10 0
V10 e10 s10 DC 0 AC 56e-1 180
RI10 e10 m10 82e-2
LI10 m10 10 15e-7
VS11 0 s11 0
C11 s11 2 33e-6
VS12 12 s12 0
V12 e12 s12 DC 0 AC 68e0 0
RI12 e12 m12 10e-3
LI12 m12 19 33e-6
VS13 11 s13 0
R13 s13 4 27e0
VS14 1 s14 0
L14 s14 18 56e-4
VS15 8 s15 0
C15 s15 2 39e-7
VS16 5 s16 0
R16 s16 11 22e1
VS17 14 s17 0
L17 s17 11 39e-4
VS18 21 s18 0
R18 s18 18 68e0
VS19 3 s19 0
R19 s19 11 22e1
VS20 17 s20 0
C20 s20 4 22e-5
VS21 18 s21 0
V21 e21 s21 DC 0 AC 18e0 120
RI21 e21 1 33e-1
VS22 5 s22 0
R22 s22 11 12e-2
VS23 8 s23 0
L23 s23 16 33e-4
VS24 21 s24 0
L24 s24 13 12e-5
VS25 6 s25 0
V25 e25 s25 DC 0 AC 10e0 -120
RI25 e25 m25 22e-1
LI25 m25 3 22e-7
VS26 17 s26 0
V26 e26 s26 DC 0 AC 22e-1 -120
RI26 e26 15 27e-1
VS27 21 s27 0
R27 s27 10 12e1
VS28 8 s28 0
R28 s28 20 10e-2
VS29 8 s29 0
L29 s29 15 68e-3
VS30 11 s30 0
V30 e30 s30 DC 0 AC 10e1 0
RI30 e30 7 10e-1
VS31 9 s31 0
V31 e31 s31 DC 0 AC 10e1 0
RI31 e31 2 27e-2
VS32 9 s32 0
C32 s32 5 39e-4
VS33 8 s33 0
R33 s33 18 27e2
VS34 12 s34 0
R34 s34 9 39e2
VS35 0 s35 0
L35 s35 6 82e-4
VS36 4 s36 0
L36 s36 0 22e-2
VS37 4 s37 0
R37 s37 15 39e2
VS38 14 s38 0
L38 s38 13 27e-5
VS39 16 s39 0
R39 s39 2 18e-2
VS40 0 s40 0
R40 s40 2 22e-1
.control
set numdgt=17
ac lin 1 60 60
print v(1) v(2) v(3) v(4) v(5) v(6) v(7) v(8) v(9) v(10)
print v(11) v(12) v(13) v(14) v(15) v(16) v(17) v(18) v(19) v(20)
print v(21)
print i(vs0) i(vs1) i(vs2) i(vs3) i(vs4) i(vs5) i(vs6) i(vs7) i(vs8) i(vs9)
print i(vs10) i(vs11) i(vs12) i(vs13) i(vs14) i(vs15) i(vs16) i(vs17) i(vs18) i(vs19)
print i(vs20) i(vs21) i(vs22) i(vs23) i(vs24) i(vs25) i(vs26) i(vs27) i(vs28) i(vs29)
print i(vs30) i(vs31) i(vs32) i(vs33) i(vs34) i(vs35) i(vs36) i(vs37) i(vs38) i(vs39)
print i(vs40)
.endc
.end
