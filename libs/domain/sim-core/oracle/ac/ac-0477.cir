controls oracle ac-0477
* Generated (plan F2.7, ADR 0012): do not edit; regenerate with `pnpm sim oracle regen`. ac seed 20261031 index 477 nodes 5 elements 8
.options sparse gmin=1e-12 noopac
RG1 1 0 1000000000000
RG2 2 0 1000000000000
RG3 3 0 1000000000000
RG4 4 0 1000000000000
VS0 1 s0 0
R0 s0 3 27e2
VS1 2 s1 0
R1 s1 3 68e2
VS2 2 s2 0
R2 s2 4 68e2
VS3 3 s3 0
R3 s3 0 12e1
VS4 0 s4 0
V4 e4 s4 DC 0 AC 27e1 -120
RI4 e4 2 68e-2
VS5 4 s5 0
R5 s5 1 39e-1
VS6 3 s6 0
R6 s6 2 22e0
VS7 4 s7 0
C7 s7 3 47e-6
.control
set numdgt=17
ac lin 1 60 60
print v(1) v(2) v(3) v(4)
print i(vs0) i(vs1) i(vs2) i(vs3) i(vs4) i(vs5) i(vs6) i(vs7)
.endc
.end
