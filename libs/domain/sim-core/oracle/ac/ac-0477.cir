controls oracle ac-0477
* Generated (plan F2.7, ADR 0012): do not edit; regenerate with `pnpm sim oracle regen`. ac seed 20261031 index 477 nodes 5 elements 7
.options sparse gmin=1e-12 noopac
RG1 1 0 1000000000000
RG2 2 0 1000000000000
RG3 3 0 1000000000000
RG4 4 0 1000000000000
VS0 2 s0 0
L0 s0 3 15e-3
VS1 2 s1 0
R1 s1 4 68e2
VS2 1 s2 0
C2 s2 4 39e-4
VS3 0 s3 0
V3 e3 s3 DC 0 AC 27e1 -120
RI3 e3 2 68e-2
VS4 4 s4 0
C4 s4 3 56e-6
VS5 2 s5 0
C5 s5 1 22e-4
VS6 0 s6 0
L6 s6 1 18e-2
.control
set numdgt=17
ac lin 1 60 60
print v(1) v(2) v(3) v(4)
print i(vs0) i(vs1) i(vs2) i(vs3) i(vs4) i(vs5) i(vs6)
.endc
.end
