controls oracle ac-0181
* Generated (plan F2.7, ADR 0012): do not edit; regenerate with `pnpm sim oracle regen`. ac seed 20261031 index 181 nodes 11 elements 13
.options sparse gmin=1e-12 noopac
RG1 1 0 1000000000000
RG2 2 0 1000000000000
RG3 3 0 1000000000000
RG4 4 0 1000000000000
RG5 5 0 1000000000000
RG6 6 0 1000000000000
RG7 7 0 1000000000000
RG8 8 0 1000000000000
RG9 9 0 1000000000000
RG10 10 0 1000000000000
VS0 0 s0 0
R0 s0 5 39e1
VS1 1 s1 0
L1 s1 6 18e-3
VS2 6 s2 0
R2 s2 2 56e3
VS3 4 s3 0
L3 s3 7 68e-5
VS4 9 s4 0
L4 s4 5 15e-3
VS5 4 s5 0
R5 s5 3 18e1
VS6 10 s6 0
L6 s6 8 12e-3
VS7 8 s7 0
L7 s7 7 18e-2
VS8 10 s8 0
L8 s8 0 22e-3
VS9 0 s9 0
V9 e9 s9 DC 0 AC 39e1 0
RI9 e9 3 27e-1
VS10 2 s10 0
R10 s10 10 68e0
VS11 1 s11 0
R11 s11 5 33e0
VS12 2 s12 0
C12 s12 9 15e-5
.control
set numdgt=17
ac lin 1 60 60
print v(1) v(2) v(3) v(4) v(5) v(6) v(7) v(8) v(9) v(10)
print i(vs0) i(vs1) i(vs2) i(vs3) i(vs4) i(vs5) i(vs6) i(vs7) i(vs8) i(vs9)
print i(vs10) i(vs11) i(vs12)
.endc
.end
