controls oracle ac-0181
* Generated (plan F2.7, ADR 0012): do not edit; regenerate with `pnpm sim oracle regen`. ac seed 20261031 index 181 nodes 11 elements 21
.options sparse gmin=1e-12 noopac
RG1 1 0 1000000000000
RG2 2 0 1000000000000
RG3 3 0 1000000000000
RG4 4 0 1000000000000
RG5 5 0 1000000000000
RG6 6 0 1000000000000
RG7 7 0 1000000000000
RG8 8 0 1000000000000
RG9 9 0 1000000000000
RG10 10 0 1000000000000
VS0 6 s0 0
R0 s0 5 56e-1
VS1 10 s1 0
C1 s1 7 39e-4
VS2 0 s2 0
V2 e2 s2 DC 0 AC 56e-1 0
RI2 e2 m2 39e-2
LI2 m2 8 33e-5
VS3 10 s3 0
R3 s3 8 33e2
VS4 10 s4 0
R4 s4 6 56e0
VS5 10 s5 0
L5 s5 8 22e-3
VS6 0 s6 0
R6 s6 1 47e1
VS7 9 s7 0
L7 s7 7 56e-5
VS8 1 s8 0
L8 s8 6 15e-5
VS9 3 s9 0
L9 s9 7 15e-2
VS10 0 s10 0
R10 s10 2 56e3
VS11 10 s11 0
L11 s11 6 12e-3
VS12 5 s12 0
V12 e12 s12 DC 0 AC 47e1 120
RI12 e12 m12 47e-3
LI12 m12 2 18e-6
VS13 6 s13 0
R13 s13 4 10e-2
VS14 4 s14 0
C14 s14 0 15e-7
VS15 10 s15 0
L15 s15 1 39e-2
VS16 2 s16 0
R16 s16 10 68e0
VS17 10 s17 0
R17 s17 4 18e1
VS18 8 s18 0
V18 e18 s18 DC 0 AC 39e1 0
RI18 e18 3 27e-1
VS19 8 s19 0
L19 s19 1 47e-4
VS20 2 s20 0
C20 s20 9 15e-5
.control
set numdgt=17
ac lin 1 60 60
print v(1) v(2) v(3) v(4) v(5) v(6) v(7) v(8) v(9) v(10)
print i(vs0) i(vs1) i(vs2) i(vs3) i(vs4) i(vs5) i(vs6) i(vs7) i(vs8) i(vs9)
print i(vs10) i(vs11) i(vs12) i(vs13) i(vs14) i(vs15) i(vs16) i(vs17) i(vs18) i(vs19)
print i(vs20)
.endc
.end
