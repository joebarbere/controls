controls oracle ac-0181
* Generated (plan F2.7, ADR 0012): do not edit; regenerate with `pnpm sim oracle regen`. ac seed 20261031 index 181 nodes 11 elements 19
.options sparse gmin=1e-12 noopac
RG1 1 0 1000000000000
RG2 2 0 1000000000000
RG3 3 0 1000000000000
RG4 4 0 1000000000000
RG5 5 0 1000000000000
RG6 6 0 1000000000000
RG7 7 0 1000000000000
RG8 8 0 1000000000000
RG9 9 0 1000000000000
RG10 10 0 1000000000000
VS0 6 s0 0
R0 s0 2 56e3
VS1 10 s1 0
L1 s1 5 12e-3
VS2 1 s2 0
L2 s2 5 15e-5
VS3 10 s3 0
R3 s3 8 33e2
VS4 10 s4 0
R4 s4 4 18e1
VS5 3 s5 0
L5 s5 7 15e-2
VS6 0 s6 0
V6 e6 s6 DC 0 AC 47e1 120
RI6 e6 2 47e-3
VS7 8 s7 0
L7 s7 1 47e-4
VS8 4 s8 0
C8 s8 6 15e-7
VS9 10 s9 0
L9 s9 1 39e-2
VS10 5 s10 0
R10 s10 4 10e-2
VS11 10 s11 0
R11 s11 5 56e0
VS12 2 s12 0
R12 s12 10 68e0
VS13 6 s13 0
V13 e13 s13 DC 0 AC 56e-1 0
RI13 e13 8 39e-2
VS14 2 s14 0
C14 s14 9 15e-5
VS15 8 s15 0
V15 e15 s15 DC 0 AC 39e1 0
RI15 e15 3 27e-1
VS16 6 s16 0
R16 s16 1 47e1
VS17 10 s17 0
L17 s17 8 22e-3
VS18 10 s18 0
C18 s18 7 39e-4
.control
set numdgt=17
ac lin 1 60 60
print v(1) v(2) v(3) v(4) v(5) v(6) v(7) v(8) v(9) v(10)
print i(vs0) i(vs1) i(vs2) i(vs3) i(vs4) i(vs5) i(vs6) i(vs7) i(vs8) i(vs9)
print i(vs10) i(vs11) i(vs12) i(vs13) i(vs14) i(vs15) i(vs16) i(vs17) i(vs18)
.endc
.end
