controls oracle ac-0478
* Generated (plan F2.7, ADR 0012): do not edit; regenerate with `pnpm sim oracle regen`. ac seed 20261031 index 478 nodes 14 elements 14
.options sparse gmin=1e-12 noopac
RG1 1 0 1000000000000
RG2 2 0 1000000000000
RG3 3 0 1000000000000
RG4 4 0 1000000000000
RG5 5 0 1000000000000
RG6 6 0 1000000000000
RG7 7 0 1000000000000
RG8 8 0 1000000000000
RG9 9 0 1000000000000
RG10 10 0 1000000000000
RG11 11 0 1000000000000
RG12 12 0 1000000000000
RG13 13 0 1000000000000
VS0 0 s0 0
V0 e0 s0 DC 0 AC 56e0 180
RI0 e0 7 10e-2
VS1 8 s1 0
R1 s1 11 18e-2
VS2 12 s2 0
R2 s2 8 39e-1
VS3 5 s3 0
L3 s3 3 27e-2
VS4 11 s4 0
L4 s4 5 47e-5
VS5 9 s5 0
L5 s5 3 10e-3
VS6 5 s6 0
R6 s6 0 22e3
VS7 0 s7 0
V7 e7 s7 DC 0 AC 18e-1 180
RI7 e7 2 56e-1
VS8 5 s8 0
L8 s8 10 18e-4
VS9 5 s9 0
C9 s9 1 18e-5
VS10 2 s10 0
R10 s10 0 82e-1
VS11 5 s11 0
R11 s11 13 56e1
VS12 6 s12 0
R12 s12 10 18e2
VS13 13 s13 0
L13 s13 4 39e-4
.control
set numdgt=17
ac lin 1 60 60
print v(1) v(2) v(3) v(4) v(5) v(6) v(7) v(8) v(9) v(10)
print v(11) v(12) v(13)
print i(vs0) i(vs1) i(vs2) i(vs3) i(vs4) i(vs5) i(vs6) i(vs7) i(vs8) i(vs9)
print i(vs10) i(vs11) i(vs12) i(vs13)
.endc
.end
