controls oracle ac-0478
* Generated (plan F2.7, ADR 0012): do not edit; regenerate with `pnpm sim oracle regen`. ac seed 20261031 index 478 nodes 14 elements 21
.options sparse gmin=1e-12 noopac
RG1 1 0 1000000000000
RG2 2 0 1000000000000
RG3 3 0 1000000000000
RG4 4 0 1000000000000
RG5 5 0 1000000000000
RG6 6 0 1000000000000
RG7 7 0 1000000000000
RG8 8 0 1000000000000
RG9 9 0 1000000000000
RG10 10 0 1000000000000
RG11 11 0 1000000000000
RG12 12 0 1000000000000
RG13 13 0 1000000000000
VS0 9 s0 0
R0 s0 12 39e3
VS1 2 s1 0
R1 s1 5 10e1
VS2 3 s2 0
R2 s2 9 18e0
VS3 5 s3 0
C3 s3 1 18e-5
VS4 5 s4 0
L4 s4 8 18e-2
VS5 8 s5 0
R5 s5 7 18e-2
VS6 10 s6 0
L6 s6 0 56e-3
VS7 10 s7 0
R7 s7 4 18e-1
VS8 12 s8 0
C8 s8 7 27e-5
VS9 5 s9 0
R9 s9 13 56e1
VS10 0 s10 0
V10 e10 s10 DC 0 AC 10e0 0
RI10 e10 m10 33e-1
LI10 m10 8 39e-6
VS11 7 s11 0
L11 s11 5 47e-5
VS12 6 s12 0
V12 e12 s12 DC 0 AC 33e1 -120
RI12 e12 m12 33e-3
LI12 m12 1 33e-5
VS13 9 s13 0
V13 e13 s13 DC 0 AC 22e1 -120
RI13 e13 m13 12e-1
LI13 m13 13 12e-7
VS14 4 s14 0
R14 s14 11 68e1
VS15 5 s15 0
L15 s15 3 27e-2
VS16 7 s16 0
R16 s16 1 82e-2
VS17 6 s17 0
C17 s17 11 12e-6
VS18 11 s18 0
V18 e18 s18 DC 0 AC 18e-1 180
RI18 e18 m18 56e-1
LI18 m18 2 22e-5
VS19 5 s19 0
L19 s19 10 18e-4
VS20 5 s20 0
R20 s20 11 22e3
.control
set numdgt=17
ac lin 1 60 60
print v(1) v(2) v(3) v(4) v(5) v(6) v(7) v(8) v(9) v(10)
print v(11) v(12) v(13)
print i(vs0) i(vs1) i(vs2) i(vs3) i(vs4) i(vs5) i(vs6) i(vs7) i(vs8) i(vs9)
print i(vs10) i(vs11) i(vs12) i(vs13) i(vs14) i(vs15) i(vs16) i(vs17) i(vs18) i(vs19)
print i(vs20)
.endc
.end
