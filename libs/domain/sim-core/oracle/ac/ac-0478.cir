controls oracle ac-0478
* Generated (plan F2.7, ADR 0012): do not edit; regenerate with `pnpm sim oracle regen`. ac seed 20261031 index 478 nodes 14 elements 20
.options sparse gmin=1e-12 noopac
RG1 1 0 1000000000000
RG2 2 0 1000000000000
RG3 3 0 1000000000000
RG4 4 0 1000000000000
RG5 5 0 1000000000000
RG6 6 0 1000000000000
RG7 7 0 1000000000000
RG8 8 0 1000000000000
RG9 9 0 1000000000000
RG10 10 0 1000000000000
RG11 11 0 1000000000000
RG12 12 0 1000000000000
RG13 13 0 1000000000000
VS0 0 s0 0
V0 e0 s0 DC 0 AC 22e1 -120
RI0 e0 m0 12e-1
LI0 m0 1 56e-7
VS1 6 s1 0
R1 s1 11 39e3
VS2 4 s2 0
C2 s2 6 56e-7
VS3 9 s3 0
L3 s3 3 10e-3
VS4 5 s4 0
R4 s4 13 56e1
VS5 13 s5 0
L5 s5 4 39e-4
VS6 5 s6 0
C6 s6 1 18e-5
VS7 11 s7 0
V7 e7 s7 DC 0 AC 18e-1 180
RI7 e7 m7 56e-1
LI7 m7 2 47e-5
VS8 7 s8 0
L8 s8 5 47e-5
VS9 12 s9 0
R9 s9 8 39e-1
VS10 6 s10 0
R10 s10 10 18e2
VS11 9 s11 0
R11 s11 2 18e-1
VS12 0 s12 0
R12 s12 3 18e-1
VS13 5 s13 0
L13 s13 3 27e-2
VS14 4 s14 0
R14 s14 7 82e-2
VS15 5 s15 0
L15 s15 10 18e-4
VS16 8 s16 0
R16 s16 7 18e-2
VS17 11 s17 0
V17 e17 s17 DC 0 AC 56e0 180
RI17 e17 m17 10e-2
LI17 m17 0 68e-6
VS18 5 s18 0
R18 s18 11 22e3
VS19 12 s19 0
R19 s19 1 27e1
.control
set numdgt=17
ac lin 1 60 60
print v(1) v(2) v(3) v(4) v(5) v(6) v(7) v(8) v(9) v(10)
print v(11) v(12) v(13)
print i(vs0) i(vs1) i(vs2) i(vs3) i(vs4) i(vs5) i(vs6) i(vs7) i(vs8) i(vs9)
print i(vs10) i(vs11) i(vs12) i(vs13) i(vs14) i(vs15) i(vs16) i(vs17) i(vs18) i(vs19)
.endc
.end
