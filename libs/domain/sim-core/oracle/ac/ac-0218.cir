controls oracle ac-0218
* Generated (plan F2.7, ADR 0012): do not edit; regenerate with `pnpm sim oracle regen`. ac seed 20261031 index 218 nodes 18 elements 35
.options sparse gmin=1e-12 noopac
RG1 1 0 1000000000000
RG2 2 0 1000000000000
RG3 3 0 1000000000000
RG4 4 0 1000000000000
RG5 5 0 1000000000000
RG6 6 0 1000000000000
RG7 7 0 1000000000000
RG8 8 0 1000000000000
RG9 9 0 1000000000000
RG10 10 0 1000000000000
RG11 11 0 1000000000000
RG12 12 0 1000000000000
RG13 13 0 1000000000000
RG14 14 0 1000000000000
RG15 15 0 1000000000000
RG16 16 0 1000000000000
RG17 17 0 1000000000000
VS0 15 s0 0
L0 s0 7 56e-4
VS1 0 s1 0
V1 e1 s1 DC 0 AC 27e-1 0
RI1 e1 9 10e-1
VS2 16 s2 0
L2 s2 10 39e-2
VS3 1 s3 0
R3 s3 17 22e2
VS4 1 s4 0
L4 s4 8 33e-3
VS5 0 s5 0
V5 e5 s5 DC 0 AC 27e1 -120
RI5 e5 7 68e-2
VS6 7 s6 0
L6 s6 5 10e-5
VS7 11 s7 0
V7 e7 s7 DC 0 AC 68e-1 120
RI7 e7 2 56e-1
VS8 10 s8 0
C8 s8 5 82e-4
VS9 10 s9 0
R9 s9 7 56e0
VS10 6 s10 0
C10 s10 12 47e-5
VS11 5 s11 0
C11 s11 11 15e-5
VS12 11 s12 0
V12 e12 s12 DC 0 AC 33e0 120
RI12 e12 9 10e-1
VS13 16 s13 0
L13 s13 1 22e-3
VS14 10 s14 0
C14 s14 4 82e-6
VS15 11 s15 0
C15 s15 10 22e-4
VS16 13 s16 0
C16 s16 7 12e-4
VS17 5 s17 0
R17 s17 12 33e-2
VS18 14 s18 0
R18 s18 5 68e1
VS19 4 s19 0
R19 s19 17 12e0
VS20 12 s20 0
C20 s20 1 18e-4
VS21 2 s21 0
C21 s21 7 68e-7
VS22 0 s22 0
C22 s22 6 10e-5
VS23 4 s23 0
V23 e23 s23 DC 0 AC 68e1 120
RI23 e23 2 27e-3
VS24 12 s24 0
L24 s24 16 22e-3
VS25 16 s25 0
C25 s25 13 82e-5
VS26 7 s26 0
R26 s26 11 33e0
VS27 1 s27 0
L27 s27 3 56e-5
VS28 16 s28 0
R28 s28 3 22e1
VS29 15 s29 0
V29 e29 s29 DC 0 AC 68e-1 -120
RI29 e29 1 82e-3
VS30 3 s30 0
R30 s30 14 18e-1
VS31 3 s31 0
R31 s31 8 10e-2
VS32 9 s32 0
R32 s32 16 47e1
VS33 12 s33 0
V33 e33 s33 DC 0 AC 22e0 120
RI33 e33 15 47e-1
VS34 16 s34 0
R34 s34 5 56e2
.control
set numdgt=17
ac lin 1 60 60
print v(1) v(2) v(3) v(4) v(5) v(6) v(7) v(8) v(9) v(10)
print v(11) v(12) v(13) v(14) v(15) v(16) v(17)
print i(vs0) i(vs1) i(vs2) i(vs3) i(vs4) i(vs5) i(vs6) i(vs7) i(vs8) i(vs9)
print i(vs10) i(vs11) i(vs12) i(vs13) i(vs14) i(vs15) i(vs16) i(vs17) i(vs18) i(vs19)
print i(vs20) i(vs21) i(vs22) i(vs23) i(vs24) i(vs25) i(vs26) i(vs27) i(vs28) i(vs29)
print i(vs30) i(vs31) i(vs32) i(vs33) i(vs34)
.endc
.end
