controls oracle ac-0218
* Generated (plan F2.7, ADR 0012): do not edit; regenerate with `pnpm sim oracle regen`. ac seed 20261031 index 218 nodes 18 elements 34
.options sparse gmin=1e-12 noopac
RG1 1 0 1000000000000
RG2 2 0 1000000000000
RG3 3 0 1000000000000
RG4 4 0 1000000000000
RG5 5 0 1000000000000
RG6 6 0 1000000000000
RG7 7 0 1000000000000
RG8 8 0 1000000000000
RG9 9 0 1000000000000
RG10 10 0 1000000000000
RG11 11 0 1000000000000
RG12 12 0 1000000000000
RG13 13 0 1000000000000
RG14 14 0 1000000000000
RG15 15 0 1000000000000
RG16 16 0 1000000000000
RG17 17 0 1000000000000
VS0 6 s0 0
C0 s0 12 47e-5
VS1 1 s1 0
L1 s1 3 56e-5
VS2 0 s2 0
C2 s2 6 10e-5
VS3 5 s3 0
C3 s3 11 15e-5
VS4 2 s4 0
C4 s4 7 68e-7
VS5 0 s5 0
V5 e5 s5 DC 0 AC 27e1 -120
RI5 e5 7 68e-2
VS6 10 s6 0
C6 s6 4 82e-6
VS7 14 s7 0
R7 s7 5 68e1
VS8 10 s8 0
C8 s8 5 82e-4
VS9 3 s9 0
R9 s9 8 10e-2
VS10 16 s10 0
C10 s10 13 82e-5
VS11 12 s11 0
V11 e11 s11 DC 0 AC 22e0 120
RI11 e11 15 47e-1
VS12 1 s12 0
R12 s12 17 22e2
VS13 11 s13 0
V13 e13 s13 DC 0 AC 33e0 120
RI13 e13 9 10e-1
VS14 11 s14 0
V14 e14 s14 DC 0 AC 68e-1 120
RI14 e14 2 56e-1
VS15 4 s15 0
R15 s15 17 12e0
VS16 7 s16 0
L16 s16 5 10e-5
VS17 16 s17 0
R17 s17 5 56e2
VS18 0 s18 0
V18 e18 s18 DC 0 AC 27e-1 0
RI18 e18 9 10e-1
VS19 12 s19 0
L19 s19 16 22e-3
VS20 9 s20 0
R20 s20 16 47e1
VS21 12 s21 0
C21 s21 1 18e-4
VS22 4 s22 0
V22 e22 s22 DC 0 AC 68e1 120
RI22 e22 2 27e-3
VS23 16 s23 0
L23 s23 10 39e-2
VS24 16 s24 0
L24 s24 1 22e-3
VS25 10 s25 0
R25 s25 7 56e0
VS26 11 s26 0
C26 s26 10 22e-4
VS27 16 s27 0
R27 s27 3 22e1
VS28 3 s28 0
R28 s28 14 18e-1
VS29 15 s29 0
L29 s29 7 56e-4
VS30 15 s30 0
V30 e30 s30 DC 0 AC 68e-1 -120
RI30 e30 1 82e-3
VS31 7 s31 0
R31 s31 11 33e0
VS32 13 s32 0
C32 s32 7 12e-4
VS33 5 s33 0
R33 s33 12 33e-2
.control
set numdgt=17
ac lin 1 60 60
print v(1) v(2) v(3) v(4) v(5) v(6) v(7) v(8) v(9) v(10)
print v(11) v(12) v(13) v(14) v(15) v(16) v(17)
print i(vs0) i(vs1) i(vs2) i(vs3) i(vs4) i(vs5) i(vs6) i(vs7) i(vs8) i(vs9)
print i(vs10) i(vs11) i(vs12) i(vs13) i(vs14) i(vs15) i(vs16) i(vs17) i(vs18) i(vs19)
print i(vs20) i(vs21) i(vs22) i(vs23) i(vs24) i(vs25) i(vs26) i(vs27) i(vs28) i(vs29)
print i(vs30) i(vs31) i(vs32) i(vs33)
.endc
.end
