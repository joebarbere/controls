controls oracle ac-0218
* Generated (plan F2.7, ADR 0012): do not edit; regenerate with `pnpm sim oracle regen`. ac seed 20261031 index 218 nodes 18 elements 24
.options sparse gmin=1e-12 noopac
RG1 1 0 1000000000000
RG2 2 0 1000000000000
RG3 3 0 1000000000000
RG4 4 0 1000000000000
RG5 5 0 1000000000000
RG6 6 0 1000000000000
RG7 7 0 1000000000000
RG8 8 0 1000000000000
RG9 9 0 1000000000000
RG10 10 0 1000000000000
RG11 11 0 1000000000000
RG12 12 0 1000000000000
RG13 13 0 1000000000000
RG14 14 0 1000000000000
RG15 15 0 1000000000000
RG16 16 0 1000000000000
RG17 17 0 1000000000000
VS0 0 s0 0
V0 e0 s0 DC 0 AC 18e-1 180
RI0 e0 9 18e-3
VS1 15 s1 0
C1 s1 3 82e-7
VS2 8 s2 0
V2 e2 s2 DC 0 AC 22e0 120
RI2 e2 15 47e-1
VS3 2 s3 0
V3 e3 s3 DC 0 AC 33e-1 0
RI3 e3 13 68e-3
VS4 6 s4 0
V4 e4 s4 DC 0 AC 10e1 0
RI4 e4 16 33e-2
VS5 12 s5 0
C5 s5 1 39e-5
VS6 1 s6 0
R6 s6 6 27e-2
VS7 11 s7 0
C7 s7 10 22e-4
VS8 16 s8 0
R8 s8 3 22e1
VS9 16 s9 0
L9 s9 7 12e-3
VS10 17 s10 0
L10 s10 2 15e-2
VS11 16 s11 0
L11 s11 10 39e-2
VS12 17 s12 0
R12 s12 0 12e0
VS13 9 s13 0
R13 s13 16 47e1
VS14 15 s14 0
C14 s14 1 10e-4
VS15 14 s15 0
R15 s15 15 12e-2
VS16 5 s16 0
C16 s16 11 15e-5
VS17 16 s17 0
C17 s17 13 82e-5
VS18 4 s18 0
V18 e18 s18 DC 0 AC 82e-1 0
RI18 e18 1 15e-2
VS19 12 s19 0
R19 s19 16 56e0
VS20 8 s20 0
L20 s20 16 22e-3
VS21 14 s21 0
R21 s21 5 33e-2
VS22 11 s22 0
L22 s22 17 82e-5
VS23 7 s23 0
R23 s23 4 15e2
.control
set numdgt=17
ac lin 1 60 60
print v(1) v(2) v(3) v(4) v(5) v(6) v(7) v(8) v(9) v(10)
print v(11) v(12) v(13) v(14) v(15) v(16) v(17)
print i(vs0) i(vs1) i(vs2) i(vs3) i(vs4) i(vs5) i(vs6) i(vs7) i(vs8) i(vs9)
print i(vs10) i(vs11) i(vs12) i(vs13) i(vs14) i(vs15) i(vs16) i(vs17) i(vs18) i(vs19)
print i(vs20) i(vs21) i(vs22) i(vs23)
.endc
.end
