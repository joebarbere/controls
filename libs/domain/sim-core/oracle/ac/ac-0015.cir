controls oracle ac-0015
* Generated (plan F2.7, ADR 0012): do not edit; regenerate with `pnpm sim oracle regen`. ac seed 20261031 index 15 nodes 3 elements 4
.options sparse gmin=1e-12 noopac
RG1 1 0 1000000000000
RG2 2 0 1000000000000
VS0 1 s0 0
L0 s0 2 82e-4
VS1 0 s1 0
V1 e1 s1 DC 0 AC 27e-1 180
RI1 e1 1 12e-3
VS2 1 s2 0
C2 s2 2 82e-4
VS3 2 s3 0
L3 s3 0 56e-3
.control
set numdgt=17
ac lin 1 60 60
print v(1) v(2)
print i(vs0) i(vs1) i(vs2) i(vs3)
.endc
.end
