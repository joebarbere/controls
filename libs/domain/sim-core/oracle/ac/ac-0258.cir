controls oracle ac-0258
* Generated (plan F2.7, ADR 0012): do not edit; regenerate with `pnpm sim oracle regen`. ac seed 20261031 index 258 nodes 12 elements 20
.options sparse gmin=1e-12 noopac
RG1 1 0 1000000000000
RG2 2 0 1000000000000
RG3 3 0 1000000000000
RG4 4 0 1000000000000
RG5 5 0 1000000000000
RG6 6 0 1000000000000
RG7 7 0 1000000000000
RG8 8 0 1000000000000
RG9 9 0 1000000000000
RG10 10 0 1000000000000
RG11 11 0 1000000000000
VS0 9 s0 0
R0 s0 1 18e-1
VS1 3 s1 0
L1 s1 6 15e-3
VS2 8 s2 0
L2 s2 6 27e-2
VS3 8 s3 0
R3 s3 3 27e1
VS4 4 s4 0
R4 s4 11 18e-2
VS5 6 s5 0
C5 s5 2 68e-4
VS6 10 s6 0
L6 s6 6 39e-3
VS7 0 s7 0
V7 e7 s7 DC 0 AC 47e0 0
RI7 e7 m7 18e-1
LI7 m7 1 56e-6
VS8 6 s8 0
R8 s8 5 68e3
VS9 3 s9 0
L9 s9 11 15e-4
VS10 7 s10 0
V10 e10 s10 DC 0 AC 22e-1 120
RI10 e10 m10 47e-2
LI10 m10 0 22e-6
VS11 4 s11 0
C11 s11 10 47e-6
VS12 7 s12 0
C12 s12 9 15e-4
VS13 0 s13 0
C13 s13 4 33e-5
VS14 8 s14 0
L14 s14 4 82e-3
VS15 11 s15 0
V15 e15 s15 DC 0 AC 39e-1 180
RI15 e15 m15 56e-3
LI15 m15 5 33e-7
VS16 7 s16 0
C16 s16 2 10e-6
VS17 4 s17 0
L17 s17 3 68e-3
VS18 5 s18 0
V18 e18 s18 DC 0 AC 47e-1 180
RI18 e18 m18 27e-2
LI18 m18 0 39e-7
VS19 1 s19 0
C19 s19 11 68e-4
.control
set numdgt=17
ac lin 1 60 60
print v(1) v(2) v(3) v(4) v(5) v(6) v(7) v(8) v(9) v(10)
print v(11)
print i(vs0) i(vs1) i(vs2) i(vs3) i(vs4) i(vs5) i(vs6) i(vs7) i(vs8) i(vs9)
print i(vs10) i(vs11) i(vs12) i(vs13) i(vs14) i(vs15) i(vs16) i(vs17) i(vs18) i(vs19)
.endc
.end
