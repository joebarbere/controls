controls oracle ac-0041
* Generated (plan F2.7, ADR 0012): do not edit; regenerate with `pnpm sim oracle regen`. ac seed 20261031 index 41 nodes 19 elements 30
.options sparse gmin=1e-12 noopac
RG1 1 0 1000000000000
RG2 2 0 1000000000000
RG3 3 0 1000000000000
RG4 4 0 1000000000000
RG5 5 0 1000000000000
RG6 6 0 1000000000000
RG7 7 0 1000000000000
RG8 8 0 1000000000000
RG9 9 0 1000000000000
RG10 10 0 1000000000000
RG11 11 0 1000000000000
RG12 12 0 1000000000000
RG13 13 0 1000000000000
RG14 14 0 1000000000000
RG15 15 0 1000000000000
RG16 16 0 1000000000000
RG17 17 0 1000000000000
RG18 18 0 1000000000000
VS0 16 s0 0
R0 s0 17 47e3
VS1 7 s1 0
L1 s1 9 10e-3
VS2 2 s2 0
R2 s2 13 18e-2
VS3 5 s3 0
C3 s3 10 82e-7
VS4 10 s4 0
C4 s4 8 18e-7
VS5 1 s5 0
R5 s5 2 33e1
VS6 1 s6 0
L6 s6 5 10e-4
VS7 2 s7 0
L7 s7 7 18e-4
VS8 5 s8 0
L8 s8 0 82e-2
VS9 15 s9 0
R9 s9 4 33e1
VS10 0 s10 0
V10 e10 s10 DC 0 AC 12e0 180
RI10 e10 n10 18e-2
H10 n10 h10 VS15 -33e-4
ED10 h10 12 d10 0 68e-6
F10 0 d10 VS15 1
LD10 d10 0 1
VS11 6 s11 0
L11 s11 11 56e-3
VS12 14 s12 0
R12 s12 10 33e2
VS13 15 s13 0
R13 s13 2 18e1
VS14 12 s14 0
C14 s14 0 68e-4
VS15 11 s15 0
V15 e15 s15 DC 0 AC 56e0 180
RI15 e15 n15 56e-3
H15 n15 h15 VS10 -33e-4
ED15 h15 1 d15 0 68e-6
F15 0 d15 VS10 1
LD15 d15 0 1
VS16 17 s16 0
R16 s16 2 82e-1
VS17 10 s17 0
R17 s17 3 68e-2
VS18 4 s18 0
C18 s18 5 22e-6
VS19 10 s19 0
C19 s19 17 82e-6
VS20 4 s20 0
V20 e20 s20 DC 0 AC 15e0 120
RI20 e20 m20 56e-3
LI20 m20 18 12e-6
VS21 6 s21 0
C21 s21 12 33e-7
VS22 2 s22 0
R22 s22 0 56e0
VS23 14 s23 0
R23 s23 0 68e-2
VS24 4 s24 0
V24 e24 s24 DC 0 AC 27e1 0
RI24 e24 3 10e-2
VS25 4 s25 0
C25 s25 9 47e-6
VS26 5 s26 0
R26 s26 13 47e-2
VS27 8 s27 0
R27 s27 18 56e-1
VS28 14 s28 0
C28 s28 10 22e-4
VS29 16 s29 0
L29 s29 5 68e-5
.control
set numdgt=17
ac lin 1 60 60
print v(1) v(2) v(3) v(4) v(5) v(6) v(7) v(8) v(9) v(10)
print v(11) v(12) v(13) v(14) v(15) v(16) v(17) v(18)
print i(vs0) i(vs1) i(vs2) i(vs3) i(vs4) i(vs5) i(vs6) i(vs7) i(vs8) i(vs9)
print i(vs10) i(vs11) i(vs12) i(vs13) i(vs14) i(vs15) i(vs16) i(vs17) i(vs18) i(vs19)
print i(vs20) i(vs21) i(vs22) i(vs23) i(vs24) i(vs25) i(vs26) i(vs27) i(vs28) i(vs29)
.endc
.end
