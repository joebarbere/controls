controls oracle ac-0041
* Generated (plan F2.7, ADR 0012): do not edit; regenerate with `pnpm sim oracle regen`. ac seed 20261031 index 41 nodes 19 elements 27
.options sparse gmin=1e-12 noopac
RG1 1 0 1000000000000
RG2 2 0 1000000000000
RG3 3 0 1000000000000
RG4 4 0 1000000000000
RG5 5 0 1000000000000
RG6 6 0 1000000000000
RG7 7 0 1000000000000
RG8 8 0 1000000000000
RG9 9 0 1000000000000
RG10 10 0 1000000000000
RG11 11 0 1000000000000
RG12 12 0 1000000000000
RG13 13 0 1000000000000
RG14 14 0 1000000000000
RG15 15 0 1000000000000
RG16 16 0 1000000000000
RG17 17 0 1000000000000
RG18 18 0 1000000000000
VS0 6 s0 0
L0 s0 0 56e-3
VS1 0 s1 0
V1 e1 s1 DC 0 AC 56e0 180
RI1 e1 1 56e-3
VS2 11 s2 0
L2 s2 7 18e-4
VS3 11 s3 0
R3 s3 13 18e-2
VS4 6 s4 0
C4 s4 12 33e-7
VS5 7 s5 0
L5 s5 9 10e-3
VS6 15 s6 0
R6 s6 4 33e1
VS7 10 s7 0
C7 s7 8 18e-7
VS8 12 s8 0
C8 s8 2 68e-4
VS9 4 s9 0
C9 s9 5 22e-6
VS10 5 s10 0
C10 s10 10 82e-7
VS11 17 s11 0
R11 s11 11 82e-1
VS12 16 s12 0
L12 s12 5 68e-5
VS13 14 s13 0
R13 s13 10 33e2
VS14 10 s14 0
R14 s14 3 68e-2
VS15 1 s15 0
L15 s15 5 10e-4
VS16 1 s16 0
R16 s16 11 33e1
VS17 8 s17 0
R17 s17 18 56e-1
VS18 2 s18 0
V18 e18 s18 DC 0 AC 12e0 180
RI18 e18 12 18e-2
VS19 5 s19 0
L19 s19 2 82e-2
VS20 14 s20 0
R20 s20 2 68e-2
VS21 16 s21 0
R21 s21 17 47e3
VS22 10 s22 0
C22 s22 17 82e-6
VS23 4 s23 0
V23 e23 s23 DC 0 AC 15e0 120
RI23 e23 18 56e-3
VS24 4 s24 0
C24 s24 9 47e-6
VS25 11 s25 0
R25 s25 2 56e0
VS26 14 s26 0
C26 s26 10 22e-4
.control
set numdgt=17
ac lin 1 60 60
print v(1) v(2) v(3) v(4) v(5) v(6) v(7) v(8) v(9) v(10)
print v(11) v(12) v(13) v(14) v(15) v(16) v(17) v(18)
print i(vs0) i(vs1) i(vs2) i(vs3) i(vs4) i(vs5) i(vs6) i(vs7) i(vs8) i(vs9)
print i(vs10) i(vs11) i(vs12) i(vs13) i(vs14) i(vs15) i(vs16) i(vs17) i(vs18) i(vs19)
print i(vs20) i(vs21) i(vs22) i(vs23) i(vs24) i(vs25) i(vs26)
.endc
.end
