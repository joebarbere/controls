controls oracle ac-0041
* Generated (plan F2.7, ADR 0012): do not edit; regenerate with `pnpm sim oracle regen`. ac seed 20261031 index 41 nodes 19 elements 35
.options sparse gmin=1e-12 noopac
RG1 1 0 1000000000000
RG2 2 0 1000000000000
RG3 3 0 1000000000000
RG4 4 0 1000000000000
RG5 5 0 1000000000000
RG6 6 0 1000000000000
RG7 7 0 1000000000000
RG8 8 0 1000000000000
RG9 9 0 1000000000000
RG10 10 0 1000000000000
RG11 11 0 1000000000000
RG12 12 0 1000000000000
RG13 13 0 1000000000000
RG14 14 0 1000000000000
RG15 15 0 1000000000000
RG16 16 0 1000000000000
RG17 17 0 1000000000000
RG18 18 0 1000000000000
VS0 4 s0 0
C0 s0 5 22e-6
VS1 16 s1 0
R1 s1 3 10e2
VS2 5 s2 0
C2 s2 10 82e-7
VS3 0 s3 0
V3 e3 s3 DC 0 AC 56e0 180
RI3 e3 m3 12e-3
LI3 m3 13 56e-7
VS4 10 s4 0
R4 s4 3 68e-2
VS5 17 s5 0
L5 s5 2 10e-3
VS6 7 s6 0
L6 s6 0 10e-3
VS7 18 s7 0
C7 s7 15 39e-5
VS8 13 s8 0
C8 s8 7 68e-5
VS9 6 s9 0
C9 s9 11 82e-6
VS10 14 s10 0
R10 s10 2 68e-2
VS11 4 s11 0
V11 e11 s11 DC 0 AC 15e0 120
RI11 e11 m11 56e-3
LI11 m11 18 10e-7
VS12 9 s12 0
R12 s12 2 56e0
VS13 0 s13 0
L13 s13 5 68e-3
VS14 9 s14 0
L14 s14 7 18e-4
VS15 12 s15 0
C15 s15 2 68e-4
VS16 6 s16 0
L16 s16 8 10e-2
VS17 15 s17 0
R17 s17 4 33e1
VS18 10 s18 0
C18 s18 17 82e-6
VS19 0 s19 0
R19 s19 7 47e-2
VS20 6 s20 0
C20 s20 12 33e-7
VS21 8 s21 0
R21 s21 18 12e-2
VS22 3 s22 0
L22 s22 13 12e-4
VS23 1 s23 0
R23 s23 9 33e1
VS24 6 s24 0
R24 s24 4 27e3
VS25 17 s25 0
R25 s25 9 82e-1
VS26 17 s26 0
R26 s26 8 27e2
VS27 1 s27 0
C27 s27 3 47e-4
VS28 2 s28 0
V28 e28 s28 DC 0 AC 12e0 180
RI28 e28 m28 18e-2
LI28 m28 12 33e-5
VS29 1 s29 0
L29 s29 5 10e-4
VS30 3 s30 0
R30 s30 11 12e3
VS31 15 s31 0
L31 s31 14 27e-3
VS32 16 s32 0
L32 s32 5 68e-5
VS33 9 s33 0
L33 s33 18 47e-5
VS34 16 s34 0
R34 s34 17 47e3
.control
set numdgt=17
ac lin 1 60 60
print v(1) v(2) v(3) v(4) v(5) v(6) v(7) v(8) v(9) v(10)
print v(11) v(12) v(13) v(14) v(15) v(16) v(17) v(18)
print i(vs0) i(vs1) i(vs2) i(vs3) i(vs4) i(vs5) i(vs6) i(vs7) i(vs8) i(vs9)
print i(vs10) i(vs11) i(vs12) i(vs13) i(vs14) i(vs15) i(vs16) i(vs17) i(vs18) i(vs19)
print i(vs20) i(vs21) i(vs22) i(vs23) i(vs24) i(vs25) i(vs26) i(vs27) i(vs28) i(vs29)
print i(vs30) i(vs31) i(vs32) i(vs33) i(vs34)
.endc
.end
