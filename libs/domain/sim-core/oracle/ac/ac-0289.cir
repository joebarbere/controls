controls oracle ac-0289
* Generated (plan F2.7, ADR 0012): do not edit; regenerate with `pnpm sim oracle regen`. ac seed 20261031 index 289 nodes 23 elements 32
.options sparse gmin=1e-12 noopac
RG1 1 0 1000000000000
RG2 2 0 1000000000000
RG3 3 0 1000000000000
RG4 4 0 1000000000000
RG5 5 0 1000000000000
RG6 6 0 1000000000000
RG7 7 0 1000000000000
RG8 8 0 1000000000000
RG9 9 0 1000000000000
RG10 10 0 1000000000000
RG11 11 0 1000000000000
RG12 12 0 1000000000000
RG13 13 0 1000000000000
RG14 14 0 1000000000000
RG15 15 0 1000000000000
RG16 16 0 1000000000000
RG17 17 0 1000000000000
RG18 18 0 1000000000000
RG19 19 0 1000000000000
RG20 20 0 1000000000000
RG21 21 0 1000000000000
RG22 22 0 1000000000000
VS0 6 s0 0
L0 s0 2 27e-4
VS1 11 s1 0
R1 s1 20 39e1
VS2 9 s2 0
R2 s2 19 18e-2
VS3 18 s3 0
L3 s3 11 47e-4
VS4 7 s4 0
L4 s4 1 39e-3
VS5 5 s5 0
C5 s5 16 47e-6
VS6 15 s6 0
C6 s6 8 68e-6
VS7 19 s7 0
L7 s7 16 56e-2
VS8 4 s8 0
L8 s8 18 33e-5
VS9 8 s9 0
R9 s9 18 56e1
VS10 9 s10 0
L10 s10 6 47e-3
VS11 0 s11 0
C11 s11 4 10e-7
VS12 21 s12 0
R12 s12 3 12e2
VS13 0 s13 0
V13 e13 s13 DC 0 AC 82e1 120
RI13 e13 22 27e-1
VS14 13 s14 0
C14 s14 16 27e-5
VS15 12 s15 0
L15 s15 4 27e-5
VS16 0 s16 0
R16 s16 8 12e-2
VS17 14 s17 0
C17 s17 2 33e-4
VS18 0 s18 0
R18 s18 5 47e2
VS19 22 s19 0
L19 s19 12 47e-3
VS20 0 s20 0
R20 s20 20 12e2
VS21 15 s21 0
R21 s21 17 82e0
VS22 22 s22 0
C22 s22 3 10e-7
VS23 14 s23 0
C23 s23 22 39e-7
VS24 21 s24 0
R24 s24 6 12e1
VS25 10 s25 0
R25 s25 13 68e2
VS26 0 s26 0
C26 s26 17 56e-7
VS27 9 s27 0
V27 e27 s27 DC 0 AC 10e1 120
RI27 e27 m27 56e-2
LI27 m27 4 47e-6
VS28 6 s28 0
R28 s28 7 12e2
VS29 1 s29 0
R29 s29 22 10e-2
VS30 7 s30 0
V30 e30 s30 DC 0 AC 12e0 0
RI30 e30 m30 82e-2
LI30 m30 14 39e-5
VS31 18 s31 0
R31 s31 10 39e-2
.control
set numdgt=17
ac lin 1 60 60
print v(1) v(2) v(3) v(4) v(5) v(6) v(7) v(8) v(9) v(10)
print v(11) v(12) v(13) v(14) v(15) v(16) v(17) v(18) v(19) v(20)
print v(21) v(22)
print i(vs0) i(vs1) i(vs2) i(vs3) i(vs4) i(vs5) i(vs6) i(vs7) i(vs8) i(vs9)
print i(vs10) i(vs11) i(vs12) i(vs13) i(vs14) i(vs15) i(vs16) i(vs17) i(vs18) i(vs19)
print i(vs20) i(vs21) i(vs22) i(vs23) i(vs24) i(vs25) i(vs26) i(vs27) i(vs28) i(vs29)
print i(vs30) i(vs31)
.endc
.end
