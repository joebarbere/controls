controls oracle ac-0289
* Generated (plan F2.7, ADR 0012): do not edit; regenerate with `pnpm sim oracle regen`. ac seed 20261031 index 289 nodes 23 elements 45
.options sparse gmin=1e-12 noopac
RG1 1 0 1000000000000
RG2 2 0 1000000000000
RG3 3 0 1000000000000
RG4 4 0 1000000000000
RG5 5 0 1000000000000
RG6 6 0 1000000000000
RG7 7 0 1000000000000
RG8 8 0 1000000000000
RG9 9 0 1000000000000
RG10 10 0 1000000000000
RG11 11 0 1000000000000
RG12 12 0 1000000000000
RG13 13 0 1000000000000
RG14 14 0 1000000000000
RG15 15 0 1000000000000
RG16 16 0 1000000000000
RG17 17 0 1000000000000
RG18 18 0 1000000000000
RG19 19 0 1000000000000
RG20 20 0 1000000000000
RG21 21 0 1000000000000
RG22 22 0 1000000000000
VS0 0 s0 0
V0 e0 s0 DC 0 AC 18e0 -120
RI0 e0 3 15e-1
VS1 17 s1 0
R1 s1 12 12e1
VS2 20 s2 0
V2 e2 s2 DC 0 AC 12e0 120
RI2 e2 10 15e-3
VS3 14 s3 0
V3 e3 s3 DC 0 AC 82e1 120
RI3 e3 22 27e-1
VS4 3 s4 0
C4 s4 7 33e-4
VS5 19 s5 0
C5 s5 22 82e-6
VS6 14 s6 0
R6 s6 11 39e1
VS7 3 s7 0
C7 s7 5 27e-6
VS8 20 s8 0
L8 s8 6 47e-3
VS9 8 s9 0
L9 s9 21 47e-4
VS10 20 s10 0
V10 e10 s10 DC 0 AC 82e0 -120
RI10 e10 12 82e-3
VS11 5 s11 0
R11 s11 17 33e-2
VS12 22 s12 0
C12 s12 6 56e-7
VS13 11 s13 0
L13 s13 0 68e-5
VS14 15 s14 0
V14 e14 s14 DC 0 AC 15e0 120
RI14 e14 1 27e-1
VS15 16 s15 0
V15 e15 s15 DC 0 AC 27e-1 180
RI15 e15 14 15e-3
VS16 8 s16 0
V16 e16 s16 DC 0 AC 47e0 120
RI16 e16 22 47e-3
VS17 18 s17 0
V17 e17 s17 DC 0 AC 33e-1 120
RI17 e17 14 56e-2
VS18 18 s18 0
R18 s18 8 33e-2
VS19 21 s19 0
C19 s19 2 18e-5
VS20 8 s20 0
V20 e20 s20 DC 0 AC 12e1 120
RI20 e20 6 39e-1
VS21 2 s21 0
R21 s21 3 12e2
VS22 10 s22 0
L22 s22 12 39e-3
VS23 13 s23 0
C23 s23 22 39e-7
VS24 1 s24 0
R24 s24 22 10e-2
VS25 19 s25 0
V25 e25 s25 DC 0 AC 82e1 0
RI25 e25 6 56e-2
VS26 21 s26 0
C26 s26 9 10e-4
VS27 8 s27 0
V27 e27 s27 DC 0 AC 10e0 0
RI27 e27 3 47e-3
VS28 12 s28 0
C28 s28 0 27e-5
VS29 19 s29 0
R29 s29 0 22e3
VS30 13 s30 0
R30 s30 21 68e2
VS31 8 s31 0
R31 s31 15 56e1
VS32 5 s32 0
L32 s32 17 82e-2
VS33 4 s33 0
C33 s33 1 82e-6
VS34 8 s34 0
V34 e34 s34 DC 0 AC 10e1 120
RI34 e34 9 56e-2
VS35 4 s35 0
R35 s35 8 27e-2
VS36 9 s36 0
R36 s36 17 39e3
VS37 21 s37 0
R37 s37 5 18e2
VS38 18 s38 0
R38 s38 14 47e2
VS39 3 s39 0
L39 s39 16 47e-4
VS40 12 s40 0
C40 s40 14 68e-6
VS41 7 s41 0
L41 s41 12 10e-5
VS42 14 s42 0
R42 s42 18 39e-2
VS43 19 s43 0
R43 s43 9 27e2
VS44 10 s44 0
V44 e44 s44 DC 0 AC 33e0 180
RI44 e44 5 18e-3
.control
set numdgt=17
ac lin 1 60 60
print v(1) v(2) v(3) v(4) v(5) v(6) v(7) v(8) v(9) v(10)
print v(11) v(12) v(13) v(14) v(15) v(16) v(17) v(18) v(19) v(20)
print v(21) v(22)
print i(vs0) i(vs1) i(vs2) i(vs3) i(vs4) i(vs5) i(vs6) i(vs7) i(vs8) i(vs9)
print i(vs10) i(vs11) i(vs12) i(vs13) i(vs14) i(vs15) i(vs16) i(vs17) i(vs18) i(vs19)
print i(vs20) i(vs21) i(vs22) i(vs23) i(vs24) i(vs25) i(vs26) i(vs27) i(vs28) i(vs29)
print i(vs30) i(vs31) i(vs32) i(vs33) i(vs34) i(vs35) i(vs36) i(vs37) i(vs38) i(vs39)
print i(vs40) i(vs41) i(vs42) i(vs43) i(vs44)
.endc
.end
