controls oracle ac-0289
* Generated (plan F2.7, ADR 0012): do not edit; regenerate with `pnpm sim oracle regen`. ac seed 20261031 index 289 nodes 23 elements 42
.options sparse gmin=1e-12 noopac
RG1 1 0 1000000000000
RG2 2 0 1000000000000
RG3 3 0 1000000000000
RG4 4 0 1000000000000
RG5 5 0 1000000000000
RG6 6 0 1000000000000
RG7 7 0 1000000000000
RG8 8 0 1000000000000
RG9 9 0 1000000000000
RG10 10 0 1000000000000
RG11 11 0 1000000000000
RG12 12 0 1000000000000
RG13 13 0 1000000000000
RG14 14 0 1000000000000
RG15 15 0 1000000000000
RG16 16 0 1000000000000
RG17 17 0 1000000000000
RG18 18 0 1000000000000
RG19 19 0 1000000000000
RG20 20 0 1000000000000
RG21 21 0 1000000000000
RG22 22 0 1000000000000
VS0 0 s0 0
V0 e0 s0 DC 0 AC 47e0 120
RI0 e0 22 47e-3
VS1 21 s1 0
C1 s1 2 18e-5
VS2 10 s2 0
V2 e2 s2 DC 0 AC 33e0 180
RI2 e2 5 18e-3
VS3 3 s3 0
C3 s3 5 27e-6
VS4 21 s4 0
R4 s4 5 18e2
VS5 15 s5 0
V5 e5 s5 DC 0 AC 15e0 120
RI5 e5 1 27e-1
VS6 8 s6 0
R6 s6 21 68e2
VS7 17 s7 0
R7 s7 12 12e1
VS8 18 s8 0
V8 e8 s8 DC 0 AC 33e-1 120
RI8 e8 14 56e-2
VS9 4 s9 0
R9 s9 0 27e-2
VS10 0 s10 0
R10 s10 15 56e1
VS11 19 s11 0
C11 s11 22 82e-6
VS12 5 s12 0
R12 s12 17 33e-2
VS13 22 s13 0
C13 s13 6 56e-7
VS14 21 s14 0
C14 s14 9 10e-4
VS15 8 s15 0
C15 s15 22 39e-7
VS16 2 s16 0
R16 s16 3 12e2
VS17 14 s17 0
R17 s17 18 39e-2
VS18 7 s18 0
L18 s18 12 10e-5
VS19 19 s19 0
R19 s19 9 27e2
VS20 9 s20 0
R20 s20 17 39e3
VS21 0 s21 0
V21 e21 s21 DC 0 AC 12e1 120
RI21 e21 6 39e-1
VS22 5 s22 0
L22 s22 17 82e-2
VS23 0 s23 0
V23 e23 s23 DC 0 AC 10e1 120
RI23 e23 9 56e-2
VS24 14 s24 0
V24 e24 s24 DC 0 AC 82e1 120
RI24 e24 22 27e-1
VS25 13 s25 0
V25 e25 s25 DC 0 AC 18e0 -120
RI25 e25 3 15e-1
VS26 0 s26 0
L26 s26 21 47e-4
VS27 19 s27 0
V27 e27 s27 DC 0 AC 82e1 0
RI27 e27 6 56e-2
VS28 14 s28 0
R28 s28 11 39e1
VS29 3 s29 0
L29 s29 16 47e-4
VS30 1 s30 0
R30 s30 22 10e-2
VS31 20 s31 0
V31 e31 s31 DC 0 AC 82e0 -120
RI31 e31 12 82e-3
VS32 12 s32 0
C32 s32 14 68e-6
VS33 20 s33 0
L33 s33 6 47e-3
VS34 18 s34 0
R34 s34 14 47e2
VS35 20 s35 0
V35 e35 s35 DC 0 AC 12e0 120
RI35 e35 10 15e-3
VS36 3 s36 0
C36 s36 7 33e-4
VS37 10 s37 0
L37 s37 12 39e-3
VS38 16 s38 0
V38 e38 s38 DC 0 AC 27e-1 180
RI38 e38 14 15e-3
VS39 12 s39 0
C39 s39 13 27e-5
VS40 0 s40 0
V40 e40 s40 DC 0 AC 10e0 0
RI40 e40 3 47e-3
VS41 19 s41 0
R41 s41 13 22e3
.control
set numdgt=17
ac lin 1 60 60
print v(1) v(2) v(3) v(4) v(5) v(6) v(7) v(8) v(9) v(10)
print v(11) v(12) v(13) v(14) v(15) v(16) v(17) v(18) v(19) v(20)
print v(21) v(22)
print i(vs0) i(vs1) i(vs2) i(vs3) i(vs4) i(vs5) i(vs6) i(vs7) i(vs8) i(vs9)
print i(vs10) i(vs11) i(vs12) i(vs13) i(vs14) i(vs15) i(vs16) i(vs17) i(vs18) i(vs19)
print i(vs20) i(vs21) i(vs22) i(vs23) i(vs24) i(vs25) i(vs26) i(vs27) i(vs28) i(vs29)
print i(vs30) i(vs31) i(vs32) i(vs33) i(vs34) i(vs35) i(vs36) i(vs37) i(vs38) i(vs39)
print i(vs40) i(vs41)
.endc
.end
