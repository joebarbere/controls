controls oracle ac-0458
* Generated (plan F2.7, ADR 0012): do not edit; regenerate with `pnpm sim oracle regen`. ac seed 20261031 index 458 nodes 11 elements 19
.options sparse gmin=1e-12 noopac
RG1 1 0 1000000000000
RG2 2 0 1000000000000
RG3 3 0 1000000000000
RG4 4 0 1000000000000
RG5 5 0 1000000000000
RG6 6 0 1000000000000
RG7 7 0 1000000000000
RG8 8 0 1000000000000
RG9 9 0 1000000000000
RG10 10 0 1000000000000
VS0 0 s0 0
V0 e0 s0 DC 0 AC 56e-1 180
RI0 e0 3 18e-1
VS1 2 s1 0
V1 e1 s1 DC 0 AC 12e1 120
RI1 e1 3 68e-2
VS2 3 s2 0
R2 s2 7 27e0
VS3 2 s3 0
R3 s3 1 33e0
VS4 2 s4 0
V4 e4 s4 DC 0 AC 12e0 120
RI4 e4 m4 10e-2
LI4 m4 3 27e-5
VS5 0 s5 0
L5 s5 6 39e-5
VS6 5 s6 0
V6 e6 s6 DC 0 AC 10e0 -120
RI6 e6 m6 10e-2
LI6 m6 6 39e-5
VS7 9 s7 0
V7 e7 s7 DC 0 AC 18e0 120
RI7 e7 6 12e-3
VS8 10 s8 0
V8 e8 s8 DC 0 AC 18e-1 120
RI8 e8 m8 68e-3
LI8 m8 8 12e-7
VS9 6 s9 0
V9 e9 s9 DC 0 AC 33e0 -120
RI9 e9 0 56e-1
VS10 7 s10 0
R10 s10 4 22e3
VS11 10 s11 0
R11 s11 0 56e3
VS12 4 s12 0
R12 s12 2 15e-1
VS13 9 s13 0
C13 s13 0 22e-7
VS14 7 s14 0
C14 s14 2 10e-7
VS15 1 s15 0
R15 s15 10 82e-2
VS16 9 s16 0
R16 s16 2 68e1
VS17 8 s17 0
C17 s17 6 18e-6
VS18 5 s18 0
V18 e18 s18 DC 0 AC 33e1 180
RI18 e18 3 12e-2
.control
set numdgt=17
ac lin 1 60 60
print v(1) v(2) v(3) v(4) v(5) v(6) v(7) v(8) v(9) v(10)
print i(vs0) i(vs1) i(vs2) i(vs3) i(vs4) i(vs5) i(vs6) i(vs7) i(vs8) i(vs9)
print i(vs10) i(vs11) i(vs12) i(vs13) i(vs14) i(vs15) i(vs16) i(vs17) i(vs18)
.endc
.end
