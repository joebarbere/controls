controls oracle ac-0458
* Generated (plan F2.7, ADR 0012): do not edit; regenerate with `pnpm sim oracle regen`. ac seed 20261031 index 458 nodes 11 elements 12
.options sparse gmin=1e-12 noopac
RG1 1 0 1000000000000
RG2 2 0 1000000000000
RG3 3 0 1000000000000
RG4 4 0 1000000000000
RG5 5 0 1000000000000
RG6 6 0 1000000000000
RG7 7 0 1000000000000
RG8 8 0 1000000000000
RG9 9 0 1000000000000
RG10 10 0 1000000000000
VS0 6 s0 0
L0 s0 1 18e-2
VS1 10 s1 0
R1 s1 7 68e1
VS2 0 s2 0
V2 e2 s2 DC 0 AC 33e0 -120
RI2 e2 6 56e-1
VS3 8 s3 0
C3 s3 5 39e-6
VS4 4 s4 0
C4 s4 2 18e-6
VS5 8 s5 0
C5 s5 1 10e-7
VS6 6 s6 0
R6 s6 9 12e1
VS7 2 s7 0
V7 e7 s7 DC 0 AC 56e-1 180
RI7 e7 5 18e-1
VS8 2 s8 0
L8 s8 9 18e-5
VS9 10 s9 0
R9 s9 6 56e3
VS10 9 s10 0
V10 e10 s10 DC 0 AC 82e0 180
RI10 e10 4 12e-2
VS11 8 s11 0
R11 s11 3 22e3
.control
set numdgt=17
ac lin 1 60 60
print v(1) v(2) v(3) v(4) v(5) v(6) v(7) v(8) v(9) v(10)
print i(vs0) i(vs1) i(vs2) i(vs3) i(vs4) i(vs5) i(vs6) i(vs7) i(vs8) i(vs9)
print i(vs10) i(vs11)
.endc
.end
