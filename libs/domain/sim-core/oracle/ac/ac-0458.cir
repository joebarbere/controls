controls oracle ac-0458
* Generated (plan F2.7, ADR 0012): do not edit; regenerate with `pnpm sim oracle regen`. ac seed 20261031 index 458 nodes 11 elements 15
.options sparse gmin=1e-12 noopac
RG1 1 0 1000000000000
RG2 2 0 1000000000000
RG3 3 0 1000000000000
RG4 4 0 1000000000000
RG5 5 0 1000000000000
RG6 6 0 1000000000000
RG7 7 0 1000000000000
RG8 8 0 1000000000000
RG9 9 0 1000000000000
RG10 10 0 1000000000000
VS0 4 s0 0
L0 s0 7 10e-5
VS1 2 s1 0
L1 s1 0 18e-5
VS2 8 s2 0
C2 s2 1 10e-7
VS3 9 s3 0
R3 s3 0 12e1
VS4 8 s4 0
C4 s4 5 39e-6
VS5 10 s5 0
R5 s5 7 68e1
VS6 4 s6 0
C6 s6 2 18e-6
VS7 0 s7 0
V7 e7 s7 DC 0 AC 82e0 180
RI7 e7 m7 12e-2
LI7 m7 4 82e-7
VS8 4 s8 0
R8 s8 6 47e3
VS9 9 s9 0
L9 s9 1 18e-2
VS10 2 s10 0
V10 e10 s10 DC 0 AC 56e-1 180
RI10 e10 5 18e-1
VS11 6 s11 0
V11 e11 s11 DC 0 AC 33e0 -120
RI11 e11 9 56e-1
VS12 8 s12 0
R12 s12 3 22e3
VS13 10 s13 0
R13 s13 9 56e3
VS14 4 s14 0
C14 s14 3 47e-7
.control
set numdgt=17
ac lin 1 60 60
print v(1) v(2) v(3) v(4) v(5) v(6) v(7) v(8) v(9) v(10)
print i(vs0) i(vs1) i(vs2) i(vs3) i(vs4) i(vs5) i(vs6) i(vs7) i(vs8) i(vs9)
print i(vs10) i(vs11) i(vs12) i(vs13) i(vs14)
.endc
.end
