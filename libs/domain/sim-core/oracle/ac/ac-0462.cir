controls oracle ac-0462
* Generated (plan F2.7, ADR 0012): do not edit; regenerate with `pnpm sim oracle regen`. ac seed 20261031 index 462 nodes 16 elements 25
.options sparse gmin=1e-12 noopac
RG1 1 0 1000000000000
RG2 2 0 1000000000000
RG3 3 0 1000000000000
RG4 4 0 1000000000000
RG5 5 0 1000000000000
RG6 6 0 1000000000000
RG7 7 0 1000000000000
RG8 8 0 1000000000000
RG9 9 0 1000000000000
RG10 10 0 1000000000000
RG11 11 0 1000000000000
RG12 12 0 1000000000000
RG13 13 0 1000000000000
RG14 14 0 1000000000000
RG15 15 0 1000000000000
VS0 9 s0 0
R0 s0 10 39e-1
VS1 15 s1 0
C1 s1 5 15e-7
VS2 10 s2 0
R2 s2 1 33e-2
VS3 0 s3 0
V3 e3 s3 DC 0 AC 39e1 0
RI3 e3 m3 27e-1
LI3 m3 3 22e-6
VS4 10 s4 0
C4 s4 14 10e-4
VS5 7 s5 0
C5 s5 4 10e-6
VS6 12 s6 0
C6 s6 15 68e-6
VS7 1 s7 0
C7 s7 7 47e-4
VS8 14 s8 0
L8 s8 6 82e-3
VS9 7 s9 0
C9 s9 0 68e-5
VS10 5 s10 0
V10 e10 s10 DC 0 AC 68e0 120
RI10 e10 m10 18e-2
LI10 m10 12 15e-7
VS11 9 s11 0
L11 s11 2 18e-4
VS12 1 s12 0
R12 s12 11 15e-2
VS13 8 s13 0
R13 s13 5 22e-1
VS14 13 s14 0
L14 s14 1 39e-5
VS15 1 s15 0
R15 s15 8 47e0
VS16 6 s16 0
L16 s16 7 27e-2
VS17 13 s17 0
R17 s17 4 56e-2
VS18 8 s18 0
L18 s18 15 39e-5
VS19 11 s19 0
L19 s19 7 39e-2
VS20 2 s20 0
L20 s20 3 22e-2
VS21 14 s21 0
V21 e21 s21 DC 0 AC 68e-1 180
RI21 e21 0 18e-3
VS22 15 s22 0
L22 s22 8 68e-2
VS23 4 s23 0
R23 s23 10 39e-2
VS24 15 s24 0
C24 s24 9 22e-4
.control
set numdgt=17
ac lin 1 60 60
print v(1) v(2) v(3) v(4) v(5) v(6) v(7) v(8) v(9) v(10)
print v(11) v(12) v(13) v(14) v(15)
print i(vs0) i(vs1) i(vs2) i(vs3) i(vs4) i(vs5) i(vs6) i(vs7) i(vs8) i(vs9)
print i(vs10) i(vs11) i(vs12) i(vs13) i(vs14) i(vs15) i(vs16) i(vs17) i(vs18) i(vs19)
print i(vs20) i(vs21) i(vs22) i(vs23) i(vs24)
.endc
.end
