controls oracle ac-0462
* Generated (plan F2.7, ADR 0012): do not edit; regenerate with `pnpm sim oracle regen`. ac seed 20261031 index 462 nodes 16 elements 25
.options sparse gmin=1e-12 noopac
RG1 1 0 1000000000000
RG2 2 0 1000000000000
RG3 3 0 1000000000000
RG4 4 0 1000000000000
RG5 5 0 1000000000000
RG6 6 0 1000000000000
RG7 7 0 1000000000000
RG8 8 0 1000000000000
RG9 9 0 1000000000000
RG10 10 0 1000000000000
RG11 11 0 1000000000000
RG12 12 0 1000000000000
RG13 13 0 1000000000000
RG14 14 0 1000000000000
RG15 15 0 1000000000000
VS0 8 s0 0
L0 s0 15 39e-5
VS1 10 s1 0
R1 s1 1 33e-2
VS2 12 s2 0
C2 s2 15 68e-6
VS3 0 s3 0
V3 e3 s3 DC 0 AC 68e-1 180
RI3 e3 m3 18e-3
LI3 m3 n3 27e-7
H3 n3 h3 VS4 15e-4
ED3 h3 9 d3 0 39e-7
F3 0 d3 VS4 1
LD3 d3 0 1
VS4 3 s4 0
V4 e4 s4 DC 0 AC 22e1 -120
RI4 e4 n4 12e-2
H4 n4 h4 VS3 15e-4
ED4 h4 5 d4 0 39e-7
F4 0 d4 VS3 1
LD4 d4 0 1
VS5 2 s5 0
L5 s5 3 22e-2
VS6 13 s6 0
R6 s6 4 56e-2
VS7 14 s7 0
L7 s7 2 18e-4
VS8 7 s8 0
C8 s8 9 68e-5
VS9 13 s9 0
R9 s9 14 22e0
VS10 0 s10 0
L10 s10 6 82e-3
VS11 8 s11 0
R11 s11 5 22e-1
VS12 14 s12 0
R12 s12 10 39e-1
VS13 1 s13 0
C13 s13 7 47e-4
VS14 2 s14 0
V14 e14 s14 DC 0 AC 33e1 0
RI14 e14 m14 33e-2
LI14 m14 5 56e-6
VS15 6 s15 0
C15 s15 15 12e-6
VS16 4 s16 0
R16 s16 10 39e-2
VS17 9 s17 0
R17 s17 12 10e0
VS18 4 s18 0
L18 s18 0 18e-2
VS19 15 s19 0
C19 s19 14 22e-4
VS20 11 s20 0
L20 s20 7 39e-2
VS21 15 s21 0
L21 s21 8 68e-2
VS22 10 s22 0
C22 s22 0 10e-4
VS23 7 s23 0
C23 s23 4 10e-6
VS24 1 s24 0
R24 s24 11 15e2
.control
set numdgt=17
ac lin 1 60 60
print v(1) v(2) v(3) v(4) v(5) v(6) v(7) v(8) v(9) v(10)
print v(11) v(12) v(13) v(14) v(15)
print i(vs0) i(vs1) i(vs2) i(vs3) i(vs4) i(vs5) i(vs6) i(vs7) i(vs8) i(vs9)
print i(vs10) i(vs11) i(vs12) i(vs13) i(vs14) i(vs15) i(vs16) i(vs17) i(vs18) i(vs19)
print i(vs20) i(vs21) i(vs22) i(vs23) i(vs24)
.endc
.end
