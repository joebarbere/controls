controls oracle ac-0462
* Generated (plan F2.7, ADR 0012): do not edit; regenerate with `pnpm sim oracle regen`. ac seed 20261031 index 462 nodes 16 elements 19
.options sparse gmin=1e-12 noopac
RG1 1 0 1000000000000
RG2 2 0 1000000000000
RG3 3 0 1000000000000
RG4 4 0 1000000000000
RG5 5 0 1000000000000
RG6 6 0 1000000000000
RG7 7 0 1000000000000
RG8 8 0 1000000000000
RG9 9 0 1000000000000
RG10 10 0 1000000000000
RG11 11 0 1000000000000
RG12 12 0 1000000000000
RG13 13 0 1000000000000
RG14 14 0 1000000000000
RG15 15 0 1000000000000
VS0 11 s0 0
L0 s0 7 39e-2
VS1 0 s1 0
L1 s1 6 82e-3
VS2 10 s2 0
R2 s2 1 33e-2
VS3 4 s3 0
R3 s3 10 39e-2
VS4 1 s4 0
C4 s4 7 47e-4
VS5 14 s5 0
R5 s5 10 39e-1
VS6 7 s6 0
C6 s6 9 68e-5
VS7 8 s7 0
L7 s7 15 39e-5
VS8 7 s8 0
C8 s8 4 10e-6
VS9 12 s9 0
C9 s9 15 68e-6
VS10 14 s10 0
L10 s10 2 18e-4
VS11 15 s11 0
L11 s11 8 68e-2
VS12 4 s12 0
L12 s12 0 18e-2
VS13 2 s13 0
L13 s13 3 22e-2
VS14 10 s14 0
C14 s14 0 10e-4
VS15 0 s15 0
V15 e15 s15 DC 0 AC 68e-1 180
RI15 e15 9 18e-3
VS16 15 s16 0
C16 s16 14 22e-4
VS17 8 s17 0
R17 s17 5 22e-1
VS18 13 s18 0
R18 s18 4 56e-2
.control
set numdgt=17
ac lin 1 60 60
print v(1) v(2) v(3) v(4) v(5) v(6) v(7) v(8) v(9) v(10)
print v(11) v(12) v(13) v(14) v(15)
print i(vs0) i(vs1) i(vs2) i(vs3) i(vs4) i(vs5) i(vs6) i(vs7) i(vs8) i(vs9)
print i(vs10) i(vs11) i(vs12) i(vs13) i(vs14) i(vs15) i(vs16) i(vs17) i(vs18)
.endc
.end
