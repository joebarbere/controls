controls oracle ac-0030
* Generated (plan F2.7, ADR 0012): do not edit; regenerate with `pnpm sim oracle regen`. ac seed 20261031 index 30 nodes 27 elements 41
.options sparse gmin=1e-12 noopac
RG1 1 0 1000000000000
RG2 2 0 1000000000000
RG3 3 0 1000000000000
RG4 4 0 1000000000000
RG5 5 0 1000000000000
RG6 6 0 1000000000000
RG7 7 0 1000000000000
RG8 8 0 1000000000000
RG9 9 0 1000000000000
RG10 10 0 1000000000000
RG11 11 0 1000000000000
RG12 12 0 1000000000000
RG13 13 0 1000000000000
RG14 14 0 1000000000000
RG15 15 0 1000000000000
RG16 16 0 1000000000000
RG17 17 0 1000000000000
RG18 18 0 1000000000000
RG19 19 0 1000000000000
RG20 20 0 1000000000000
RG21 21 0 1000000000000
RG22 22 0 1000000000000
RG23 23 0 1000000000000
RG24 24 0 1000000000000
RG25 25 0 1000000000000
RG26 26 0 1000000000000
VS0 18 s0 0
R0 s0 3 82e-2
VS1 2 s1 0
C1 s1 26 10e-4
VS2 17 s2 0
L2 s2 24 10e-4
VS3 20 s3 0
R3 s3 8 27e0
VS4 11 s4 0
L4 s4 0 68e-4
VS5 13 s5 0
L5 s5 0 22e-4
VS6 25 s6 0
R6 s6 3 68e3
VS7 20 s7 0
R7 s7 7 56e2
VS8 24 s8 0
R8 s8 0 15e2
VS9 0 s9 0
V9 e9 s9 DC 0 AC 12e0 0
RI9 e9 5 68e-3
VS10 18 s10 0
L10 s10 26 15e-5
VS11 24 s11 0
L11 s11 20 47e-5
VS12 0 s12 0
C12 s12 20 12e-4
VS13 9 s13 0
L13 s13 18 12e-3
VS14 12 s14 0
R14 s14 16 39e-2
VS15 11 s15 0
R15 s15 18 12e-2
VS16 15 s16 0
C16 s16 7 33e-6
VS17 17 s17 0
C17 s17 23 22e-6
VS18 17 s18 0
C18 s18 10 47e-6
VS19 23 s19 0
R19 s19 5 12e3
VS20 8 s20 0
L20 s20 2 33e-4
VS21 4 s21 0
V21 e21 s21 DC 0 AC 39e-1 120
RI21 e21 19 18e-2
VS22 20 s22 0
R22 s22 12 10e1
VS23 3 s23 0
C23 s23 13 56e-7
VS24 15 s24 0
R24 s24 14 10e3
VS25 22 s25 0
C25 s25 11 56e-6
VS26 20 s26 0
V26 e26 s26 DC 0 AC 10e1 -120
RI26 e26 16 15e-1
VS27 10 s27 0
L27 s27 20 12e-2
VS28 4 s28 0
V28 e28 s28 DC 0 AC 39e1 -120
RI28 e28 2 27e-1
VS29 18 s29 0
L29 s29 16 47e-2
VS30 8 s30 0
C30 s30 21 15e-5
VS31 20 s31 0
C31 s31 19 15e-5
VS32 5 s32 0
R32 s32 12 47e1
VS33 6 s33 0
C33 s33 15 82e-6
VS34 3 s34 0
L34 s34 21 68e-3
VS35 10 s35 0
R35 s35 22 82e-1
VS36 17 s36 0
L36 s36 26 47e-4
VS37 18 s37 0
R37 s37 1 82e3
VS38 2 s38 0
V38 e38 s38 DC 0 AC 12e0 -120
RI38 e38 7 12e-3
VS39 9 s39 0
V39 e39 s39 DC 0 AC 82e-1 180
RI39 e39 14 27e-2
VS40 20 s40 0
L40 s40 2 15e-4
.control
set numdgt=17
ac lin 1 60 60
print v(1) v(2) v(3) v(4) v(5) v(6) v(7) v(8) v(9) v(10)
print v(11) v(12) v(13) v(14) v(15) v(16) v(17) v(18) v(19) v(20)
print v(21) v(22) v(23) v(24) v(25) v(26)
print i(vs0) i(vs1) i(vs2) i(vs3) i(vs4) i(vs5) i(vs6) i(vs7) i(vs8) i(vs9)
print i(vs10) i(vs11) i(vs12) i(vs13) i(vs14) i(vs15) i(vs16) i(vs17) i(vs18) i(vs19)
print i(vs20) i(vs21) i(vs22) i(vs23) i(vs24) i(vs25) i(vs26) i(vs27) i(vs28) i(vs29)
print i(vs30) i(vs31) i(vs32) i(vs33) i(vs34) i(vs35) i(vs36) i(vs37) i(vs38) i(vs39)
print i(vs40)
.endc
.end
