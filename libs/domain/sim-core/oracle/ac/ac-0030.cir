controls oracle ac-0030
* Generated (plan F2.7, ADR 0012): do not edit; regenerate with `pnpm sim oracle regen`. ac seed 20261031 index 30 nodes 27 elements 49
.options sparse gmin=1e-12 noopac
RG1 1 0 1000000000000
RG2 2 0 1000000000000
RG3 3 0 1000000000000
RG4 4 0 1000000000000
RG5 5 0 1000000000000
RG6 6 0 1000000000000
RG7 7 0 1000000000000
RG8 8 0 1000000000000
RG9 9 0 1000000000000
RG10 10 0 1000000000000
RG11 11 0 1000000000000
RG12 12 0 1000000000000
RG13 13 0 1000000000000
RG14 14 0 1000000000000
RG15 15 0 1000000000000
RG16 16 0 1000000000000
RG17 17 0 1000000000000
RG18 18 0 1000000000000
RG19 19 0 1000000000000
RG20 20 0 1000000000000
RG21 21 0 1000000000000
RG22 22 0 1000000000000
RG23 23 0 1000000000000
RG24 24 0 1000000000000
RG25 25 0 1000000000000
RG26 26 0 1000000000000
VS0 0 s0 0
L0 s0 3 27e-2
VS1 0 s1 0
V1 e1 s1 DC 0 AC 27e1 120
RI1 e1 19 33e-3
VS2 26 s2 0
R2 s2 6 12e-2
VS3 13 s3 0
C3 s3 16 18e-5
VS4 2 s4 0
V4 e4 s4 DC 0 AC 12e0 -120
RI4 e4 m4 18e-2
LI4 m4 8 82e-6
VS5 0 s5 0
L5 s5 19 47e-3
VS6 9 s6 0
V6 e6 s6 DC 0 AC 10e1 0
RI6 e6 m6 39e-3
LI6 m6 2 56e-5
VS7 22 s7 0
L7 s7 8 12e-2
VS8 3 s8 0
R8 s8 18 18e1
VS9 17 s9 0
R9 s9 0 22e3
VS10 4 s10 0
C10 s10 9 82e-6
VS11 3 s11 0
C11 s11 11 10e-4
VS12 3 s12 0
L12 s12 15 10e-3
VS13 25 s13 0
R13 s13 13 27e-2
VS14 3 s14 0
R14 s14 20 10e0
VS15 9 s15 0
L15 s15 25 22e-5
VS16 10 s16 0
C16 s16 11 18e-4
VS17 1 s17 0
C17 s17 23 39e-7
VS18 21 s18 0
R18 s18 3 18e3
VS19 14 s19 0
C19 s19 13 15e-6
VS20 2 s20 0
R20 s20 26 39e3
VS21 20 s21 0
R21 s21 25 27e2
VS22 10 s22 0
R22 s22 7 27e0
VS23 23 s23 0
L23 s23 10 15e-5
VS24 1 s24 0
V24 e24 s24 DC 0 AC 12e0 -120
RI24 e24 7 12e-3
VS25 25 s25 0
C25 s25 26 10e-7
VS26 12 s26 0
C26 s26 2 33e-5
VS27 5 s27 0
C27 s27 16 33e-4
VS28 1 s28 0
C28 s28 26 10e-4
VS29 10 s29 0
V29 e29 s29 DC 0 AC 12e-1 120
RI29 e29 14 10e-2
VS30 18 s30 0
L30 s30 26 15e-5
VS31 19 s31 0
C31 s31 2 33e-5
VS32 15 s32 0
L32 s32 6 68e-3
VS33 9 s33 0
C33 s33 23 22e-6
VS34 24 s34 0
L34 s34 13 47e-4
VS35 11 s35 0
R35 s35 10 15e-2
VS36 26 s36 0
R36 s36 0 39e2
VS37 22 s37 0
C37 s37 19 56e-6
VS38 25 s38 0
R38 s38 24 56e2
VS39 12 s39 0
R39 s39 20 10e2
VS40 12 s40 0
L40 s40 23 56e-3
VS41 10 s41 0
C41 s41 5 22e-6
VS42 16 s42 0
C42 s42 13 68e-4
VS43 26 s43 0
R43 s43 20 56e-1
VS44 7 s44 0
R44 s44 2 39e-1
VS45 1 s45 0
R45 s45 21 10e3
VS46 17 s46 0
R46 s46 19 47e1
VS47 23 s47 0
R47 s47 21 82e-2
VS48 4 s48 0
C48 s48 1 27e-4
.control
set numdgt=17
ac lin 1 60 60
print v(1) v(2) v(3) v(4) v(5) v(6) v(7) v(8) v(9) v(10)
print v(11) v(12) v(13) v(14) v(15) v(16) v(17) v(18) v(19) v(20)
print v(21) v(22) v(23) v(24) v(25) v(26)
print i(vs0) i(vs1) i(vs2) i(vs3) i(vs4) i(vs5) i(vs6) i(vs7) i(vs8) i(vs9)
print i(vs10) i(vs11) i(vs12) i(vs13) i(vs14) i(vs15) i(vs16) i(vs17) i(vs18) i(vs19)
print i(vs20) i(vs21) i(vs22) i(vs23) i(vs24) i(vs25) i(vs26) i(vs27) i(vs28) i(vs29)
print i(vs30) i(vs31) i(vs32) i(vs33) i(vs34) i(vs35) i(vs36) i(vs37) i(vs38) i(vs39)
print i(vs40) i(vs41) i(vs42) i(vs43) i(vs44) i(vs45) i(vs46) i(vs47) i(vs48)
.endc
.end
