controls oracle ac-0030
* Generated (plan F2.7, ADR 0012): do not edit; regenerate with `pnpm sim oracle regen`. ac seed 20261031 index 30 nodes 27 elements 44
.options sparse gmin=1e-12 noopac
RG1 1 0 1000000000000
RG2 2 0 1000000000000
RG3 3 0 1000000000000
RG4 4 0 1000000000000
RG5 5 0 1000000000000
RG6 6 0 1000000000000
RG7 7 0 1000000000000
RG8 8 0 1000000000000
RG9 9 0 1000000000000
RG10 10 0 1000000000000
RG11 11 0 1000000000000
RG12 12 0 1000000000000
RG13 13 0 1000000000000
RG14 14 0 1000000000000
RG15 15 0 1000000000000
RG16 16 0 1000000000000
RG17 17 0 1000000000000
RG18 18 0 1000000000000
RG19 19 0 1000000000000
RG20 20 0 1000000000000
RG21 21 0 1000000000000
RG22 22 0 1000000000000
RG23 23 0 1000000000000
RG24 24 0 1000000000000
RG25 25 0 1000000000000
RG26 26 0 1000000000000
VS0 25 s0 0
R0 s0 12 15e-2
VS1 11 s1 0
L1 s1 2 68e-4
VS2 0 s2 0
V2 e2 s2 DC 0 AC 12e0 -120
RI2 e2 n2 12e-3
H2 n2 h2 VS11 33e-4
ED2 h2 7 d2 0 27e-7
F2 0 d2 VS11 1
LD2 d2 0 1
VS3 3 s3 0
L3 s3 21 68e-3
VS4 15 s4 0
C4 s4 7 33e-6
VS5 6 s5 0
C5 s5 15 82e-6
VS6 12 s6 0
R6 s6 16 39e-2
VS7 20 s7 0
R7 s7 12 10e1
VS8 2 s8 0
C8 s8 20 12e-4
VS9 15 s9 0
R9 s9 14 10e3
VS10 20 s10 0
R10 s10 8 27e0
VS11 20 s11 0
V11 e11 s11 DC 0 AC 10e1 -120
RI11 e11 n11 15e-1
H11 n11 h11 VS2 33e-4
ED11 h11 16 d11 0 27e-7
F11 0 d11 VS2 1
LD11 d11 0 1
VS12 17 s12 0
L12 s12 26 47e-4
VS13 7 s13 0
L13 s13 6 22e-2
VS14 8 s14 0
L14 s14 0 33e-4
VS15 17 s15 0
L15 s15 24 10e-4
VS16 8 s16 0
C16 s16 21 15e-5
VS17 4 s17 0
V17 e17 s17 DC 0 AC 39e-1 120
RI17 e17 m17 18e-2
LI17 m17 19 27e-7
VS18 24 s18 0
R18 s18 2 15e2
VS19 13 s19 0
L19 s19 2 22e-4
VS20 5 s20 0
R20 s20 12 47e1
VS21 4 s21 0
V21 e21 s21 DC 0 AC 39e1 -120
RI21 e21 0 27e-1
VS22 20 s22 0
R22 s22 7 56e2
VS23 22 s23 0
C23 s23 11 56e-6
VS24 18 s24 0
R24 s24 3 82e-2
VS25 25 s25 0
R25 s25 3 68e3
VS26 24 s26 0
L26 s26 20 47e-5
VS27 3 s27 0
C27 s27 13 56e-7
VS28 20 s28 0
L28 s28 0 15e-4
VS29 9 s29 0
V29 e29 s29 DC 0 AC 82e-1 180
RI29 e29 m29 27e-2
LI29 m29 14 39e-6
VS30 18 s30 0
R30 s30 1 82e3
VS31 2 s31 0
V31 e31 s31 DC 0 AC 12e0 0
RI31 e31 m31 68e-3
LI31 m31 5 68e-6
VS32 11 s32 0
R32 s32 18 12e-2
VS33 17 s33 0
C33 s33 23 22e-6
VS34 18 s34 0
L34 s34 26 15e-5
VS35 9 s35 0
L35 s35 18 12e-3
VS36 0 s36 0
C36 s36 26 10e-4
VS37 21 s37 0
R37 s37 1 12e2
VS38 23 s38 0
R38 s38 5 12e3
VS39 10 s39 0
L39 s39 20 12e-2
VS40 10 s40 0
R40 s40 22 82e-1
VS41 17 s41 0
C41 s41 10 47e-6
VS42 20 s42 0
C42 s42 19 15e-5
VS43 18 s43 0
L43 s43 16 47e-2
.control
set numdgt=17
ac lin 1 60 60
print v(1) v(2) v(3) v(4) v(5) v(6) v(7) v(8) v(9) v(10)
print v(11) v(12) v(13) v(14) v(15) v(16) v(17) v(18) v(19) v(20)
print v(21) v(22) v(23) v(24) v(25) v(26)
print i(vs0) i(vs1) i(vs2) i(vs3) i(vs4) i(vs5) i(vs6) i(vs7) i(vs8) i(vs9)
print i(vs10) i(vs11) i(vs12) i(vs13) i(vs14) i(vs15) i(vs16) i(vs17) i(vs18) i(vs19)
print i(vs20) i(vs21) i(vs22) i(vs23) i(vs24) i(vs25) i(vs26) i(vs27) i(vs28) i(vs29)
print i(vs30) i(vs31) i(vs32) i(vs33) i(vs34) i(vs35) i(vs36) i(vs37) i(vs38) i(vs39)
print i(vs40) i(vs41) i(vs42) i(vs43)
.endc
.end
