controls oracle ac-0072
* Generated (plan F2.7, ADR 0012): do not edit; regenerate with `pnpm sim oracle regen`. ac seed 20261031 index 72 nodes 5 elements 9
.options sparse gmin=1e-12 noopac
RG1 1 0 1000000000000
RG2 2 0 1000000000000
RG3 3 0 1000000000000
RG4 4 0 1000000000000
VS0 4 s0 0
R0 s0 0 10e0
VS1 2 s1 0
C1 s1 4 47e-4
VS2 2 s2 0
C2 s2 1 15e-6
VS3 0 s3 0
V3 e3 s3 DC 0 AC 12e-1 180
RI3 e3 m3 56e-3
LI3 m3 3 10e-5
VS4 0 s4 0
R4 s4 2 15e-1
VS5 2 s5 0
L5 s5 3 33e-2
VS6 1 s6 0
V6 e6 s6 DC 0 AC 33e0 180
RI6 e6 2 39e-2
VS7 4 s7 0
V7 e7 s7 DC 0 AC 12e-1 180
RI7 e7 3 15e-3
VS8 3 s8 0
V8 e8 s8 DC 0 AC 33e-1 -120
RI8 e8 m8 56e-1
LI8 m8 1 47e-6
.control
set numdgt=17
ac lin 1 60 60
print v(1) v(2) v(3) v(4)
print i(vs0) i(vs1) i(vs2) i(vs3) i(vs4) i(vs5) i(vs6) i(vs7) i(vs8)
.endc
.end
