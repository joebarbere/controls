controls oracle ac-0072
* Generated (plan F2.7, ADR 0012): do not edit; regenerate with `pnpm sim oracle regen`. ac seed 20261031 index 72 nodes 5 elements 6
.options sparse gmin=1e-12 noopac
RG1 1 0 1000000000000
RG2 2 0 1000000000000
RG3 3 0 1000000000000
RG4 4 0 1000000000000
VS0 3 s0 0
C0 s0 0 47e-5
VS1 1 s1 0
R1 s1 0 10e0
VS2 3 s2 0
R2 s2 2 68e-2
VS3 0 s3 0
V3 e3 s3 DC 0 AC 33e0 180
RI3 e3 2 39e-2
VS4 4 s4 0
C4 s4 1 12e-6
VS5 3 s5 0
L5 s5 4 33e-5
.control
set numdgt=17
ac lin 1 60 60
print v(1) v(2) v(3) v(4)
print i(vs0) i(vs1) i(vs2) i(vs3) i(vs4) i(vs5)
.endc
.end
