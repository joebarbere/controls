controls oracle ac-0072
* Generated (plan F2.7, ADR 0012): do not edit; regenerate with `pnpm sim oracle regen`. ac seed 20261031 index 72 nodes 5 elements 5
.options sparse gmin=1e-12 noopac
RG1 1 0 1000000000000
RG2 2 0 1000000000000
RG3 3 0 1000000000000
RG4 4 0 1000000000000
VS0 0 s0 0
V0 e0 s0 DC 0 AC 33e0 180
RI0 e0 2 39e-2
VS1 2 s1 0
C1 s1 0 18e-6
VS2 4 s2 0
C2 s2 1 12e-6
VS3 3 s3 0
L3 s3 4 33e-5
VS4 3 s4 0
C4 s4 0 47e-5
.control
set numdgt=17
ac lin 1 60 60
print v(1) v(2) v(3) v(4)
print i(vs0) i(vs1) i(vs2) i(vs3) i(vs4)
.endc
.end
