controls oracle ac-0040
* Generated (plan F2.7, ADR 0012): do not edit; regenerate with `pnpm sim oracle regen`. ac seed 20261031 index 40 nodes 26 elements 46
.options sparse gmin=1e-12 noopac
RG1 1 0 1000000000000
RG2 2 0 1000000000000
RG3 3 0 1000000000000
RG4 4 0 1000000000000
RG5 5 0 1000000000000
RG6 6 0 1000000000000
RG7 7 0 1000000000000
RG8 8 0 1000000000000
RG9 9 0 1000000000000
RG10 10 0 1000000000000
RG11 11 0 1000000000000
RG12 12 0 1000000000000
RG13 13 0 1000000000000
RG14 14 0 1000000000000
RG15 15 0 1000000000000
RG16 16 0 1000000000000
RG17 17 0 1000000000000
RG18 18 0 1000000000000
RG19 19 0 1000000000000
RG20 20 0 1000000000000
RG21 21 0 1000000000000
RG22 22 0 1000000000000
RG23 23 0 1000000000000
RG24 24 0 1000000000000
RG25 25 0 1000000000000
VS0 3 s0 0
R0 s0 12 27e-1
VS1 13 s1 0
R1 s1 11 47e3
VS2 16 s2 0
C2 s2 12 56e-4
VS3 8 s3 0
L3 s3 11 12e-5
VS4 10 s4 0
R4 s4 0 39e0
VS5 9 s5 0
R5 s5 1 27e-2
VS6 0 s6 0
V6 e6 s6 DC 0 AC 56e1 180
RI6 e6 5 82e-3
VS7 15 s7 0
R7 s7 8 47e-1
VS8 18 s8 0
R8 s8 4 27e0
VS9 23 s9 0
R9 s9 10 68e-2
VS10 1 s10 0
V10 e10 s10 DC 0 AC 82e1 0
RI10 e10 12 10e-2
VS11 17 s11 0
R11 s11 3 39e2
VS12 20 s12 0
R12 s12 7 15e-1
VS13 13 s13 0
V13 e13 s13 DC 0 AC 22e1 -120
RI13 e13 6 15e-1
VS14 9 s14 0
V14 e14 s14 DC 0 AC 10e1 120
RI14 e14 5 10e-3
VS15 9 s15 0
L15 s15 22 39e-5
VS16 24 s16 0
L16 s16 20 27e-5
VS17 19 s17 0
R17 s17 10 27e-2
VS18 4 s18 0
R18 s18 21 82e-1
VS19 5 s19 0
L19 s19 14 10e-4
VS20 25 s20 0
L20 s20 19 10e-3
VS21 25 s21 0
L21 s21 7 68e-4
VS22 13 s22 0
L22 s22 23 39e-4
VS23 25 s23 0
R23 s23 0 27e-1
VS24 19 s24 0
V24 e24 s24 DC 0 AC 33e1 0
RI24 e24 12 12e-2
VS25 9 s25 0
R25 s25 24 27e-1
VS26 12 s26 0
L26 s26 6 10e-3
VS27 6 s27 0
V27 e27 s27 DC 0 AC 18e0 180
RI27 e27 21 15e-1
VS28 7 s28 0
C28 s28 19 22e-6
VS29 13 s29 0
L29 s29 1 12e-2
VS30 5 s30 0
L30 s30 17 33e-2
VS31 7 s31 0
R31 s31 13 10e2
VS32 12 s32 0
C32 s32 13 22e-4
VS33 25 s33 0
C33 s33 15 47e-6
VS34 1 s34 0
R34 s34 13 68e-2
VS35 13 s35 0
C35 s35 17 12e-7
VS36 16 s36 0
V36 e36 s36 DC 0 AC 82e1 180
RI36 e36 18 10e-3
VS37 8 s37 0
V37 e37 s37 DC 0 AC 10e0 0
RI37 e37 7 18e-1
VS38 7 s38 0
V38 e38 s38 DC 0 AC 33e1 180
RI38 e38 19 82e-1
VS39 25 s39 0
R39 s39 18 82e2
VS40 6 s40 0
R40 s40 10 18e2
VS41 2 s41 0
C41 s41 10 39e-4
VS42 6 s42 0
R42 s42 9 47e1
VS43 24 s43 0
L43 s43 16 82e-2
VS44 10 s44 0
L44 s44 13 56e-3
VS45 8 s45 0
L45 s45 18 15e-2
.control
set numdgt=17
ac lin 1 60 60
print v(1) v(2) v(3) v(4) v(5) v(6) v(7) v(8) v(9) v(10)
print v(11) v(12) v(13) v(14) v(15) v(16) v(17) v(18) v(19) v(20)
print v(21) v(22) v(23) v(24) v(25)
print i(vs0) i(vs1) i(vs2) i(vs3) i(vs4) i(vs5) i(vs6) i(vs7) i(vs8) i(vs9)
print i(vs10) i(vs11) i(vs12) i(vs13) i(vs14) i(vs15) i(vs16) i(vs17) i(vs18) i(vs19)
print i(vs20) i(vs21) i(vs22) i(vs23) i(vs24) i(vs25) i(vs26) i(vs27) i(vs28) i(vs29)
print i(vs30) i(vs31) i(vs32) i(vs33) i(vs34) i(vs35) i(vs36) i(vs37) i(vs38) i(vs39)
print i(vs40) i(vs41) i(vs42) i(vs43) i(vs44) i(vs45)
.endc
.end
