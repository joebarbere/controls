controls oracle ac-0040
* Generated (plan F2.7, ADR 0012): do not edit; regenerate with `pnpm sim oracle regen`. ac seed 20261031 index 40 nodes 26 elements 49
.options sparse gmin=1e-12 noopac
RG1 1 0 1000000000000
RG2 2 0 1000000000000
RG3 3 0 1000000000000
RG4 4 0 1000000000000
RG5 5 0 1000000000000
RG6 6 0 1000000000000
RG7 7 0 1000000000000
RG8 8 0 1000000000000
RG9 9 0 1000000000000
RG10 10 0 1000000000000
RG11 11 0 1000000000000
RG12 12 0 1000000000000
RG13 13 0 1000000000000
RG14 14 0 1000000000000
RG15 15 0 1000000000000
RG16 16 0 1000000000000
RG17 17 0 1000000000000
RG18 18 0 1000000000000
RG19 19 0 1000000000000
RG20 20 0 1000000000000
RG21 21 0 1000000000000
RG22 22 0 1000000000000
RG23 23 0 1000000000000
RG24 24 0 1000000000000
RG25 25 0 1000000000000
VS0 0 s0 0
V0 e0 s0 DC 0 AC 82e1 180
RI0 e0 18 10e-3
VS1 20 s1 0
R1 s1 7 15e-1
VS2 5 s2 0
L2 s2 14 10e-4
VS3 9 s3 0
R3 s3 1 27e-2
VS4 13 s4 0
V4 e4 s4 DC 0 AC 56e1 180
RI4 e4 5 82e-3
VS5 10 s5 0
L5 s5 16 56e-3
VS6 1 s6 0
V6 e6 s6 DC 0 AC 82e1 0
RI6 e6 12 10e-2
VS7 18 s7 0
R7 s7 4 27e0
VS8 7 s8 0
R8 s8 16 10e2
VS9 25 s9 0
L9 s9 7 68e-4
VS10 25 s10 0
L10 s10 19 10e-3
VS11 25 s11 0
C11 s11 15 47e-6
VS12 15 s12 0
R12 s12 8 47e-1
VS13 25 s13 0
R13 s13 13 27e-1
VS14 16 s14 0
R14 s14 11 47e3
VS15 2 s15 0
C15 s15 10 39e-4
VS16 9 s16 0
R16 s16 24 27e-1
VS17 25 s17 0
R17 s17 18 82e2
VS18 10 s18 0
R18 s18 13 39e0
VS19 6 s19 0
V19 e19 s19 DC 0 AC 18e0 180
RI19 e19 m19 15e-1
LI19 m19 21 82e-6
VS20 22 s20 0
R20 s20 23 39e0
VS21 16 s21 0
V21 e21 s21 DC 0 AC 22e1 -120
RI21 e21 6 15e-1
VS22 8 s22 0
V22 e22 s22 DC 0 AC 10e0 0
RI22 e22 7 18e-1
VS23 12 s23 0
C23 s23 16 22e-4
VS24 3 s24 0
R24 s24 12 27e-1
VS25 4 s25 0
R25 s25 21 82e-1
VS26 16 s26 0
L26 s26 1 12e-2
VS27 6 s27 0
R27 s27 9 47e1
VS28 2 s28 0
L28 s28 23 68e-3
VS29 12 s29 0
L29 s29 6 10e-3
VS30 19 s30 0
R30 s30 10 27e-2
VS31 5 s31 0
L31 s31 17 33e-2
VS32 0 s32 0
C32 s32 12 56e-4
VS33 23 s33 0
R33 s33 10 68e-2
VS34 7 s34 0
V34 e34 s34 DC 0 AC 33e1 180
RI34 e34 19 82e-1
VS35 9 s35 0
V35 e35 s35 DC 0 AC 10e1 120
RI35 e35 m35 10e-3
LI35 m35 5 10e-5
VS36 16 s36 0
C36 s36 17 12e-7
VS37 8 s37 0
L37 s37 18 15e-2
VS38 8 s38 0
L38 s38 11 12e-5
VS39 6 s39 0
R39 s39 10 18e2
VS40 19 s40 0
V40 e40 s40 DC 0 AC 33e1 0
RI40 e40 m40 12e-2
LI40 m40 12 33e-6
VS41 24 s41 0
L41 s41 0 82e-2
VS42 1 s42 0
R42 s42 16 68e-2
VS43 7 s43 0
C43 s43 19 22e-6
VS44 24 s44 0
L44 s44 20 27e-5
VS45 17 s45 0
R45 s45 3 39e2
VS46 19 s46 0
C46 s46 14 18e-7
VS47 9 s47 0
L47 s47 22 39e-5
VS48 16 s48 0
L48 s48 23 39e-4
.control
set numdgt=17
ac lin 1 60 60
print v(1) v(2) v(3) v(4) v(5) v(6) v(7) v(8) v(9) v(10)
print v(11) v(12) v(13) v(14) v(15) v(16) v(17) v(18) v(19) v(20)
print v(21) v(22) v(23) v(24) v(25)
print i(vs0) i(vs1) i(vs2) i(vs3) i(vs4) i(vs5) i(vs6) i(vs7) i(vs8) i(vs9)
print i(vs10) i(vs11) i(vs12) i(vs13) i(vs14) i(vs15) i(vs16) i(vs17) i(vs18) i(vs19)
print i(vs20) i(vs21) i(vs22) i(vs23) i(vs24) i(vs25) i(vs26) i(vs27) i(vs28) i(vs29)
print i(vs30) i(vs31) i(vs32) i(vs33) i(vs34) i(vs35) i(vs36) i(vs37) i(vs38) i(vs39)
print i(vs40) i(vs41) i(vs42) i(vs43) i(vs44) i(vs45) i(vs46) i(vs47) i(vs48)
.endc
.end
