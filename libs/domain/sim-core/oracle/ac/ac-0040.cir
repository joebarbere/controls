controls oracle ac-0040
* Generated (plan F2.7, ADR 0012): do not edit; regenerate with `pnpm sim oracle regen`. ac seed 20261031 index 40 nodes 26 elements 37
.options sparse gmin=1e-12 noopac
RG1 1 0 1000000000000
RG2 2 0 1000000000000
RG3 3 0 1000000000000
RG4 4 0 1000000000000
RG5 5 0 1000000000000
RG6 6 0 1000000000000
RG7 7 0 1000000000000
RG8 8 0 1000000000000
RG9 9 0 1000000000000
RG10 10 0 1000000000000
RG11 11 0 1000000000000
RG12 12 0 1000000000000
RG13 13 0 1000000000000
RG14 14 0 1000000000000
RG15 15 0 1000000000000
RG16 16 0 1000000000000
RG17 17 0 1000000000000
RG18 18 0 1000000000000
RG19 19 0 1000000000000
RG20 20 0 1000000000000
RG21 21 0 1000000000000
RG22 22 0 1000000000000
RG23 23 0 1000000000000
RG24 24 0 1000000000000
RG25 25 0 1000000000000
VS0 10 s0 0
L0 s0 7 15e-4
VS1 20 s1 0
C1 s1 7 27e-7
VS2 15 s2 0
R2 s2 0 18e-2
VS3 17 s3 0
L3 s3 1 18e-2
VS4 0 s4 0
V4 e4 s4 DC 0 AC 82e1 0
RI4 e4 m4 10e-2
LI4 m4 24 56e-7
VS5 11 s5 0
L5 s5 20 47e-2
VS6 10 s6 0
V6 e6 s6 DC 0 AC 22e1 -120
RI6 e6 12 12e-3
VS7 10 s7 0
L7 s7 17 68e-2
VS8 21 s8 0
L8 s8 9 12e-4
VS9 10 s9 0
V9 e9 s9 DC 0 AC 22e1 -120
RI9 e9 m9 15e-1
LI9 m9 6 15e-5
VS10 5 s10 0
R10 s10 12 47e1
VS11 4 s11 0
L11 s11 11 15e-2
VS12 3 s12 0
R12 s12 16 68e-2
VS13 13 s13 0
C13 s13 4 39e-5
VS14 23 s14 0
R14 s14 12 27e0
VS15 6 s15 0
V15 e15 s15 DC 0 AC 82e1 -120
RI15 e15 m15 68e-2
LI15 m15 25 33e-6
VS16 2 s16 0
C16 s16 13 56e-5
VS17 12 s17 0
C17 s17 18 47e-5
VS18 25 s18 0
R18 s18 13 27e-1
VS19 23 s19 0
C19 s19 19 33e-4
VS20 13 s20 0
R20 s20 1 39e3
VS21 25 s21 0
V21 e21 s21 DC 0 AC 33e1 0
RI21 e21 24 12e-2
VS22 9 s22 0
L22 s22 19 27e-2
VS23 22 s23 0
C23 s23 15 22e-6
VS24 16 s24 0
R24 s24 8 10e0
VS25 6 s25 0
L25 s25 16 47e-2
VS26 1 s26 0
L26 s26 25 10e-2
VS27 22 s27 0
L27 s27 20 33e-3
VS28 13 s28 0
V28 e28 s28 DC 0 AC 18e1 180
RI28 e28 14 22e-1
VS29 2 s29 0
R29 s29 8 27e0
VS30 5 s30 0
V30 e30 s30 DC 0 AC 15e1 -120
RI30 e30 m30 12e-3
LI30 m30 18 82e-7
VS31 3 s31 0
V31 e31 s31 DC 0 AC 22e-1 0
RI31 e31 0 33e-3
VS32 14 s32 0
R32 s32 16 27e-2
VS33 13 s33 0
R33 s33 9 10e3
VS34 25 s34 0
C34 s34 21 56e-4
VS35 25 s35 0
R35 s35 0 10e-1
VS36 18 s36 0
L36 s36 6 10e-2
.control
set numdgt=17
ac lin 1 60 60
print v(1) v(2) v(3) v(4) v(5) v(6) v(7) v(8) v(9) v(10)
print v(11) v(12) v(13) v(14) v(15) v(16) v(17) v(18) v(19) v(20)
print v(21) v(22) v(23) v(24) v(25)
print i(vs0) i(vs1) i(vs2) i(vs3) i(vs4) i(vs5) i(vs6) i(vs7) i(vs8) i(vs9)
print i(vs10) i(vs11) i(vs12) i(vs13) i(vs14) i(vs15) i(vs16) i(vs17) i(vs18) i(vs19)
print i(vs20) i(vs21) i(vs22) i(vs23) i(vs24) i(vs25) i(vs26) i(vs27) i(vs28) i(vs29)
print i(vs30) i(vs31) i(vs32) i(vs33) i(vs34) i(vs35) i(vs36)
.endc
.end
