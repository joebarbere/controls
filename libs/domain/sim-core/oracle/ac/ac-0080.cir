controls oracle ac-0080
* Generated (plan F2.7, ADR 0012): do not edit; regenerate with `pnpm sim oracle regen`. ac seed 20261031 index 80 nodes 29 elements 53
.options sparse gmin=1e-12 noopac
RG1 1 0 1000000000000
RG2 2 0 1000000000000
RG3 3 0 1000000000000
RG4 4 0 1000000000000
RG5 5 0 1000000000000
RG6 6 0 1000000000000
RG7 7 0 1000000000000
RG8 8 0 1000000000000
RG9 9 0 1000000000000
RG10 10 0 1000000000000
RG11 11 0 1000000000000
RG12 12 0 1000000000000
RG13 13 0 1000000000000
RG14 14 0 1000000000000
RG15 15 0 1000000000000
RG16 16 0 1000000000000
RG17 17 0 1000000000000
RG18 18 0 1000000000000
RG19 19 0 1000000000000
RG20 20 0 1000000000000
RG21 21 0 1000000000000
RG22 22 0 1000000000000
RG23 23 0 1000000000000
RG24 24 0 1000000000000
RG25 25 0 1000000000000
RG26 26 0 1000000000000
RG27 27 0 1000000000000
RG28 28 0 1000000000000
VS0 15 s0 0
L0 s0 0 68e-2
VS1 20 s1 0
L1 s1 3 22e-5
VS2 0 s2 0
C2 s2 7 47e-7
VS3 13 s3 0
L3 s3 10 56e-5
VS4 12 s4 0
R4 s4 23 33e-1
VS5 18 s5 0
C5 s5 14 22e-7
VS6 23 s6 0
R6 s6 26 22e1
VS7 0 s7 0
V7 e7 s7 DC 0 AC 15e1 120
RI7 e7 15 27e-2
VS8 22 s8 0
V8 e8 s8 DC 0 AC 68e-1 120
RI8 e8 6 12e-2
VS9 8 s9 0
R9 s9 21 22e-2
VS10 16 s10 0
R10 s10 19 56e1
VS11 3 s11 0
C11 s11 1 18e-4
VS12 20 s12 0
R12 s12 9 12e-1
VS13 16 s13 0
R13 s13 4 10e3
VS14 13 s14 0
C14 s14 10 12e-7
VS15 21 s15 0
L15 s15 24 39e-5
VS16 16 s16 0
V16 e16 s16 DC 0 AC 82e-1 120
RI16 e16 m16 82e-1
LI16 m16 28 22e-7
VS17 11 s17 0
R17 s17 28 27e2
VS18 14 s18 0
R18 s18 11 56e-2
VS19 0 s19 0
L19 s19 17 68e-2
VS20 22 s20 0
R20 s20 9 27e2
VS21 19 s21 0
C21 s21 3 27e-4
VS22 5 s22 0
C22 s22 4 47e-7
VS23 17 s23 0
L23 s23 7 82e-5
VS24 22 s24 0
L24 s24 27 27e-3
VS25 27 s25 0
V25 e25 s25 DC 0 AC 10e-1 120
RI25 e25 m25 68e-1
LI25 m25 23 27e-5
VS26 2 s26 0
R26 s26 18 68e-1
VS27 0 s27 0
C27 s27 6 15e-6
VS28 20 s28 0
R28 s28 18 10e0
VS29 10 s29 0
C29 s29 22 12e-7
VS30 3 s30 0
R30 s30 19 47e1
VS31 24 s31 0
C31 s31 27 12e-4
VS32 14 s32 0
R32 s32 13 39e2
VS33 13 s33 0
R33 s33 23 27e3
VS34 10 s34 0
L34 s34 8 47e-3
VS35 2 s35 0
V35 e35 s35 DC 0 AC 82e0 120
RI35 e35 19 22e-1
VS36 18 s36 0
L36 s36 16 15e-4
VS37 25 s37 0
L37 s37 5 82e-2
VS38 3 s38 0
L38 s38 15 39e-4
VS39 7 s39 0
C39 s39 11 82e-4
VS40 16 s40 0
R40 s40 14 22e0
VS41 6 s41 0
V41 e41 s41 DC 0 AC 39e1 180
RI41 e41 m41 33e-3
LI41 m41 19 15e-6
VS42 12 s42 0
R42 s42 22 47e0
VS43 20 s43 0
L43 s43 15 10e-4
VS44 26 s44 0
V44 e44 s44 DC 0 AC 18e1 -120
RI44 e44 m44 22e-2
LI44 m44 25 68e-7
VS45 20 s45 0
V45 e45 s45 DC 0 AC 12e0 -120
RI45 e45 0 12e-1
VS46 26 s46 0
C46 s46 6 82e-5
VS47 15 s47 0
V47 e47 s47 DC 0 AC 22e1 120
RI47 e47 m47 33e-2
LI47 m47 1 15e-6
VS48 3 s48 0
C48 s48 0 68e-7
VS49 1 s49 0
L49 s49 17 56e-4
VS50 18 s50 0
L50 s50 5 56e-3
VS51 25 s51 0
L51 s51 22 18e-5
VS52 3 s52 0
L52 s52 27 18e-4
.control
set numdgt=17
ac lin 1 60 60
print v(1) v(2) v(3) v(4) v(5) v(6) v(7) v(8) v(9) v(10)
print v(11) v(12) v(13) v(14) v(15) v(16) v(17) v(18) v(19) v(20)
print v(21) v(22) v(23) v(24) v(25) v(26) v(27) v(28)
print i(vs0) i(vs1) i(vs2) i(vs3) i(vs4) i(vs5) i(vs6) i(vs7) i(vs8) i(vs9)
print i(vs10) i(vs11) i(vs12) i(vs13) i(vs14) i(vs15) i(vs16) i(vs17) i(vs18) i(vs19)
print i(vs20) i(vs21) i(vs22) i(vs23) i(vs24) i(vs25) i(vs26) i(vs27) i(vs28) i(vs29)
print i(vs30) i(vs31) i(vs32) i(vs33) i(vs34) i(vs35) i(vs36) i(vs37) i(vs38) i(vs39)
print i(vs40) i(vs41) i(vs42) i(vs43) i(vs44) i(vs45) i(vs46) i(vs47) i(vs48) i(vs49)
print i(vs50) i(vs51) i(vs52)
.endc
.end
