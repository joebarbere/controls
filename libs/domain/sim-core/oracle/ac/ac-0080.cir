controls oracle ac-0080
* Generated (plan F2.7, ADR 0012): do not edit; regenerate with `pnpm sim oracle regen`. ac seed 20261031 index 80 nodes 29 elements 44
.options sparse gmin=1e-12 noopac
RG1 1 0 1000000000000
RG2 2 0 1000000000000
RG3 3 0 1000000000000
RG4 4 0 1000000000000
RG5 5 0 1000000000000
RG6 6 0 1000000000000
RG7 7 0 1000000000000
RG8 8 0 1000000000000
RG9 9 0 1000000000000
RG10 10 0 1000000000000
RG11 11 0 1000000000000
RG12 12 0 1000000000000
RG13 13 0 1000000000000
RG14 14 0 1000000000000
RG15 15 0 1000000000000
RG16 16 0 1000000000000
RG17 17 0 1000000000000
RG18 18 0 1000000000000
RG19 19 0 1000000000000
RG20 20 0 1000000000000
RG21 21 0 1000000000000
RG22 22 0 1000000000000
RG23 23 0 1000000000000
RG24 24 0 1000000000000
RG25 25 0 1000000000000
RG26 26 0 1000000000000
RG27 27 0 1000000000000
RG28 28 0 1000000000000
VS0 25 s0 0
L0 s0 19 27e-3
VS1 12 s1 0
C1 s1 26 12e-6
VS2 0 s2 0
V2 e2 s2 DC 0 AC 22e-1 180
RI2 e2 m2 10e-2
LI2 m2 20 56e-5
VS3 14 s3 0
L3 s3 16 10e-5
VS4 7 s4 0
C4 s4 3 33e-7
VS5 14 s5 0
L5 s5 28 82e-3
VS6 7 s6 0
R6 s6 24 18e2
VS7 8 s7 0
R7 s7 28 22e-1
VS8 6 s8 0
V8 e8 s8 DC 0 AC 39e1 180
RI8 e8 14 33e-3
VS9 11 s9 0
V9 e9 s9 DC 0 AC 39e0 0
RI9 e9 m9 33e-2
LI9 m9 13 27e-7
VS10 2 s10 0
C10 s10 18 68e-7
VS11 6 s11 0
R11 s11 10 18e-1
VS12 0 s12 0
L12 s12 23 33e-5
VS13 5 s13 0
C13 s13 9 10e-4
VS14 16 s14 0
L14 s14 14 12e-3
VS15 18 s15 0
C15 s15 0 22e-7
VS16 18 s16 0
L16 s16 14 22e-3
VS17 18 s17 0
V17 e17 s17 DC 0 AC 12e1 120
RI17 e17 27 18e-2
VS18 0 s18 0
L18 s18 12 39e-3
VS19 18 s19 0
R19 s19 7 12e-2
VS20 14 s20 0
R20 s20 13 33e3
VS21 2 s21 0
R21 s21 10 47e1
VS22 22 s22 0
R22 s22 26 56e-2
VS23 15 s23 0
R23 s23 3 18e2
VS24 28 s24 0
R24 s24 2 39e1
VS25 0 s25 0
L25 s25 14 47e-3
VS26 5 s26 0
V26 e26 s26 DC 0 AC 22e-1 0
RI26 e26 m26 18e-3
LI26 m26 6 27e-5
VS27 3 s27 0
C27 s27 11 12e-4
VS28 1 s28 0
V28 e28 s28 DC 0 AC 10e-1 120
RI28 e28 m28 68e-1
LI28 m28 21 47e-5
VS29 2 s29 0
R29 s29 1 15e-2
VS30 12 s30 0
L30 s30 17 68e-2
VS31 16 s31 0
R31 s31 19 39e1
VS32 24 s32 0
V32 e32 s32 DC 0 AC 15e1 180
RI32 e32 m32 56e-3
LI32 m32 5 22e-5
VS33 8 s33 0
C33 s33 20 47e-7
VS34 8 s34 0
L34 s34 21 22e-2
VS35 15 s35 0
L35 s35 7 56e-3
VS36 9 s36 0
R36 s36 2 15e-2
VS37 4 s37 0
C37 s37 22 27e-7
VS38 27 s38 0
L38 s38 14 39e-4
VS39 4 s39 0
V39 e39 s39 DC 0 AC 27e-1 180
RI39 e39 m39 27e-1
LI39 m39 23 56e-6
VS40 25 s40 0
C40 s40 10 82e-5
VS41 11 s41 0
L41 s41 17 27e-4
VS42 3 s42 0
R42 s42 0 82e-1
VS43 25 s43 0
R43 s43 19 82e2
.control
set numdgt=17
ac lin 1 60 60
print v(1) v(2) v(3) v(4) v(5) v(6) v(7) v(8) v(9) v(10)
print v(11) v(12) v(13) v(14) v(15) v(16) v(17) v(18) v(19) v(20)
print v(21) v(22) v(23) v(24) v(25) v(26) v(27) v(28)
print i(vs0) i(vs1) i(vs2) i(vs3) i(vs4) i(vs5) i(vs6) i(vs7) i(vs8) i(vs9)
print i(vs10) i(vs11) i(vs12) i(vs13) i(vs14) i(vs15) i(vs16) i(vs17) i(vs18) i(vs19)
print i(vs20) i(vs21) i(vs22) i(vs23) i(vs24) i(vs25) i(vs26) i(vs27) i(vs28) i(vs29)
print i(vs30) i(vs31) i(vs32) i(vs33) i(vs34) i(vs35) i(vs36) i(vs37) i(vs38) i(vs39)
print i(vs40) i(vs41) i(vs42) i(vs43)
.endc
.end
