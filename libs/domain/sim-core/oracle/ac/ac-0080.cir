controls oracle ac-0080
* Generated (plan F2.7, ADR 0012): do not edit; regenerate with `pnpm sim oracle regen`. ac seed 20261031 index 80 nodes 29 elements 35
.options sparse gmin=1e-12 noopac
RG1 1 0 1000000000000
RG2 2 0 1000000000000
RG3 3 0 1000000000000
RG4 4 0 1000000000000
RG5 5 0 1000000000000
RG6 6 0 1000000000000
RG7 7 0 1000000000000
RG8 8 0 1000000000000
RG9 9 0 1000000000000
RG10 10 0 1000000000000
RG11 11 0 1000000000000
RG12 12 0 1000000000000
RG13 13 0 1000000000000
RG14 14 0 1000000000000
RG15 15 0 1000000000000
RG16 16 0 1000000000000
RG17 17 0 1000000000000
RG18 18 0 1000000000000
RG19 19 0 1000000000000
RG20 20 0 1000000000000
RG21 21 0 1000000000000
RG22 22 0 1000000000000
RG23 23 0 1000000000000
RG24 24 0 1000000000000
RG25 25 0 1000000000000
RG26 26 0 1000000000000
RG27 27 0 1000000000000
RG28 28 0 1000000000000
VS0 7 s0 0
R0 s0 24 18e2
VS1 0 s1 0
V1 e1 s1 DC 0 AC 39e0 0
RI1 e1 13 33e-2
VS2 25 s2 0
R2 s2 19 82e2
VS3 6 s3 0
R3 s3 10 18e-1
VS4 15 s4 0
R4 s4 3 18e2
VS5 3 s5 0
C5 s5 0 12e-4
VS6 3 s6 0
R6 s6 14 82e-1
VS7 11 s7 0
R7 s7 13 33e3
VS8 7 s8 0
C8 s8 3 33e-7
VS9 18 s9 0
C9 s9 14 22e-7
VS10 18 s10 0
V10 e10 s10 DC 0 AC 12e1 120
RI10 e10 27 18e-2
VS11 8 s11 0
L11 s11 21 22e-2
VS12 14 s12 0
L12 s12 11 47e-3
VS13 18 s13 0
R13 s13 7 12e-2
VS14 0 s14 0
L14 s14 17 27e-4
VS15 14 s15 0
L15 s15 23 33e-5
VS16 14 s16 0
L16 s16 12 39e-3
VS17 8 s17 0
R17 s17 28 22e-1
VS18 6 s18 0
V18 e18 s18 DC 0 AC 39e1 180
RI18 e18 11 33e-3
VS19 9 s19 0
R19 s19 2 15e-2
VS20 2 s20 0
R20 s20 1 15e-2
VS21 5 s21 0
C21 s21 9 10e-4
VS22 4 s22 0
C22 s22 22 27e-7
VS23 18 s23 0
L23 s23 11 22e-3
VS24 2 s24 0
C24 s24 18 68e-7
VS25 11 s25 0
L25 s25 16 10e-5
VS26 16 s26 0
R26 s26 19 39e1
VS27 14 s27 0
V27 e27 s27 DC 0 AC 22e-1 180
RI27 e27 20 10e-2
VS28 5 s28 0
V28 e28 s28 DC 0 AC 22e-1 0
RI28 e28 6 18e-3
VS29 11 s29 0
L29 s29 28 82e-3
VS30 4 s30 0
V30 e30 s30 DC 0 AC 27e-1 180
RI30 e30 23 27e-1
VS31 16 s31 0
L31 s31 11 12e-3
VS32 12 s32 0
C32 s32 26 12e-6
VS33 25 s33 0
L33 s33 19 27e-3
VS34 28 s34 0
R34 s34 2 39e1
.control
set numdgt=17
ac lin 1 60 60
print v(1) v(2) v(3) v(4) v(5) v(6) v(7) v(8) v(9) v(10)
print v(11) v(12) v(13) v(14) v(15) v(16) v(17) v(18) v(19) v(20)
print v(21) v(22) v(23) v(24) v(25) v(26) v(27) v(28)
print i(vs0) i(vs1) i(vs2) i(vs3) i(vs4) i(vs5) i(vs6) i(vs7) i(vs8) i(vs9)
print i(vs10) i(vs11) i(vs12) i(vs13) i(vs14) i(vs15) i(vs16) i(vs17) i(vs18) i(vs19)
print i(vs20) i(vs21) i(vs22) i(vs23) i(vs24) i(vs25) i(vs26) i(vs27) i(vs28) i(vs29)
print i(vs30) i(vs31) i(vs32) i(vs33) i(vs34)
.endc
.end
