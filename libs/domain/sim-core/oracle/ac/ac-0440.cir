controls oracle ac-0440
* Generated (plan F2.7, ADR 0012): do not edit; regenerate with `pnpm sim oracle regen`. ac seed 20261031 index 440 nodes 15 elements 21
.options sparse gmin=1e-12 noopac
RG1 1 0 1000000000000
RG2 2 0 1000000000000
RG3 3 0 1000000000000
RG4 4 0 1000000000000
RG5 5 0 1000000000000
RG6 6 0 1000000000000
RG7 7 0 1000000000000
RG8 8 0 1000000000000
RG9 9 0 1000000000000
RG10 10 0 1000000000000
RG11 11 0 1000000000000
RG12 12 0 1000000000000
RG13 13 0 1000000000000
RG14 14 0 1000000000000
VS0 2 s0 0
C0 s0 3 15e-5
VS1 10 s1 0
R1 s1 1 56e1
VS2 0 s2 0
V2 e2 s2 DC 0 AC 39e-1 -120
RI2 e2 m2 12e-3
LI2 m2 n2 82e-6
H2 n2 h2 VS8 -22e-4
ED2 h2 13 d2 0 10e-6
F2 0 d2 VS8 1
LD2 d2 0 1
VS3 6 s3 0
L3 s3 1 68e-5
VS4 9 s4 0
L4 s4 14 22e-4
VS5 12 s5 0
R5 s5 0 82e2
VS6 11 s6 0
R6 s6 1 68e1
VS7 0 s7 0
L7 s7 7 15e-3
VS8 12 s8 0
V8 e8 s8 DC 0 AC 18e1 120
RI8 e8 n8 10e-2
H8 n8 h8 VS2 -22e-4
ED8 h8 13 d8 0 10e-6
F8 0 d8 VS2 1
LD8 d8 0 1
VS9 5 s9 0
R9 s9 3 22e-1
VS10 4 s10 0
R10 s10 10 22e3
VS11 2 s11 0
L11 s11 10 56e-4
VS12 8 s12 0
V12 e12 s12 DC 0 AC 18e1 180
RI12 e12 14 18e-3
VS13 9 s13 0
V13 e13 s13 DC 0 AC 10e-1 0
RI13 e13 10 47e-2
VS14 9 s14 0
C14 s14 8 47e-7
VS15 6 s15 0
C15 s15 8 27e-5
VS16 3 s16 0
V16 e16 s16 DC 0 AC 27e1 0
RI16 e16 0 47e-3
VS17 12 s17 0
L17 s17 4 12e-5
VS18 14 s18 0
L18 s18 11 10e-2
VS19 14 s19 0
V19 e19 s19 DC 0 AC 33e0 0
RI19 e19 m19 33e-2
LI19 m19 7 27e-6
VS20 1 s20 0
V20 e20 s20 DC 0 AC 82e0 120
RI20 e20 5 12e-1
.control
set numdgt=17
ac lin 1 60 60
print v(1) v(2) v(3) v(4) v(5) v(6) v(7) v(8) v(9) v(10)
print v(11) v(12) v(13) v(14)
print i(vs0) i(vs1) i(vs2) i(vs3) i(vs4) i(vs5) i(vs6) i(vs7) i(vs8) i(vs9)
print i(vs10) i(vs11) i(vs12) i(vs13) i(vs14) i(vs15) i(vs16) i(vs17) i(vs18) i(vs19)
print i(vs20)
.endc
.end
