controls oracle ac-0440
* Generated (plan F2.7, ADR 0012): do not edit; regenerate with `pnpm sim oracle regen`. ac seed 20261031 index 440 nodes 15 elements 21
.options sparse gmin=1e-12 noopac
RG1 1 0 1000000000000
RG2 2 0 1000000000000
RG3 3 0 1000000000000
RG4 4 0 1000000000000
RG5 5 0 1000000000000
RG6 6 0 1000000000000
RG7 7 0 1000000000000
RG8 8 0 1000000000000
RG9 9 0 1000000000000
RG10 10 0 1000000000000
RG11 11 0 1000000000000
RG12 12 0 1000000000000
RG13 13 0 1000000000000
RG14 14 0 1000000000000
VS0 2 s0 0
L0 s0 10 56e-4
VS1 11 s1 0
C1 s1 4 15e-7
VS2 1 s2 0
R2 s2 14 27e-2
VS3 1 s3 0
L3 s3 2 47e-5
VS4 11 s4 0
L4 s4 8 27e-2
VS5 8 s5 0
R5 s5 3 82e0
VS6 0 s6 0
V6 e6 s6 DC 0 AC 10e-1 0
RI6 e6 m6 47e-2
LI6 m6 10 39e-6
VS7 14 s7 0
V7 e7 s7 DC 0 AC 56e0 -120
RI7 e7 m7 82e-3
LI7 m7 2 18e-7
VS8 9 s8 0
R8 s8 8 82e1
VS9 9 s9 0
C9 s9 4 82e-4
VS10 10 s10 0
V10 e10 s10 DC 0 AC 15e0 180
RI10 e10 m10 39e-2
LI10 m10 6 15e-6
VS11 2 s11 0
C11 s11 9 15e-5
VS12 1 s12 0
R12 s12 3 56e1
VS13 9 s13 0
V13 e13 s13 DC 0 AC 47e-1 180
RI13 e13 13 10e-3
VS14 6 s14 0
L14 s14 13 27e-3
VS15 5 s15 0
R15 s15 0 22e2
VS16 5 s16 0
C16 s16 8 47e-6
VS17 12 s17 0
V17 e17 s17 DC 0 AC 22e1 0
RI17 e17 m17 39e-1
LI17 m17 4 56e-5
VS18 10 s18 0
L18 s18 7 10e-2
VS19 9 s19 0
C19 s19 12 18e-4
VS20 7 s20 0
C20 s20 0 10e-6
.control
set numdgt=17
ac lin 1 60 60
print v(1) v(2) v(3) v(4) v(5) v(6) v(7) v(8) v(9) v(10)
print v(11) v(12) v(13) v(14)
print i(vs0) i(vs1) i(vs2) i(vs3) i(vs4) i(vs5) i(vs6) i(vs7) i(vs8) i(vs9)
print i(vs10) i(vs11) i(vs12) i(vs13) i(vs14) i(vs15) i(vs16) i(vs17) i(vs18) i(vs19)
print i(vs20)
.endc
.end
