controls oracle ac-0440
* Generated (plan F2.7, ADR 0012): do not edit; regenerate with `pnpm sim oracle regen`. ac seed 20261031 index 440 nodes 15 elements 16
.options sparse gmin=1e-12 noopac
RG1 1 0 1000000000000
RG2 2 0 1000000000000
RG3 3 0 1000000000000
RG4 4 0 1000000000000
RG5 5 0 1000000000000
RG6 6 0 1000000000000
RG7 7 0 1000000000000
RG8 8 0 1000000000000
RG9 9 0 1000000000000
RG10 10 0 1000000000000
RG11 11 0 1000000000000
RG12 12 0 1000000000000
RG13 13 0 1000000000000
RG14 14 0 1000000000000
VS0 0 s0 0
V0 e0 s0 DC 0 AC 10e-1 0
RI0 e0 10 47e-2
VS1 2 s1 0
L1 s1 10 56e-4
VS2 14 s2 0
L2 s2 11 10e-2
VS3 4 s3 0
R3 s3 10 22e3
VS4 3 s4 0
L4 s4 7 15e-3
VS5 8 s5 0
V5 e5 s5 DC 0 AC 18e1 180
RI5 e5 14 18e-3
VS6 9 s6 0
V6 e6 s6 DC 0 AC 27e1 0
RI6 e6 3 47e-3
VS7 3 s7 0
V7 e7 s7 DC 0 AC 39e-1 -120
RI7 e7 13 12e-3
VS8 0 s8 0
C8 s8 8 47e-7
VS9 14 s9 0
V9 e9 s9 DC 0 AC 33e0 0
RI9 e9 7 33e-2
VS10 12 s10 0
R10 s10 3 82e2
VS11 10 s11 0
R11 s11 1 56e1
VS12 5 s12 0
R12 s12 9 22e-1
VS13 6 s13 0
C13 s13 8 27e-5
VS14 0 s14 0
L14 s14 14 22e-4
VS15 2 s15 0
C15 s15 9 15e-5
.control
set numdgt=17
ac lin 1 60 60
print v(1) v(2) v(3) v(4) v(5) v(6) v(7) v(8) v(9) v(10)
print v(11) v(12) v(13) v(14)
print i(vs0) i(vs1) i(vs2) i(vs3) i(vs4) i(vs5) i(vs6) i(vs7) i(vs8) i(vs9)
print i(vs10) i(vs11) i(vs12) i(vs13) i(vs14) i(vs15)
.endc
.end
