controls oracle ac-0489
* Generated (plan F2.7, ADR 0012): do not edit; regenerate with `pnpm sim oracle regen`. ac seed 20261031 index 489 nodes 27 elements 39
.options sparse gmin=1e-12 noopac
RG1 1 0 1000000000000
RG2 2 0 1000000000000
RG3 3 0 1000000000000
RG4 4 0 1000000000000
RG5 5 0 1000000000000
RG6 6 0 1000000000000
RG7 7 0 1000000000000
RG8 8 0 1000000000000
RG9 9 0 1000000000000
RG10 10 0 1000000000000
RG11 11 0 1000000000000
RG12 12 0 1000000000000
RG13 13 0 1000000000000
RG14 14 0 1000000000000
RG15 15 0 1000000000000
RG16 16 0 1000000000000
RG17 17 0 1000000000000
RG18 18 0 1000000000000
RG19 19 0 1000000000000
RG20 20 0 1000000000000
RG21 21 0 1000000000000
RG22 22 0 1000000000000
RG23 23 0 1000000000000
RG24 24 0 1000000000000
RG25 25 0 1000000000000
RG26 26 0 1000000000000
VS0 0 s0 0
V0 e0 s0 DC 0 AC 10e1 120
RI0 e0 m0 27e-3
LI0 m0 13 27e-5
VS1 3 s1 0
L1 s1 15 82e-5
VS2 1 s2 0
C2 s2 6 22e-6
VS3 16 s3 0
R3 s3 18 68e-2
VS4 20 s4 0
R4 s4 16 68e1
VS5 4 s5 0
L5 s5 1 15e-2
VS6 1 s6 0
C6 s6 0 56e-4
VS7 23 s7 0
L7 s7 6 39e-5
VS8 8 s8 0
L8 s8 12 12e-3
VS9 17 s9 0
R9 s9 20 68e3
VS10 9 s10 0
V10 e10 s10 DC 0 AC 82e0 180
RI10 e10 m10 82e-3
LI10 m10 12 15e-5
VS11 25 s11 0
L11 s11 3 22e-2
VS12 26 s12 0
R12 s12 19 12e2
VS13 4 s13 0
V13 e13 s13 DC 0 AC 15e0 0
RI13 e13 m13 56e-2
LI13 m13 25 68e-5
VS14 14 s14 0
R14 s14 12 56e0
VS15 11 s15 0
C15 s15 17 82e-7
VS16 23 s16 0
V16 e16 s16 DC 0 AC 82e1 120
RI16 e16 m16 10e-3
LI16 m16 12 15e-6
VS17 11 s17 0
C17 s17 21 27e-7
VS18 8 s18 0
R18 s18 23 22e0
VS19 15 s19 0
L19 s19 0 15e-5
VS20 7 s20 0
R20 s20 0 15e2
VS21 15 s21 0
R21 s21 24 27e-1
VS22 9 s22 0
R22 s22 10 68e2
VS23 16 s23 0
R23 s23 24 22e-2
VS24 19 s24 0
C24 s24 1 33e-7
VS25 18 s25 0
C25 s25 11 18e-7
VS26 22 s26 0
L26 s26 2 47e-4
VS27 21 s27 0
L27 s27 1 27e-3
VS28 26 s28 0
R28 s28 10 68e1
VS29 17 s29 0
R29 s29 14 47e-2
VS30 10 s30 0
L30 s30 4 27e-2
VS31 13 s31 0
C31 s31 4 47e-7
VS32 10 s32 0
R32 s32 2 22e-2
VS33 17 s33 0
R33 s33 3 10e-1
VS34 11 s34 0
C34 s34 5 33e-7
VS35 22 s35 0
L35 s35 7 82e-4
VS36 9 s36 0
L36 s36 19 22e-5
VS37 24 s37 0
V37 e37 s37 DC 0 AC 39e0 120
RI37 e37 10 33e-2
VS38 10 s38 0
C38 s38 5 10e-5
.control
set numdgt=17
ac lin 1 60 60
print v(1) v(2) v(3) v(4) v(5) v(6) v(7) v(8) v(9) v(10)
print v(11) v(12) v(13) v(14) v(15) v(16) v(17) v(18) v(19) v(20)
print v(21) v(22) v(23) v(24) v(25) v(26)
print i(vs0) i(vs1) i(vs2) i(vs3) i(vs4) i(vs5) i(vs6) i(vs7) i(vs8) i(vs9)
print i(vs10) i(vs11) i(vs12) i(vs13) i(vs14) i(vs15) i(vs16) i(vs17) i(vs18) i(vs19)
print i(vs20) i(vs21) i(vs22) i(vs23) i(vs24) i(vs25) i(vs26) i(vs27) i(vs28) i(vs29)
print i(vs30) i(vs31) i(vs32) i(vs33) i(vs34) i(vs35) i(vs36) i(vs37) i(vs38)
.endc
.end
