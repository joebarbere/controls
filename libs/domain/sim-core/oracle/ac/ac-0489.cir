controls oracle ac-0489
* Generated (plan F2.7, ADR 0012): do not edit; regenerate with `pnpm sim oracle regen`. ac seed 20261031 index 489 nodes 27 elements 52
.options sparse gmin=1e-12 noopac
RG1 1 0 1000000000000
RG2 2 0 1000000000000
RG3 3 0 1000000000000
RG4 4 0 1000000000000
RG5 5 0 1000000000000
RG6 6 0 1000000000000
RG7 7 0 1000000000000
RG8 8 0 1000000000000
RG9 9 0 1000000000000
RG10 10 0 1000000000000
RG11 11 0 1000000000000
RG12 12 0 1000000000000
RG13 13 0 1000000000000
RG14 14 0 1000000000000
RG15 15 0 1000000000000
RG16 16 0 1000000000000
RG17 17 0 1000000000000
RG18 18 0 1000000000000
RG19 19 0 1000000000000
RG20 20 0 1000000000000
RG21 21 0 1000000000000
RG22 22 0 1000000000000
RG23 23 0 1000000000000
RG24 24 0 1000000000000
RG25 25 0 1000000000000
RG26 26 0 1000000000000
VS0 26 s0 0
L0 s0 9 82e-4
VS1 26 s1 0
R1 s1 13 68e1
VS2 0 s2 0
V2 e2 s2 DC 0 AC 15e0 -120
RI2 e2 9 47e-1
VS3 15 s3 0
L3 s3 10 15e-5
VS4 13 s4 0
C4 s4 5 10e-5
VS5 10 s5 0
R5 s5 26 47e-2
VS6 21 s6 0
V6 e6 s6 DC 0 AC 15e1 0
RI6 e6 0 15e-1
VS7 4 s7 0
V7 e7 s7 DC 0 AC 15e0 0
RI7 e7 25 56e-2
VS8 20 s8 0
L8 s8 10 10e-3
VS9 23 s9 0
V9 e9 s9 DC 0 AC 33e-1 -120
RI9 e9 12 39e-2
VS10 26 s10 0
C10 s10 7 68e-7
VS11 14 s11 0
R11 s11 25 18e2
VS12 1 s12 0
L12 s12 18 82e-5
VS13 14 s13 0
R13 s13 7 82e0
VS14 24 s14 0
V14 e14 s14 DC 0 AC 39e0 120
RI14 e14 13 33e-2
VS15 14 s15 0
C15 s15 16 82e-6
VS16 15 s16 0
L16 s16 23 18e-3
VS17 9 s17 0
L17 s17 12 12e-4
VS18 22 s18 0
C18 s18 7 15e-6
VS19 15 s19 0
R19 s19 13 33e1
VS20 16 s20 0
C20 s20 6 18e-4
VS21 7 s21 0
R21 s21 23 27e3
VS22 11 s22 0
C22 s22 17 82e-7
VS23 5 s23 0
L23 s23 10 10e-3
VS24 6 s24 0
V24 e24 s24 DC 0 AC 33e-1 180
RI24 e24 8 22e-3
VS25 4 s25 0
L25 s25 19 56e-5
VS26 5 s26 0
R26 s26 23 82e-1
VS27 19 s27 0
C27 s27 2 15e-7
VS28 13 s28 0
R28 s28 19 12e1
VS29 12 s29 0
L29 s29 9 56e-3
VS30 26 s30 0
C30 s30 23 82e-5
VS31 13 s31 0
L31 s31 4 27e-2
VS32 11 s32 0
L32 s32 20 18e-5
VS33 22 s33 0
L33 s33 25 82e-5
VS34 20 s34 0
R34 s34 4 68e3
VS35 7 s35 0
C35 s35 18 18e-6
VS36 24 s36 0
V36 e36 s36 DC 0 AC 12e-1 120
RI36 e36 11 39e-3
VS37 17 s37 0
R37 s37 14 47e-2
VS38 17 s38 0
V38 e38 s38 DC 0 AC 10e1 0
RI38 e38 21 56e-2
VS39 23 s39 0
V39 e39 s39 DC 0 AC 27e-1 0
RI39 e39 21 12e-2
VS40 26 s40 0
R40 s40 1 68e1
VS41 9 s41 0
V41 e41 s41 DC 0 AC 82e0 180
RI41 e41 12 82e-3
VS42 9 s42 0
R42 s42 13 68e2
VS43 15 s43 0
L43 s43 23 27e-2
VS44 11 s44 0
C44 s44 5 33e-7
VS45 16 s45 0
L45 s45 14 82e-4
VS46 3 s46 0
C46 s46 20 56e-7
VS47 3 s47 0
L47 s47 18 18e-5
VS48 12 s48 0
L48 s48 10 27e-3
VS49 4 s49 0
R49 s49 6 56e2
VS50 1 s50 0
L50 s50 20 10e-4
VS51 15 s51 0
R51 s51 2 33e2
.control
set numdgt=17
ac lin 1 60 60
print v(1) v(2) v(3) v(4) v(5) v(6) v(7) v(8) v(9) v(10)
print v(11) v(12) v(13) v(14) v(15) v(16) v(17) v(18) v(19) v(20)
print v(21) v(22) v(23) v(24) v(25) v(26)
print i(vs0) i(vs1) i(vs2) i(vs3) i(vs4) i(vs5) i(vs6) i(vs7) i(vs8) i(vs9)
print i(vs10) i(vs11) i(vs12) i(vs13) i(vs14) i(vs15) i(vs16) i(vs17) i(vs18) i(vs19)
print i(vs20) i(vs21) i(vs22) i(vs23) i(vs24) i(vs25) i(vs26) i(vs27) i(vs28) i(vs29)
print i(vs30) i(vs31) i(vs32) i(vs33) i(vs34) i(vs35) i(vs36) i(vs37) i(vs38) i(vs39)
print i(vs40) i(vs41) i(vs42) i(vs43) i(vs44) i(vs45) i(vs46) i(vs47) i(vs48) i(vs49)
print i(vs50) i(vs51)
.endc
.end
