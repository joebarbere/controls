controls oracle ac-0412
* Generated (plan F2.7, ADR 0012): do not edit; regenerate with `pnpm sim oracle regen`. ac seed 20261031 index 412 nodes 13 elements 21
.options sparse gmin=1e-12 noopac
RG1 1 0 1000000000000
RG2 2 0 1000000000000
RG3 3 0 1000000000000
RG4 4 0 1000000000000
RG5 5 0 1000000000000
RG6 6 0 1000000000000
RG7 7 0 1000000000000
RG8 8 0 1000000000000
RG9 9 0 1000000000000
RG10 10 0 1000000000000
RG11 11 0 1000000000000
RG12 12 0 1000000000000
VS0 11 s0 0
L0 s0 4 33e-2
VS1 9 s1 0
L1 s1 1 33e-4
VS2 9 s2 0
R2 s2 2 18e-1
VS3 5 s3 0
C3 s3 11 47e-7
VS4 11 s4 0
R4 s4 2 27e0
VS5 6 s5 0
R5 s5 7 27e-2
VS6 7 s6 0
C6 s6 8 68e-6
VS7 12 s7 0
R7 s7 1 22e-2
VS8 3 s8 0
C8 s8 7 15e-6
VS9 0 s9 0
V9 e9 s9 DC 0 AC 33e1 -120
RI9 e9 m9 22e-2
LI9 m9 3 68e-6
VS10 6 s10 0
V10 e10 s10 DC 0 AC 15e0 -120
RI10 e10 m10 56e-1
LI10 m10 4 12e-5
VS11 9 s11 0
V11 e11 s11 DC 0 AC 33e-1 120
RI11 e11 m11 12e-3
LI11 m11 4 15e-6
VS12 1 s12 0
L12 s12 4 18e-5
VS13 8 s13 0
L13 s13 1 68e-3
VS14 0 s14 0
R14 s14 4 10e0
VS15 10 s15 0
R15 s15 4 27e-2
VS16 10 s16 0
V16 e16 s16 DC 0 AC 33e-1 180
RI16 e16 m16 82e-3
LI16 m16 3 39e-5
VS17 9 s17 0
V17 e17 s17 DC 0 AC 18e-1 180
RI17 e17 m17 12e-1
LI17 m17 4 68e-5
VS18 11 s18 0
C18 s18 12 10e-5
VS19 7 s19 0
R19 s19 4 68e2
VS20 4 s20 0
L20 s20 5 56e-2
.control
set numdgt=17
ac lin 1 60 60
print v(1) v(2) v(3) v(4) v(5) v(6) v(7) v(8) v(9) v(10)
print v(11) v(12)
print i(vs0) i(vs1) i(vs2) i(vs3) i(vs4) i(vs5) i(vs6) i(vs7) i(vs8) i(vs9)
print i(vs10) i(vs11) i(vs12) i(vs13) i(vs14) i(vs15) i(vs16) i(vs17) i(vs18) i(vs19)
print i(vs20)
.endc
.end
