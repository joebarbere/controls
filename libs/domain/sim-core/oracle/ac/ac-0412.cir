controls oracle ac-0412
* Generated (plan F2.7, ADR 0012): do not edit; regenerate with `pnpm sim oracle regen`. ac seed 20261031 index 412 nodes 13 elements 16
.options sparse gmin=1e-12 noopac
RG1 1 0 1000000000000
RG2 2 0 1000000000000
RG3 3 0 1000000000000
RG4 4 0 1000000000000
RG5 5 0 1000000000000
RG6 6 0 1000000000000
RG7 7 0 1000000000000
RG8 8 0 1000000000000
RG9 9 0 1000000000000
RG10 10 0 1000000000000
RG11 11 0 1000000000000
RG12 12 0 1000000000000
VS0 4 s0 0
R0 s0 9 10e2
VS1 10 s1 0
R1 s1 9 27e-2
VS2 2 s2 0
R2 s2 5 39e2
VS3 0 s3 0
V3 e3 s3 DC 0 AC 33e-1 120
RI3 e3 9 12e-3
VS4 11 s4 0
C4 s4 12 10e-5
VS5 6 s5 0
V5 e5 s5 DC 0 AC 12e1 180
RI5 e5 11 68e-1
VS6 8 s6 0
C6 s6 2 27e-7
VS7 7 s7 0
C7 s7 8 68e-6
VS8 6 s8 0
R8 s8 7 27e-2
VS9 9 s9 0
V9 e9 s9 DC 0 AC 47e0 0
RI9 e9 1 33e-2
VS10 6 s10 0
V10 e10 s10 DC 0 AC 15e0 -120
RI10 e10 9 56e-1
VS11 7 s11 0
R11 s11 9 68e2
VS12 2 s12 0
L12 s12 3 18e-4
VS13 0 s13 0
C13 s13 10 39e-6
VS14 0 s14 0
R14 s14 2 18e-1
VS15 11 s15 0
L15 s15 9 33e-2
.control
set numdgt=17
ac lin 1 60 60
print v(1) v(2) v(3) v(4) v(5) v(6) v(7) v(8) v(9) v(10)
print v(11) v(12)
print i(vs0) i(vs1) i(vs2) i(vs3) i(vs4) i(vs5) i(vs6) i(vs7) i(vs8) i(vs9)
print i(vs10) i(vs11) i(vs12) i(vs13) i(vs14) i(vs15)
.endc
.end
