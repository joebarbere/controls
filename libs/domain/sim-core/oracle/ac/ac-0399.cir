controls oracle ac-0399
* Generated (plan F2.7, ADR 0012): do not edit; regenerate with `pnpm sim oracle regen`. ac seed 20261031 index 399 nodes 4 elements 4
.options sparse gmin=1e-12 noopac
RG1 1 0 1000000000000
RG2 2 0 1000000000000
RG3 3 0 1000000000000
VS0 0 s0 0
V0 e0 s0 DC 0 AC 68e1 120
RI0 e0 m0 15e-1
LI0 m0 2 47e-6
VS1 3 s1 0
C1 s1 2 33e-5
VS2 1 s2 0
C2 s2 3 22e-5
VS3 1 s3 0
L3 s3 0 47e-3
.control
set numdgt=17
ac lin 1 60 60
print v(1) v(2) v(3)
print i(vs0) i(vs1) i(vs2) i(vs3)
.endc
.end
