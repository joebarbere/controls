controls oracle ac-0457
* Generated (plan F2.7, ADR 0012): do not edit; regenerate with `pnpm sim oracle regen`. ac seed 20261031 index 457 nodes 7 elements 10
.options sparse gmin=1e-12 noopac
RG1 1 0 1000000000000
RG2 2 0 1000000000000
RG3 3 0 1000000000000
RG4 4 0 1000000000000
RG5 5 0 1000000000000
RG6 6 0 1000000000000
VS0 5 s0 0
R0 s0 6 12e1
VS1 3 s1 0
R1 s1 2 33e-1
VS2 3 s2 0
R2 s2 5 10e0
VS3 5 s3 0
L3 s3 1 56e-2
VS4 3 s4 0
C4 s4 0 10e-5
VS5 0 s5 0
V5 e5 s5 DC 0 AC 39e0 120
RI5 e5 4 82e-2
VS6 1 s6 0
R6 s6 0 27e3
VS7 6 s7 0
L7 s7 0 15e-4
VS8 2 s8 0
C8 s8 6 10e-5
VS9 1 s9 0
R9 s9 4 12e1
.control
set numdgt=17
ac lin 1 60 60
print v(1) v(2) v(3) v(4) v(5) v(6)
print i(vs0) i(vs1) i(vs2) i(vs3) i(vs4) i(vs5) i(vs6) i(vs7) i(vs8) i(vs9)
.endc
.end
