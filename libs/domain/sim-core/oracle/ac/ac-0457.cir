controls oracle ac-0457
* Generated (plan F2.7, ADR 0012): do not edit; regenerate with `pnpm sim oracle regen`. ac seed 20261031 index 457 nodes 7 elements 9
.options sparse gmin=1e-12 noopac
RG1 1 0 1000000000000
RG2 2 0 1000000000000
RG3 3 0 1000000000000
RG4 4 0 1000000000000
RG5 5 0 1000000000000
RG6 6 0 1000000000000
VS0 2 s0 0
C0 s0 6 10e-5
VS1 1 s1 0
R1 s1 0 27e3
VS2 6 s2 0
L2 s2 0 15e-4
VS3 1 s3 0
R3 s3 4 12e1
VS4 3 s4 0
C4 s4 0 10e-5
VS5 5 s5 0
R5 s5 6 12e1
VS6 5 s6 0
L6 s6 1 56e-2
VS7 3 s7 0
R7 s7 5 10e0
VS8 0 s8 0
V8 e8 s8 DC 0 AC 39e0 120
RI8 e8 4 82e-2
.control
set numdgt=17
ac lin 1 60 60
print v(1) v(2) v(3) v(4) v(5) v(6)
print i(vs0) i(vs1) i(vs2) i(vs3) i(vs4) i(vs5) i(vs6) i(vs7) i(vs8)
.endc
.end
