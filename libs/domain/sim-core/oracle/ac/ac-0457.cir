controls oracle ac-0457
* Generated (plan F2.7, ADR 0012): do not edit; regenerate with `pnpm sim oracle regen`. ac seed 20261031 index 457 nodes 7 elements 12
.options sparse gmin=1e-12 noopac
RG1 1 0 1000000000000
RG2 2 0 1000000000000
RG3 3 0 1000000000000
RG4 4 0 1000000000000
RG5 5 0 1000000000000
RG6 6 0 1000000000000
VS0 4 s0 0
L0 s0 3 18e-3
VS1 6 s1 0
R1 s1 4 33e-2
VS2 2 s2 0
C2 s2 6 10e-5
VS3 5 s3 0
R3 s3 6 12e1
VS4 0 s4 0
V4 e4 s4 DC 0 AC 39e0 120
RI4 e4 m4 82e-2
LI4 m4 4 68e-7
VS5 2 s5 0
V5 e5 s5 DC 0 AC 33e-1 120
RI5 e5 5 10e-1
VS6 5 s6 0
R6 s6 3 39e2
VS7 1 s7 0
R7 s7 0 27e3
VS8 4 s8 0
C8 s8 3 39e-7
VS9 6 s9 0
L9 s9 0 15e-4
VS10 3 s10 0
C10 s10 0 10e-5
VS11 5 s11 0
C11 s11 1 82e-5
.control
set numdgt=17
ac lin 1 60 60
print v(1) v(2) v(3) v(4) v(5) v(6)
print i(vs0) i(vs1) i(vs2) i(vs3) i(vs4) i(vs5) i(vs6) i(vs7) i(vs8) i(vs9)
print i(vs10) i(vs11)
.endc
.end
