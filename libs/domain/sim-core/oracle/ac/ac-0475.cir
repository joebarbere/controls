controls oracle ac-0475
* Generated (plan F2.7, ADR 0012): do not edit; regenerate with `pnpm sim oracle regen`. ac seed 20261031 index 475 nodes 23 elements 30
.options sparse gmin=1e-12 noopac
RG1 1 0 1000000000000
RG2 2 0 1000000000000
RG3 3 0 1000000000000
RG4 4 0 1000000000000
RG5 5 0 1000000000000
RG6 6 0 1000000000000
RG7 7 0 1000000000000
RG8 8 0 1000000000000
RG9 9 0 1000000000000
RG10 10 0 1000000000000
RG11 11 0 1000000000000
RG12 12 0 1000000000000
RG13 13 0 1000000000000
RG14 14 0 1000000000000
RG15 15 0 1000000000000
RG16 16 0 1000000000000
RG17 17 0 1000000000000
RG18 18 0 1000000000000
RG19 19 0 1000000000000
RG20 20 0 1000000000000
RG21 21 0 1000000000000
RG22 22 0 1000000000000
VS0 1 s0 0
R0 s0 20 12e1
VS1 15 s1 0
R1 s1 4 68e2
VS2 4 s2 0
L2 s2 1 10e-3
VS3 16 s3 0
R3 s3 10 56e-1
VS4 9 s4 0
R4 s4 20 39e1
VS5 21 s5 0
C5 s5 20 82e-6
VS6 0 s6 0
L6 s6 18 18e-5
VS7 3 s7 0
C7 s7 12 39e-4
VS8 0 s8 0
V8 e8 s8 DC 0 AC 33e1 180
RI8 e8 m8 18e-3
LI8 m8 9 18e-6
VS9 21 s9 0
R9 s9 13 82e3
VS10 19 s10 0
L10 s10 10 27e-5
VS11 3 s11 0
R11 s11 19 33e1
VS12 14 s12 0
L12 s12 7 68e-2
VS13 20 s13 0
L13 s13 5 22e-5
VS14 22 s14 0
C14 s14 7 15e-4
VS15 11 s15 0
L15 s15 17 15e-3
VS16 13 s16 0
R16 s16 7 39e2
VS17 12 s17 0
R17 s17 20 56e1
VS18 18 s18 0
L18 s18 7 56e-5
VS19 18 s19 0
C19 s19 8 27e-7
VS20 9 s20 0
V20 e20 s20 DC 0 AC 82e0 120
RI20 e20 2 22e-3
VS21 3 s21 0
C21 s21 22 56e-5
VS22 16 s22 0
R22 s22 11 47e2
VS23 14 s23 0
L23 s23 5 27e-5
VS24 6 s24 0
R24 s24 17 39e0
VS25 15 s25 0
C25 s25 6 10e-4
VS26 17 s26 0
R26 s26 10 12e3
VS27 2 s27 0
L27 s27 1 27e-4
VS28 17 s28 0
C28 s28 1 47e-4
VS29 8 s29 0
R29 s29 9 22e-1
.control
set numdgt=17
ac lin 1 60 60
print v(1) v(2) v(3) v(4) v(5) v(6) v(7) v(8) v(9) v(10)
print v(11) v(12) v(13) v(14) v(15) v(16) v(17) v(18) v(19) v(20)
print v(21) v(22)
print i(vs0) i(vs1) i(vs2) i(vs3) i(vs4) i(vs5) i(vs6) i(vs7) i(vs8) i(vs9)
print i(vs10) i(vs11) i(vs12) i(vs13) i(vs14) i(vs15) i(vs16) i(vs17) i(vs18) i(vs19)
print i(vs20) i(vs21) i(vs22) i(vs23) i(vs24) i(vs25) i(vs26) i(vs27) i(vs28) i(vs29)
.endc
.end
