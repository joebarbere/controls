controls oracle ac-0475
* Generated (plan F2.7, ADR 0012): do not edit; regenerate with `pnpm sim oracle regen`. ac seed 20261031 index 475 nodes 23 elements 33
.options sparse gmin=1e-12 noopac
RG1 1 0 1000000000000
RG2 2 0 1000000000000
RG3 3 0 1000000000000
RG4 4 0 1000000000000
RG5 5 0 1000000000000
RG6 6 0 1000000000000
RG7 7 0 1000000000000
RG8 8 0 1000000000000
RG9 9 0 1000000000000
RG10 10 0 1000000000000
RG11 11 0 1000000000000
RG12 12 0 1000000000000
RG13 13 0 1000000000000
RG14 14 0 1000000000000
RG15 15 0 1000000000000
RG16 16 0 1000000000000
RG17 17 0 1000000000000
RG18 18 0 1000000000000
RG19 19 0 1000000000000
RG20 20 0 1000000000000
RG21 21 0 1000000000000
RG22 22 0 1000000000000
VS0 4 s0 0
L0 s0 1 10e-3
VS1 17 s1 0
R1 s1 10 12e3
VS2 15 s2 0
C2 s2 6 10e-4
VS3 18 s3 0
L3 s3 6 18e-2
VS4 0 s4 0
R4 s4 21 56e-1
VS5 22 s5 0
C5 s5 7 15e-4
VS6 13 s6 0
R6 s6 7 39e2
VS7 0 s7 0
V7 e7 s7 DC 0 AC 82e0 120
RI7 e7 2 22e-3
VS8 12 s8 0
R8 s8 20 56e1
VS9 3 s9 0
C9 s9 12 39e-4
VS10 17 s10 0
C10 s10 1 47e-4
VS11 9 s11 0
V11 e11 s11 DC 0 AC 33e1 180
RI11 e11 m11 18e-3
LI11 m11 0 68e-6
VS12 18 s12 0
L12 s12 7 56e-5
VS13 9 s13 0
V13 e13 s13 DC 0 AC 18e-1 0
RI13 e13 m13 39e-3
LI13 m13 20 22e-6
VS14 8 s14 0
R14 s14 0 22e-1
VS15 15 s15 0
L15 s15 10 22e-5
VS16 21 s16 0
C16 s16 20 82e-6
VS17 13 s17 0
R17 s17 16 15e-2
VS18 2 s18 0
L18 s18 1 27e-4
VS19 13 s19 0
L19 s19 3 10e-2
VS20 11 s20 0
V20 e20 s20 DC 0 AC 22e1 -120
RI20 e20 13 18e-3
VS21 14 s21 0
L21 s21 4 82e-5
VS22 1 s22 0
R22 s22 20 12e1
VS23 15 s23 0
R23 s23 4 68e2
VS24 16 s24 0
R24 s24 10 56e-1
VS25 22 s25 0
C25 s25 6 56e-5
VS26 19 s26 0
L26 s26 10 27e-5
VS27 13 s27 0
C27 s27 0 68e-5
VS28 20 s28 0
L28 s28 5 22e-5
VS29 18 s29 0
C29 s29 8 27e-7
VS30 11 s30 0
L30 s30 17 15e-3
VS31 0 s31 0
C31 s31 19 18e-4
VS32 14 s32 0
L32 s32 5 27e-5
.control
set numdgt=17
ac lin 1 60 60
print v(1) v(2) v(3) v(4) v(5) v(6) v(7) v(8) v(9) v(10)
print v(11) v(12) v(13) v(14) v(15) v(16) v(17) v(18) v(19) v(20)
print v(21) v(22)
print i(vs0) i(vs1) i(vs2) i(vs3) i(vs4) i(vs5) i(vs6) i(vs7) i(vs8) i(vs9)
print i(vs10) i(vs11) i(vs12) i(vs13) i(vs14) i(vs15) i(vs16) i(vs17) i(vs18) i(vs19)
print i(vs20) i(vs21) i(vs22) i(vs23) i(vs24) i(vs25) i(vs26) i(vs27) i(vs28) i(vs29)
print i(vs30) i(vs31) i(vs32)
.endc
.end
