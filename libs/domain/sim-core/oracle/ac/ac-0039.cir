controls oracle ac-0039
* Generated (plan F2.7, ADR 0012): do not edit; regenerate with `pnpm sim oracle regen`. ac seed 20261031 index 39 nodes 29 elements 30
.options sparse gmin=1e-12 noopac
RG1 1 0 1000000000000
RG2 2 0 1000000000000
RG3 3 0 1000000000000
RG4 4 0 1000000000000
RG5 5 0 1000000000000
RG6 6 0 1000000000000
RG7 7 0 1000000000000
RG8 8 0 1000000000000
RG9 9 0 1000000000000
RG10 10 0 1000000000000
RG11 11 0 1000000000000
RG12 12 0 1000000000000
RG13 13 0 1000000000000
RG14 14 0 1000000000000
RG15 15 0 1000000000000
RG16 16 0 1000000000000
RG17 17 0 1000000000000
RG18 18 0 1000000000000
RG19 19 0 1000000000000
RG20 20 0 1000000000000
RG21 21 0 1000000000000
RG22 22 0 1000000000000
RG23 23 0 1000000000000
RG24 24 0 1000000000000
RG25 25 0 1000000000000
RG26 26 0 1000000000000
RG27 27 0 1000000000000
RG28 28 0 1000000000000
VS0 0 s0 0
V0 e0 s0 DC 0 AC 22e0 -120
RI0 e0 13 82e-3
VS1 22 s1 0
R1 s1 26 56e1
VS2 9 s2 0
L2 s2 10 39e-2
VS3 10 s3 0
R3 s3 20 33e0
VS4 3 s4 0
L4 s4 25 33e-3
VS5 28 s5 0
V5 e5 s5 DC 0 AC 33e-1 120
RI5 e5 23 27e-2
VS6 7 s6 0
L6 s6 1 10e-3
VS7 12 s7 0
R7 s7 15 12e3
VS8 7 s8 0
C8 s8 10 68e-5
VS9 13 s9 0
V9 e9 s9 DC 0 AC 68e-1 180
RI9 e9 7 22e-2
VS10 3 s10 0
C10 s10 14 12e-5
VS11 2 s11 0
R11 s11 10 56e-2
VS12 23 s12 0
R12 s12 28 82e-2
VS13 4 s13 0
V13 e13 s13 DC 0 AC 39e1 180
RI13 e13 21 27e-2
VS14 23 s14 0
C14 s14 7 18e-5
VS15 9 s15 0
V15 e15 s15 DC 0 AC 27e-1 120
RI15 e15 24 56e-3
VS16 7 s16 0
R16 s16 26 12e-1
VS17 18 s17 0
V17 e17 s17 DC 0 AC 33e-1 180
RI17 e17 3 22e-1
VS18 4 s18 0
C18 s18 2 39e-6
VS19 6 s19 0
R19 s19 27 22e-2
VS20 24 s20 0
R20 s20 16 82e1
VS21 8 s21 0
V21 e21 s21 DC 0 AC 27e1 120
RI21 e21 23 39e-2
VS22 17 s22 0
L22 s22 7 68e-2
VS23 2 s23 0
C23 s23 12 12e-7
VS24 25 s24 0
C24 s24 19 15e-5
VS25 24 s25 0
V25 e25 s25 DC 0 AC 82e0 -120
RI25 e25 26 68e-2
VS26 7 s26 0
C26 s26 5 15e-4
VS27 18 s27 0
R27 s27 11 22e-2
VS28 6 s28 0
V28 e28 s28 DC 0 AC 15e-1 180
RI28 e28 13 82e-2
VS29 13 s29 0
V29 e29 s29 DC 0 AC 33e1 120
RI29 e29 3 82e-2
.control
set numdgt=17
ac lin 1 60 60
print v(1) v(2) v(3) v(4) v(5) v(6) v(7) v(8) v(9) v(10)
print v(11) v(12) v(13) v(14) v(15) v(16) v(17) v(18) v(19) v(20)
print v(21) v(22) v(23) v(24) v(25) v(26) v(27) v(28)
print i(vs0) i(vs1) i(vs2) i(vs3) i(vs4) i(vs5) i(vs6) i(vs7) i(vs8) i(vs9)
print i(vs10) i(vs11) i(vs12) i(vs13) i(vs14) i(vs15) i(vs16) i(vs17) i(vs18) i(vs19)
print i(vs20) i(vs21) i(vs22) i(vs23) i(vs24) i(vs25) i(vs26) i(vs27) i(vs28) i(vs29)
.endc
.end
