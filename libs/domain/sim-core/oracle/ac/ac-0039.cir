controls oracle ac-0039
* Generated (plan F2.7, ADR 0012): do not edit; regenerate with `pnpm sim oracle regen`. ac seed 20261031 index 39 nodes 29 elements 53
.options sparse gmin=1e-12 noopac
RG1 1 0 1000000000000
RG2 2 0 1000000000000
RG3 3 0 1000000000000
RG4 4 0 1000000000000
RG5 5 0 1000000000000
RG6 6 0 1000000000000
RG7 7 0 1000000000000
RG8 8 0 1000000000000
RG9 9 0 1000000000000
RG10 10 0 1000000000000
RG11 11 0 1000000000000
RG12 12 0 1000000000000
RG13 13 0 1000000000000
RG14 14 0 1000000000000
RG15 15 0 1000000000000
RG16 16 0 1000000000000
RG17 17 0 1000000000000
RG18 18 0 1000000000000
RG19 19 0 1000000000000
RG20 20 0 1000000000000
RG21 21 0 1000000000000
RG22 22 0 1000000000000
RG23 23 0 1000000000000
RG24 24 0 1000000000000
RG25 25 0 1000000000000
RG26 26 0 1000000000000
RG27 27 0 1000000000000
RG28 28 0 1000000000000
VS0 3 s0 0
L0 s0 5 39e-4
VS1 12 s1 0
C1 s1 9 47e-5
VS2 1 s2 0
R2 s2 28 47e2
VS3 0 s3 0
V3 e3 s3 DC 0 AC 33e-1 180
RI3 e3 24 22e-1
VS4 12 s4 0
L4 s4 24 39e-2
VS5 23 s5 0
R5 s5 8 15e-2
VS6 18 s6 0
L6 s6 1 39e-3
VS7 10 s7 0
R7 s7 26 56e-2
VS8 1 s8 0
L8 s8 20 10e-4
VS9 1 s9 0
L9 s9 15 56e-3
VS10 10 s10 0
V10 e10 s10 DC 0 AC 15e0 180
RI10 e10 9 68e-2
VS11 10 s11 0
R11 s11 19 33e1
VS12 23 s12 0
R12 s12 21 82e-2
VS13 1 s13 0
L13 s13 16 39e-3
VS14 25 s14 0
L14 s14 10 15e-2
VS15 26 s15 0
R15 s15 21 68e3
VS16 13 s16 0
V16 e16 s16 DC 0 AC 27e1 120
RI16 e16 m16 39e-2
LI16 m16 6 33e-6
VS17 23 s17 0
C17 s17 20 22e-5
VS18 23 s18 0
R18 s18 18 15e1
VS19 14 s19 0
R19 s19 19 82e-2
VS20 10 s20 0
L20 s20 13 12e-5
VS21 14 s21 0
V21 e21 s21 DC 0 AC 22e1 -120
RI21 e21 m21 12e-2
LI21 m21 3 22e-5
VS22 23 s22 0
R22 s22 18 10e3
VS23 25 s23 0
R23 s23 26 56e1
VS24 23 s24 0
L24 s24 5 15e-3
VS25 21 s25 0
V25 e25 s25 DC 0 AC 27e-1 0
RI25 e25 m25 10e-2
LI25 m25 16 22e-7
VS26 26 s26 0
R26 s26 7 82e-1
VS27 2 s27 0
R27 s27 6 82e-2
VS28 11 s28 0
C28 s28 6 27e-5
VS29 3 s29 0
C29 s29 25 18e-6
VS30 2 s30 0
C30 s30 27 27e-7
VS31 1 s31 0
V31 e31 s31 DC 0 AC 22e0 120
RI31 e31 0 33e-2
VS32 9 s32 0
V32 e32 s32 DC 0 AC 22e0 -120
RI32 e32 4 82e-3
VS33 22 s33 0
V33 e33 s33 DC 0 AC 68e-1 180
RI33 e33 m33 22e-2
LI33 m33 7 18e-6
VS34 3 s34 0
V34 e34 s34 DC 0 AC 68e-1 0
RI34 e34 26 68e-2
VS35 2 s35 0
V35 e35 s35 DC 0 AC 33e0 180
RI35 e35 16 22e-3
VS36 23 s36 0
R36 s36 25 12e0
VS37 11 s37 0
L37 s37 26 39e-4
VS38 14 s38 0
V38 e38 s38 DC 0 AC 39e0 0
RI38 e38 m38 68e-3
LI38 m38 21 39e-5
VS39 7 s39 0
V39 e39 s39 DC 0 AC 18e-1 -120
RI39 e39 m39 56e-1
LI39 m39 5 12e-6
VS40 4 s40 0
C40 s40 6 47e-7
VS41 0 s41 0
L41 s41 27 27e-2
VS42 22 s42 0
R42 s42 5 22e3
VS43 2 s43 0
C43 s43 7 18e-5
VS44 7 s44 0
L44 s44 23 33e-3
VS45 19 s45 0
R45 s45 8 68e1
VS46 3 s46 0
R46 s46 17 27e3
VS47 15 s47 0
L47 s47 1 56e-4
VS48 24 s48 0
V48 e48 s48 DC 0 AC 68e0 0
RI48 e48 7 22e-3
VS49 3 s49 0
R49 s49 28 82e1
VS50 18 s50 0
R50 s50 11 10e0
VS51 6 s51 0
R51 s51 5 47e-1
VS52 17 s52 0
L52 s52 15 18e-4
.control
set numdgt=17
ac lin 1 60 60
print v(1) v(2) v(3) v(4) v(5) v(6) v(7) v(8) v(9) v(10)
print v(11) v(12) v(13) v(14) v(15) v(16) v(17) v(18) v(19) v(20)
print v(21) v(22) v(23) v(24) v(25) v(26) v(27) v(28)
print i(vs0) i(vs1) i(vs2) i(vs3) i(vs4) i(vs5) i(vs6) i(vs7) i(vs8) i(vs9)
print i(vs10) i(vs11) i(vs12) i(vs13) i(vs14) i(vs15) i(vs16) i(vs17) i(vs18) i(vs19)
print i(vs20) i(vs21) i(vs22) i(vs23) i(vs24) i(vs25) i(vs26) i(vs27) i(vs28) i(vs29)
print i(vs30) i(vs31) i(vs32) i(vs33) i(vs34) i(vs35) i(vs36) i(vs37) i(vs38) i(vs39)
print i(vs40) i(vs41) i(vs42) i(vs43) i(vs44) i(vs45) i(vs46) i(vs47) i(vs48) i(vs49)
print i(vs50) i(vs51) i(vs52)
.endc
.end
