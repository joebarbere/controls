controls oracle ac-0361
* Generated (plan F2.7, ADR 0012): do not edit; regenerate with `pnpm sim oracle regen`. ac seed 20261031 index 361 nodes 30 elements 47
.options sparse gmin=1e-12 noopac
RG1 1 0 1000000000000
RG2 2 0 1000000000000
RG3 3 0 1000000000000
RG4 4 0 1000000000000
RG5 5 0 1000000000000
RG6 6 0 1000000000000
RG7 7 0 1000000000000
RG8 8 0 1000000000000
RG9 9 0 1000000000000
RG10 10 0 1000000000000
RG11 11 0 1000000000000
RG12 12 0 1000000000000
RG13 13 0 1000000000000
RG14 14 0 1000000000000
RG15 15 0 1000000000000
RG16 16 0 1000000000000
RG17 17 0 1000000000000
RG18 18 0 1000000000000
RG19 19 0 1000000000000
RG20 20 0 1000000000000
RG21 21 0 1000000000000
RG22 22 0 1000000000000
RG23 23 0 1000000000000
RG24 24 0 1000000000000
RG25 25 0 1000000000000
RG26 26 0 1000000000000
RG27 27 0 1000000000000
RG28 28 0 1000000000000
RG29 29 0 1000000000000
VS0 15 s0 0
C0 s0 20 22e-5
VS1 3 s1 0
R1 s1 8 39e3
VS2 5 s2 0
L2 s2 12 39e-3
VS3 9 s3 0
L3 s3 5 18e-3
VS4 0 s4 0
V4 e4 s4 DC 0 AC 18e1 0
RI4 e4 m4 68e-3
LI4 m4 15 15e-6
VS5 24 s5 0
V5 e5 s5 DC 0 AC 27e1 0
RI5 e5 15 18e-2
VS6 10 s6 0
L6 s6 27 68e-4
VS7 18 s7 0
V7 e7 s7 DC 0 AC 82e0 0
RI7 e7 8 22e-3
VS8 15 s8 0
C8 s8 4 27e-4
VS9 3 s9 0
L9 s9 2 18e-2
VS10 19 s10 0
C10 s10 17 33e-6
VS11 25 s11 0
V11 e11 s11 DC 0 AC 18e1 -120
RI11 e11 6 10e-3
VS12 21 s12 0
V12 e12 s12 DC 0 AC 18e0 180
RI12 e12 m12 18e-1
LI12 m12 25 12e-5
VS13 25 s13 0
R13 s13 9 22e0
VS14 4 s14 0
V14 e14 s14 DC 0 AC 27e1 120
RI14 e14 26 27e-1
VS15 10 s15 0
V15 e15 s15 DC 0 AC 10e1 0
RI15 e15 9 10e-3
VS16 11 s16 0
C16 s16 18 47e-4
VS17 17 s17 0
L17 s17 8 33e-2
VS18 28 s18 0
C18 s18 17 82e-6
VS19 28 s19 0
R19 s19 14 22e0
VS20 0 s20 0
C20 s20 29 56e-4
VS21 13 s21 0
R21 s21 21 56e-1
VS22 12 s22 0
C22 s22 29 33e-7
VS23 18 s23 0
C23 s23 16 15e-6
VS24 23 s24 0
C24 s24 16 22e-5
VS25 24 s25 0
V25 e25 s25 DC 0 AC 56e0 -120
RI25 e25 m25 18e-3
LI25 m25 13 33e-5
VS26 26 s26 0
R26 s26 3 47e3
VS27 2 s27 0
L27 s27 1 39e-4
VS28 22 s28 0
L28 s28 6 82e-3
VS29 5 s29 0
R29 s29 4 56e1
VS30 14 s30 0
R30 s30 15 27e3
VS31 9 s31 0
R31 s31 19 27e0
VS32 27 s32 0
L32 s32 23 18e-3
VS33 23 s33 0
R33 s33 19 12e3
VS34 7 s34 0
R34 s34 25 47e0
VS35 16 s35 0
V35 e35 s35 DC 0 AC 39e-1 0
RI35 e35 12 39e-3
VS36 25 s36 0
L36 s36 12 82e-2
VS37 7 s37 0
R37 s37 13 12e2
VS38 15 s38 0
R38 s38 1 56e3
VS39 2 s39 0
R39 s39 3 27e-1
VS40 8 s40 0
L40 s40 22 10e-2
VS41 15 s41 0
C41 s41 28 39e-4
VS42 20 s42 0
C42 s42 14 39e-4
VS43 17 s43 0
R43 s43 23 22e1
VS44 27 s44 0
C44 s44 11 82e-4
VS45 4 s45 0
R45 s45 16 12e0
VS46 25 s46 0
R46 s46 27 47e0
.control
set numdgt=17
ac lin 1 60 60
print v(1) v(2) v(3) v(4) v(5) v(6) v(7) v(8) v(9) v(10)
print v(11) v(12) v(13) v(14) v(15) v(16) v(17) v(18) v(19) v(20)
print v(21) v(22) v(23) v(24) v(25) v(26) v(27) v(28) v(29)
print i(vs0) i(vs1) i(vs2) i(vs3) i(vs4) i(vs5) i(vs6) i(vs7) i(vs8) i(vs9)
print i(vs10) i(vs11) i(vs12) i(vs13) i(vs14) i(vs15) i(vs16) i(vs17) i(vs18) i(vs19)
print i(vs20) i(vs21) i(vs22) i(vs23) i(vs24) i(vs25) i(vs26) i(vs27) i(vs28) i(vs29)
print i(vs30) i(vs31) i(vs32) i(vs33) i(vs34) i(vs35) i(vs36) i(vs37) i(vs38) i(vs39)
print i(vs40) i(vs41) i(vs42) i(vs43) i(vs44) i(vs45) i(vs46)
.endc
.end
