controls oracle ac-0361
* Generated (plan F2.7, ADR 0012): do not edit; regenerate with `pnpm sim oracle regen`. ac seed 20261031 index 361 nodes 30 elements 50
.options sparse gmin=1e-12 noopac
RG1 1 0 1000000000000
RG2 2 0 1000000000000
RG3 3 0 1000000000000
RG4 4 0 1000000000000
RG5 5 0 1000000000000
RG6 6 0 1000000000000
RG7 7 0 1000000000000
RG8 8 0 1000000000000
RG9 9 0 1000000000000
RG10 10 0 1000000000000
RG11 11 0 1000000000000
RG12 12 0 1000000000000
RG13 13 0 1000000000000
RG14 14 0 1000000000000
RG15 15 0 1000000000000
RG16 16 0 1000000000000
RG17 17 0 1000000000000
RG18 18 0 1000000000000
RG19 19 0 1000000000000
RG20 20 0 1000000000000
RG21 21 0 1000000000000
RG22 22 0 1000000000000
RG23 23 0 1000000000000
RG24 24 0 1000000000000
RG25 25 0 1000000000000
RG26 26 0 1000000000000
RG27 27 0 1000000000000
RG28 28 0 1000000000000
RG29 29 0 1000000000000
VS0 28 s0 0
C0 s0 17 82e-6
VS1 5 s1 0
R1 s1 15 12e2
VS2 28 s2 0
R2 s2 24 33e1
VS3 9 s3 0
R3 s3 19 27e0
VS4 21 s4 0
R4 s4 10 27e1
VS5 18 s5 0
L5 s5 16 82e-2
VS6 3 s6 0
R6 s6 9 12e-1
VS7 7 s7 0
R7 s7 25 47e0
VS8 0 s8 0
V8 e8 s8 DC 0 AC 10e1 120
RI8 e8 17 18e-3
VS9 7 s9 0
R9 s9 6 27e3
VS10 26 s10 0
C10 s10 15 12e-4
VS11 29 s11 0
V11 e11 s11 DC 0 AC 18e1 180
RI11 e11 23 12e-1
VS12 10 s12 0
C12 s12 19 10e-5
VS13 25 s13 0
L13 s13 12 82e-2
VS14 15 s14 0
C14 s14 4 27e-4
VS15 10 s15 0
R15 s15 6 18e2
VS16 26 s16 0
R16 s16 3 22e2
VS17 5 s17 0
V17 e17 s17 DC 0 AC 27e1 120
RI17 e17 10 27e-1
VS18 25 s18 0
R18 s18 6 47e0
VS19 15 s19 0
R19 s19 22 56e-1
VS20 16 s20 0
R20 s20 11 82e3
VS21 20 s21 0
R21 s21 29 33e-2
VS22 16 s22 0
V22 e22 s22 DC 0 AC 39e-1 0
RI22 e22 12 39e-3
VS23 14 s23 0
R23 s23 10 15e-1
VS24 0 s24 0
C24 s24 12 33e-4
VS25 1 s25 0
V25 e25 s25 DC 0 AC 18e0 0
RI25 e25 12 15e-2
VS26 20 s26 0
V26 e26 s26 DC 0 AC 18e1 180
RI26 e26 5 22e-3
VS27 0 s27 0
V27 e27 s27 DC 0 AC 22e-1 120
RI27 e27 25 12e-1
VS28 26 s28 0
C28 s28 9 56e-5
VS29 29 s29 0
C29 s29 27 47e-4
VS30 3 s30 0
R30 s30 8 39e3
VS31 17 s31 0
C31 s31 11 33e-7
VS32 14 s32 0
R32 s32 15 27e3
VS33 6 s33 0
C33 s33 13 82e-4
VS34 17 s34 0
L34 s34 8 33e-2
VS35 3 s35 0
R35 s35 29 56e2
VS36 27 s36 0
V36 e36 s36 DC 0 AC 56e0 -120
RI36 e36 25 18e-3
VS37 8 s37 0
L37 s37 22 10e-2
VS38 19 s38 0
R38 s38 3 82e-2
VS39 8 s39 0
C39 s39 11 27e-4
VS40 24 s40 0
C40 s40 6 33e-6
VS41 17 s41 0
R41 s41 4 39e-1
VS42 28 s42 0
L42 s42 7 47e-4
VS43 6 s43 0
R43 s43 23 68e1
VS44 19 s44 0
R44 s44 11 56e-1
VS45 3 s45 0
L45 s45 4 27e-4
VS46 15 s46 0
R46 s46 10 10e2
VS47 2 s47 0
C47 s47 5 68e-4
VS48 9 s48 0
C48 s48 18 22e-5
VS49 23 s49 0
C49 s49 16 22e-5
.control
set numdgt=17
ac lin 1 60 60
print v(1) v(2) v(3) v(4) v(5) v(6) v(7) v(8) v(9) v(10)
print v(11) v(12) v(13) v(14) v(15) v(16) v(17) v(18) v(19) v(20)
print v(21) v(22) v(23) v(24) v(25) v(26) v(27) v(28) v(29)
print i(vs0) i(vs1) i(vs2) i(vs3) i(vs4) i(vs5) i(vs6) i(vs7) i(vs8) i(vs9)
print i(vs10) i(vs11) i(vs12) i(vs13) i(vs14) i(vs15) i(vs16) i(vs17) i(vs18) i(vs19)
print i(vs20) i(vs21) i(vs22) i(vs23) i(vs24) i(vs25) i(vs26) i(vs27) i(vs28) i(vs29)
print i(vs30) i(vs31) i(vs32) i(vs33) i(vs34) i(vs35) i(vs36) i(vs37) i(vs38) i(vs39)
print i(vs40) i(vs41) i(vs42) i(vs43) i(vs44) i(vs45) i(vs46) i(vs47) i(vs48) i(vs49)
.endc
.end
