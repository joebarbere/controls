controls oracle ac-0361
* Generated (plan F2.7, ADR 0012): do not edit; regenerate with `pnpm sim oracle regen`. ac seed 20261031 index 361 nodes 30 elements 54
.options sparse gmin=1e-12 noopac
RG1 1 0 1000000000000
RG2 2 0 1000000000000
RG3 3 0 1000000000000
RG4 4 0 1000000000000
RG5 5 0 1000000000000
RG6 6 0 1000000000000
RG7 7 0 1000000000000
RG8 8 0 1000000000000
RG9 9 0 1000000000000
RG10 10 0 1000000000000
RG11 11 0 1000000000000
RG12 12 0 1000000000000
RG13 13 0 1000000000000
RG14 14 0 1000000000000
RG15 15 0 1000000000000
RG16 16 0 1000000000000
RG17 17 0 1000000000000
RG18 18 0 1000000000000
RG19 19 0 1000000000000
RG20 20 0 1000000000000
RG21 21 0 1000000000000
RG22 22 0 1000000000000
RG23 23 0 1000000000000
RG24 24 0 1000000000000
RG25 25 0 1000000000000
RG26 26 0 1000000000000
RG27 27 0 1000000000000
RG28 28 0 1000000000000
RG29 29 0 1000000000000
VS0 3 s0 0
R0 s0 9 12e-1
VS1 6 s1 0
C1 s1 12 33e-4
VS2 2 s2 0
C2 s2 5 68e-4
VS3 0 s3 0
V3 e3 s3 DC 0 AC 56e0 -120
RI3 e3 25 18e-3
VS4 7 s4 0
R4 s4 25 47e0
VS5 1 s5 0
V5 e5 s5 DC 0 AC 18e0 0
RI5 e5 12 15e-2
VS6 23 s6 0
C6 s6 16 22e-5
VS7 7 s7 0
R7 s7 27 27e3
VS8 24 s8 0
C8 s8 27 33e-6
VS9 26 s9 0
L9 s9 13 27e-2
VS10 8 s10 0
C10 s10 11 27e-4
VS11 15 s11 0
R11 s11 10 10e2
VS12 25 s12 0
R12 s12 1 33e-2
VS13 28 s13 0
L13 s13 7 47e-4
VS14 28 s14 0
C14 s14 17 82e-6
VS15 3 s15 0
L15 s15 21 56e-3
VS16 21 s16 0
R16 s16 10 27e1
VS17 26 s17 0
R17 s17 3 22e2
VS18 16 s18 0
R18 s18 11 82e3
VS19 10 s19 0
C19 s19 19 10e-5
VS20 16 s20 0
V20 e20 s20 DC 0 AC 39e-1 0
RI20 e20 12 39e-3
VS21 17 s21 0
R21 s21 4 39e-1
VS22 25 s22 0
L22 s22 12 82e-2
VS23 25 s23 0
R23 s23 27 47e0
VS24 14 s24 0
R24 s24 15 27e3
VS25 9 s25 0
R25 s25 19 27e0
VS26 6 s26 0
V26 e26 s26 DC 0 AC 10e1 120
RI26 e26 17 18e-3
VS27 26 s27 0
C27 s27 15 12e-4
VS28 14 s28 0
R28 s28 10 15e-1
VS29 17 s29 0
C29 s29 11 33e-7
VS30 20 s30 0
V30 e30 s30 DC 0 AC 18e1 180
RI30 e30 5 22e-3
VS31 26 s31 0
C31 s31 9 56e-5
VS32 5 s32 0
R32 s32 15 12e2
VS33 5 s33 0
V33 e33 s33 DC 0 AC 27e1 120
RI33 e33 10 27e-1
VS34 18 s34 0
L34 s34 16 82e-2
VS35 6 s35 0
V35 e35 s35 DC 0 AC 22e-1 120
RI35 e35 25 12e-1
VS36 29 s36 0
V36 e36 s36 DC 0 AC 18e1 180
RI36 e36 23 12e-1
VS37 3 s37 0
R37 s37 8 39e3
VS38 2 s38 0
L38 s38 23 47e-3
VS39 28 s39 0
R39 s39 24 33e1
VS40 19 s40 0
R40 s40 11 56e-1
VS41 8 s41 0
L41 s41 22 10e-2
VS42 27 s42 0
C42 s42 13 82e-4
VS43 10 s43 0
R43 s43 27 18e2
VS44 3 s44 0
R44 s44 29 56e2
VS45 20 s45 0
R45 s45 29 33e-2
VS46 17 s46 0
L46 s46 8 33e-2
VS47 9 s47 0
C47 s47 18 22e-5
VS48 29 s48 0
C48 s48 0 47e-4
VS49 19 s49 0
R49 s49 3 82e-2
VS50 15 s50 0
C50 s50 4 27e-4
VS51 15 s51 0
R51 s51 22 56e-1
VS52 27 s52 0
R52 s52 23 68e1
VS53 3 s53 0
L53 s53 4 27e-4
.control
set numdgt=17
ac lin 1 60 60
print v(1) v(2) v(3) v(4) v(5) v(6) v(7) v(8) v(9) v(10)
print v(11) v(12) v(13) v(14) v(15) v(16) v(17) v(18) v(19) v(20)
print v(21) v(22) v(23) v(24) v(25) v(26) v(27) v(28) v(29)
print i(vs0) i(vs1) i(vs2) i(vs3) i(vs4) i(vs5) i(vs6) i(vs7) i(vs8) i(vs9)
print i(vs10) i(vs11) i(vs12) i(vs13) i(vs14) i(vs15) i(vs16) i(vs17) i(vs18) i(vs19)
print i(vs20) i(vs21) i(vs22) i(vs23) i(vs24) i(vs25) i(vs26) i(vs27) i(vs28) i(vs29)
print i(vs30) i(vs31) i(vs32) i(vs33) i(vs34) i(vs35) i(vs36) i(vs37) i(vs38) i(vs39)
print i(vs40) i(vs41) i(vs42) i(vs43) i(vs44) i(vs45) i(vs46) i(vs47) i(vs48) i(vs49)
print i(vs50) i(vs51) i(vs52) i(vs53)
.endc
.end
