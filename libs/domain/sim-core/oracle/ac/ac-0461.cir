controls oracle ac-0461
* Generated (plan F2.7, ADR 0012): do not edit; regenerate with `pnpm sim oracle regen`. ac seed 20261031 index 461 nodes 15 elements 24
.options sparse gmin=1e-12 noopac
RG1 1 0 1000000000000
RG2 2 0 1000000000000
RG3 3 0 1000000000000
RG4 4 0 1000000000000
RG5 5 0 1000000000000
RG6 6 0 1000000000000
RG7 7 0 1000000000000
RG8 8 0 1000000000000
RG9 9 0 1000000000000
RG10 10 0 1000000000000
RG11 11 0 1000000000000
RG12 12 0 1000000000000
RG13 13 0 1000000000000
RG14 14 0 1000000000000
VS0 5 s0 0
R0 s0 1 33e2
VS1 2 s1 0
L1 s1 14 47e-5
VS2 0 s2 0
L2 s2 5 33e-2
VS3 0 s3 0
C3 s3 14 10e-6
VS4 5 s4 0
L4 s4 11 10e-3
VS5 11 s5 0
R5 s5 7 47e3
VS6 1 s6 0
L6 s6 6 39e-2
VS7 12 s7 0
L7 s7 10 82e-5
VS8 9 s8 0
C8 s8 7 15e-5
VS9 0 s9 0
V9 e9 s9 DC 0 AC 68e-1 0
RI9 e9 3 22e-1
VS10 10 s10 0
V10 e10 s10 DC 0 AC 56e0 180
RI10 e10 m10 39e-3
LI10 m10 5 27e-7
VS11 6 s11 0
V11 e11 s11 DC 0 AC 15e-1 120
RI11 e11 m11 22e-2
LI11 m11 3 68e-5
VS12 12 s12 0
L12 s12 2 15e-2
VS13 2 s13 0
L13 s13 5 39e-5
VS14 2 s14 0
V14 e14 s14 DC 0 AC 82e0 -120
RI14 e14 3 47e-3
VS15 5 s15 0
L15 s15 0 47e-4
VS16 8 s16 0
V16 e16 s16 DC 0 AC 12e0 0
RI16 e16 4 27e-1
VS17 3 s17 0
R17 s17 9 82e3
VS18 2 s18 0
R18 s18 4 27e-1
VS19 10 s19 0
C19 s19 8 18e-7
VS20 4 s20 0
L20 s20 2 47e-4
VS21 13 s21 0
R21 s21 7 12e0
VS22 8 s22 0
V22 e22 s22 DC 0 AC 15e0 -120
RI22 e22 2 10e-2
VS23 13 s23 0
R23 s23 8 18e-2
.control
set numdgt=17
ac lin 1 60 60
print v(1) v(2) v(3) v(4) v(5) v(6) v(7) v(8) v(9) v(10)
print v(11) v(12) v(13) v(14)
print i(vs0) i(vs1) i(vs2) i(vs3) i(vs4) i(vs5) i(vs6) i(vs7) i(vs8) i(vs9)
print i(vs10) i(vs11) i(vs12) i(vs13) i(vs14) i(vs15) i(vs16) i(vs17) i(vs18) i(vs19)
print i(vs20) i(vs21) i(vs22) i(vs23)
.endc
.end
