controls oracle ac-0461
* Generated (plan F2.7, ADR 0012): do not edit; regenerate with `pnpm sim oracle regen`. ac seed 20261031 index 461 nodes 15 elements 28
.options sparse gmin=1e-12 noopac
RG1 1 0 1000000000000
RG2 2 0 1000000000000
RG3 3 0 1000000000000
RG4 4 0 1000000000000
RG5 5 0 1000000000000
RG6 6 0 1000000000000
RG7 7 0 1000000000000
RG8 8 0 1000000000000
RG9 9 0 1000000000000
RG10 10 0 1000000000000
RG11 11 0 1000000000000
RG12 12 0 1000000000000
RG13 13 0 1000000000000
RG14 14 0 1000000000000
VS0 9 s0 0
R0 s0 11 10e-2
VS1 10 s1 0
R1 s1 2 47e-1
VS2 0 s2 0
V2 e2 s2 DC 0 AC 82e-1 120
RI2 e2 7 47e-2
VS3 8 s3 0
R3 s3 7 47e-2
VS4 9 s4 0
V4 e4 s4 DC 0 AC 82e-1 0
RI4 e4 10 68e-3
VS5 2 s5 0
V5 e5 s5 DC 0 AC 82e0 -120
RI5 e5 3 47e-3
VS6 8 s6 0
V6 e6 s6 DC 0 AC 12e0 -120
RI6 e6 5 18e-3
VS7 9 s7 0
L7 s7 1 18e-4
VS8 3 s8 0
L8 s8 13 82e-5
VS9 6 s9 0
L9 s9 4 56e-4
VS10 8 s10 0
R10 s10 12 33e2
VS11 13 s11 0
V11 e11 s11 DC 0 AC 56e1 180
RI11 e11 12 56e-1
VS12 4 s12 0
L12 s12 2 47e-4
VS13 8 s13 0
R13 s13 1 27e-1
VS14 5 s14 0
V14 e14 s14 DC 0 AC 68e0 0
RI14 e14 9 82e-1
VS15 3 s15 0
C15 s15 2 10e-4
VS16 8 s16 0
R16 s16 6 56e-2
VS17 8 s17 0
V17 e17 s17 DC 0 AC 68e-1 0
RI17 e17 13 22e-1
VS18 9 s18 0
R18 s18 3 18e-1
VS19 10 s19 0
V19 e19 s19 DC 0 AC 18e0 180
RI19 e19 14 10e-3
VS20 11 s20 0
L20 s20 9 47e-2
VS21 14 s21 0
C21 s21 7 12e-7
VS22 5 s22 0
R22 s22 14 27e1
VS23 3 s23 0
C23 s23 2 33e-5
VS24 0 s24 0
V24 e24 s24 DC 0 AC 68e1 0
RI24 e24 4 12e-3
VS25 9 s25 0
V25 e25 s25 DC 0 AC 15e0 -120
RI25 e25 2 10e-2
VS26 4 s26 0
R26 s26 10 68e0
VS27 9 s27 0
C27 s27 0 10e-5
.control
set numdgt=17
ac lin 1 60 60
print v(1) v(2) v(3) v(4) v(5) v(6) v(7) v(8) v(9) v(10)
print v(11) v(12) v(13) v(14)
print i(vs0) i(vs1) i(vs2) i(vs3) i(vs4) i(vs5) i(vs6) i(vs7) i(vs8) i(vs9)
print i(vs10) i(vs11) i(vs12) i(vs13) i(vs14) i(vs15) i(vs16) i(vs17) i(vs18) i(vs19)
print i(vs20) i(vs21) i(vs22) i(vs23) i(vs24) i(vs25) i(vs26) i(vs27)
.endc
.end
