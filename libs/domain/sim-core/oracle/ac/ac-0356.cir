controls oracle ac-0356
* Generated (plan F2.7, ADR 0012): do not edit; regenerate with `pnpm sim oracle regen`. ac seed 20261031 index 356 nodes 12 elements 16
.options sparse gmin=1e-12 noopac
RG1 1 0 1000000000000
RG2 2 0 1000000000000
RG3 3 0 1000000000000
RG4 4 0 1000000000000
RG5 5 0 1000000000000
RG6 6 0 1000000000000
RG7 7 0 1000000000000
RG8 8 0 1000000000000
RG9 9 0 1000000000000
RG10 10 0 1000000000000
RG11 11 0 1000000000000
VS0 5 s0 0
L0 s0 11 39e-4
VS1 8 s1 0
C1 s1 4 10e-6
VS2 11 s2 0
L2 s2 7 39e-2
VS3 10 s3 0
L3 s3 1 12e-2
VS4 4 s4 0
L4 s4 0 12e-4
VS5 5 s5 0
R5 s5 7 10e2
VS6 2 s6 0
C6 s6 0 12e-5
VS7 2 s7 0
R7 s7 3 82e-2
VS8 1 s8 0
L8 s8 2 39e-2
VS9 0 s9 0
V9 e9 s9 DC 0 AC 68e1 -120
RI9 e9 7 47e-3
VS10 9 s10 0
L10 s10 8 15e-2
VS11 7 s11 0
V11 e11 s11 DC 0 AC 18e-1 180
RI11 e11 m11 22e-1
LI11 m11 9 18e-7
VS12 3 s12 0
R12 s12 11 15e2
VS13 4 s13 0
C13 s13 6 68e-4
VS14 1 s14 0
R14 s14 4 47e-2
VS15 10 s15 0
L15 s15 6 10e-4
.control
set numdgt=17
ac lin 1 60 60
print v(1) v(2) v(3) v(4) v(5) v(6) v(7) v(8) v(9) v(10)
print v(11)
print i(vs0) i(vs1) i(vs2) i(vs3) i(vs4) i(vs5) i(vs6) i(vs7) i(vs8) i(vs9)
print i(vs10) i(vs11) i(vs12) i(vs13) i(vs14) i(vs15)
.endc
.end
