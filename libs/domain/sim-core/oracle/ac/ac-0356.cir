controls oracle ac-0356
* Generated (plan F2.7, ADR 0012): do not edit; regenerate with `pnpm sim oracle regen`. ac seed 20261031 index 356 nodes 12 elements 16
.options sparse gmin=1e-12 noopac
RG1 1 0 1000000000000
RG2 2 0 1000000000000
RG3 3 0 1000000000000
RG4 4 0 1000000000000
RG5 5 0 1000000000000
RG6 6 0 1000000000000
RG7 7 0 1000000000000
RG8 8 0 1000000000000
RG9 9 0 1000000000000
RG10 10 0 1000000000000
RG11 11 0 1000000000000
VS0 10 s0 0
R0 s0 1 68e1
VS1 3 s1 0
C1 s1 6 82e-6
VS2 4 s2 0
L2 s2 6 12e-4
VS3 5 s3 0
R3 s3 1 27e0
VS4 0 s4 0
V4 e4 s4 DC 0 AC 56e0 180
RI4 e4 5 47e-2
VS5 9 s5 0
V5 e5 s5 DC 0 AC 27e-1 120
RI5 e5 5 68e-3
VS6 10 s6 0
V6 e6 s6 DC 0 AC 18e-1 180
RI6 e6 3 22e-1
VS7 1 s7 0
R7 s7 2 18e0
VS8 7 s8 0
V8 e8 s8 DC 0 AC 68e1 -120
RI8 e8 9 47e-3
VS9 11 s9 0
L9 s9 0 12e-4
VS10 4 s10 0
C10 s10 7 39e-6
VS11 8 s11 0
V11 e11 s11 DC 0 AC 18e0 180
RI11 e11 11 15e-2
VS12 8 s12 0
R12 s12 3 56e-1
VS13 11 s13 0
R13 s13 9 18e-1
VS14 6 s14 0
C14 s14 5 18e-7
VS15 5 s15 0
L15 s15 2 47e-4
.control
set numdgt=17
ac lin 1 60 60
print v(1) v(2) v(3) v(4) v(5) v(6) v(7) v(8) v(9) v(10)
print v(11)
print i(vs0) i(vs1) i(vs2) i(vs3) i(vs4) i(vs5) i(vs6) i(vs7) i(vs8) i(vs9)
print i(vs10) i(vs11) i(vs12) i(vs13) i(vs14) i(vs15)
.endc
.end
