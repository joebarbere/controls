controls oracle ac-0111
* Generated (plan F2.7, ADR 0012): do not edit; regenerate with `pnpm sim oracle regen`. ac seed 20261031 index 111 nodes 19 elements 32
.options sparse gmin=1e-12 noopac
RG1 1 0 1000000000000
RG2 2 0 1000000000000
RG3 3 0 1000000000000
RG4 4 0 1000000000000
RG5 5 0 1000000000000
RG6 6 0 1000000000000
RG7 7 0 1000000000000
RG8 8 0 1000000000000
RG9 9 0 1000000000000
RG10 10 0 1000000000000
RG11 11 0 1000000000000
RG12 12 0 1000000000000
RG13 13 0 1000000000000
RG14 14 0 1000000000000
RG15 15 0 1000000000000
RG16 16 0 1000000000000
RG17 17 0 1000000000000
RG18 18 0 1000000000000
VS0 5 s0 0
R0 s0 4 18e3
VS1 11 s1 0
R1 s1 5 12e3
VS2 10 s2 0
R2 s2 17 15e2
VS3 11 s3 0
L3 s3 18 15e-4
VS4 5 s4 0
R4 s4 15 33e-1
VS5 16 s5 0
L5 s5 2 15e-3
VS6 0 s6 0
V6 e6 s6 DC 0 AC 18e-1 -120
RI6 e6 m6 39e-3
LI6 m6 17 56e-5
VS7 4 s7 0
L7 s7 9 12e-3
VS8 1 s8 0
R8 s8 7 12e0
VS9 9 s9 0
C9 s9 12 56e-7
VS10 15 s10 0
L10 s10 8 22e-3
VS11 1 s11 0
L11 s11 2 10e-4
VS12 9 s12 0
L12 s12 12 82e-2
VS13 0 s13 0
C13 s13 2 68e-5
VS14 6 s14 0
R14 s14 3 56e1
VS15 12 s15 0
R15 s15 6 10e-1
VS16 10 s16 0
C16 s16 16 22e-4
VS17 8 s17 0
R17 s17 3 18e2
VS18 17 s18 0
C18 s18 14 39e-4
VS19 1 s19 0
C19 s19 3 33e-7
VS20 13 s20 0
L20 s20 4 82e-5
VS21 12 s21 0
L21 s21 5 68e-5
VS22 5 s22 0
L22 s22 1 12e-3
VS23 10 s23 0
C23 s23 2 27e-4
VS24 11 s24 0
L24 s24 12 12e-2
VS25 12 s25 0
V25 e25 s25 DC 0 AC 18e1 180
RI25 e25 5 12e-2
VS26 7 s26 0
C26 s26 11 12e-5
VS27 8 s27 0
R27 s27 14 12e1
VS28 17 s28 0
C28 s28 14 10e-6
VS29 5 s29 0
L29 s29 3 82e-4
VS30 14 s30 0
R30 s30 5 68e2
VS31 18 s31 0
R31 s31 13 82e2
.control
set numdgt=17
ac lin 1 60 60
print v(1) v(2) v(3) v(4) v(5) v(6) v(7) v(8) v(9) v(10)
print v(11) v(12) v(13) v(14) v(15) v(16) v(17) v(18)
print i(vs0) i(vs1) i(vs2) i(vs3) i(vs4) i(vs5) i(vs6) i(vs7) i(vs8) i(vs9)
print i(vs10) i(vs11) i(vs12) i(vs13) i(vs14) i(vs15) i(vs16) i(vs17) i(vs18) i(vs19)
print i(vs20) i(vs21) i(vs22) i(vs23) i(vs24) i(vs25) i(vs26) i(vs27) i(vs28) i(vs29)
print i(vs30) i(vs31)
.endc
.end
