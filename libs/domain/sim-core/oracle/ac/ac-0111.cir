controls oracle ac-0111
* Generated (plan F2.7, ADR 0012): do not edit; regenerate with `pnpm sim oracle regen`. ac seed 20261031 index 111 nodes 19 elements 32
.options sparse gmin=1e-12 noopac
RG1 1 0 1000000000000
RG2 2 0 1000000000000
RG3 3 0 1000000000000
RG4 4 0 1000000000000
RG5 5 0 1000000000000
RG6 6 0 1000000000000
RG7 7 0 1000000000000
RG8 8 0 1000000000000
RG9 9 0 1000000000000
RG10 10 0 1000000000000
RG11 11 0 1000000000000
RG12 12 0 1000000000000
RG13 13 0 1000000000000
RG14 14 0 1000000000000
RG15 15 0 1000000000000
RG16 16 0 1000000000000
RG17 17 0 1000000000000
RG18 18 0 1000000000000
VS0 10 s0 0
R0 s0 4 18e3
VS1 0 s1 0
V1 e1 s1 DC 0 AC 33e0 -120
RI1 e1 16 82e-3
VS2 0 s2 0
L2 s2 9 68e-4
VS3 11 s3 0
C3 s3 15 68e-5
VS4 6 s4 0
L4 s4 14 56e-4
VS5 11 s5 0
R5 s5 10 12e3
VS6 4 s6 0
R6 s6 14 47e-1
VS7 7 s7 0
C7 s7 2 22e-5
VS8 0 s8 0
R8 s8 17 22e2
VS9 8 s9 0
R9 s9 17 12e0
VS10 1 s10 0
L10 s10 2 10e-4
VS11 17 s11 0
L11 s11 9 82e-4
VS12 14 s12 0
V12 e12 s12 DC 0 AC 12e-1 180
RI12 e12 9 12e-2
VS13 4 s13 0
V13 e13 s13 DC 0 AC 68e-1 180
RI13 e13 14 10e-2
VS14 9 s14 0
L14 s14 1 10e-5
VS15 10 s15 0
L15 s15 8 12e-2
VS16 13 s16 0
C16 s16 2 39e-4
VS17 4 s17 0
V17 e17 s17 DC 0 AC 68e0 0
RI17 e17 5 22e-3
VS18 12 s18 0
V18 e18 s18 DC 0 AC 18e1 180
RI18 e18 10 12e-2
VS19 7 s19 0
L19 s19 10 82e-4
VS20 14 s20 0
L20 s20 1 33e-4
VS21 5 s21 0
R21 s21 12 22e0
VS22 0 s22 0
C22 s22 5 56e-5
VS23 10 s23 0
L23 s23 1 12e-3
VS24 7 s24 0
V24 e24 s24 DC 0 AC 82e0 -120
RI24 e24 5 39e-3
VS25 10 s25 0
L25 s25 3 82e-4
VS26 7 s26 0
C26 s26 4 56e-4
VS27 3 s27 0
R27 s27 18 33e2
VS28 15 s28 0
L28 s28 18 18e-3
VS29 12 s29 0
C29 s29 6 12e-4
VS30 15 s30 0
R30 s30 17 33e1
VS31 3 s31 0
R31 s31 0 39e3
.control
set numdgt=17
ac lin 1 60 60
print v(1) v(2) v(3) v(4) v(5) v(6) v(7) v(8) v(9) v(10)
print v(11) v(12) v(13) v(14) v(15) v(16) v(17) v(18)
print i(vs0) i(vs1) i(vs2) i(vs3) i(vs4) i(vs5) i(vs6) i(vs7) i(vs8) i(vs9)
print i(vs10) i(vs11) i(vs12) i(vs13) i(vs14) i(vs15) i(vs16) i(vs17) i(vs18) i(vs19)
print i(vs20) i(vs21) i(vs22) i(vs23) i(vs24) i(vs25) i(vs26) i(vs27) i(vs28) i(vs29)
print i(vs30) i(vs31)
.endc
.end
