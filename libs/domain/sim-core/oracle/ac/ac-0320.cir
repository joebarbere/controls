controls oracle ac-0320
* Generated (plan F2.7, ADR 0012): do not edit; regenerate with `pnpm sim oracle regen`. ac seed 20261031 index 320 nodes 3 elements 6
.options sparse gmin=1e-12 noopac
RG1 1 0 1000000000000
RG2 2 0 1000000000000
VS0 2 s0 0
L0 s0 1 18e-4
VS1 0 s1 0
V1 e1 s1 DC 0 AC 27e0 120
RI1 e1 2 33e-1
VS2 1 s2 0
L2 s2 0 12e-2
VS3 2 s3 0
R3 s3 0 39e3
VS4 1 s4 0
C4 s4 0 22e-4
VS5 2 s5 0
R5 s5 1 10e2
.control
set numdgt=17
ac lin 1 60 60
print v(1) v(2)
print i(vs0) i(vs1) i(vs2) i(vs3) i(vs4) i(vs5)
.endc
.end
