controls oracle ac-0298
* Generated (plan F2.7, ADR 0012): do not edit; regenerate with `pnpm sim oracle regen`. ac seed 20261031 index 298 nodes 10 elements 19
.options sparse gmin=1e-12 noopac
RG1 1 0 1000000000000
RG2 2 0 1000000000000
RG3 3 0 1000000000000
RG4 4 0 1000000000000
RG5 5 0 1000000000000
RG6 6 0 1000000000000
RG7 7 0 1000000000000
RG8 8 0 1000000000000
RG9 9 0 1000000000000
VS0 1 s0 0
C0 s0 5 12e-7
VS1 9 s1 0
C1 s1 8 18e-6
VS2 0 s2 0
V2 e2 s2 DC 0 AC 15e0 0
RI2 e2 9 39e-3
VS3 5 s3 0
L3 s3 4 15e-5
VS4 3 s4 0
C4 s4 7 39e-7
VS5 0 s5 0
V5 e5 s5 DC 0 AC 33e-1 -120
RI5 e5 4 18e-3
VS6 3 s6 0
V6 e6 s6 DC 0 AC 68e1 -120
RI6 e6 m6 33e-1
LI6 m6 0 12e-7
VS7 8 s7 0
V7 e7 s7 DC 0 AC 82e1 -120
RI7 e7 7 39e-2
VS8 7 s8 0
V8 e8 s8 DC 0 AC 33e-1 120
RI8 e8 m8 22e-2
LI8 m8 8 47e-5
VS9 9 s9 0
V9 e9 s9 DC 0 AC 68e1 0
RI9 e9 m9 18e-2
LI9 m9 7 39e-6
VS10 3 s10 0
R10 s10 0 10e3
VS11 7 s11 0
C11 s11 3 68e-6
VS12 9 s12 0
C12 s12 1 33e-7
VS13 6 s13 0
L13 s13 8 12e-4
VS14 9 s14 0
L14 s14 1 33e-2
VS15 9 s15 0
C15 s15 2 18e-4
VS16 8 s16 0
R16 s16 2 12e2
VS17 1 s17 0
V17 e17 s17 DC 0 AC 56e-1 120
RI17 e17 3 15e-1
VS18 6 s18 0
C18 s18 3 27e-6
.control
set numdgt=17
ac lin 1 60 60
print v(1) v(2) v(3) v(4) v(5) v(6) v(7) v(8) v(9)
print i(vs0) i(vs1) i(vs2) i(vs3) i(vs4) i(vs5) i(vs6) i(vs7) i(vs8) i(vs9)
print i(vs10) i(vs11) i(vs12) i(vs13) i(vs14) i(vs15) i(vs16) i(vs17) i(vs18)
.endc
.end
