controls oracle ac-0298
* Generated (plan F2.7, ADR 0012): do not edit; regenerate with `pnpm sim oracle regen`. ac seed 20261031 index 298 nodes 10 elements 21
.options sparse gmin=1e-12 noopac
RG1 1 0 1000000000000
RG2 2 0 1000000000000
RG3 3 0 1000000000000
RG4 4 0 1000000000000
RG5 5 0 1000000000000
RG6 6 0 1000000000000
RG7 7 0 1000000000000
RG8 8 0 1000000000000
RG9 9 0 1000000000000
VS0 3 s0 0
C0 s0 0 82e-5
VS1 1 s1 0
C1 s1 9 22e-7
VS2 4 s2 0
C2 s2 8 68e-5
VS3 7 s3 0
C3 s3 2 22e-5
VS4 8 s4 0
R4 s4 2 12e2
VS5 3 s5 0
C5 s5 6 56e-4
VS6 4 s6 0
L6 s6 5 82e-2
VS7 9 s7 0
R7 s7 4 15e3
VS8 0 s8 0
V8 e8 s8 DC 0 AC 56e-1 120
RI8 e8 m8 15e-1
LI8 m8 n8 10e-7
H8 n8 h8 VS9 -22e-3
ED8 h8 7 d8 0 -56e-6
F8 0 d8 VS9 1
LD8 d8 0 1
VS9 2 s9 0
V9 e9 s9 DC 0 AC 47e0 -120
RI9 e9 m9 68e-2
LI9 m9 n9 22e-5
H9 n9 h9 VS8 -22e-3
ED9 h9 8 d9 0 -56e-6
F9 0 d9 VS8 1
LD9 d9 0 1
VS10 5 s10 0
C10 s10 2 18e-4
VS11 3 s11 0
R11 s11 4 10e3
VS12 3 s12 0
V12 e12 s12 DC 0 AC 68e1 -120
RI12 e12 m12 33e-1
LI12 m12 4 68e-5
VS13 3 s13 0
C13 s13 7 39e-7
VS14 6 s14 0
R14 s14 8 12e1
VS15 3 s15 0
R15 s15 7 39e1
VS16 6 s16 0
R16 s16 1 56e-1
VS17 7 s17 0
V17 e17 s17 DC 0 AC 68e0 180
RI17 e17 6 18e-1
VS18 7 s18 0
C18 s18 3 68e-6
VS19 9 s19 0
C19 s19 1 33e-7
VS20 7 s20 0
V20 e20 s20 DC 0 AC 33e-1 120
RI20 e20 8 22e-2
.control
set numdgt=17
ac lin 1 60 60
print v(1) v(2) v(3) v(4) v(5) v(6) v(7) v(8) v(9)
print i(vs0) i(vs1) i(vs2) i(vs3) i(vs4) i(vs5) i(vs6) i(vs7) i(vs8) i(vs9)
print i(vs10) i(vs11) i(vs12) i(vs13) i(vs14) i(vs15) i(vs16) i(vs17) i(vs18) i(vs19)
print i(vs20)
.endc
.end
