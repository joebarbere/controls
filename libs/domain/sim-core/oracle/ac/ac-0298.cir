controls oracle ac-0298
* Generated (plan F2.7, ADR 0012): do not edit; regenerate with `pnpm sim oracle regen`. ac seed 20261031 index 298 nodes 10 elements 19
.options sparse gmin=1e-12 noopac
RG1 1 0 1000000000000
RG2 2 0 1000000000000
RG3 3 0 1000000000000
RG4 4 0 1000000000000
RG5 5 0 1000000000000
RG6 6 0 1000000000000
RG7 7 0 1000000000000
RG8 8 0 1000000000000
RG9 9 0 1000000000000
VS0 3 s0 0
R0 s0 7 10e3
VS1 0 s1 0
C1 s1 3 68e-6
VS2 8 s2 0
R2 s2 2 12e2
VS3 0 s3 0
V3 e3 s3 DC 0 AC 68e0 180
RI3 e3 6 18e-1
VS4 3 s4 0
C4 s4 6 56e-4
VS5 9 s5 0
R5 s5 7 15e3
VS6 6 s6 0
R6 s6 8 12e1
VS7 3 s7 0
C7 s7 4 82e-5
VS8 2 s8 0
V8 e8 s8 DC 0 AC 47e0 -120
RI8 e8 8 68e-2
VS9 1 s9 0
C9 s9 9 22e-7
VS10 5 s10 0
C10 s10 2 18e-4
VS11 0 s11 0
V11 e11 s11 DC 0 AC 33e-1 120
RI11 e11 8 22e-2
VS12 3 s12 0
C12 s12 0 39e-7
VS13 7 s13 0
L13 s13 5 82e-2
VS14 3 s14 0
V14 e14 s14 DC 0 AC 68e1 -120
RI14 e14 7 33e-1
VS15 7 s15 0
C15 s15 8 68e-5
VS16 9 s16 0
C16 s16 1 33e-7
VS17 3 s17 0
R17 s17 0 39e1
VS18 0 s18 0
C18 s18 2 22e-5
.control
set numdgt=17
ac lin 1 60 60
print v(1) v(2) v(3) v(4) v(5) v(6) v(7) v(8) v(9)
print i(vs0) i(vs1) i(vs2) i(vs3) i(vs4) i(vs5) i(vs6) i(vs7) i(vs8) i(vs9)
print i(vs10) i(vs11) i(vs12) i(vs13) i(vs14) i(vs15) i(vs16) i(vs17) i(vs18)
.endc
.end
