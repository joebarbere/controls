controls oracle ac-0423
* Generated (plan F2.7, ADR 0012): do not edit; regenerate with `pnpm sim oracle regen`. ac seed 20261031 index 423 nodes 25 elements 33
.options sparse gmin=1e-12 noopac
RG1 1 0 1000000000000
RG2 2 0 1000000000000
RG3 3 0 1000000000000
RG4 4 0 1000000000000
RG5 5 0 1000000000000
RG6 6 0 1000000000000
RG7 7 0 1000000000000
RG8 8 0 1000000000000
RG9 9 0 1000000000000
RG10 10 0 1000000000000
RG11 11 0 1000000000000
RG12 12 0 1000000000000
RG13 13 0 1000000000000
RG14 14 0 1000000000000
RG15 15 0 1000000000000
RG16 16 0 1000000000000
RG17 17 0 1000000000000
RG18 18 0 1000000000000
RG19 19 0 1000000000000
RG20 20 0 1000000000000
RG21 21 0 1000000000000
RG22 22 0 1000000000000
RG23 23 0 1000000000000
RG24 24 0 1000000000000
VS0 1 s0 0
R0 s0 17 18e2
VS1 23 s1 0
R1 s1 9 56e-2
VS2 16 s2 0
R2 s2 10 18e2
VS3 0 s3 0
V3 e3 s3 DC 0 AC 47e0 0
RI3 e3 4 33e-2
VS4 14 s4 0
L4 s4 13 27e-3
VS5 12 s5 0
R5 s5 22 22e-1
VS6 23 s6 0
C6 s6 8 18e-6
VS7 13 s7 0
C7 s7 11 15e-5
VS8 14 s8 0
L8 s8 6 56e-3
VS9 10 s9 0
C9 s9 16 27e-4
VS10 15 s10 0
R10 s10 13 27e3
VS11 8 s11 0
C11 s11 21 18e-5
VS12 23 s12 0
R12 s12 14 22e3
VS13 13 s13 0
C13 s13 14 68e-7
VS14 23 s14 0
C14 s14 13 68e-7
VS15 6 s15 0
L15 s15 22 56e-3
VS16 13 s16 0
C16 s16 10 18e-4
VS17 7 s17 0
L17 s17 13 18e-2
VS18 22 s18 0
R18 s18 13 18e0
VS19 0 s19 0
L19 s19 2 27e-4
VS20 24 s20 0
C20 s20 15 22e-6
VS21 13 s21 0
R21 s21 9 82e0
VS22 17 s22 0
R22 s22 10 82e3
VS23 20 s23 0
C23 s23 10 18e-6
VS24 4 s24 0
C24 s24 7 15e-4
VS25 0 s25 0
R25 s25 6 82e-2
VS26 23 s26 0
R26 s26 21 22e3
VS27 8 s27 0
V27 e27 s27 DC 0 AC 15e1 120
RI27 e27 21 10e-3
VS28 23 s28 0
V28 e28 s28 DC 0 AC 33e0 180
RI28 e28 18 27e-1
VS29 5 s29 0
L29 s29 14 27e-4
VS30 11 s30 0
R30 s30 10 18e3
VS31 6 s31 0
R31 s31 3 18e0
VS32 1 s32 0
L32 s32 19 27e-5
.control
set numdgt=17
ac lin 1 60 60
print v(1) v(2) v(3) v(4) v(5) v(6) v(7) v(8) v(9) v(10)
print v(11) v(12) v(13) v(14) v(15) v(16) v(17) v(18) v(19) v(20)
print v(21) v(22) v(23) v(24)
print i(vs0) i(vs1) i(vs2) i(vs3) i(vs4) i(vs5) i(vs6) i(vs7) i(vs8) i(vs9)
print i(vs10) i(vs11) i(vs12) i(vs13) i(vs14) i(vs15) i(vs16) i(vs17) i(vs18) i(vs19)
print i(vs20) i(vs21) i(vs22) i(vs23) i(vs24) i(vs25) i(vs26) i(vs27) i(vs28) i(vs29)
print i(vs30) i(vs31) i(vs32)
.endc
.end
