controls oracle ac-0423
* Generated (plan F2.7, ADR 0012): do not edit; regenerate with `pnpm sim oracle regen`. ac seed 20261031 index 423 nodes 25 elements 48
.options sparse gmin=1e-12 noopac
RG1 1 0 1000000000000
RG2 2 0 1000000000000
RG3 3 0 1000000000000
RG4 4 0 1000000000000
RG5 5 0 1000000000000
RG6 6 0 1000000000000
RG7 7 0 1000000000000
RG8 8 0 1000000000000
RG9 9 0 1000000000000
RG10 10 0 1000000000000
RG11 11 0 1000000000000
RG12 12 0 1000000000000
RG13 13 0 1000000000000
RG14 14 0 1000000000000
RG15 15 0 1000000000000
RG16 16 0 1000000000000
RG17 17 0 1000000000000
RG18 18 0 1000000000000
RG19 19 0 1000000000000
RG20 20 0 1000000000000
RG21 21 0 1000000000000
RG22 22 0 1000000000000
RG23 23 0 1000000000000
RG24 24 0 1000000000000
VS0 0 s0 0
V0 e0 s0 DC 0 AC 47e0 -120
RI0 e0 13 27e-1
VS1 0 s1 0
V1 e1 s1 DC 0 AC 82e0 0
RI1 e1 m1 27e-2
LI1 m1 20 68e-5
VS2 16 s2 0
R2 s2 10 18e2
VS3 21 s3 0
R3 s3 13 68e0
VS4 23 s4 0
R4 s4 14 22e3
VS5 7 s5 0
L5 s5 22 18e-2
VS6 22 s6 0
R6 s6 18 82e-2
VS7 15 s7 0
R7 s7 20 56e0
VS8 22 s8 0
C8 s8 10 18e-4
VS9 11 s9 0
L9 s9 13 68e-3
VS10 12 s10 0
R10 s10 15 68e-1
VS11 5 s11 0
R11 s11 0 15e0
VS12 12 s12 0
R12 s12 18 22e0
VS13 9 s13 0
L13 s13 5 82e-5
VS14 19 s14 0
C14 s14 15 82e-5
VS15 0 s15 0
C15 s15 24 82e-4
VS16 6 s16 0
R16 s16 13 39e2
VS17 14 s17 0
C17 s17 24 15e-6
VS18 20 s18 0
R18 s18 21 47e0
VS19 23 s19 0
R19 s19 5 82e-2
VS20 13 s20 0
L20 s20 1 12e-5
VS21 23 s21 0
R21 s21 11 39e1
VS22 10 s22 0
R22 s22 21 22e1
VS23 4 s23 0
C23 s23 7 15e-4
VS24 16 s24 0
R24 s24 10 47e-2
VS25 14 s25 0
V25 e25 s25 DC 0 AC 47e-1 -120
RI25 e25 m25 10e-1
LI25 m25 15 22e-5
VS26 2 s26 0
R26 s26 15 22e1
VS27 4 s27 0
R27 s27 0 47e-2
VS28 15 s28 0
R28 s28 1 12e1
VS29 21 s29 0
L29 s29 6 10e-4
VS30 8 s30 0
R30 s30 20 39e-1
VS31 13 s31 0
V31 e31 s31 DC 0 AC 47e0 0
RI31 e31 m31 33e-2
LI31 m31 4 47e-6
VS32 15 s32 0
R32 s32 22 27e3
VS33 6 s33 0
L33 s33 9 15e-3
VS34 21 s34 0
R34 s34 8 15e-1
VS35 23 s35 0
C35 s35 22 68e-7
VS36 21 s36 0
L36 s36 23 15e-2
VS37 0 s37 0
R37 s37 3 27e1
VS38 8 s38 0
V38 e38 s38 DC 0 AC 15e1 120
RI38 e38 21 10e-3
VS39 18 s39 0
L39 s39 4 47e-3
VS40 10 s40 0
C40 s40 16 27e-4
VS41 16 s41 0
L41 s41 2 10e-5
VS42 17 s42 0
L42 s42 15 47e-4
VS43 19 s43 0
R43 s43 14 56e-2
VS44 0 s44 0
L44 s44 7 33e-3
VS45 24 s45 0
L45 s45 17 12e-5
VS46 23 s46 0
C46 s46 8 18e-6
VS47 22 s47 0
C47 s47 3 12e-5
.control
set numdgt=17
ac lin 1 60 60
print v(1) v(2) v(3) v(4) v(5) v(6) v(7) v(8) v(9) v(10)
print v(11) v(12) v(13) v(14) v(15) v(16) v(17) v(18) v(19) v(20)
print v(21) v(22) v(23) v(24)
print i(vs0) i(vs1) i(vs2) i(vs3) i(vs4) i(vs5) i(vs6) i(vs7) i(vs8) i(vs9)
print i(vs10) i(vs11) i(vs12) i(vs13) i(vs14) i(vs15) i(vs16) i(vs17) i(vs18) i(vs19)
print i(vs20) i(vs21) i(vs22) i(vs23) i(vs24) i(vs25) i(vs26) i(vs27) i(vs28) i(vs29)
print i(vs30) i(vs31) i(vs32) i(vs33) i(vs34) i(vs35) i(vs36) i(vs37) i(vs38) i(vs39)
print i(vs40) i(vs41) i(vs42) i(vs43) i(vs44) i(vs45) i(vs46) i(vs47)
.endc
.end
