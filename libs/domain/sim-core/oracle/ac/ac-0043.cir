controls oracle ac-0043
* Generated (plan F2.7, ADR 0012): do not edit; regenerate with `pnpm sim oracle regen`. ac seed 20261031 index 43 nodes 3 elements 5
.options sparse gmin=1e-12 noopac
RG1 1 0 1000000000000
RG2 2 0 1000000000000
VS0 1 s0 0
C0 s0 2 22e-6
VS1 0 s1 0
V1 e1 s1 DC 0 AC 39e1 120
RI1 e1 1 33e-3
VS2 0 s2 0
V2 e2 s2 DC 0 AC 39e1 180
RI2 e2 2 12e-3
VS3 1 s3 0
V3 e3 s3 DC 0 AC 68e0 0
RI3 e3 m3 33e-1
LI3 m3 0 22e-7
VS4 1 s4 0
V4 e4 s4 DC 0 AC 68e-1 0
RI4 e4 0 82e-2
.control
set numdgt=17
ac lin 1 60 60
print v(1) v(2)
print i(vs0) i(vs1) i(vs2) i(vs3) i(vs4)
.endc
.end
