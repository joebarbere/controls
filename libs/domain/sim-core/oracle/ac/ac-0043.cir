controls oracle ac-0043
* Generated (plan F2.7, ADR 0012): do not edit; regenerate with `pnpm sim oracle regen`. ac seed 20261031 index 43 nodes 3 elements 3
.options sparse gmin=1e-12 noopac
RG1 1 0 1000000000000
RG2 2 0 1000000000000
VS0 0 s0 0
V0 e0 s0 DC 0 AC 39e1 180
RI0 e0 2 12e-3
VS1 2 s1 0
R1 s1 1 56e3
VS2 0 s2 0
R2 s2 1 33e2
.control
set numdgt=17
ac lin 1 60 60
print v(1) v(2)
print i(vs0) i(vs1) i(vs2)
.endc
.end
