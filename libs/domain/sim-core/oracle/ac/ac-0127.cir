controls oracle ac-0127
* Generated (plan F2.7, ADR 0012): do not edit; regenerate with `pnpm sim oracle regen`. ac seed 20261031 index 127 nodes 6 elements 9
.options sparse gmin=1e-12 noopac
RG1 1 0 1000000000000
RG2 2 0 1000000000000
RG3 3 0 1000000000000
RG4 4 0 1000000000000
RG5 5 0 1000000000000
VS0 5 s0 0
C0 s0 0 68e-4
VS1 0 s1 0
V1 e1 s1 DC 0 AC 22e1 180
RI1 e1 m1 22e-3
LI1 m1 1 10e-5
VS2 5 s2 0
R2 s2 2 33e-1
VS3 3 s3 0
L3 s3 4 15e-2
VS4 4 s4 0
C4 s4 2 22e-6
VS5 4 s5 0
R5 s5 1 15e-1
VS6 5 s6 0
L6 s6 3 39e-5
VS7 3 s7 0
C7 s7 2 12e-7
VS8 5 s8 0
V8 e8 s8 DC 0 AC 33e-1 -120
RI8 e8 4 82e-1
.control
set numdgt=17
ac lin 1 60 60
print v(1) v(2) v(3) v(4) v(5)
print i(vs0) i(vs1) i(vs2) i(vs3) i(vs4) i(vs5) i(vs6) i(vs7) i(vs8)
.endc
.end
