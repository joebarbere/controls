controls oracle ac-0305
* Generated (plan F2.7, ADR 0012): do not edit; regenerate with `pnpm sim oracle regen`. ac seed 20261031 index 305 nodes 2 elements 4
.options sparse gmin=1e-12 noopac
RG1 1 0 1000000000000
VS0 0 s0 0
C0 s0 1 22e-6
VS1 0 s1 0
V1 e1 s1 DC 0 AC 39e0 180
RI1 e1 m1 33e-1
LI1 m1 1 68e-5
VS2 0 s2 0
R2 s2 1 47e-2
VS3 0 s3 0
R3 s3 1 33e2
.control
set numdgt=17
ac lin 1 60 60
print v(1)
print i(vs0) i(vs1) i(vs2) i(vs3)
.endc
.end
