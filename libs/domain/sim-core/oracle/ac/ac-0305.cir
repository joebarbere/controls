controls oracle ac-0305
* Generated (plan F2.7, ADR 0012): do not edit; regenerate with `pnpm sim oracle regen`. ac seed 20261031 index 305 nodes 2 elements 4
.options sparse gmin=1e-12 noopac
RG1 1 0 1000000000000
VS0 0 s0 0
R0 s0 1 47e-2
VS1 0 s1 0
R1 s1 1 33e2
VS2 0 s2 0
C2 s2 1 22e-6
VS3 0 s3 0
V3 e3 s3 DC 0 AC 39e0 180
RI3 e3 m3 33e-1
LI3 m3 1 68e-6
.control
set numdgt=17
ac lin 1 60 60
print v(1)
print i(vs0) i(vs1) i(vs2) i(vs3)
.endc
.end
