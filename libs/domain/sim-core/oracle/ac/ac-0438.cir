controls oracle ac-0438
* Generated (plan F2.7, ADR 0012): do not edit; regenerate with `pnpm sim oracle regen`. ac seed 20261031 index 438 nodes 28 elements 38
.options sparse gmin=1e-12 noopac
RG1 1 0 1000000000000
RG2 2 0 1000000000000
RG3 3 0 1000000000000
RG4 4 0 1000000000000
RG5 5 0 1000000000000
RG6 6 0 1000000000000
RG7 7 0 1000000000000
RG8 8 0 1000000000000
RG9 9 0 1000000000000
RG10 10 0 1000000000000
RG11 11 0 1000000000000
RG12 12 0 1000000000000
RG13 13 0 1000000000000
RG14 14 0 1000000000000
RG15 15 0 1000000000000
RG16 16 0 1000000000000
RG17 17 0 1000000000000
RG18 18 0 1000000000000
RG19 19 0 1000000000000
RG20 20 0 1000000000000
RG21 21 0 1000000000000
RG22 22 0 1000000000000
RG23 23 0 1000000000000
RG24 24 0 1000000000000
RG25 25 0 1000000000000
RG26 26 0 1000000000000
RG27 27 0 1000000000000
VS0 23 s0 0
R0 s0 3 12e0
VS1 5 s1 0
L1 s1 19 15e-4
VS2 19 s2 0
L2 s2 10 22e-5
VS3 8 s3 0
R3 s3 1 22e2
VS4 0 s4 0
V4 e4 s4 DC 0 AC 39e-1 120
RI4 e4 m4 47e-2
LI4 m4 n4 56e-6
H4 n4 h4 VS7 -39e-4
ED4 h4 16 d4 0 -27e-6
F4 0 d4 VS7 1
LD4 d4 0 1
VS5 7 s5 0
R5 s5 15 47e-2
VS6 2 s6 0
R6 s6 25 12e-2
VS7 23 s7 0
V7 e7 s7 DC 0 AC 47e-1 0
RI7 e7 n7 27e-3
H7 n7 h7 VS4 -39e-4
ED7 h7 11 d7 0 -27e-6
F7 0 d7 VS4 1
LD7 d7 0 1
VS8 14 s8 0
R8 s8 18 15e3
VS9 0 s9 0
R9 s9 8 27e-1
VS10 20 s10 0
L10 s10 27 56e-2
VS11 11 s11 0
R11 s11 7 15e-1
VS12 6 s12 0
R12 s12 25 27e2
VS13 18 s13 0
R13 s13 22 82e2
VS14 18 s14 0
R14 s14 19 39e3
VS15 16 s15 0
C15 s15 26 82e-5
VS16 18 s16 0
V16 e16 s16 DC 0 AC 12e1 120
RI16 e16 m16 39e-2
LI16 m16 23 33e-7
VS17 12 s17 0
V17 e17 s17 DC 0 AC 39e-1 120
RI17 e17 m17 22e-1
LI17 m17 23 22e-6
VS18 10 s18 0
V18 e18 s18 DC 0 AC 68e1 -120
RI18 e18 27 68e-2
VS19 26 s19 0
R19 s19 25 39e-1
VS20 5 s20 0
V20 e20 s20 DC 0 AC 27e-1 -120
RI20 e20 m20 12e-3
LI20 m20 11 10e-5
VS21 2 s21 0
L21 s21 4 18e-4
VS22 17 s22 0
V22 e22 s22 DC 0 AC 10e1 -120
RI22 e22 m22 68e-3
LI22 m22 24 33e-5
VS23 14 s23 0
C23 s23 16 68e-6
VS24 15 s24 0
R24 s24 17 10e-2
VS25 26 s25 0
C25 s25 13 82e-4
VS26 3 s26 0
L26 s26 9 27e-3
VS27 21 s27 0
C27 s27 19 39e-6
VS28 9 s28 0
L28 s28 23 18e-3
VS29 4 s29 0
R29 s29 19 27e-2
VS30 9 s30 0
V30 e30 s30 DC 0 AC 27e0 180
RI30 e30 m30 39e-3
LI30 m30 1 33e-6
VS31 21 s31 0
V31 e31 s31 DC 0 AC 18e0 180
RI31 e31 20 12e-2
VS32 6 s32 0
L32 s32 22 82e-5
VS33 13 s33 0
R33 s33 22 10e3
VS34 15 s34 0
L34 s34 19 47e-4
VS35 7 s35 0
R35 s35 12 10e0
VS36 20 s36 0
R36 s36 1 27e3
VS37 24 s37 0
V37 e37 s37 DC 0 AC 82e1 0
RI37 e37 m37 22e-1
LI37 m37 7 27e-5
.control
set numdgt=17
ac lin 1 60 60
print v(1) v(2) v(3) v(4) v(5) v(6) v(7) v(8) v(9) v(10)
print v(11) v(12) v(13) v(14) v(15) v(16) v(17) v(18) v(19) v(20)
print v(21) v(22) v(23) v(24) v(25) v(26) v(27)
print i(vs0) i(vs1) i(vs2) i(vs3) i(vs4) i(vs5) i(vs6) i(vs7) i(vs8) i(vs9)
print i(vs10) i(vs11) i(vs12) i(vs13) i(vs14) i(vs15) i(vs16) i(vs17) i(vs18) i(vs19)
print i(vs20) i(vs21) i(vs22) i(vs23) i(vs24) i(vs25) i(vs26) i(vs27) i(vs28) i(vs29)
print i(vs30) i(vs31) i(vs32) i(vs33) i(vs34) i(vs35) i(vs36) i(vs37)
.endc
.end
