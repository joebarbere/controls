controls oracle ac-0438
* Generated (plan F2.7, ADR 0012): do not edit; regenerate with `pnpm sim oracle regen`. ac seed 20261031 index 438 nodes 28 elements 28
.options sparse gmin=1e-12 noopac
RG1 1 0 1000000000000
RG2 2 0 1000000000000
RG3 3 0 1000000000000
RG4 4 0 1000000000000
RG5 5 0 1000000000000
RG6 6 0 1000000000000
RG7 7 0 1000000000000
RG8 8 0 1000000000000
RG9 9 0 1000000000000
RG10 10 0 1000000000000
RG11 11 0 1000000000000
RG12 12 0 1000000000000
RG13 13 0 1000000000000
RG14 14 0 1000000000000
RG15 15 0 1000000000000
RG16 16 0 1000000000000
RG17 17 0 1000000000000
RG18 18 0 1000000000000
RG19 19 0 1000000000000
RG20 20 0 1000000000000
RG21 21 0 1000000000000
RG22 22 0 1000000000000
RG23 23 0 1000000000000
RG24 24 0 1000000000000
RG25 25 0 1000000000000
RG26 26 0 1000000000000
RG27 27 0 1000000000000
VS0 26 s0 0
C0 s0 13 82e-4
VS1 11 s1 0
R1 s1 7 15e-1
VS2 6 s2 0
R2 s2 25 27e2
VS3 8 s3 0
R3 s3 1 22e2
VS4 0 s4 0
V4 e4 s4 DC 0 AC 47e-1 0
RI4 e4 11 27e-3
VS5 16 s5 0
C5 s5 26 82e-5
VS6 23 s6 0
L6 s6 0 10e-4
VS7 12 s7 0
V7 e7 s7 DC 0 AC 39e-1 120
RI7 e7 0 22e-1
VS8 15 s8 0
R8 s8 17 10e-2
VS9 23 s9 0
R9 s9 22 82e2
VS10 21 s10 0
V10 e10 s10 DC 0 AC 18e0 180
RI10 e10 20 12e-2
VS11 10 s11 0
V11 e11 s11 DC 0 AC 68e1 -120
RI11 e11 27 68e-2
VS12 26 s12 0
R12 s12 25 39e-1
VS13 9 s13 0
L13 s13 0 18e-3
VS14 5 s14 0
L14 s14 19 15e-4
VS15 2 s15 0
L15 s15 4 18e-4
VS16 7 s16 0
R16 s16 15 47e-2
VS17 18 s17 0
R17 s17 8 27e-1
VS18 20 s18 0
R18 s18 1 27e3
VS19 14 s19 0
R19 s19 23 15e3
VS20 23 s20 0
V20 e20 s20 DC 0 AC 12e1 120
RI20 e20 0 39e-2
VS21 20 s21 0
L21 s21 27 56e-2
VS22 3 s22 0
L22 s22 9 27e-3
VS23 19 s23 0
L23 s23 10 22e-5
VS24 4 s24 0
R24 s24 19 27e-2
VS25 23 s25 0
R25 s25 19 39e3
VS26 24 s26 0
V26 e26 s26 DC 0 AC 82e1 0
RI26 e26 7 22e-1
VS27 2 s27 0
R27 s27 25 12e-2
.control
set numdgt=17
ac lin 1 60 60
print v(1) v(2) v(3) v(4) v(5) v(6) v(7) v(8) v(9) v(10)
print v(11) v(12) v(13) v(14) v(15) v(16) v(17) v(18) v(19) v(20)
print v(21) v(22) v(23) v(24) v(25) v(26) v(27)
print i(vs0) i(vs1) i(vs2) i(vs3) i(vs4) i(vs5) i(vs6) i(vs7) i(vs8) i(vs9)
print i(vs10) i(vs11) i(vs12) i(vs13) i(vs14) i(vs15) i(vs16) i(vs17) i(vs18) i(vs19)
print i(vs20) i(vs21) i(vs22) i(vs23) i(vs24) i(vs25) i(vs26) i(vs27)
.endc
.end
