controls oracle ac-0205
* Generated (plan F2.7, ADR 0012): do not edit; regenerate with `pnpm sim oracle regen`. ac seed 20261031 index 205 nodes 17 elements 33
.options sparse gmin=1e-12 noopac
RG1 1 0 1000000000000
RG2 2 0 1000000000000
RG3 3 0 1000000000000
RG4 4 0 1000000000000
RG5 5 0 1000000000000
RG6 6 0 1000000000000
RG7 7 0 1000000000000
RG8 8 0 1000000000000
RG9 9 0 1000000000000
RG10 10 0 1000000000000
RG11 11 0 1000000000000
RG12 12 0 1000000000000
RG13 13 0 1000000000000
RG14 14 0 1000000000000
RG15 15 0 1000000000000
RG16 16 0 1000000000000
VS0 8 s0 0
L0 s0 2 15e-5
VS1 10 s1 0
C1 s1 11 82e-4
VS2 6 s2 0
R2 s2 11 22e3
VS3 13 s3 0
R3 s3 6 15e-2
VS4 9 s4 0
R4 s4 11 47e-2
VS5 0 s5 0
V5 e5 s5 DC 0 AC 82e-1 120
RI5 e5 n5 10e-3
H5 n5 h5 VS6 27e-4
ED5 h5 10 d5 0 -47e-5
F5 0 d5 VS6 1
LD5 d5 0 1
VS6 3 s6 0
V6 e6 s6 DC 0 AC 15e1 0
RI6 e6 n6 12e-2
H6 n6 h6 VS5 27e-4
ED6 h6 13 d6 0 -47e-5
F6 0 d6 VS5 1
LD6 d6 0 1
VS7 6 s7 0
R7 s7 13 39e2
VS8 5 s8 0
R8 s8 3 10e2
VS9 6 s9 0
C9 s9 10 18e-7
VS10 15 s10 0
L10 s10 5 39e-3
VS11 12 s11 0
L11 s11 14 18e-5
VS12 4 s12 0
C12 s12 5 39e-6
VS13 0 s13 0
V13 e13 s13 DC 0 AC 10e1 -120
RI13 e13 m13 39e-2
LI13 m13 3 10e-6
VS14 9 s14 0
R14 s14 15 56e1
VS15 11 s15 0
V15 e15 s15 DC 0 AC 82e1 180
RI15 e15 13 56e-3
VS16 16 s16 0
R16 s16 15 15e2
VS17 7 s17 0
V17 e17 s17 DC 0 AC 47e-1 -120
RI17 e17 12 18e-2
VS18 8 s18 0
R18 s18 4 22e-2
VS19 6 s19 0
R19 s19 7 47e3
VS20 1 s20 0
R20 s20 16 33e3
VS21 2 s21 0
V21 e21 s21 DC 0 AC 82e0 -120
RI21 e21 m21 39e-3
LI21 m21 16 56e-5
VS22 12 s22 0
C22 s22 14 18e-5
VS23 15 s23 0
L23 s23 6 68e-3
VS24 2 s24 0
V24 e24 s24 DC 0 AC 12e-1 -120
RI24 e24 m24 33e-3
LI24 m24 3 33e-6
VS25 13 s25 0
V25 e25 s25 DC 0 AC 82e1 180
RI25 e25 3 39e-2
VS26 14 s26 0
L26 s26 6 82e-5
VS27 6 s27 0
L27 s27 2 27e-5
VS28 12 s28 0
C28 s28 3 18e-5
VS29 3 s29 0
L29 s29 5 68e-3
VS30 4 s30 0
V30 e30 s30 DC 0 AC 12e-1 0
RI30 e30 m30 22e-1
LI30 m30 16 68e-7
VS31 1 s31 0
L31 s31 6 39e-5
VS32 3 s32 0
L32 s32 1 22e-2
.control
set numdgt=17
ac lin 1 60 60
print v(1) v(2) v(3) v(4) v(5) v(6) v(7) v(8) v(9) v(10)
print v(11) v(12) v(13) v(14) v(15) v(16)
print i(vs0) i(vs1) i(vs2) i(vs3) i(vs4) i(vs5) i(vs6) i(vs7) i(vs8) i(vs9)
print i(vs10) i(vs11) i(vs12) i(vs13) i(vs14) i(vs15) i(vs16) i(vs17) i(vs18) i(vs19)
print i(vs20) i(vs21) i(vs22) i(vs23) i(vs24) i(vs25) i(vs26) i(vs27) i(vs28) i(vs29)
print i(vs30) i(vs31) i(vs32)
.endc
.end
