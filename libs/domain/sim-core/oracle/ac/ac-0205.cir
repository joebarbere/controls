controls oracle ac-0205
* Generated (plan F2.7, ADR 0012): do not edit; regenerate with `pnpm sim oracle regen`. ac seed 20261031 index 205 nodes 17 elements 32
.options sparse gmin=1e-12 noopac
RG1 1 0 1000000000000
RG2 2 0 1000000000000
RG3 3 0 1000000000000
RG4 4 0 1000000000000
RG5 5 0 1000000000000
RG6 6 0 1000000000000
RG7 7 0 1000000000000
RG8 8 0 1000000000000
RG9 9 0 1000000000000
RG10 10 0 1000000000000
RG11 11 0 1000000000000
RG12 12 0 1000000000000
RG13 13 0 1000000000000
RG14 14 0 1000000000000
RG15 15 0 1000000000000
RG16 16 0 1000000000000
VS0 0 s0 0
V0 e0 s0 DC 0 AC 82e1 180
RI0 e0 3 39e-2
VS1 3 s1 0
L1 s1 1 22e-2
VS2 1 s2 0
R2 s2 16 33e3
VS3 13 s3 0
R3 s3 7 47e3
VS4 7 s4 0
V4 e4 s4 DC 0 AC 47e-1 -120
RI4 e4 12 18e-2
VS5 2 s5 0
V5 e5 s5 DC 0 AC 12e-1 -120
RI5 e5 3 33e-3
VS6 6 s6 0
V6 e6 s6 DC 0 AC 82e-1 120
RI6 e6 10 10e-3
VS7 9 s7 0
R7 s7 11 47e-2
VS8 2 s8 0
V8 e8 s8 DC 0 AC 82e0 -120
RI8 e8 16 39e-3
VS9 15 s9 0
L9 s9 13 68e-3
VS10 13 s10 0
R10 s10 11 22e3
VS11 1 s11 0
L11 s11 13 39e-5
VS12 14 s12 0
L12 s12 13 82e-5
VS13 12 s13 0
C13 s13 14 18e-5
VS14 16 s14 0
R14 s14 15 15e2
VS15 8 s15 0
L15 s15 2 15e-5
VS16 3 s16 0
L16 s16 5 68e-3
VS17 13 s17 0
L17 s17 2 27e-5
VS18 6 s18 0
V18 e18 s18 DC 0 AC 10e1 -120
RI18 e18 3 39e-2
VS19 5 s19 0
R19 s19 3 10e2
VS20 13 s20 0
R20 s20 0 39e2
VS21 13 s21 0
C21 s21 10 18e-7
VS22 3 s22 0
V22 e22 s22 DC 0 AC 15e1 0
RI22 e22 0 12e-2
VS23 4 s23 0
V23 e23 s23 DC 0 AC 12e-1 0
RI23 e23 16 22e-1
VS24 15 s24 0
L24 s24 5 39e-3
VS25 11 s25 0
V25 e25 s25 DC 0 AC 82e1 180
RI25 e25 0 56e-3
VS26 4 s26 0
C26 s26 5 39e-6
VS27 0 s27 0
R27 s27 13 15e-2
VS28 10 s28 0
C28 s28 11 82e-4
VS29 9 s29 0
R29 s29 15 56e1
VS30 12 s30 0
C30 s30 3 18e-5
VS31 12 s31 0
L31 s31 14 18e-5
.control
set numdgt=17
ac lin 1 60 60
print v(1) v(2) v(3) v(4) v(5) v(6) v(7) v(8) v(9) v(10)
print v(11) v(12) v(13) v(14) v(15) v(16)
print i(vs0) i(vs1) i(vs2) i(vs3) i(vs4) i(vs5) i(vs6) i(vs7) i(vs8) i(vs9)
print i(vs10) i(vs11) i(vs12) i(vs13) i(vs14) i(vs15) i(vs16) i(vs17) i(vs18) i(vs19)
print i(vs20) i(vs21) i(vs22) i(vs23) i(vs24) i(vs25) i(vs26) i(vs27) i(vs28) i(vs29)
print i(vs30) i(vs31)
.endc
.end
