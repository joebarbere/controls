controls oracle ac-0205
* Generated (plan F2.7, ADR 0012): do not edit; regenerate with `pnpm sim oracle regen`. ac seed 20261031 index 205 nodes 17 elements 32
.options sparse gmin=1e-12 noopac
RG1 1 0 1000000000000
RG2 2 0 1000000000000
RG3 3 0 1000000000000
RG4 4 0 1000000000000
RG5 5 0 1000000000000
RG6 6 0 1000000000000
RG7 7 0 1000000000000
RG8 8 0 1000000000000
RG9 9 0 1000000000000
RG10 10 0 1000000000000
RG11 11 0 1000000000000
RG12 12 0 1000000000000
RG13 13 0 1000000000000
RG14 14 0 1000000000000
RG15 15 0 1000000000000
RG16 16 0 1000000000000
VS0 4 s0 0
C0 s0 12 56e-7
VS1 11 s1 0
L1 s1 13 39e-3
VS2 0 s2 0
V2 e2 s2 DC 0 AC 10e-1 180
RI2 e2 m2 33e-1
LI2 m2 13 82e-5
VS3 8 s3 0
R3 s3 11 22e3
VS4 4 s4 0
L4 s4 9 56e-2
VS5 1 s5 0
R5 s5 16 12e0
VS6 0 s6 0
C6 s6 12 56e-4
VS7 3 s7 0
L7 s7 6 12e-3
VS8 14 s8 0
L8 s8 8 82e-5
VS9 13 s9 0
V9 e9 s9 DC 0 AC 18e1 0
RI9 e9 15 10e-2
VS10 13 s10 0
R10 s10 8 15e-2
VS11 6 s11 0
R11 s11 11 39e-1
VS12 15 s12 0
L12 s12 8 68e-3
VS13 15 s13 0
R13 s13 10 10e1
VS14 4 s14 0
R14 s14 15 33e-2
VS15 7 s15 0
R15 s15 9 47e0
VS16 2 s16 0
L16 s16 4 22e-5
VS17 1 s17 0
L17 s17 8 39e-5
VS18 16 s18 0
R18 s18 15 15e2
VS19 12 s19 0
V19 e19 s19 DC 0 AC 33e0 120
RI19 e19 m19 82e-2
LI19 m19 8 18e-6
VS20 3 s20 0
V20 e20 s20 DC 0 AC 33e-1 -120
RI20 e20 m20 39e-1
LI20 m20 0 82e-7
VS21 16 s21 0
V21 e21 s21 DC 0 AC 18e1 120
RI21 e21 0 56e-1
VS22 15 s22 0
L22 s22 5 39e-3
VS23 10 s23 0
C23 s23 12 82e-6
VS24 8 s24 0
R24 s24 7 47e3
VS25 3 s25 0
V25 e25 s25 DC 0 AC 15e1 0
RI25 e25 m25 12e-2
LI25 m25 13 68e-5
VS26 14 s26 0
V26 e26 s26 DC 0 AC 39e1 0
RI26 e26 m26 56e-2
LI26 m26 9 68e-7
VS27 2 s27 0
V27 e27 s27 DC 0 AC 82e0 -120
RI27 e27 16 39e-3
VS28 9 s28 0
R28 s28 15 56e1
VS29 8 s29 0
V29 e29 s29 DC 0 AC 56e0 -120
RI29 e29 9 22e-1
VS30 12 s30 0
L30 s30 5 68e-4
VS31 6 s31 0
C31 s31 14 18e-5
.control
set numdgt=17
ac lin 1 60 60
print v(1) v(2) v(3) v(4) v(5) v(6) v(7) v(8) v(9) v(10)
print v(11) v(12) v(13) v(14) v(15) v(16)
print i(vs0) i(vs1) i(vs2) i(vs3) i(vs4) i(vs5) i(vs6) i(vs7) i(vs8) i(vs9)
print i(vs10) i(vs11) i(vs12) i(vs13) i(vs14) i(vs15) i(vs16) i(vs17) i(vs18) i(vs19)
print i(vs20) i(vs21) i(vs22) i(vs23) i(vs24) i(vs25) i(vs26) i(vs27) i(vs28) i(vs29)
print i(vs30) i(vs31)
.endc
.end
