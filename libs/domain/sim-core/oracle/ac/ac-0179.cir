controls oracle ac-0179
* Generated (plan F2.7, ADR 0012): do not edit; regenerate with `pnpm sim oracle regen`. ac seed 20261031 index 179 nodes 18 elements 34
.options sparse gmin=1e-12 noopac
RG1 1 0 1000000000000
RG2 2 0 1000000000000
RG3 3 0 1000000000000
RG4 4 0 1000000000000
RG5 5 0 1000000000000
RG6 6 0 1000000000000
RG7 7 0 1000000000000
RG8 8 0 1000000000000
RG9 9 0 1000000000000
RG10 10 0 1000000000000
RG11 11 0 1000000000000
RG12 12 0 1000000000000
RG13 13 0 1000000000000
RG14 14 0 1000000000000
RG15 15 0 1000000000000
RG16 16 0 1000000000000
RG17 17 0 1000000000000
VS0 14 s0 0
L0 s0 11 18e-4
VS1 6 s1 0
R1 s1 3 15e-1
VS2 2 s2 0
R2 s2 1 68e1
VS3 8 s3 0
R3 s3 4 27e3
VS4 3 s4 0
R4 s4 12 47e0
VS5 7 s5 0
L5 s5 8 33e-2
VS6 0 s6 0
V6 e6 s6 DC 0 AC 68e0 -120
RI6 e6 16 15e-3
VS7 16 s7 0
C7 s7 3 15e-6
VS8 5 s8 0
C8 s8 16 15e-4
VS9 13 s9 0
R9 s9 16 22e-2
VS10 10 s10 0
C10 s10 9 33e-4
VS11 16 s11 0
C11 s11 2 22e-4
VS12 12 s12 0
R12 s12 16 82e3
VS13 0 s13 0
R13 s13 17 82e0
VS14 15 s14 0
L14 s14 8 33e-4
VS15 11 s15 0
C15 s15 0 15e-5
VS16 7 s16 0
V16 e16 s16 DC 0 AC 10e-1 0
RI16 e16 10 12e-3
VS17 13 s17 0
R17 s17 3 33e1
VS18 9 s18 0
L18 s18 13 82e-5
VS19 2 s19 0
C19 s19 0 82e-6
VS20 10 s20 0
V20 e20 s20 DC 0 AC 22e-1 -120
RI20 e20 1 39e-2
VS21 3 s21 0
L21 s21 12 12e-5
VS22 1 s22 0
C22 s22 14 27e-6
VS23 6 s23 0
R23 s23 13 56e1
VS24 16 s24 0
L24 s24 8 18e-2
VS25 16 s25 0
L25 s25 12 18e-5
VS26 15 s26 0
C26 s26 2 10e-5
VS27 2 s27 0
C27 s27 17 68e-4
VS28 1 s28 0
C28 s28 2 10e-4
VS29 5 s29 0
R29 s29 6 82e1
VS30 7 s30 0
L30 s30 3 12e-3
VS31 13 s31 0
L31 s31 6 33e-5
VS32 0 s32 0
V32 e32 s32 DC 0 AC 47e1 180
RI32 e32 4 33e-1
VS33 14 s33 0
L33 s33 3 68e-4
.control
set numdgt=17
ac lin 1 60 60
print v(1) v(2) v(3) v(4) v(5) v(6) v(7) v(8) v(9) v(10)
print v(11) v(12) v(13) v(14) v(15) v(16) v(17)
print i(vs0) i(vs1) i(vs2) i(vs3) i(vs4) i(vs5) i(vs6) i(vs7) i(vs8) i(vs9)
print i(vs10) i(vs11) i(vs12) i(vs13) i(vs14) i(vs15) i(vs16) i(vs17) i(vs18) i(vs19)
print i(vs20) i(vs21) i(vs22) i(vs23) i(vs24) i(vs25) i(vs26) i(vs27) i(vs28) i(vs29)
print i(vs30) i(vs31) i(vs32) i(vs33)
.endc
.end
