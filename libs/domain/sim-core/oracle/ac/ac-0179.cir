controls oracle ac-0179
* Generated (plan F2.7, ADR 0012): do not edit; regenerate with `pnpm sim oracle regen`. ac seed 20261031 index 179 nodes 18 elements 26
.options sparse gmin=1e-12 noopac
RG1 1 0 1000000000000
RG2 2 0 1000000000000
RG3 3 0 1000000000000
RG4 4 0 1000000000000
RG5 5 0 1000000000000
RG6 6 0 1000000000000
RG7 7 0 1000000000000
RG8 8 0 1000000000000
RG9 9 0 1000000000000
RG10 10 0 1000000000000
RG11 11 0 1000000000000
RG12 12 0 1000000000000
RG13 13 0 1000000000000
RG14 14 0 1000000000000
RG15 15 0 1000000000000
RG16 16 0 1000000000000
RG17 17 0 1000000000000
VS0 13 s0 0
L0 s0 6 33e-5
VS1 0 s1 0
R1 s1 8 10e1
VS2 0 s2 0
V2 e2 s2 DC 0 AC 39e0 0
RI2 e2 m2 33e-2
LI2 m2 4 56e-5
VS3 2 s3 0
R3 s3 6 39e-2
VS4 7 s4 0
V4 e4 s4 DC 0 AC 10e-1 -120
RI4 e4 1 22e-2
VS5 1 s5 0
C5 s5 14 27e-6
VS6 5 s6 0
L6 s6 15 33e-3
VS7 3 s7 0
V7 e7 s7 DC 0 AC 68e0 -120
RI7 e7 16 15e-3
VS8 2 s8 0
V8 e8 s8 DC 0 AC 27e0 120
RI8 e8 m8 12e-2
LI8 m8 7 68e-5
VS9 10 s9 0
R9 s9 4 82e1
VS10 13 s10 0
C10 s10 10 15e-4
VS11 6 s11 0
C11 s11 3 15e-5
VS12 6 s12 0
V12 e12 s12 DC 0 AC 47e1 180
RI12 e12 15 33e-1
VS13 12 s13 0
R13 s13 14 22e-1
VS14 2 s14 0
C14 s14 5 18e-7
VS15 10 s15 0
R15 s15 5 18e0
VS16 7 s16 0
C16 s16 0 33e-4
VS17 5 s17 0
R17 s17 11 33e2
VS18 11 s18 0
V18 e18 s18 DC 0 AC 10e0 -120
RI18 e18 0 82e-2
VS19 0 s19 0
R19 s19 16 82e3
VS20 8 s20 0
L20 s20 17 39e-2
VS21 12 s21 0
R21 s21 0 47e0
VS22 9 s22 0
R22 s22 7 68e1
VS23 9 s23 0
L23 s23 2 15e-2
VS24 5 s24 0
R24 s24 17 33e3
VS25 10 s25 0
L25 s25 16 82e-5
.control
set numdgt=17
ac lin 1 60 60
print v(1) v(2) v(3) v(4) v(5) v(6) v(7) v(8) v(9) v(10)
print v(11) v(12) v(13) v(14) v(15) v(16) v(17)
print i(vs0) i(vs1) i(vs2) i(vs3) i(vs4) i(vs5) i(vs6) i(vs7) i(vs8) i(vs9)
print i(vs10) i(vs11) i(vs12) i(vs13) i(vs14) i(vs15) i(vs16) i(vs17) i(vs18) i(vs19)
print i(vs20) i(vs21) i(vs22) i(vs23) i(vs24) i(vs25)
.endc
.end
