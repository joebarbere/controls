controls oracle ac-0179
* Generated (plan F2.7, ADR 0012): do not edit; regenerate with `pnpm sim oracle regen`. ac seed 20261031 index 179 nodes 18 elements 33
.options sparse gmin=1e-12 noopac
RG1 1 0 1000000000000
RG2 2 0 1000000000000
RG3 3 0 1000000000000
RG4 4 0 1000000000000
RG5 5 0 1000000000000
RG6 6 0 1000000000000
RG7 7 0 1000000000000
RG8 8 0 1000000000000
RG9 9 0 1000000000000
RG10 10 0 1000000000000
RG11 11 0 1000000000000
RG12 12 0 1000000000000
RG13 13 0 1000000000000
RG14 14 0 1000000000000
RG15 15 0 1000000000000
RG16 16 0 1000000000000
RG17 17 0 1000000000000
VS0 7 s0 0
R0 s0 12 47e0
VS1 2 s1 0
C1 s1 3 82e-6
VS2 10 s2 0
C2 s2 9 33e-4
VS3 14 s3 0
L3 s3 11 18e-4
VS4 6 s4 0
R4 s4 13 56e1
VS5 16 s5 0
L5 s5 8 18e-2
VS6 0 s6 0
V6 e6 s6 DC 0 AC 10e-1 0
RI6 e6 10 12e-3
VS7 13 s7 0
R7 s7 7 33e1
VS8 0 s8 0
L8 s8 8 33e-2
VS9 6 s9 0
R9 s9 7 15e-1
VS10 7 s10 0
L10 s10 12 12e-5
VS11 16 s11 0
C11 s11 7 15e-6
VS12 8 s12 0
R12 s12 4 27e3
VS13 0 s13 0
L13 s13 7 12e-3
VS14 16 s14 0
C14 s14 2 22e-4
VS15 16 s15 0
L15 s15 12 18e-5
VS16 3 s16 0
V16 e16 s16 DC 0 AC 47e1 180
RI16 e16 4 33e-1
VS17 10 s17 0
V17 e17 s17 DC 0 AC 22e-1 -120
RI17 e17 1 39e-2
VS18 5 s18 0
R18 s18 6 82e1
VS19 13 s19 0
R19 s19 16 22e-2
VS20 11 s20 0
C20 s20 3 15e-5
VS21 2 s21 0
R21 s21 1 68e1
VS22 15 s22 0
C22 s22 2 10e-5
VS23 14 s23 0
L23 s23 7 68e-4
VS24 13 s24 0
L24 s24 6 33e-5
VS25 2 s25 0
C25 s25 17 68e-4
VS26 3 s26 0
V26 e26 s26 DC 0 AC 68e0 -120
RI26 e26 16 15e-3
VS27 15 s27 0
L27 s27 8 33e-4
VS28 1 s28 0
C28 s28 2 10e-4
VS29 12 s29 0
R29 s29 16 82e3
VS30 1 s30 0
C30 s30 14 27e-6
VS31 5 s31 0
C31 s31 16 15e-4
VS32 3 s32 0
R32 s32 17 82e0
.control
set numdgt=17
ac lin 1 60 60
print v(1) v(2) v(3) v(4) v(5) v(6) v(7) v(8) v(9) v(10)
print v(11) v(12) v(13) v(14) v(15) v(16) v(17)
print i(vs0) i(vs1) i(vs2) i(vs3) i(vs4) i(vs5) i(vs6) i(vs7) i(vs8) i(vs9)
print i(vs10) i(vs11) i(vs12) i(vs13) i(vs14) i(vs15) i(vs16) i(vs17) i(vs18) i(vs19)
print i(vs20) i(vs21) i(vs22) i(vs23) i(vs24) i(vs25) i(vs26) i(vs27) i(vs28) i(vs29)
print i(vs30) i(vs31) i(vs32)
.endc
.end
