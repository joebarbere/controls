controls oracle ac-0143
* Generated (plan F2.7, ADR 0012): do not edit; regenerate with `pnpm sim oracle regen`. ac seed 20261031 index 143 nodes 7 elements 11
.options sparse gmin=1e-12 noopac
RG1 1 0 1000000000000
RG2 2 0 1000000000000
RG3 3 0 1000000000000
RG4 4 0 1000000000000
RG5 5 0 1000000000000
RG6 6 0 1000000000000
VS0 2 s0 0
L0 s0 6 12e-2
VS1 3 s1 0
L1 s1 1 27e-5
VS2 6 s2 0
L2 s2 4 18e-3
VS3 0 s3 0
R3 s3 2 56e1
VS4 1 s4 0
R4 s4 3 10e0
VS5 3 s5 0
C5 s5 4 56e-5
VS6 1 s6 0
R6 s6 2 82e-1
VS7 0 s7 0
V7 e7 s7 DC 0 AC 12e1 -120
RI7 e7 m7 15e-3
LI7 m7 1 22e-5
VS8 6 s8 0
V8 e8 s8 DC 0 AC 56e-1 120
RI8 e8 m8 47e-1
LI8 m8 5 82e-7
VS9 6 s9 0
V9 e9 s9 DC 0 AC 82e-1 180
RI9 e9 m9 15e-3
LI9 m9 1 56e-7
VS10 3 s10 0
C10 s10 5 10e-4
.control
set numdgt=17
ac lin 1 60 60
print v(1) v(2) v(3) v(4) v(5) v(6)
print i(vs0) i(vs1) i(vs2) i(vs3) i(vs4) i(vs5) i(vs6) i(vs7) i(vs8) i(vs9)
print i(vs10)
.endc
.end
