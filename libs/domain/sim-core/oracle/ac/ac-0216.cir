controls oracle ac-0216
* Generated (plan F2.7, ADR 0012): do not edit; regenerate with `pnpm sim oracle regen`. ac seed 20261031 index 216 nodes 14 elements 23
.options sparse gmin=1e-12 noopac
RG1 1 0 1000000000000
RG2 2 0 1000000000000
RG3 3 0 1000000000000
RG4 4 0 1000000000000
RG5 5 0 1000000000000
RG6 6 0 1000000000000
RG7 7 0 1000000000000
RG8 8 0 1000000000000
RG9 9 0 1000000000000
RG10 10 0 1000000000000
RG11 11 0 1000000000000
RG12 12 0 1000000000000
RG13 13 0 1000000000000
VS0 9 s0 0
L0 s0 12 18e-2
VS1 11 s1 0
C1 s1 2 39e-4
VS2 8 s2 0
R2 s2 6 82e1
VS3 0 s3 0
V3 e3 s3 DC 0 AC 33e-1 120
RI3 e3 m3 18e-1
LI3 m3 2 10e-5
VS4 10 s4 0
R4 s4 1 12e-2
VS5 1 s5 0
R5 s5 2 39e3
VS6 8 s6 0
V6 e6 s6 DC 0 AC 15e1 180
RI6 e6 3 27e-1
VS7 1 s7 0
C7 s7 7 39e-6
VS8 5 s8 0
C8 s8 11 68e-4
VS9 13 s9 0
L9 s9 11 12e-3
VS10 3 s10 0
R10 s10 12 27e-2
VS11 12 s11 0
R11 s11 10 18e3
VS12 11 s12 0
L12 s12 3 12e-3
VS13 0 s13 0
R13 s13 9 15e1
VS14 10 s14 0
C14 s14 2 82e-7
VS15 8 s15 0
V15 e15 s15 DC 0 AC 22e-1 -120
RI15 e15 5 82e-1
VS16 5 s16 0
R16 s16 10 10e-2
VS17 8 s17 0
R17 s17 2 15e-1
VS18 13 s18 0
R18 s18 2 47e3
VS19 7 s19 0
C19 s19 9 33e-7
VS20 4 s20 0
R20 s20 10 56e-2
VS21 7 s21 0
L21 s21 6 10e-4
VS22 4 s22 0
L22 s22 1 82e-5
.control
set numdgt=17
ac lin 1 60 60
print v(1) v(2) v(3) v(4) v(5) v(6) v(7) v(8) v(9) v(10)
print v(11) v(12) v(13)
print i(vs0) i(vs1) i(vs2) i(vs3) i(vs4) i(vs5) i(vs6) i(vs7) i(vs8) i(vs9)
print i(vs10) i(vs11) i(vs12) i(vs13) i(vs14) i(vs15) i(vs16) i(vs17) i(vs18) i(vs19)
print i(vs20) i(vs21) i(vs22)
.endc
.end
