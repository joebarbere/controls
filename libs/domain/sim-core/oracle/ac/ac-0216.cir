controls oracle ac-0216
* Generated (plan F2.7, ADR 0012): do not edit; regenerate with `pnpm sim oracle regen`. ac seed 20261031 index 216 nodes 14 elements 21
.options sparse gmin=1e-12 noopac
RG1 1 0 1000000000000
RG2 2 0 1000000000000
RG3 3 0 1000000000000
RG4 4 0 1000000000000
RG5 5 0 1000000000000
RG6 6 0 1000000000000
RG7 7 0 1000000000000
RG8 8 0 1000000000000
RG9 9 0 1000000000000
RG10 10 0 1000000000000
RG11 11 0 1000000000000
RG12 12 0 1000000000000
RG13 13 0 1000000000000
VS0 5 s0 0
C0 s0 6 47e-5
VS1 10 s1 0
C1 s1 1 82e-7
VS2 4 s2 0
L2 s2 0 82e-5
VS3 0 s3 0
R3 s3 1 39e3
VS4 3 s4 0
R4 s4 7 56e3
VS5 13 s5 0
C5 s5 2 27e-6
VS6 6 s6 0
C6 s6 8 12e-6
VS7 0 s7 0
V7 e7 s7 DC 0 AC 33e0 120
RI7 e7 5 12e-1
VS8 8 s8 0
R8 s8 1 15e-1
VS9 12 s9 0
L9 s9 10 82e-3
VS10 0 s10 0
C10 s10 9 12e-7
VS11 9 s11 0
L11 s11 12 39e-2
VS12 6 s12 0
R12 s12 1 47e3
VS13 7 s13 0
L13 s13 1 27e-5
VS14 4 s14 0
L14 s14 3 10e-4
VS15 12 s15 0
C15 s15 2 82e-5
VS16 11 s16 0
V16 e16 s16 DC 0 AC 68e-1 0
RI16 e16 m16 27e-3
LI16 m16 8 10e-5
VS17 0 s17 0
L17 s17 2 68e-3
VS18 2 s18 0
V18 e18 s18 DC 0 AC 33e-1 120
RI18 e18 1 18e-1
VS19 13 s19 0
C19 s19 8 39e-4
VS20 11 s20 0
R20 s20 12 27e-2
.control
set numdgt=17
ac lin 1 60 60
print v(1) v(2) v(3) v(4) v(5) v(6) v(7) v(8) v(9) v(10)
print v(11) v(12) v(13)
print i(vs0) i(vs1) i(vs2) i(vs3) i(vs4) i(vs5) i(vs6) i(vs7) i(vs8) i(vs9)
print i(vs10) i(vs11) i(vs12) i(vs13) i(vs14) i(vs15) i(vs16) i(vs17) i(vs18) i(vs19)
print i(vs20)
.endc
.end
