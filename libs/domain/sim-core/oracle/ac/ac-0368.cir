controls oracle ac-0368
* Generated (plan F2.7, ADR 0012): do not edit; regenerate with `pnpm sim oracle regen`. ac seed 20261031 index 368 nodes 4 elements 7
.options sparse gmin=1e-12 noopac
RG1 1 0 1000000000000
RG2 2 0 1000000000000
RG3 3 0 1000000000000
VS0 0 s0 0
R0 s0 3 68e1
VS1 1 s1 0
C1 s1 3 10e-7
VS2 2 s2 0
C2 s2 0 27e-6
VS3 1 s3 0
R3 s3 2 22e2
VS4 0 s4 0
R4 s4 1 27e-2
VS5 0 s5 0
V5 e5 s5 DC 0 AC 27e-1 120
RI5 e5 2 10e-2
VS6 3 s6 0
C6 s6 1 56e-5
.control
set numdgt=17
ac lin 1 60 60
print v(1) v(2) v(3)
print i(vs0) i(vs1) i(vs2) i(vs3) i(vs4) i(vs5) i(vs6)
.endc
.end
