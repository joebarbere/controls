controls oracle ac-0368
* Generated (plan F2.7, ADR 0012): do not edit; regenerate with `pnpm sim oracle regen`. ac seed 20261031 index 368 nodes 4 elements 7
.options sparse gmin=1e-12 noopac
RG1 1 0 1000000000000
RG2 2 0 1000000000000
RG3 3 0 1000000000000
VS0 0 s0 0
R0 s0 1 27e-2
VS1 3 s1 0
C1 s1 2 27e-5
VS2 1 s2 0
R2 s2 2 22e2
VS3 1 s3 0
C3 s3 3 10e-7
VS4 0 s4 0
R4 s4 3 68e1
VS5 1 s5 0
C5 s5 2 68e-6
VS6 0 s6 0
V6 e6 s6 DC 0 AC 27e-1 120
RI6 e6 2 10e-2
.control
set numdgt=17
ac lin 1 60 60
print v(1) v(2) v(3)
print i(vs0) i(vs1) i(vs2) i(vs3) i(vs4) i(vs5) i(vs6)
.endc
.end
