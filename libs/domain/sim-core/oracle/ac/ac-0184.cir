controls oracle ac-0184
* Generated (plan F2.7, ADR 0012): do not edit; regenerate with `pnpm sim oracle regen`. ac seed 20261031 index 184 nodes 12 elements 20
.options sparse gmin=1e-12 noopac
RG1 1 0 1000000000000
RG2 2 0 1000000000000
RG3 3 0 1000000000000
RG4 4 0 1000000000000
RG5 5 0 1000000000000
RG6 6 0 1000000000000
RG7 7 0 1000000000000
RG8 8 0 1000000000000
RG9 9 0 1000000000000
RG10 10 0 1000000000000
RG11 11 0 1000000000000
VS0 10 s0 0
C0 s0 3 22e-7
VS1 0 s1 0
V1 e1 s1 DC 0 AC 22e-1 120
RI1 e1 10 27e-1
VS2 11 s2 0
R2 s2 9 18e1
VS3 3 s3 0
R3 s3 1 27e-2
VS4 3 s4 0
L4 s4 10 15e-5
VS5 3 s5 0
V5 e5 s5 DC 0 AC 18e-1 -120
RI5 e5 8 10e-1
VS6 2 s6 0
V6 e6 s6 DC 0 AC 82e-1 -120
RI6 e6 5 39e-2
VS7 11 s7 0
L7 s7 8 22e-2
VS8 2 s8 0
R8 s8 8 68e1
VS9 7 s9 0
V9 e9 s9 DC 0 AC 68e0 0
RI9 e9 3 47e-3
VS10 9 s10 0
R10 s10 3 10e1
VS11 8 s11 0
R11 s11 2 18e-1
VS12 5 s12 0
R12 s12 1 12e-1
VS13 1 s13 0
C13 s13 6 68e-5
VS14 10 s14 0
L14 s14 1 82e-3
VS15 0 s15 0
R15 s15 1 10e1
VS16 4 s16 0
L16 s16 9 33e-4
VS17 6 s17 0
R17 s17 2 39e0
VS18 9 s18 0
R18 s18 6 68e0
VS19 4 s19 0
C19 s19 10 39e-6
.control
set numdgt=17
ac lin 1 60 60
print v(1) v(2) v(3) v(4) v(5) v(6) v(7) v(8) v(9) v(10)
print v(11)
print i(vs0) i(vs1) i(vs2) i(vs3) i(vs4) i(vs5) i(vs6) i(vs7) i(vs8) i(vs9)
print i(vs10) i(vs11) i(vs12) i(vs13) i(vs14) i(vs15) i(vs16) i(vs17) i(vs18) i(vs19)
.endc
.end
