controls oracle ac-0435
* Generated (plan F2.7, ADR 0012): do not edit; regenerate with `pnpm sim oracle regen`. ac seed 20261031 index 435 nodes 11 elements 19
.options sparse gmin=1e-12 noopac
RG1 1 0 1000000000000
RG2 2 0 1000000000000
RG3 3 0 1000000000000
RG4 4 0 1000000000000
RG5 5 0 1000000000000
RG6 6 0 1000000000000
RG7 7 0 1000000000000
RG8 8 0 1000000000000
RG9 9 0 1000000000000
RG10 10 0 1000000000000
VS0 6 s0 0
R0 s0 9 56e-2
VS1 10 s1 0
R1 s1 6 33e3
VS2 8 s2 0
R2 s2 4 68e-2
VS3 9 s3 0
R3 s3 10 39e-1
VS4 6 s4 0
C4 s4 2 47e-5
VS5 8 s5 0
L5 s5 6 47e-4
VS6 8 s6 0
R6 s6 7 47e2
VS7 3 s7 0
R7 s7 8 68e2
VS8 0 s8 0
L8 s8 3 39e-4
VS9 6 s9 0
R9 s9 8 27e-2
VS10 5 s10 0
C10 s10 2 12e-7
VS11 0 s11 0
V11 e11 s11 DC 0 AC 27e1 0
RI11 e11 m11 18e-1
LI11 m11 3 27e-7
VS12 6 s12 0
C12 s12 3 22e-6
VS13 1 s13 0
L13 s13 3 56e-2
VS14 7 s14 0
L14 s14 10 10e-4
VS15 2 s15 0
L15 s15 8 22e-4
VS16 1 s16 0
V16 e16 s16 DC 0 AC 33e-1 -120
RI16 e16 m16 12e-2
LI16 m16 4 39e-6
VS17 6 s17 0
L17 s17 5 10e-4
VS18 4 s18 0
C18 s18 0 12e-7
.control
set numdgt=17
ac lin 1 60 60
print v(1) v(2) v(3) v(4) v(5) v(6) v(7) v(8) v(9) v(10)
print i(vs0) i(vs1) i(vs2) i(vs3) i(vs4) i(vs5) i(vs6) i(vs7) i(vs8) i(vs9)
print i(vs10) i(vs11) i(vs12) i(vs13) i(vs14) i(vs15) i(vs16) i(vs17) i(vs18)
.endc
.end
