controls oracle ac-0435
* Generated (plan F2.7, ADR 0012): do not edit; regenerate with `pnpm sim oracle regen`. ac seed 20261031 index 435 nodes 11 elements 14
.options sparse gmin=1e-12 noopac
RG1 1 0 1000000000000
RG2 2 0 1000000000000
RG3 3 0 1000000000000
RG4 4 0 1000000000000
RG5 5 0 1000000000000
RG6 6 0 1000000000000
RG7 7 0 1000000000000
RG8 8 0 1000000000000
RG9 9 0 1000000000000
RG10 10 0 1000000000000
VS0 6 s0 0
C0 s0 3 22e-6
VS1 0 s1 0
V1 e1 s1 DC 0 AC 33e-1 -120
RI1 e1 1 56e-3
VS2 4 s2 0
C2 s2 8 12e-7
VS3 1 s3 0
L3 s3 6 47e-4
VS4 6 s4 0
R4 s4 1 27e-2
VS5 7 s5 0
L5 s5 10 10e-4
VS6 10 s6 0
R6 s6 6 33e3
VS7 10 s7 0
L7 s7 5 18e-2
VS8 6 s8 0
C8 s8 2 47e-5
VS9 8 s9 0
V9 e9 s9 DC 0 AC 27e1 0
RI9 e9 3 18e-1
VS10 5 s10 0
C10 s10 2 12e-7
VS11 9 s11 0
R11 s11 10 39e-1
VS12 3 s12 0
R12 s12 1 68e2
VS13 8 s13 0
L13 s13 3 39e-4
.control
set numdgt=17
ac lin 1 60 60
print v(1) v(2) v(3) v(4) v(5) v(6) v(7) v(8) v(9) v(10)
print i(vs0) i(vs1) i(vs2) i(vs3) i(vs4) i(vs5) i(vs6) i(vs7) i(vs8) i(vs9)
print i(vs10) i(vs11) i(vs12) i(vs13)
.endc
.end
