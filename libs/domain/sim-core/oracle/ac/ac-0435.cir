controls oracle ac-0435
* Generated (plan F2.7, ADR 0012): do not edit; regenerate with `pnpm sim oracle regen`. ac seed 20261031 index 435 nodes 11 elements 17
.options sparse gmin=1e-12 noopac
RG1 1 0 1000000000000
RG2 2 0 1000000000000
RG3 3 0 1000000000000
RG4 4 0 1000000000000
RG5 5 0 1000000000000
RG6 6 0 1000000000000
RG7 7 0 1000000000000
RG8 8 0 1000000000000
RG9 9 0 1000000000000
RG10 10 0 1000000000000
VS0 1 s0 0
L0 s0 6 47e-4
VS1 7 s1 0
L1 s1 10 10e-4
VS2 6 s2 0
C2 s2 3 22e-6
VS3 9 s3 0
R3 s3 10 39e-1
VS4 10 s4 0
R4 s4 6 33e3
VS5 3 s5 0
R5 s5 1 68e2
VS6 0 s6 0
V6 e6 s6 DC 0 AC 33e-1 -120
RI6 e6 m6 12e-2
LI6 m6 4 68e-7
VS7 6 s7 0
R7 s7 9 56e-2
VS8 8 s8 0
L8 s8 3 39e-4
VS9 4 s9 0
C9 s9 8 12e-7
VS10 0 s10 0
V10 e10 s10 DC 0 AC 33e-1 -120
RI10 e10 m10 56e-3
LI10 m10 1 12e-5
VS11 10 s11 0
L11 s11 5 18e-2
VS12 8 s12 0
V12 e12 s12 DC 0 AC 27e1 0
RI12 e12 3 18e-1
VS13 6 s13 0
R13 s13 1 27e-2
VS14 6 s14 0
C14 s14 2 47e-5
VS15 5 s15 0
C15 s15 2 12e-7
VS16 1 s16 0
R16 s16 7 47e2
.control
set numdgt=17
ac lin 1 60 60
print v(1) v(2) v(3) v(4) v(5) v(6) v(7) v(8) v(9) v(10)
print i(vs0) i(vs1) i(vs2) i(vs3) i(vs4) i(vs5) i(vs6) i(vs7) i(vs8) i(vs9)
print i(vs10) i(vs11) i(vs12) i(vs13) i(vs14) i(vs15) i(vs16)
.endc
.end
