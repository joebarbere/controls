controls oracle ac-0004
* Generated (plan F2.7, ADR 0012): do not edit; regenerate with `pnpm sim oracle regen`. ac seed 20261031 index 4 nodes 25 elements 49
.options sparse gmin=1e-12 noopac
RG1 1 0 1000000000000
RG2 2 0 1000000000000
RG3 3 0 1000000000000
RG4 4 0 1000000000000
RG5 5 0 1000000000000
RG6 6 0 1000000000000
RG7 7 0 1000000000000
RG8 8 0 1000000000000
RG9 9 0 1000000000000
RG10 10 0 1000000000000
RG11 11 0 1000000000000
RG12 12 0 1000000000000
RG13 13 0 1000000000000
RG14 14 0 1000000000000
RG15 15 0 1000000000000
RG16 16 0 1000000000000
RG17 17 0 1000000000000
RG18 18 0 1000000000000
RG19 19 0 1000000000000
RG20 20 0 1000000000000
RG21 21 0 1000000000000
RG22 22 0 1000000000000
RG23 23 0 1000000000000
RG24 24 0 1000000000000
VS0 11 s0 0
R0 s0 13 33e2
VS1 12 s1 0
R1 s1 8 15e-2
VS2 23 s2 0
C2 s2 3 12e-5
VS3 2 s3 0
C3 s3 19 18e-7
VS4 2 s4 0
C4 s4 20 27e-5
VS5 19 s5 0
R5 s5 8 22e1
VS6 7 s6 0
L6 s6 0 47e-2
VS7 7 s7 0
L7 s7 16 68e-5
VS8 24 s8 0
R8 s8 21 33e-2
VS9 10 s9 0
R9 s9 5 15e0
VS10 17 s10 0
C10 s10 7 33e-5
VS11 16 s11 0
L11 s11 9 22e-3
VS12 5 s12 0
C12 s12 18 18e-7
VS13 0 s13 0
V13 e13 s13 DC 0 AC 22e-1 0
RI13 e13 n13 56e-2
H13 n13 h13 VS14 39e-3
ED13 h13 13 d13 0 18e-7
F13 0 d13 VS14 1
LD13 d13 0 1
VS14 7 s14 0
V14 e14 s14 DC 0 AC 39e1 120
RI14 e14 n14 47e-1
H14 n14 h14 VS13 39e-3
ED14 h14 3 d14 0 18e-7
F14 0 d14 VS13 1
LD14 d14 0 1
VS15 18 s15 0
R15 s15 16 18e-1
VS16 3 s16 0
R16 s16 19 47e0
VS17 13 s17 0
L17 s17 11 33e-4
VS18 0 s18 0
V18 e18 s18 DC 0 AC 22e0 120
RI18 e18 8 12e-2
VS19 6 s19 0
R19 s19 12 47e2
VS20 14 s20 0
L20 s20 20 47e-4
VS21 7 s21 0
L21 s21 19 12e-3
VS22 5 s22 0
V22 e22 s22 DC 0 AC 82e-1 0
RI22 e22 7 33e-1
VS23 8 s23 0
C23 s23 13 68e-6
VS24 0 s24 0
C24 s24 7 39e-5
VS25 24 s25 0
C25 s25 20 22e-6
VS26 17 s26 0
R26 s26 18 39e1
VS27 24 s27 0
V27 e27 s27 DC 0 AC 12e1 120
RI27 e27 m27 68e-1
LI27 m27 7 68e-7
VS28 2 s28 0
V28 e28 s28 DC 0 AC 18e0 120
RI28 e28 m28 39e-1
LI28 m28 14 39e-5
VS29 17 s29 0
R29 s29 14 82e2
VS30 8 s30 0
V30 e30 s30 DC 0 AC 27e0 120
RI30 e30 m30 68e-1
LI30 m30 9 22e-7
VS31 22 s31 0
C31 s31 4 22e-7
VS32 17 s32 0
R32 s32 5 12e-2
VS33 10 s33 0
C33 s33 8 68e-7
VS34 15 s34 0
L34 s34 1 18e-5
VS35 24 s35 0
C35 s35 0 82e-7
VS36 7 s36 0
C36 s36 19 68e-7
VS37 8 s37 0
R37 s37 13 56e2
VS38 24 s38 0
L38 s38 0 18e-4
VS39 21 s39 0
R39 s39 7 82e2
VS40 6 s40 0
R40 s40 20 82e3
VS41 12 s41 0
R41 s41 7 39e-1
VS42 23 s42 0
R42 s42 6 10e1
VS43 20 s43 0
V43 e43 s43 DC 0 AC 10e1 120
RI43 e43 15 82e-2
VS44 7 s44 0
V44 e44 s44 DC 0 AC 12e1 120
RI44 e44 11 10e-1
VS45 11 s45 0
C45 s45 4 22e-7
VS46 14 s46 0
L46 s46 18 22e-5
VS47 1 s47 0
L47 s47 16 47e-5
VS48 22 s48 0
R48 s48 18 10e-2
.control
set numdgt=17
ac lin 1 60 60
print v(1) v(2) v(3) v(4) v(5) v(6) v(7) v(8) v(9) v(10)
print v(11) v(12) v(13) v(14) v(15) v(16) v(17) v(18) v(19) v(20)
print v(21) v(22) v(23) v(24)
print i(vs0) i(vs1) i(vs2) i(vs3) i(vs4) i(vs5) i(vs6) i(vs7) i(vs8) i(vs9)
print i(vs10) i(vs11) i(vs12) i(vs13) i(vs14) i(vs15) i(vs16) i(vs17) i(vs18) i(vs19)
print i(vs20) i(vs21) i(vs22) i(vs23) i(vs24) i(vs25) i(vs26) i(vs27) i(vs28) i(vs29)
print i(vs30) i(vs31) i(vs32) i(vs33) i(vs34) i(vs35) i(vs36) i(vs37) i(vs38) i(vs39)
print i(vs40) i(vs41) i(vs42) i(vs43) i(vs44) i(vs45) i(vs46) i(vs47) i(vs48)
.endc
.end
