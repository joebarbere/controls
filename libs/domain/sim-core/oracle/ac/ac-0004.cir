controls oracle ac-0004
* Generated (plan F2.7, ADR 0012): do not edit; regenerate with `pnpm sim oracle regen`. ac seed 20261031 index 4 nodes 25 elements 46
.options sparse gmin=1e-12 noopac
RG1 1 0 1000000000000
RG2 2 0 1000000000000
RG3 3 0 1000000000000
RG4 4 0 1000000000000
RG5 5 0 1000000000000
RG6 6 0 1000000000000
RG7 7 0 1000000000000
RG8 8 0 1000000000000
RG9 9 0 1000000000000
RG10 10 0 1000000000000
RG11 11 0 1000000000000
RG12 12 0 1000000000000
RG13 13 0 1000000000000
RG14 14 0 1000000000000
RG15 15 0 1000000000000
RG16 16 0 1000000000000
RG17 17 0 1000000000000
RG18 18 0 1000000000000
RG19 19 0 1000000000000
RG20 20 0 1000000000000
RG21 21 0 1000000000000
RG22 22 0 1000000000000
RG23 23 0 1000000000000
RG24 24 0 1000000000000
VS0 24 s0 0
R0 s0 21 33e-2
VS1 8 s1 0
C1 s1 13 68e-6
VS2 7 s2 0
L2 s2 16 68e-5
VS3 11 s3 0
C3 s3 4 22e-7
VS4 6 s4 0
R4 s4 20 82e3
VS5 1 s5 0
L5 s5 16 47e-5
VS6 15 s6 0
L6 s6 1 18e-5
VS7 24 s7 0
C7 s7 20 22e-6
VS8 10 s8 0
R8 s8 5 15e0
VS9 17 s9 0
R9 s9 18 39e1
VS10 2 s10 0
C10 s10 20 27e-5
VS11 13 s11 0
L11 s11 11 33e-4
VS12 14 s12 0
L12 s12 20 47e-4
VS13 7 s13 0
C13 s13 19 68e-7
VS14 0 s14 0
V14 e14 s14 DC 0 AC 22e-1 0
RI14 e14 13 56e-2
VS15 14 s15 0
L15 s15 18 22e-5
VS16 8 s16 0
R16 s16 13 56e2
VS17 17 s17 0
C17 s17 7 33e-5
VS18 24 s18 0
L18 s18 0 18e-4
VS19 2 s19 0
V19 e19 s19 DC 0 AC 18e0 120
RI19 e19 14 39e-1
VS20 7 s20 0
V20 e20 s20 DC 0 AC 39e1 120
RI20 e20 3 47e-1
VS21 7 s21 0
L21 s21 0 47e-2
VS22 12 s22 0
R22 s22 8 15e-2
VS23 16 s23 0
L23 s23 9 22e-3
VS24 22 s24 0
R24 s24 18 10e-2
VS25 17 s25 0
R25 s25 14 82e2
VS26 20 s26 0
V26 e26 s26 DC 0 AC 10e1 120
RI26 e26 15 82e-2
VS27 23 s27 0
R27 s27 6 10e1
VS28 5 s28 0
V28 e28 s28 DC 0 AC 82e-1 0
RI28 e28 7 33e-1
VS29 0 s29 0
C29 s29 7 39e-5
VS30 5 s30 0
C30 s30 18 18e-7
VS31 11 s31 0
R31 s31 13 33e2
VS32 3 s32 0
R32 s32 19 47e0
VS33 7 s33 0
V33 e33 s33 DC 0 AC 12e1 120
RI33 e33 11 10e-1
VS34 24 s34 0
V34 e34 s34 DC 0 AC 12e1 120
RI34 e34 7 68e-1
VS35 10 s35 0
C35 s35 8 68e-7
VS36 22 s36 0
C36 s36 4 22e-7
VS37 24 s37 0
C37 s37 0 82e-7
VS38 18 s38 0
R38 s38 16 18e-1
VS39 17 s39 0
R39 s39 5 12e-2
VS40 19 s40 0
R40 s40 8 22e1
VS41 2 s41 0
C41 s41 19 18e-7
VS42 6 s42 0
R42 s42 12 47e2
VS43 7 s43 0
L43 s43 19 12e-3
VS44 0 s44 0
V44 e44 s44 DC 0 AC 22e0 120
RI44 e44 8 12e-2
VS45 12 s45 0
R45 s45 7 39e-1
.control
set numdgt=17
ac lin 1 60 60
print v(1) v(2) v(3) v(4) v(5) v(6) v(7) v(8) v(9) v(10)
print v(11) v(12) v(13) v(14) v(15) v(16) v(17) v(18) v(19) v(20)
print v(21) v(22) v(23) v(24)
print i(vs0) i(vs1) i(vs2) i(vs3) i(vs4) i(vs5) i(vs6) i(vs7) i(vs8) i(vs9)
print i(vs10) i(vs11) i(vs12) i(vs13) i(vs14) i(vs15) i(vs16) i(vs17) i(vs18) i(vs19)
print i(vs20) i(vs21) i(vs22) i(vs23) i(vs24) i(vs25) i(vs26) i(vs27) i(vs28) i(vs29)
print i(vs30) i(vs31) i(vs32) i(vs33) i(vs34) i(vs35) i(vs36) i(vs37) i(vs38) i(vs39)
print i(vs40) i(vs41) i(vs42) i(vs43) i(vs44) i(vs45)
.endc
.end
