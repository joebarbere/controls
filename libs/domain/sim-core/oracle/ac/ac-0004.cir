controls oracle ac-0004
* Generated (plan F2.7, ADR 0012): do not edit; regenerate with `pnpm sim oracle regen`. ac seed 20261031 index 4 nodes 25 elements 32
.options sparse gmin=1e-12 noopac
RG1 1 0 1000000000000
RG2 2 0 1000000000000
RG3 3 0 1000000000000
RG4 4 0 1000000000000
RG5 5 0 1000000000000
RG6 6 0 1000000000000
RG7 7 0 1000000000000
RG8 8 0 1000000000000
RG9 9 0 1000000000000
RG10 10 0 1000000000000
RG11 11 0 1000000000000
RG12 12 0 1000000000000
RG13 13 0 1000000000000
RG14 14 0 1000000000000
RG15 15 0 1000000000000
RG16 16 0 1000000000000
RG17 17 0 1000000000000
RG18 18 0 1000000000000
RG19 19 0 1000000000000
RG20 20 0 1000000000000
RG21 21 0 1000000000000
RG22 22 0 1000000000000
RG23 23 0 1000000000000
RG24 24 0 1000000000000
VS0 21 s0 0
L0 s0 19 12e-3
VS1 12 s1 0
L1 s1 4 10e-4
VS2 22 s2 0
C2 s2 24 39e-5
VS3 13 s3 0
C3 s3 8 12e-7
VS4 18 s4 0
C4 s4 20 18e-7
VS5 0 s5 0
V5 e5 s5 DC 0 AC 22e0 120
RI5 e5 m5 12e-2
LI5 m5 7 68e-6
VS6 13 s6 0
L6 s6 12 27e-4
VS7 16 s7 0
R7 s7 17 10e1
VS8 20 s8 0
V8 e8 s8 DC 0 AC 82e0 -120
RI8 e8 15 68e-3
VS9 0 s9 0
L9 s9 15 82e-3
VS10 14 s10 0
R10 s10 24 33e-2
VS11 9 s11 0
C11 s11 2 22e-6
VS12 6 s12 0
R12 s12 20 82e3
VS13 21 s13 0
V13 e13 s13 DC 0 AC 12e1 120
RI13 e13 11 10e-1
VS14 1 s14 0
L14 s14 18 56e-5
VS15 2 s15 0
R15 s15 6 82e2
VS16 24 s16 0
R16 s16 3 22e0
VS17 6 s17 0
C17 s17 22 56e-7
VS18 16 s18 0
L18 s18 23 18e-5
VS19 4 s19 0
L19 s19 3 68e-5
VS20 17 s20 0
R20 s20 19 47e0
VS21 6 s21 0
R21 s21 12 47e2
VS22 7 s22 0
R22 s22 8 56e2
VS23 13 s23 0
R23 s23 9 68e0
VS24 12 s24 0
L24 s24 14 12e-5
VS25 20 s25 0
L25 s25 10 22e-5
VS26 10 s26 0
R26 s26 4 56e1
VS27 23 s27 0
L27 s27 1 22e-3
VS28 0 s28 0
C28 s28 5 22e-7
VS29 13 s29 0
R29 s29 11 39e3
VS30 12 s30 0
R30 s30 21 39e-1
VS31 5 s31 0
V31 e31 s31 DC 0 AC 10e-1 -120
RI31 e31 m31 22e-1
LI31 m31 6 15e-5
.control
set numdgt=17
ac lin 1 60 60
print v(1) v(2) v(3) v(4) v(5) v(6) v(7) v(8) v(9) v(10)
print v(11) v(12) v(13) v(14) v(15) v(16) v(17) v(18) v(19) v(20)
print v(21) v(22) v(23) v(24)
print i(vs0) i(vs1) i(vs2) i(vs3) i(vs4) i(vs5) i(vs6) i(vs7) i(vs8) i(vs9)
print i(vs10) i(vs11) i(vs12) i(vs13) i(vs14) i(vs15) i(vs16) i(vs17) i(vs18) i(vs19)
print i(vs20) i(vs21) i(vs22) i(vs23) i(vs24) i(vs25) i(vs26) i(vs27) i(vs28) i(vs29)
print i(vs30) i(vs31)
.endc
.end
