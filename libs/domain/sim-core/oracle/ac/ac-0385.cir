controls oracle ac-0385
* Generated (plan F2.7, ADR 0012): do not edit; regenerate with `pnpm sim oracle regen`. ac seed 20261031 index 385 nodes 27 elements 47
.options sparse gmin=1e-12 noopac
RG1 1 0 1000000000000
RG2 2 0 1000000000000
RG3 3 0 1000000000000
RG4 4 0 1000000000000
RG5 5 0 1000000000000
RG6 6 0 1000000000000
RG7 7 0 1000000000000
RG8 8 0 1000000000000
RG9 9 0 1000000000000
RG10 10 0 1000000000000
RG11 11 0 1000000000000
RG12 12 0 1000000000000
RG13 13 0 1000000000000
RG14 14 0 1000000000000
RG15 15 0 1000000000000
RG16 16 0 1000000000000
RG17 17 0 1000000000000
RG18 18 0 1000000000000
RG19 19 0 1000000000000
RG20 20 0 1000000000000
RG21 21 0 1000000000000
RG22 22 0 1000000000000
RG23 23 0 1000000000000
RG24 24 0 1000000000000
RG25 25 0 1000000000000
RG26 26 0 1000000000000
VS0 3 s0 0
C0 s0 7 22e-5
VS1 19 s1 0
C1 s1 5 82e-4
VS2 17 s2 0
C2 s2 4 47e-7
VS3 7 s3 0
C3 s3 11 39e-6
VS4 26 s4 0
R4 s4 23 18e1
VS5 23 s5 0
C5 s5 7 56e-6
VS6 0 s6 0
V6 e6 s6 DC 0 AC 10e0 180
RI6 e6 2 27e-2
VS7 18 s7 0
L7 s7 9 27e-4
VS8 13 s8 0
R8 s8 16 68e3
VS9 18 s9 0
R9 s9 24 27e-1
VS10 8 s10 0
L10 s10 16 12e-3
VS11 6 s11 0
R11 s11 11 33e1
VS12 11 s12 0
R12 s12 7 18e2
VS13 25 s13 0
L13 s13 9 33e-5
VS14 15 s14 0
R14 s14 19 10e1
VS15 0 s15 0
R15 s15 18 56e-2
VS16 5 s16 0
L16 s16 11 22e-2
VS17 20 s17 0
R17 s17 10 27e2
VS18 2 s18 0
L18 s18 15 22e-2
VS19 11 s19 0
C19 s19 2 12e-5
VS20 22 s20 0
R20 s20 1 27e3
VS21 21 s21 0
V21 e21 s21 DC 0 AC 39e0 -120
RI21 e21 m21 82e-1
LI21 m21 1 12e-6
VS22 8 s22 0
C22 s22 25 12e-4
VS23 12 s23 0
V23 e23 s23 DC 0 AC 39e0 120
RI23 e23 m23 82e-1
LI23 m23 5 82e-7
VS24 26 s24 0
C24 s24 4 12e-5
VS25 18 s25 0
R25 s25 14 10e3
VS26 6 s26 0
C26 s26 22 15e-7
VS27 25 s27 0
L27 s27 24 27e-5
VS28 1 s28 0
R28 s28 5 56e3
VS29 18 s29 0
V29 e29 s29 DC 0 AC 15e1 120
RI29 e29 m29 22e-3
LI29 m29 14 56e-7
VS30 12 s30 0
R30 s30 17 12e0
VS31 1 s31 0
V31 e31 s31 DC 0 AC 12e0 0
RI31 e31 m31 68e-1
LI31 m31 10 27e-7
VS32 21 s32 0
L32 s32 12 10e-2
VS33 23 s33 0
V33 e33 s33 DC 0 AC 18e-1 180
RI33 e33 25 27e-2
VS34 14 s34 0
R34 s34 13 68e-2
VS35 6 s35 0
C35 s35 1 56e-6
VS36 7 s36 0
C36 s36 18 39e-7
VS37 13 s37 0
R37 s37 12 27e2
VS38 14 s38 0
R38 s38 6 10e-2
VS39 4 s39 0
L39 s39 19 27e-4
VS40 7 s40 0
R40 s40 11 47e-2
VS41 6 s41 0
R41 s41 3 10e-1
VS42 1 s42 0
V42 e42 s42 DC 0 AC 27e1 0
RI42 e42 24 68e-1
VS43 20 s43 0
C43 s43 2 33e-5
VS44 16 s44 0
V44 e44 s44 DC 0 AC 68e0 -120
RI44 e44 m44 56e-1
LI44 m44 23 56e-5
VS45 18 s45 0
C45 s45 14 47e-4
VS46 2 s46 0
L46 s46 19 68e-2
.control
set numdgt=17
ac lin 1 60 60
print v(1) v(2) v(3) v(4) v(5) v(6) v(7) v(8) v(9) v(10)
print v(11) v(12) v(13) v(14) v(15) v(16) v(17) v(18) v(19) v(20)
print v(21) v(22) v(23) v(24) v(25) v(26)
print i(vs0) i(vs1) i(vs2) i(vs3) i(vs4) i(vs5) i(vs6) i(vs7) i(vs8) i(vs9)
print i(vs10) i(vs11) i(vs12) i(vs13) i(vs14) i(vs15) i(vs16) i(vs17) i(vs18) i(vs19)
print i(vs20) i(vs21) i(vs22) i(vs23) i(vs24) i(vs25) i(vs26) i(vs27) i(vs28) i(vs29)
print i(vs30) i(vs31) i(vs32) i(vs33) i(vs34) i(vs35) i(vs36) i(vs37) i(vs38) i(vs39)
print i(vs40) i(vs41) i(vs42) i(vs43) i(vs44) i(vs45) i(vs46)
.endc
.end
