controls oracle ac-0385
* Generated (plan F2.7, ADR 0012): do not edit; regenerate with `pnpm sim oracle regen`. ac seed 20261031 index 385 nodes 27 elements 48
.options sparse gmin=1e-12 noopac
RG1 1 0 1000000000000
RG2 2 0 1000000000000
RG3 3 0 1000000000000
RG4 4 0 1000000000000
RG5 5 0 1000000000000
RG6 6 0 1000000000000
RG7 7 0 1000000000000
RG8 8 0 1000000000000
RG9 9 0 1000000000000
RG10 10 0 1000000000000
RG11 11 0 1000000000000
RG12 12 0 1000000000000
RG13 13 0 1000000000000
RG14 14 0 1000000000000
RG15 15 0 1000000000000
RG16 16 0 1000000000000
RG17 17 0 1000000000000
RG18 18 0 1000000000000
RG19 19 0 1000000000000
RG20 20 0 1000000000000
RG21 21 0 1000000000000
RG22 22 0 1000000000000
RG23 23 0 1000000000000
RG24 24 0 1000000000000
RG25 25 0 1000000000000
RG26 26 0 1000000000000
VS0 5 s0 0
R0 s0 24 27e-1
VS1 0 s1 0
L1 s1 22 12e-2
VS2 0 s2 0
V2 e2 s2 DC 0 AC 68e0 -120
RI2 e2 n2 56e-1
H2 n2 h2 VS8 -56e-2
ED2 h2 16 d2 0 33e-7
F2 0 d2 VS8 1
LD2 d2 0 1
VS3 14 s3 0
R3 s3 16 12e-2
VS4 12 s4 0
C4 s4 3 82e-6
VS5 20 s5 0
L5 s5 6 22e-2
VS6 21 s6 0
R6 s6 24 18e1
VS7 15 s7 0
L7 s7 13 18e-4
VS8 18 s8 0
V8 e8 s8 DC 0 AC 39e0 -120
RI8 e8 n8 82e-1
H8 n8 h8 VS2 -56e-2
ED8 h8 2 d8 0 33e-7
F8 0 d8 VS2 1
LD8 d8 0 1
VS9 0 s9 0
L9 s9 7 68e-3
VS10 2 s10 0
V10 e10 s10 DC 0 AC 15e0 -120
RI10 e10 19 68e-1
VS11 7 s11 0
L11 s11 12 82e-4
VS12 3 s12 0
L12 s12 11 56e-2
VS13 9 s13 0
R13 s13 12 12e0
VS14 17 s14 0
L14 s14 3 18e-4
VS15 14 s15 0
C15 s15 15 18e-5
VS16 17 s16 0
L16 s16 12 27e-4
VS17 5 s17 0
R17 s17 11 27e2
VS18 24 s18 0
L18 s18 25 27e-2
VS19 26 s19 0
R19 s19 16 39e-2
VS20 2 s20 0
L20 s20 23 22e-2
VS21 7 s21 0
R21 s21 25 10e-1
VS22 4 s22 0
C22 s22 5 82e-4
VS23 14 s23 0
C23 s23 8 10e-6
VS24 25 s24 0
R24 s24 24 18e3
VS25 2 s25 0
L25 s25 25 33e-5
VS26 6 s26 0
L26 s26 19 56e-3
VS27 10 s27 0
C27 s27 25 22e-6
VS28 13 s28 0
R28 s28 2 22e2
VS29 17 s29 0
R29 s29 21 68e-1
VS30 17 s30 0
L30 s30 22 47e-5
VS31 6 s31 0
L31 s31 1 27e-4
VS32 9 s32 0
L32 s32 20 39e-5
VS33 11 s33 0
V33 e33 s33 DC 0 AC 47e0 120
RI33 e33 m33 33e-1
LI33 m33 0 22e-5
VS34 22 s34 0
V34 e34 s34 DC 0 AC 22e-1 0
RI34 e34 m34 47e-3
LI34 m34 6 10e-7
VS35 25 s35 0
V35 e35 s35 DC 0 AC 18e-1 0
RI35 e35 m35 18e-3
LI35 m35 16 47e-6
VS36 4 s36 0
C36 s36 16 12e-5
VS37 15 s37 0
C37 s37 18 39e-6
VS38 1 s38 0
R38 s38 7 12e1
VS39 9 s39 0
L39 s39 3 27e-3
VS40 24 s40 0
R40 s40 15 12e1
VS41 22 s41 0
R41 s41 10 33e-1
VS42 14 s42 0
V42 e42 s42 DC 0 AC 68e1 180
RI42 e42 m42 47e-1
LI42 m42 15 47e-6
VS43 12 s43 0
R43 s43 2 12e0
VS44 26 s44 0
L44 s44 23 27e-5
VS45 6 s45 0
V45 e45 s45 DC 0 AC 82e0 120
RI45 e45 m45 12e-1
LI45 m45 26 56e-5
VS46 20 s46 0
L46 s46 8 47e-3
VS47 10 s47 0
R47 s47 22 68e0
.control
set numdgt=17
ac lin 1 60 60
print v(1) v(2) v(3) v(4) v(5) v(6) v(7) v(8) v(9) v(10)
print v(11) v(12) v(13) v(14) v(15) v(16) v(17) v(18) v(19) v(20)
print v(21) v(22) v(23) v(24) v(25) v(26)
print i(vs0) i(vs1) i(vs2) i(vs3) i(vs4) i(vs5) i(vs6) i(vs7) i(vs8) i(vs9)
print i(vs10) i(vs11) i(vs12) i(vs13) i(vs14) i(vs15) i(vs16) i(vs17) i(vs18) i(vs19)
print i(vs20) i(vs21) i(vs22) i(vs23) i(vs24) i(vs25) i(vs26) i(vs27) i(vs28) i(vs29)
print i(vs30) i(vs31) i(vs32) i(vs33) i(vs34) i(vs35) i(vs36) i(vs37) i(vs38) i(vs39)
print i(vs40) i(vs41) i(vs42) i(vs43) i(vs44) i(vs45) i(vs46) i(vs47)
.endc
.end
