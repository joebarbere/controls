controls oracle ac-0385
* Generated (plan F2.7, ADR 0012): do not edit; regenerate with `pnpm sim oracle regen`. ac seed 20261031 index 385 nodes 27 elements 47
.options sparse gmin=1e-12 noopac
RG1 1 0 1000000000000
RG2 2 0 1000000000000
RG3 3 0 1000000000000
RG4 4 0 1000000000000
RG5 5 0 1000000000000
RG6 6 0 1000000000000
RG7 7 0 1000000000000
RG8 8 0 1000000000000
RG9 9 0 1000000000000
RG10 10 0 1000000000000
RG11 11 0 1000000000000
RG12 12 0 1000000000000
RG13 13 0 1000000000000
RG14 14 0 1000000000000
RG15 15 0 1000000000000
RG16 16 0 1000000000000
RG17 17 0 1000000000000
RG18 18 0 1000000000000
RG19 19 0 1000000000000
RG20 20 0 1000000000000
RG21 21 0 1000000000000
RG22 22 0 1000000000000
RG23 23 0 1000000000000
RG24 24 0 1000000000000
RG25 25 0 1000000000000
RG26 26 0 1000000000000
VS0 17 s0 0
L0 s0 3 18e-4
VS1 14 s1 0
R1 s1 2 12e-2
VS2 10 s2 0
R2 s2 22 68e0
VS3 26 s3 0
L3 s3 23 27e-5
VS4 0 s4 0
V4 e4 s4 DC 0 AC 15e0 -120
RI4 e4 19 68e-1
VS5 4 s5 0
C5 s5 5 82e-4
VS6 14 s6 0
C6 s6 8 10e-6
VS7 15 s7 0
L7 s7 13 18e-4
VS8 26 s8 0
R8 s8 2 39e-2
VS9 17 s9 0
L9 s9 12 27e-4
VS10 10 s10 0
C10 s10 25 22e-6
VS11 9 s11 0
L11 s11 20 39e-5
VS12 24 s12 0
L12 s12 25 27e-2
VS13 25 s13 0
V13 e13 s13 DC 0 AC 18e-1 0
RI13 e13 2 18e-3
VS14 11 s14 0
V14 e14 s14 DC 0 AC 47e0 120
RI14 e14 16 33e-1
VS15 18 s15 0
V15 e15 s15 DC 0 AC 39e0 -120
RI15 e15 0 82e-1
VS16 13 s16 0
R16 s16 0 22e2
VS17 6 s17 0
L17 s17 1 27e-4
VS18 6 s18 0
V18 e18 s18 DC 0 AC 82e0 120
RI18 e18 26 12e-1
VS19 1 s19 0
R19 s19 7 12e1
VS20 25 s20 0
R20 s20 24 18e3
VS21 7 s21 0
R21 s21 25 10e-1
VS22 9 s22 0
R22 s22 12 12e0
VS23 22 s23 0
V23 e23 s23 DC 0 AC 22e-1 0
RI23 e23 6 47e-3
VS24 9 s24 0
L24 s24 3 27e-3
VS25 12 s25 0
C25 s25 3 82e-6
VS26 4 s26 0
C26 s26 2 12e-5
VS27 3 s27 0
L27 s27 11 56e-2
VS28 17 s28 0
R28 s28 21 68e-1
VS29 12 s29 0
R29 s29 0 12e0
VS30 16 s30 0
L30 s30 7 68e-3
VS31 24 s31 0
R31 s31 15 12e1
VS32 5 s32 0
R32 s32 24 27e-1
VS33 16 s33 0
V33 e33 s33 DC 0 AC 68e0 -120
RI33 e33 2 56e-1
VS34 5 s34 0
R34 s34 11 27e2
VS35 20 s35 0
L35 s35 6 22e-2
VS36 14 s36 0
V36 e36 s36 DC 0 AC 68e1 180
RI36 e36 15 47e-1
VS37 16 s37 0
L37 s37 22 12e-2
VS38 17 s38 0
L38 s38 22 47e-5
VS39 0 s39 0
L39 s39 25 33e-5
VS40 20 s40 0
L40 s40 8 47e-3
VS41 6 s41 0
L41 s41 19 56e-3
VS42 14 s42 0
C42 s42 15 18e-5
VS43 22 s43 0
R43 s43 10 33e-1
VS44 15 s44 0
C44 s44 18 39e-6
VS45 7 s45 0
L45 s45 12 82e-4
VS46 21 s46 0
R46 s46 24 18e1
.control
set numdgt=17
ac lin 1 60 60
print v(1) v(2) v(3) v(4) v(5) v(6) v(7) v(8) v(9) v(10)
print v(11) v(12) v(13) v(14) v(15) v(16) v(17) v(18) v(19) v(20)
print v(21) v(22) v(23) v(24) v(25) v(26)
print i(vs0) i(vs1) i(vs2) i(vs3) i(vs4) i(vs5) i(vs6) i(vs7) i(vs8) i(vs9)
print i(vs10) i(vs11) i(vs12) i(vs13) i(vs14) i(vs15) i(vs16) i(vs17) i(vs18) i(vs19)
print i(vs20) i(vs21) i(vs22) i(vs23) i(vs24) i(vs25) i(vs26) i(vs27) i(vs28) i(vs29)
print i(vs30) i(vs31) i(vs32) i(vs33) i(vs34) i(vs35) i(vs36) i(vs37) i(vs38) i(vs39)
print i(vs40) i(vs41) i(vs42) i(vs43) i(vs44) i(vs45) i(vs46)
.endc
.end
