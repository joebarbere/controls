controls oracle ac-0427
* Generated (plan F2.7, ADR 0012): do not edit; regenerate with `pnpm sim oracle regen`. ac seed 20261031 index 427 nodes 22 elements 34
.options sparse gmin=1e-12 noopac
RG1 1 0 1000000000000
RG2 2 0 1000000000000
RG3 3 0 1000000000000
RG4 4 0 1000000000000
RG5 5 0 1000000000000
RG6 6 0 1000000000000
RG7 7 0 1000000000000
RG8 8 0 1000000000000
RG9 9 0 1000000000000
RG10 10 0 1000000000000
RG11 11 0 1000000000000
RG12 12 0 1000000000000
RG13 13 0 1000000000000
RG14 14 0 1000000000000
RG15 15 0 1000000000000
RG16 16 0 1000000000000
RG17 17 0 1000000000000
RG18 18 0 1000000000000
RG19 19 0 1000000000000
RG20 20 0 1000000000000
RG21 21 0 1000000000000
VS0 0 s0 0
V0 e0 s0 DC 0 AC 22e-1 0
RI0 e0 m0 68e-1
LI0 m0 20 33e-7
VS1 5 s1 0
C1 s1 1 12e-6
VS2 9 s2 0
R2 s2 13 33e-1
VS3 3 s3 0
L3 s3 1 10e-2
VS4 18 s4 0
C4 s4 7 22e-5
VS5 5 s5 0
V5 e5 s5 DC 0 AC 18e1 180
RI5 e5 12 22e-3
VS6 20 s6 0
C6 s6 5 27e-6
VS7 16 s7 0
R7 s7 17 12e0
VS8 15 s8 0
L8 s8 3 27e-2
VS9 18 s9 0
R9 s9 1 56e-2
VS10 7 s10 0
L10 s10 1 10e-2
VS11 10 s11 0
C11 s11 11 47e-4
VS12 15 s12 0
R12 s12 0 15e-2
VS13 7 s13 0
C13 s13 6 18e-4
VS14 7 s14 0
R14 s14 19 22e-2
VS15 8 s15 0
C15 s15 14 39e-5
VS16 14 s16 0
R16 s16 15 39e2
VS17 6 s17 0
L17 s17 21 33e-2
VS18 6 s18 0
R18 s18 11 82e0
VS19 4 s19 0
R19 s19 10 33e1
VS20 15 s20 0
R20 s20 21 33e-2
VS21 20 s21 0
C21 s21 7 56e-5
VS22 5 s22 0
V22 e22 s22 DC 0 AC 68e1 120
RI22 e22 m22 68e-3
LI22 m22 14 68e-5
VS23 8 s23 0
R23 s23 15 15e0
VS24 10 s24 0
R24 s24 14 33e1
VS25 21 s25 0
R25 s25 10 82e1
VS26 7 s26 0
C26 s26 8 27e-6
VS27 8 s27 0
L27 s27 18 27e-2
VS28 16 s28 0
V28 e28 s28 DC 0 AC 18e0 0
RI28 e28 19 68e-2
VS29 13 s29 0
L29 s29 8 56e-2
VS30 17 s30 0
R30 s30 15 22e-1
VS31 2 s31 0
R31 s31 9 27e-1
VS32 2 s32 0
L32 s32 4 56e-3
VS33 11 s33 0
R33 s33 12 10e-1
.control
set numdgt=17
ac lin 1 60 60
print v(1) v(2) v(3) v(4) v(5) v(6) v(7) v(8) v(9) v(10)
print v(11) v(12) v(13) v(14) v(15) v(16) v(17) v(18) v(19) v(20)
print v(21)
print i(vs0) i(vs1) i(vs2) i(vs3) i(vs4) i(vs5) i(vs6) i(vs7) i(vs8) i(vs9)
print i(vs10) i(vs11) i(vs12) i(vs13) i(vs14) i(vs15) i(vs16) i(vs17) i(vs18) i(vs19)
print i(vs20) i(vs21) i(vs22) i(vs23) i(vs24) i(vs25) i(vs26) i(vs27) i(vs28) i(vs29)
print i(vs30) i(vs31) i(vs32) i(vs33)
.endc
.end
