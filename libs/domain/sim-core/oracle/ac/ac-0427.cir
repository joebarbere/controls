controls oracle ac-0427
* Generated (plan F2.7, ADR 0012): do not edit; regenerate with `pnpm sim oracle regen`. ac seed 20261031 index 427 nodes 22 elements 33
.options sparse gmin=1e-12 noopac
RG1 1 0 1000000000000
RG2 2 0 1000000000000
RG3 3 0 1000000000000
RG4 4 0 1000000000000
RG5 5 0 1000000000000
RG6 6 0 1000000000000
RG7 7 0 1000000000000
RG8 8 0 1000000000000
RG9 9 0 1000000000000
RG10 10 0 1000000000000
RG11 11 0 1000000000000
RG12 12 0 1000000000000
RG13 13 0 1000000000000
RG14 14 0 1000000000000
RG15 15 0 1000000000000
RG16 16 0 1000000000000
RG17 17 0 1000000000000
RG18 18 0 1000000000000
RG19 19 0 1000000000000
RG20 20 0 1000000000000
RG21 21 0 1000000000000
VS0 10 s0 0
R0 s0 3 22e3
VS1 12 s1 0
C1 s1 0 68e-4
VS2 15 s2 0
L2 s2 3 27e-2
VS3 5 s3 0
C3 s3 1 12e-6
VS4 20 s4 0
C4 s4 5 27e-6
VS5 9 s5 0
C5 s5 5 39e-6
VS6 0 s6 0
C6 s6 3 82e-5
VS7 21 s7 0
L7 s7 0 18e-3
VS8 15 s8 0
R8 s8 8 15e-2
VS9 15 s9 0
L9 s9 17 15e-2
VS10 7 s10 0
R10 s10 19 22e-2
VS11 18 s11 0
C11 s11 0 39e-5
VS12 16 s12 0
R12 s12 18 27e2
VS13 3 s13 0
R13 s13 16 68e-1
VS14 0 s14 0
V14 e14 s14 DC 0 AC 27e-1 -120
RI14 e14 8 10e-2
VS15 5 s15 0
V15 e15 s15 DC 0 AC 18e1 180
RI15 e15 12 22e-3
VS16 2 s16 0
R16 s16 9 27e-1
VS17 10 s17 0
R17 s17 14 33e1
VS18 6 s18 0
L18 s18 1 27e-3
VS19 18 s19 0
C19 s19 7 22e-5
VS20 3 s20 0
L20 s20 4 12e-5
VS21 9 s21 0
R21 s21 13 33e-1
VS22 0 s22 0
C22 s22 14 39e-5
VS23 15 s23 0
R23 s23 21 12e3
VS24 5 s24 0
V24 e24 s24 DC 0 AC 68e1 120
RI24 e24 14 68e-3
VS25 4 s25 0
R25 s25 19 82e3
VS26 20 s26 0
R26 s26 15 68e1
VS27 11 s27 0
R27 s27 2 47e0
VS28 2 s28 0
L28 s28 4 56e-3
VS29 5 s29 0
L29 s29 11 82e-4
VS30 14 s30 0
R30 s30 15 12e2
VS31 6 s31 0
R31 s31 3 56e3
VS32 17 s32 0
V32 e32 s32 DC 0 AC 39e0 -120
RI32 e32 13 56e-1
.control
set numdgt=17
ac lin 1 60 60
print v(1) v(2) v(3) v(4) v(5) v(6) v(7) v(8) v(9) v(10)
print v(11) v(12) v(13) v(14) v(15) v(16) v(17) v(18) v(19) v(20)
print v(21)
print i(vs0) i(vs1) i(vs2) i(vs3) i(vs4) i(vs5) i(vs6) i(vs7) i(vs8) i(vs9)
print i(vs10) i(vs11) i(vs12) i(vs13) i(vs14) i(vs15) i(vs16) i(vs17) i(vs18) i(vs19)
print i(vs20) i(vs21) i(vs22) i(vs23) i(vs24) i(vs25) i(vs26) i(vs27) i(vs28) i(vs29)
print i(vs30) i(vs31) i(vs32)
.endc
.end
