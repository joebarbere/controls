controls oracle ac-0427
* Generated (plan F2.7, ADR 0012): do not edit; regenerate with `pnpm sim oracle regen`. ac seed 20261031 index 427 nodes 22 elements 25
.options sparse gmin=1e-12 noopac
RG1 1 0 1000000000000
RG2 2 0 1000000000000
RG3 3 0 1000000000000
RG4 4 0 1000000000000
RG5 5 0 1000000000000
RG6 6 0 1000000000000
RG7 7 0 1000000000000
RG8 8 0 1000000000000
RG9 9 0 1000000000000
RG10 10 0 1000000000000
RG11 11 0 1000000000000
RG12 12 0 1000000000000
RG13 13 0 1000000000000
RG14 14 0 1000000000000
RG15 15 0 1000000000000
RG16 16 0 1000000000000
RG17 17 0 1000000000000
RG18 18 0 1000000000000
RG19 19 0 1000000000000
RG20 20 0 1000000000000
RG21 21 0 1000000000000
VS0 6 s0 0
L0 s0 1 27e-3
VS1 15 s1 0
R1 s1 21 12e3
VS2 0 s2 0
V2 e2 s2 DC 0 AC 39e0 -120
RI2 e2 13 56e-1
VS3 18 s3 0
C3 s3 7 22e-5
VS4 2 s4 0
R4 s4 9 27e-1
VS5 17 s5 0
C5 s5 14 39e-5
VS6 20 s6 0
R6 s6 15 68e1
VS7 15 s7 0
L7 s7 0 15e-2
VS8 11 s8 0
R8 s8 2 47e0
VS9 17 s9 0
C9 s9 3 82e-5
VS10 10 s10 0
R10 s10 14 33e1
VS11 18 s11 0
C11 s11 17 39e-5
VS12 5 s12 0
V12 e12 s12 DC 0 AC 68e1 120
RI12 e12 14 68e-3
VS13 16 s13 0
R13 s13 18 27e2
VS14 15 s14 0
R14 s14 8 15e-2
VS15 9 s15 0
R15 s15 13 33e-1
VS16 5 s16 0
V16 e16 s16 DC 0 AC 18e1 180
RI16 e16 12 22e-3
VS17 15 s17 0
L17 s17 3 27e-2
VS18 20 s18 0
C18 s18 5 27e-6
VS19 2 s19 0
L19 s19 4 56e-3
VS20 5 s20 0
C20 s20 1 12e-6
VS21 10 s21 0
R21 s21 3 22e3
VS22 14 s22 0
R22 s22 15 12e2
VS23 9 s23 0
C23 s23 5 39e-6
VS24 7 s24 0
R24 s24 19 22e-2
.control
set numdgt=17
ac lin 1 60 60
print v(1) v(2) v(3) v(4) v(5) v(6) v(7) v(8) v(9) v(10)
print v(11) v(12) v(13) v(14) v(15) v(16) v(17) v(18) v(19) v(20)
print v(21)
print i(vs0) i(vs1) i(vs2) i(vs3) i(vs4) i(vs5) i(vs6) i(vs7) i(vs8) i(vs9)
print i(vs10) i(vs11) i(vs12) i(vs13) i(vs14) i(vs15) i(vs16) i(vs17) i(vs18) i(vs19)
print i(vs20) i(vs21) i(vs22) i(vs23) i(vs24)
.endc
.end
