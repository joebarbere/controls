controls oracle ac-0362
* Generated (plan F2.7, ADR 0012): do not edit; regenerate with `pnpm sim oracle regen`. ac seed 20261031 index 362 nodes 20 elements 38
.options sparse gmin=1e-12 noopac
RG1 1 0 1000000000000
RG2 2 0 1000000000000
RG3 3 0 1000000000000
RG4 4 0 1000000000000
RG5 5 0 1000000000000
RG6 6 0 1000000000000
RG7 7 0 1000000000000
RG8 8 0 1000000000000
RG9 9 0 1000000000000
RG10 10 0 1000000000000
RG11 11 0 1000000000000
RG12 12 0 1000000000000
RG13 13 0 1000000000000
RG14 14 0 1000000000000
RG15 15 0 1000000000000
RG16 16 0 1000000000000
RG17 17 0 1000000000000
RG18 18 0 1000000000000
RG19 19 0 1000000000000
VS0 16 s0 0
R0 s0 10 27e2
VS1 3 s1 0
C1 s1 16 15e-6
VS2 2 s2 0
L2 s2 9 22e-3
VS3 12 s3 0
L3 s3 0 47e-5
VS4 3 s4 0
R4 s4 17 56e3
VS5 6 s5 0
L5 s5 14 33e-5
VS6 11 s6 0
R6 s6 8 22e1
VS7 17 s7 0
L7 s7 19 12e-5
VS8 0 s8 0
V8 e8 s8 DC 0 AC 56e1 0
RI8 e8 m8 12e-3
LI8 m8 11 82e-6
VS9 18 s9 0
C9 s9 12 47e-5
VS10 10 s10 0
V10 e10 s10 DC 0 AC 12e0 180
RI10 e10 m10 10e-3
LI10 m10 6 15e-7
VS11 13 s11 0
R11 s11 8 47e3
VS12 14 s12 0
C12 s12 12 82e-6
VS13 0 s13 0
R13 s13 5 15e2
VS14 4 s14 0
V14 e14 s14 DC 0 AC 33e0 -120
RI14 e14 9 10e-1
VS15 4 s15 0
L15 s15 17 47e-3
VS16 13 s16 0
C16 s16 3 47e-7
VS17 18 s17 0
R17 s17 10 39e1
VS18 18 s18 0
V18 e18 s18 DC 0 AC 56e-1 0
RI18 e18 19 39e-3
VS19 14 s19 0
L19 s19 17 68e-4
VS20 10 s20 0
C20 s20 17 82e-6
VS21 3 s21 0
R21 s21 6 18e2
VS22 12 s22 0
V22 e22 s22 DC 0 AC 12e0 0
RI22 e22 4 39e-1
VS23 1 s23 0
V23 e23 s23 DC 0 AC 12e0 0
RI23 e23 5 22e-1
VS24 10 s24 0
L24 s24 17 10e-4
VS25 11 s25 0
V25 e25 s25 DC 0 AC 56e1 180
RI25 e25 m25 15e-1
LI25 m25 10 18e-6
VS26 13 s26 0
R26 s26 15 18e2
VS27 17 s27 0
V27 e27 s27 DC 0 AC 12e-1 180
RI27 e27 m27 22e-1
LI27 m27 7 22e-7
VS28 3 s28 0
V28 e28 s28 DC 0 AC 12e0 180
RI28 e28 2 15e-2
VS29 11 s29 0
L29 s29 3 68e-5
VS30 11 s30 0
L30 s30 1 10e-3
VS31 10 s31 0
C31 s31 7 39e-7
VS32 5 s32 0
R32 s32 4 18e-2
VS33 1 s33 0
C33 s33 9 68e-7
VS34 4 s34 0
L34 s34 15 56e-4
VS35 12 s35 0
R35 s35 4 68e0
VS36 3 s36 0
L36 s36 7 47e-3
VS37 12 s37 0
V37 e37 s37 DC 0 AC 56e1 0
RI37 e37 8 18e-2
.control
set numdgt=17
ac lin 1 60 60
print v(1) v(2) v(3) v(4) v(5) v(6) v(7) v(8) v(9) v(10)
print v(11) v(12) v(13) v(14) v(15) v(16) v(17) v(18) v(19)
print i(vs0) i(vs1) i(vs2) i(vs3) i(vs4) i(vs5) i(vs6) i(vs7) i(vs8) i(vs9)
print i(vs10) i(vs11) i(vs12) i(vs13) i(vs14) i(vs15) i(vs16) i(vs17) i(vs18) i(vs19)
print i(vs20) i(vs21) i(vs22) i(vs23) i(vs24) i(vs25) i(vs26) i(vs27) i(vs28) i(vs29)
print i(vs30) i(vs31) i(vs32) i(vs33) i(vs34) i(vs35) i(vs36) i(vs37)
.endc
.end
