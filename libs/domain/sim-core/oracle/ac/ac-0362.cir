controls oracle ac-0362
* Generated (plan F2.7, ADR 0012): do not edit; regenerate with `pnpm sim oracle regen`. ac seed 20261031 index 362 nodes 20 elements 30
.options sparse gmin=1e-12 noopac
RG1 1 0 1000000000000
RG2 2 0 1000000000000
RG3 3 0 1000000000000
RG4 4 0 1000000000000
RG5 5 0 1000000000000
RG6 6 0 1000000000000
RG7 7 0 1000000000000
RG8 8 0 1000000000000
RG9 9 0 1000000000000
RG10 10 0 1000000000000
RG11 11 0 1000000000000
RG12 12 0 1000000000000
RG13 13 0 1000000000000
RG14 14 0 1000000000000
RG15 15 0 1000000000000
RG16 16 0 1000000000000
RG17 17 0 1000000000000
RG18 18 0 1000000000000
RG19 19 0 1000000000000
VS0 14 s0 0
R0 s0 1 10e2
VS1 7 s1 0
C1 s1 13 27e-6
VS2 10 s2 0
L2 s2 17 10e-4
VS3 9 s3 0
C3 s3 5 33e-4
VS4 4 s4 0
L4 s4 17 47e-3
VS5 1 s5 0
R5 s5 5 18e3
VS6 0 s6 0
V6 e6 s6 DC 0 AC 68e-1 0
RI6 e6 m6 27e-1
LI6 m6 7 68e-5
VS7 15 s7 0
L7 s7 18 68e-5
VS8 11 s8 0
R8 s8 8 22e1
VS9 2 s9 0
L9 s9 9 22e-3
VS10 14 s10 0
L10 s10 2 18e-3
VS11 17 s11 0
L11 s11 19 12e-5
VS12 3 s12 0
V12 e12 s12 DC 0 AC 56e1 0
RI12 e12 11 12e-3
VS13 6 s13 0
C13 s13 16 10e-7
VS14 5 s14 0
C14 s14 16 15e-6
VS15 13 s15 0
L15 s15 3 68e-4
VS16 16 s16 0
R16 s16 10 27e2
VS17 5 s17 0
L17 s17 1 56e-2
VS18 11 s18 0
L18 s18 15 15e-3
VS19 12 s19 0
R19 s19 11 68e3
VS20 1 s20 0
L20 s20 15 10e-2
VS21 19 s21 0
V21 e21 s21 DC 0 AC 47e0 180
RI21 e21 m21 39e-3
LI21 m21 6 47e-6
VS22 2 s22 0
V22 e22 s22 DC 0 AC 33e0 -120
RI22 e22 m22 39e-2
LI22 m22 0 27e-5
VS23 15 s23 0
R23 s23 7 18e1
VS24 4 s24 0
L24 s24 15 56e-4
VS25 12 s25 0
R25 s25 9 27e-1
VS26 8 s26 0
R26 s26 6 22e0
VS27 4 s27 0
V27 e27 s27 DC 0 AC 33e0 -120
RI27 e27 m27 10e-1
LI27 m27 9 82e-5
VS28 18 s28 0
C28 s28 9 18e-5
VS29 10 s29 0
R29 s29 13 47e-1
.control
set numdgt=17
ac lin 1 60 60
print v(1) v(2) v(3) v(4) v(5) v(6) v(7) v(8) v(9) v(10)
print v(11) v(12) v(13) v(14) v(15) v(16) v(17) v(18) v(19)
print i(vs0) i(vs1) i(vs2) i(vs3) i(vs4) i(vs5) i(vs6) i(vs7) i(vs8) i(vs9)
print i(vs10) i(vs11) i(vs12) i(vs13) i(vs14) i(vs15) i(vs16) i(vs17) i(vs18) i(vs19)
print i(vs20) i(vs21) i(vs22) i(vs23) i(vs24) i(vs25) i(vs26) i(vs27) i(vs28) i(vs29)
.endc
.end
