controls oracle ac-0243
* Generated (plan F2.7, ADR 0012): do not edit; regenerate with `pnpm sim oracle regen`. ac seed 20261031 index 243 nodes 8 elements 11
.options sparse gmin=1e-12 noopac
RG1 1 0 1000000000000
RG2 2 0 1000000000000
RG3 3 0 1000000000000
RG4 4 0 1000000000000
RG5 5 0 1000000000000
RG6 6 0 1000000000000
RG7 7 0 1000000000000
VS0 6 s0 0
L0 s0 4 33e-3
VS1 1 s1 0
R1 s1 7 39e2
VS2 7 s2 0
C2 s2 2 39e-4
VS3 1 s3 0
R3 s3 2 33e3
VS4 0 s4 0
L4 s4 3 10e-2
VS5 4 s5 0
R5 s5 5 33e3
VS6 2 s6 0
L6 s6 3 15e-3
VS7 0 s7 0
V7 e7 s7 DC 0 AC 27e-1 -120
RI7 e7 7 18e-3
VS8 5 s8 0
V8 e8 s8 DC 0 AC 12e1 0
RI8 e8 m8 22e-1
LI8 m8 3 22e-7
VS9 2 s9 0
R9 s9 6 15e2
VS10 0 s10 0
C10 s10 4 82e-6
.control
set numdgt=17
ac lin 1 60 60
print v(1) v(2) v(3) v(4) v(5) v(6) v(7)
print i(vs0) i(vs1) i(vs2) i(vs3) i(vs4) i(vs5) i(vs6) i(vs7) i(vs8) i(vs9)
print i(vs10)
.endc
.end
