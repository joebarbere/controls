controls oracle ac-0243
* Generated (plan F2.7, ADR 0012): do not edit; regenerate with `pnpm sim oracle regen`. ac seed 20261031 index 243 nodes 8 elements 9
.options sparse gmin=1e-12 noopac
RG1 1 0 1000000000000
RG2 2 0 1000000000000
RG3 3 0 1000000000000
RG4 4 0 1000000000000
RG5 5 0 1000000000000
RG6 6 0 1000000000000
RG7 7 0 1000000000000
VS0 3 s0 0
R0 s0 0 18e3
VS1 1 s1 0
R1 s1 5 33e3
VS2 5 s2 0
R2 s2 6 15e2
VS3 2 s3 0
L3 s3 3 10e-2
VS4 1 s4 0
R4 s4 7 39e2
VS5 0 s5 0
V5 e5 s5 DC 0 AC 12e1 0
RI5 e5 3 22e-1
VS6 5 s6 0
L6 s6 3 15e-3
VS7 4 s7 0
V7 e7 s7 DC 0 AC 10e1 180
RI7 e7 6 33e-1
VS8 7 s8 0
C8 s8 5 39e-4
.control
set numdgt=17
ac lin 1 60 60
print v(1) v(2) v(3) v(4) v(5) v(6) v(7)
print i(vs0) i(vs1) i(vs2) i(vs3) i(vs4) i(vs5) i(vs6) i(vs7) i(vs8)
.endc
.end
