controls oracle ac-0243
* Generated (plan F2.7, ADR 0012): do not edit; regenerate with `pnpm sim oracle regen`. ac seed 20261031 index 243 nodes 8 elements 11
.options sparse gmin=1e-12 noopac
RG1 1 0 1000000000000
RG2 2 0 1000000000000
RG3 3 0 1000000000000
RG4 4 0 1000000000000
RG5 5 0 1000000000000
RG6 6 0 1000000000000
RG7 7 0 1000000000000
VS0 1 s0 0
R0 s0 5 33e3
VS1 5 s1 0
L1 s1 3 15e-3
VS2 0 s2 0
V2 e2 s2 DC 0 AC 12e1 0
RI2 e2 n2 22e-1
H2 n2 h2 VS3 -39e-4
ED2 h2 3 d2 0 -82e-6
F2 0 d2 VS3 1
LD2 d2 0 1
VS3 2 s3 0
V3 e3 s3 DC 0 AC 27e-1 -120
RI3 e3 n3 18e-3
H3 n3 h3 VS2 -39e-4
ED3 h3 6 d3 0 -82e-6
F3 0 d3 VS2 1
LD3 d3 0 1
VS4 0 s4 0
R4 s4 4 68e3
VS5 7 s5 0
C5 s5 5 39e-4
VS6 1 s6 0
R6 s6 7 39e2
VS7 4 s7 0
V7 e7 s7 DC 0 AC 10e1 180
RI7 e7 6 33e-1
VS8 5 s8 0
R8 s8 6 15e2
VS9 2 s9 0
L9 s9 3 10e-2
VS10 4 s10 0
R10 s10 7 18e-2
.control
set numdgt=17
ac lin 1 60 60
print v(1) v(2) v(3) v(4) v(5) v(6) v(7)
print i(vs0) i(vs1) i(vs2) i(vs3) i(vs4) i(vs5) i(vs6) i(vs7) i(vs8) i(vs9)
print i(vs10)
.endc
.end
