controls oracle ac-0322
* Generated (plan F2.7, ADR 0012): do not edit; regenerate with `pnpm sim oracle regen`. ac seed 20261031 index 322 nodes 29 elements 52
.options sparse gmin=1e-12 noopac
RG1 1 0 1000000000000
RG2 2 0 1000000000000
RG3 3 0 1000000000000
RG4 4 0 1000000000000
RG5 5 0 1000000000000
RG6 6 0 1000000000000
RG7 7 0 1000000000000
RG8 8 0 1000000000000
RG9 9 0 1000000000000
RG10 10 0 1000000000000
RG11 11 0 1000000000000
RG12 12 0 1000000000000
RG13 13 0 1000000000000
RG14 14 0 1000000000000
RG15 15 0 1000000000000
RG16 16 0 1000000000000
RG17 17 0 1000000000000
RG18 18 0 1000000000000
RG19 19 0 1000000000000
RG20 20 0 1000000000000
RG21 21 0 1000000000000
RG22 22 0 1000000000000
RG23 23 0 1000000000000
RG24 24 0 1000000000000
RG25 25 0 1000000000000
RG26 26 0 1000000000000
RG27 27 0 1000000000000
RG28 28 0 1000000000000
VS0 26 s0 0
R0 s0 23 12e1
VS1 14 s1 0
C1 s1 19 39e-6
VS2 0 s2 0
V2 e2 s2 DC 0 AC 22e0 120
RI2 e2 16 68e-1
VS3 22 s3 0
L3 s3 20 27e-4
VS4 10 s4 0
V4 e4 s4 DC 0 AC 33e-1 0
RI4 e4 22 22e-2
VS5 18 s5 0
L5 s5 14 18e-4
VS6 15 s6 0
R6 s6 3 33e-2
VS7 9 s7 0
V7 e7 s7 DC 0 AC 18e-1 120
RI7 e7 0 18e-3
VS8 24 s8 0
C8 s8 12 22e-4
VS9 21 s9 0
R9 s9 2 10e1
VS10 23 s10 0
R10 s10 12 27e1
VS11 20 s11 0
L11 s11 14 27e-4
VS12 17 s12 0
R12 s12 28 12e2
VS13 12 s13 0
L13 s13 16 10e-4
VS14 16 s14 0
L14 s14 7 39e-5
VS15 22 s15 0
V15 e15 s15 DC 0 AC 10e1 180
RI15 e15 16 68e-2
VS16 12 s16 0
L16 s16 24 12e-3
VS17 13 s17 0
R17 s17 19 82e1
VS18 9 s18 0
R18 s18 4 82e3
VS19 11 s19 0
C19 s19 26 39e-6
VS20 1 s20 0
R20 s20 28 15e0
VS21 9 s21 0
C21 s21 12 33e-7
VS22 6 s22 0
C22 s22 22 47e-4
VS23 10 s23 0
L23 s23 28 10e-3
VS24 24 s24 0
C24 s24 16 12e-4
VS25 3 s25 0
V25 e25 s25 DC 0 AC 56e-1 120
RI25 e25 18 18e-2
VS26 27 s26 0
C26 s26 20 15e-5
VS27 4 s27 0
L27 s27 20 68e-4
VS28 6 s28 0
L28 s28 16 22e-4
VS29 0 s29 0
R29 s29 2 47e1
VS30 26 s30 0
V30 e30 s30 DC 0 AC 68e1 0
RI30 e30 2 39e-2
VS31 11 s31 0
R31 s31 7 18e-2
VS32 28 s32 0
C32 s32 12 82e-7
VS33 11 s33 0
R33 s33 24 15e2
VS34 15 s34 0
V34 e34 s34 DC 0 AC 33e1 180
RI34 e34 18 47e-3
VS35 1 s35 0
R35 s35 20 27e0
VS36 18 s36 0
C36 s36 2 33e-6
VS37 21 s37 0
R37 s37 16 39e0
VS38 10 s38 0
C38 s38 16 12e-6
VS39 8 s39 0
C39 s39 6 82e-6
VS40 5 s40 0
C40 s40 19 12e-7
VS41 20 s41 0
R41 s41 15 33e0
VS42 24 s42 0
C42 s42 19 47e-4
VS43 8 s43 0
L43 s43 6 18e-2
VS44 13 s44 0
C44 s44 17 56e-6
VS45 0 s45 0
V45 e45 s45 DC 0 AC 27e0 0
RI45 e45 22 56e-1
VS46 6 s46 0
C46 s46 13 18e-4
VS47 0 s47 0
C47 s47 6 22e-5
VS48 17 s48 0
R48 s48 25 12e-2
VS49 22 s49 0
R49 s49 6 33e-2
VS50 22 s50 0
C50 s50 17 10e-5
VS51 5 s51 0
L51 s51 17 33e-2
.control
set numdgt=17
ac lin 1 60 60
print v(1) v(2) v(3) v(4) v(5) v(6) v(7) v(8) v(9) v(10)
print v(11) v(12) v(13) v(14) v(15) v(16) v(17) v(18) v(19) v(20)
print v(21) v(22) v(23) v(24) v(25) v(26) v(27) v(28)
print i(vs0) i(vs1) i(vs2) i(vs3) i(vs4) i(vs5) i(vs6) i(vs7) i(vs8) i(vs9)
print i(vs10) i(vs11) i(vs12) i(vs13) i(vs14) i(vs15) i(vs16) i(vs17) i(vs18) i(vs19)
print i(vs20) i(vs21) i(vs22) i(vs23) i(vs24) i(vs25) i(vs26) i(vs27) i(vs28) i(vs29)
print i(vs30) i(vs31) i(vs32) i(vs33) i(vs34) i(vs35) i(vs36) i(vs37) i(vs38) i(vs39)
print i(vs40) i(vs41) i(vs42) i(vs43) i(vs44) i(vs45) i(vs46) i(vs47) i(vs48) i(vs49)
print i(vs50) i(vs51)
.endc
.end
