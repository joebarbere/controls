controls oracle ac-0322
* Generated (plan F2.7, ADR 0012): do not edit; regenerate with `pnpm sim oracle regen`. ac seed 20261031 index 322 nodes 29 elements 40
.options sparse gmin=1e-12 noopac
RG1 1 0 1000000000000
RG2 2 0 1000000000000
RG3 3 0 1000000000000
RG4 4 0 1000000000000
RG5 5 0 1000000000000
RG6 6 0 1000000000000
RG7 7 0 1000000000000
RG8 8 0 1000000000000
RG9 9 0 1000000000000
RG10 10 0 1000000000000
RG11 11 0 1000000000000
RG12 12 0 1000000000000
RG13 13 0 1000000000000
RG14 14 0 1000000000000
RG15 15 0 1000000000000
RG16 16 0 1000000000000
RG17 17 0 1000000000000
RG18 18 0 1000000000000
RG19 19 0 1000000000000
RG20 20 0 1000000000000
RG21 21 0 1000000000000
RG22 22 0 1000000000000
RG23 23 0 1000000000000
RG24 24 0 1000000000000
RG25 25 0 1000000000000
RG26 26 0 1000000000000
RG27 27 0 1000000000000
RG28 28 0 1000000000000
VS0 10 s0 0
C0 s0 27 15e-6
VS1 4 s1 0
R1 s1 0 33e-2
VS2 20 s2 0
R2 s2 18 56e2
VS3 9 s3 0
R3 s3 4 82e3
VS4 10 s4 0
L4 s4 15 47e-2
VS5 20 s5 0
L5 s5 22 56e-4
VS6 21 s6 0
R6 s6 19 10e1
VS7 9 s7 0
L7 s7 22 10e-4
VS8 23 s8 0
R8 s8 19 15e0
VS9 23 s9 0
C9 s9 3 56e-4
VS10 12 s10 0
R10 s10 1 33e2
VS11 8 s11 0
C11 s11 6 82e-6
VS12 8 s12 0
R12 s12 25 12e1
VS13 15 s13 0
R13 s13 16 27e1
VS14 26 s14 0
L14 s14 9 33e-3
VS15 22 s15 0
R15 s15 26 82e2
VS16 20 s16 0
R16 s16 13 27e3
VS17 0 s17 0
V17 e17 s17 DC 0 AC 82e0 180
RI17 e17 11 39e-3
VS18 24 s18 0
V18 e18 s18 DC 0 AC 68e0 -120
RI18 e18 2 33e-2
VS19 10 s19 0
C19 s19 2 56e-4
VS20 13 s20 0
C20 s20 3 56e-5
VS21 11 s21 0
R21 s21 7 18e-2
VS22 10 s22 0
V22 e22 s22 DC 0 AC 18e-1 0
RI22 e22 16 56e-3
VS23 28 s23 0
R23 s23 2 18e-2
VS24 19 s24 0
C24 s24 12 82e-5
VS25 9 s25 0
L25 s25 21 10e-5
VS26 21 s26 0
R26 s26 16 39e0
VS27 22 s27 0
C27 s27 6 22e-5
VS28 22 s28 0
V28 e28 s28 DC 0 AC 27e0 0
RI28 e28 10 56e-1
VS29 3 s29 0
V29 e29 s29 DC 0 AC 56e-1 120
RI29 e29 18 18e-2
VS30 12 s30 0
C30 s30 9 56e-4
VS31 27 s31 0
R31 s31 14 33e-1
VS32 5 s32 0
L32 s32 17 33e-2
VS33 19 s33 0
L33 s33 13 10e-3
VS34 16 s34 0
L34 s34 7 39e-5
VS35 20 s35 0
L35 s35 28 56e-5
VS36 17 s36 0
C36 s36 22 10e-7
VS37 17 s37 0
R37 s37 25 12e-2
VS38 1 s38 0
L38 s38 5 47e-5
VS39 24 s39 0
C39 s39 14 27e-7
.control
set numdgt=17
ac lin 1 60 60
print v(1) v(2) v(3) v(4) v(5) v(6) v(7) v(8) v(9) v(10)
print v(11) v(12) v(13) v(14) v(15) v(16) v(17) v(18) v(19) v(20)
print v(21) v(22) v(23) v(24) v(25) v(26) v(27) v(28)
print i(vs0) i(vs1) i(vs2) i(vs3) i(vs4) i(vs5) i(vs6) i(vs7) i(vs8) i(vs9)
print i(vs10) i(vs11) i(vs12) i(vs13) i(vs14) i(vs15) i(vs16) i(vs17) i(vs18) i(vs19)
print i(vs20) i(vs21) i(vs22) i(vs23) i(vs24) i(vs25) i(vs26) i(vs27) i(vs28) i(vs29)
print i(vs30) i(vs31) i(vs32) i(vs33) i(vs34) i(vs35) i(vs36) i(vs37) i(vs38) i(vs39)
.endc
.end
