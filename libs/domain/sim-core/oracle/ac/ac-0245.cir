controls oracle ac-0245
* Generated (plan F2.7, ADR 0012): do not edit; regenerate with `pnpm sim oracle regen`. ac seed 20261031 index 245 nodes 21 elements 32
.options sparse gmin=1e-12 noopac
RG1 1 0 1000000000000
RG2 2 0 1000000000000
RG3 3 0 1000000000000
RG4 4 0 1000000000000
RG5 5 0 1000000000000
RG6 6 0 1000000000000
RG7 7 0 1000000000000
RG8 8 0 1000000000000
RG9 9 0 1000000000000
RG10 10 0 1000000000000
RG11 11 0 1000000000000
RG12 12 0 1000000000000
RG13 13 0 1000000000000
RG14 14 0 1000000000000
RG15 15 0 1000000000000
RG16 16 0 1000000000000
RG17 17 0 1000000000000
RG18 18 0 1000000000000
RG19 19 0 1000000000000
RG20 20 0 1000000000000
VS0 13 s0 0
L0 s0 14 47e-5
VS1 0 s1 0
V1 e1 s1 DC 0 AC 15e1 120
RI1 e1 m1 18e-3
LI1 m1 12 47e-5
VS2 9 s2 0
L2 s2 11 27e-4
VS3 20 s3 0
V3 e3 s3 DC 0 AC 68e1 -120
RI3 e3 18 10e-3
VS4 14 s4 0
L4 s4 10 39e-4
VS5 20 s5 0
C5 s5 11 47e-5
VS6 19 s6 0
L6 s6 0 82e-2
VS7 4 s7 0
L7 s7 16 39e-3
VS8 4 s8 0
C8 s8 2 33e-5
VS9 4 s9 0
C9 s9 13 18e-6
VS10 8 s10 0
V10 e10 s10 DC 0 AC 56e1 -120
RI10 e10 m10 27e-1
LI10 m10 10 82e-6
VS11 16 s11 0
R11 s11 7 82e-2
VS12 0 s12 0
L12 s12 9 68e-4
VS13 1 s13 0
V13 e13 s13 DC 0 AC 22e-1 0
RI13 e13 m13 82e-2
LI13 m13 20 27e-6
VS14 14 s14 0
V14 e14 s14 DC 0 AC 18e1 120
RI14 e14 16 56e-2
VS15 15 s15 0
V15 e15 s15 DC 0 AC 47e-1 180
RI15 e15 m15 12e-2
LI15 m15 16 33e-5
VS16 19 s16 0
R16 s16 17 27e3
VS17 18 s17 0
C17 s17 17 47e-5
VS18 20 s18 0
R18 s18 16 33e2
VS19 15 s19 0
R19 s19 18 15e2
VS20 19 s20 0
V20 e20 s20 DC 0 AC 39e1 180
RI20 e20 17 10e-3
VS21 2 s21 0
R21 s21 14 39e0
VS22 10 s22 0
L22 s22 5 12e-4
VS23 7 s23 0
R23 s23 3 22e-2
VS24 8 s24 0
L24 s24 5 68e-3
VS25 0 s25 0
L25 s25 3 18e-4
VS26 17 s26 0
C26 s26 8 47e-5
VS27 12 s27 0
C27 s27 11 47e-7
VS28 16 s28 0
V28 e28 s28 DC 0 AC 47e-1 120
RI28 e28 6 18e-3
VS29 1 s29 0
L29 s29 16 12e-4
VS30 20 s30 0
L30 s30 6 56e-4
VS31 0 s31 0
C31 s31 10 68e-5
.control
set numdgt=17
ac lin 1 60 60
print v(1) v(2) v(3) v(4) v(5) v(6) v(7) v(8) v(9) v(10)
print v(11) v(12) v(13) v(14) v(15) v(16) v(17) v(18) v(19) v(20)
print i(vs0) i(vs1) i(vs2) i(vs3) i(vs4) i(vs5) i(vs6) i(vs7) i(vs8) i(vs9)
print i(vs10) i(vs11) i(vs12) i(vs13) i(vs14) i(vs15) i(vs16) i(vs17) i(vs18) i(vs19)
print i(vs20) i(vs21) i(vs22) i(vs23) i(vs24) i(vs25) i(vs26) i(vs27) i(vs28) i(vs29)
print i(vs30) i(vs31)
.endc
.end
