controls oracle ac-0245
* Generated (plan F2.7, ADR 0012): do not edit; regenerate with `pnpm sim oracle regen`. ac seed 20261031 index 245 nodes 21 elements 40
.options sparse gmin=1e-12 noopac
RG1 1 0 1000000000000
RG2 2 0 1000000000000
RG3 3 0 1000000000000
RG4 4 0 1000000000000
RG5 5 0 1000000000000
RG6 6 0 1000000000000
RG7 7 0 1000000000000
RG8 8 0 1000000000000
RG9 9 0 1000000000000
RG10 10 0 1000000000000
RG11 11 0 1000000000000
RG12 12 0 1000000000000
RG13 13 0 1000000000000
RG14 14 0 1000000000000
RG15 15 0 1000000000000
RG16 16 0 1000000000000
RG17 17 0 1000000000000
RG18 18 0 1000000000000
RG19 19 0 1000000000000
RG20 20 0 1000000000000
VS0 4 s0 0
R0 s0 8 56e3
VS1 5 s1 0
L1 s1 15 15e-5
VS2 0 s2 0
V2 e2 s2 DC 0 AC 27e-1 120
RI2 e2 11 39e-1
VS3 6 s3 0
C3 s3 13 82e-4
VS4 10 s4 0
C4 s4 13 15e-4
VS5 8 s5 0
R5 s5 1 10e2
VS6 6 s6 0
L6 s6 17 27e-3
VS7 9 s7 0
L7 s7 19 10e-5
VS8 4 s8 0
R8 s8 2 10e-2
VS9 10 s9 0
V9 e9 s9 DC 0 AC 10e1 180
RI9 e9 15 68e-3
VS10 11 s10 0
R10 s10 14 56e3
VS11 15 s11 0
V11 e11 s11 DC 0 AC 12e1 120
RI11 e11 m11 27e-3
LI11 m11 18 39e-6
VS12 8 s12 0
L12 s12 10 39e-4
VS13 16 s13 0
V13 e13 s13 DC 0 AC 68e-1 180
RI13 e13 14 33e-1
VS14 4 s14 0
V14 e14 s14 DC 0 AC 15e1 120
RI14 e14 m14 18e-3
LI14 m14 0 12e-6
VS15 17 s15 0
V15 e15 s15 DC 0 AC 22e0 -120
RI15 e15 13 56e-2
VS16 12 s16 0
R16 s16 4 18e3
VS17 15 s17 0
R17 s17 10 22e3
VS18 4 s18 0
V18 e18 s18 DC 0 AC 10e1 180
RI18 e18 8 47e-1
VS19 10 s19 0
V19 e19 s19 DC 0 AC 47e0 120
RI19 e19 7 12e-1
VS20 17 s20 0
C20 s20 4 10e-5
VS21 19 s21 0
C21 s21 3 39e-5
VS22 2 s22 0
C22 s22 18 10e-6
VS23 13 s23 0
V23 e23 s23 DC 0 AC 18e0 120
RI23 e23 9 22e-1
VS24 16 s24 0
R24 s24 20 47e3
VS25 7 s25 0
L25 s25 3 56e-3
VS26 0 s26 0
C26 s26 7 33e-7
VS27 3 s27 0
R27 s27 0 33e2
VS28 14 s28 0
R28 s28 1 68e2
VS29 14 s29 0
R29 s29 9 12e-1
VS30 11 s30 0
L30 s30 8 47e-5
VS31 20 s31 0
R31 s31 16 56e0
VS32 12 s32 0
L32 s32 8 22e-3
VS33 5 s33 0
L33 s33 17 22e-2
VS34 20 s34 0
L34 s34 4 22e-3
VS35 8 s35 0
V35 e35 s35 DC 0 AC 18e1 120
RI35 e35 16 56e-2
VS36 16 s36 0
C36 s36 5 56e-6
VS37 3 s37 0
V37 e37 s37 DC 0 AC 68e1 180
RI37 e37 m37 47e-1
LI37 m37 8 22e-6
VS38 7 s38 0
V38 e38 s38 DC 0 AC 47e-1 120
RI38 e38 11 18e-3
VS39 17 s39 0
C39 s39 8 82e-4
.control
set numdgt=17
ac lin 1 60 60
print v(1) v(2) v(3) v(4) v(5) v(6) v(7) v(8) v(9) v(10)
print v(11) v(12) v(13) v(14) v(15) v(16) v(17) v(18) v(19) v(20)
print i(vs0) i(vs1) i(vs2) i(vs3) i(vs4) i(vs5) i(vs6) i(vs7) i(vs8) i(vs9)
print i(vs10) i(vs11) i(vs12) i(vs13) i(vs14) i(vs15) i(vs16) i(vs17) i(vs18) i(vs19)
print i(vs20) i(vs21) i(vs22) i(vs23) i(vs24) i(vs25) i(vs26) i(vs27) i(vs28) i(vs29)
print i(vs30) i(vs31) i(vs32) i(vs33) i(vs34) i(vs35) i(vs36) i(vs37) i(vs38) i(vs39)
.endc
.end
