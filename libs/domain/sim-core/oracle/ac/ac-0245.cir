controls oracle ac-0245
* Generated (plan F2.7, ADR 0012): do not edit; regenerate with `pnpm sim oracle regen`. ac seed 20261031 index 245 nodes 21 elements 25
.options sparse gmin=1e-12 noopac
RG1 1 0 1000000000000
RG2 2 0 1000000000000
RG3 3 0 1000000000000
RG4 4 0 1000000000000
RG5 5 0 1000000000000
RG6 6 0 1000000000000
RG7 7 0 1000000000000
RG8 8 0 1000000000000
RG9 9 0 1000000000000
RG10 10 0 1000000000000
RG11 11 0 1000000000000
RG12 12 0 1000000000000
RG13 13 0 1000000000000
RG14 14 0 1000000000000
RG15 15 0 1000000000000
RG16 16 0 1000000000000
RG17 17 0 1000000000000
RG18 18 0 1000000000000
RG19 19 0 1000000000000
RG20 20 0 1000000000000
VS0 14 s0 0
L0 s0 10 39e-4
VS1 8 s1 0
L1 s1 5 68e-3
VS2 0 s2 0
V2 e2 s2 DC 0 AC 15e1 120
RI2 e2 12 18e-3
VS3 4 s3 0
L3 s3 16 39e-3
VS4 20 s4 0
L4 s4 6 56e-4
VS5 4 s5 0
C5 s5 13 18e-6
VS6 0 s6 0
L6 s6 3 18e-4
VS7 1 s7 0
L7 s7 16 12e-4
VS8 19 s8 0
L8 s8 0 82e-2
VS9 0 s9 0
C9 s9 10 68e-5
VS10 0 s10 0
L10 s10 9 68e-4
VS11 20 s11 0
R11 s11 16 33e2
VS12 20 s12 0
V12 e12 s12 DC 0 AC 68e1 -120
RI12 e12 18 10e-3
VS13 14 s13 0
V13 e13 s13 DC 0 AC 18e1 120
RI13 e13 16 56e-2
VS14 10 s14 0
L14 s14 5 12e-4
VS15 16 s15 0
R15 s15 7 82e-2
VS16 20 s16 0
C16 s16 11 47e-5
VS17 19 s17 0
R17 s17 17 27e3
VS18 18 s18 0
C18 s18 17 47e-5
VS19 15 s19 0
R19 s19 18 15e2
VS20 4 s20 0
C20 s20 2 33e-5
VS21 2 s21 0
R21 s21 14 39e0
VS22 19 s22 0
V22 e22 s22 DC 0 AC 39e1 180
RI22 e22 17 10e-3
VS23 15 s23 0
V23 e23 s23 DC 0 AC 47e-1 180
RI23 e23 16 12e-2
VS24 8 s24 0
V24 e24 s24 DC 0 AC 56e1 -120
RI24 e24 10 27e-1
.control
set numdgt=17
ac lin 1 60 60
print v(1) v(2) v(3) v(4) v(5) v(6) v(7) v(8) v(9) v(10)
print v(11) v(12) v(13) v(14) v(15) v(16) v(17) v(18) v(19) v(20)
print i(vs0) i(vs1) i(vs2) i(vs3) i(vs4) i(vs5) i(vs6) i(vs7) i(vs8) i(vs9)
print i(vs10) i(vs11) i(vs12) i(vs13) i(vs14) i(vs15) i(vs16) i(vs17) i(vs18) i(vs19)
print i(vs20) i(vs21) i(vs22) i(vs23) i(vs24)
.endc
.end
