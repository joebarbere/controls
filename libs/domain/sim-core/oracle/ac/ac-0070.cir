controls oracle ac-0070
* Generated (plan F2.7, ADR 0012): do not edit; regenerate with `pnpm sim oracle regen`. ac seed 20261031 index 70 nodes 21 elements 30
.options sparse gmin=1e-12 noopac
RG1 1 0 1000000000000
RG2 2 0 1000000000000
RG3 3 0 1000000000000
RG4 4 0 1000000000000
RG5 5 0 1000000000000
RG6 6 0 1000000000000
RG7 7 0 1000000000000
RG8 8 0 1000000000000
RG9 9 0 1000000000000
RG10 10 0 1000000000000
RG11 11 0 1000000000000
RG12 12 0 1000000000000
RG13 13 0 1000000000000
RG14 14 0 1000000000000
RG15 15 0 1000000000000
RG16 16 0 1000000000000
RG17 17 0 1000000000000
RG18 18 0 1000000000000
RG19 19 0 1000000000000
RG20 20 0 1000000000000
VS0 0 s0 0
R0 s0 18 47e-1
VS1 11 s1 0
L1 s1 20 15e-3
VS2 6 s2 0
R2 s2 10 82e3
VS3 3 s3 0
L3 s3 8 39e-3
VS4 11 s4 0
R4 s4 5 27e-2
VS5 0 s5 0
V5 e5 s5 DC 0 AC 18e1 -120
RI5 e5 11 10e-2
VS6 14 s6 0
R6 s6 9 82e3
VS7 19 s7 0
V7 e7 s7 DC 0 AC 39e-1 -120
RI7 e7 2 18e-3
VS8 15 s8 0
L8 s8 5 15e-5
VS9 7 s9 0
V9 e9 s9 DC 0 AC 10e-1 180
RI9 e9 15 68e-1
VS10 4 s10 0
L10 s10 8 22e-5
VS11 15 s11 0
L11 s11 8 12e-4
VS12 14 s12 0
L12 s12 5 68e-4
VS13 4 s13 0
L13 s13 19 10e-4
VS14 3 s14 0
C14 s14 2 47e-4
VS15 7 s15 0
V15 e15 s15 DC 0 AC 10e1 0
RI15 e15 2 10e-3
VS16 10 s16 0
L16 s16 5 39e-3
VS17 0 s17 0
L17 s17 19 22e-4
VS18 13 s18 0
R18 s18 18 39e3
VS19 8 s19 0
R19 s19 19 33e-1
VS20 18 s20 0
V20 e20 s20 DC 0 AC 15e0 -120
RI20 e20 12 39e-2
VS21 1 s21 0
L21 s21 4 39e-4
VS22 14 s22 0
L22 s22 5 33e-4
VS23 16 s23 0
L23 s23 19 39e-4
VS24 17 s24 0
L24 s24 8 33e-3
VS25 19 s25 0
V25 e25 s25 DC 0 AC 18e0 -120
RI25 e25 11 39e-2
VS26 19 s26 0
C26 s26 1 39e-5
VS27 20 s27 0
L27 s27 5 33e-3
VS28 2 s28 0
R28 s28 6 39e-2
VS29 8 s29 0
C29 s29 2 56e-5
.control
set numdgt=17
ac lin 1 60 60
print v(1) v(2) v(3) v(4) v(5) v(6) v(7) v(8) v(9) v(10)
print v(11) v(12) v(13) v(14) v(15) v(16) v(17) v(18) v(19) v(20)
print i(vs0) i(vs1) i(vs2) i(vs3) i(vs4) i(vs5) i(vs6) i(vs7) i(vs8) i(vs9)
print i(vs10) i(vs11) i(vs12) i(vs13) i(vs14) i(vs15) i(vs16) i(vs17) i(vs18) i(vs19)
print i(vs20) i(vs21) i(vs22) i(vs23) i(vs24) i(vs25) i(vs26) i(vs27) i(vs28) i(vs29)
.endc
.end
