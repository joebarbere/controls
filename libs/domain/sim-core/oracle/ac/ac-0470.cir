controls oracle ac-0470
* Generated (plan F2.7, ADR 0012): do not edit; regenerate with `pnpm sim oracle regen`. ac seed 20261031 index 470 nodes 14 elements 22
.options sparse gmin=1e-12 noopac
RG1 1 0 1000000000000
RG2 2 0 1000000000000
RG3 3 0 1000000000000
RG4 4 0 1000000000000
RG5 5 0 1000000000000
RG6 6 0 1000000000000
RG7 7 0 1000000000000
RG8 8 0 1000000000000
RG9 9 0 1000000000000
RG10 10 0 1000000000000
RG11 11 0 1000000000000
RG12 12 0 1000000000000
RG13 13 0 1000000000000
VS0 8 s0 0
L0 s0 7 15e-5
VS1 13 s1 0
R1 s1 2 39e3
VS2 0 s2 0
V2 e2 s2 DC 0 AC 15e-1 180
RI2 e2 6 56e-2
VS3 3 s3 0
R3 s3 1 12e3
VS4 7 s4 0
V4 e4 s4 DC 0 AC 12e0 0
RI4 e4 13 33e-1
VS5 10 s5 0
R5 s5 3 22e0
VS6 9 s6 0
C6 s6 12 56e-6
VS7 6 s7 0
L7 s7 11 27e-5
VS8 7 s8 0
L8 s8 4 15e-5
VS9 13 s9 0
C9 s9 7 18e-5
VS10 5 s10 0
C10 s10 2 27e-7
VS11 6 s11 0
R11 s11 2 68e3
VS12 3 s12 0
R12 s12 13 47e-1
VS13 11 s13 0
R13 s13 6 47e3
VS14 11 s14 0
C14 s14 9 68e-6
VS15 5 s15 0
R15 s15 3 22e1
VS16 1 s16 0
L16 s16 12 12e-4
VS17 1 s17 0
V17 e17 s17 DC 0 AC 18e1 0
RI17 e17 13 47e-2
VS18 6 s18 0
R18 s18 3 12e1
VS19 9 s19 0
R19 s19 5 22e-2
VS20 4 s20 0
C20 s20 10 82e-4
VS21 1 s21 0
V21 e21 s21 DC 0 AC 47e1 180
RI21 e21 6 10e-2
.control
set numdgt=17
ac lin 1 60 60
print v(1) v(2) v(3) v(4) v(5) v(6) v(7) v(8) v(9) v(10)
print v(11) v(12) v(13)
print i(vs0) i(vs1) i(vs2) i(vs3) i(vs4) i(vs5) i(vs6) i(vs7) i(vs8) i(vs9)
print i(vs10) i(vs11) i(vs12) i(vs13) i(vs14) i(vs15) i(vs16) i(vs17) i(vs18) i(vs19)
print i(vs20) i(vs21)
.endc
.end
