controls oracle ac-0470
* Generated (plan F2.7, ADR 0012): do not edit; regenerate with `pnpm sim oracle regen`. ac seed 20261031 index 470 nodes 14 elements 24
.options sparse gmin=1e-12 noopac
RG1 1 0 1000000000000
RG2 2 0 1000000000000
RG3 3 0 1000000000000
RG4 4 0 1000000000000
RG5 5 0 1000000000000
RG6 6 0 1000000000000
RG7 7 0 1000000000000
RG8 8 0 1000000000000
RG9 9 0 1000000000000
RG10 10 0 1000000000000
RG11 11 0 1000000000000
RG12 12 0 1000000000000
RG13 13 0 1000000000000
VS0 11 s0 0
R0 s0 7 47e3
VS1 7 s1 0
L1 s1 8 56e-3
VS2 5 s2 0
C2 s2 2 27e-7
VS3 3 s3 0
R3 s3 13 47e-1
VS4 1 s4 0
L4 s4 12 12e-4
VS5 0 s5 0
V5 e5 s5 DC 0 AC 12e0 0
RI5 e5 13 33e-1
VS6 4 s6 0
C6 s6 10 82e-4
VS7 13 s7 0
C7 s7 0 18e-5
VS8 1 s8 0
V8 e8 s8 DC 0 AC 18e1 0
RI8 e8 13 47e-2
VS9 9 s9 0
R9 s9 5 22e-2
VS10 0 s10 0
L10 s10 4 15e-5
VS11 9 s11 0
C11 s11 12 56e-6
VS12 7 s12 0
L12 s12 11 27e-5
VS13 10 s13 0
R13 s13 3 22e0
VS14 7 s14 0
R14 s14 2 68e3
VS15 6 s15 0
V15 e15 s15 DC 0 AC 15e-1 180
RI15 e15 7 56e-2
VS16 8 s16 0
L16 s16 0 15e-5
VS17 11 s17 0
C17 s17 9 68e-6
VS18 1 s18 0
V18 e18 s18 DC 0 AC 47e1 180
RI18 e18 7 10e-2
VS19 6 s19 0
R19 s19 9 10e2
VS20 13 s20 0
R20 s20 2 39e3
VS21 7 s21 0
R21 s21 3 12e1
VS22 3 s22 0
R22 s22 1 12e3
VS23 5 s23 0
R23 s23 3 22e1
.control
set numdgt=17
ac lin 1 60 60
print v(1) v(2) v(3) v(4) v(5) v(6) v(7) v(8) v(9) v(10)
print v(11) v(12) v(13)
print i(vs0) i(vs1) i(vs2) i(vs3) i(vs4) i(vs5) i(vs6) i(vs7) i(vs8) i(vs9)
print i(vs10) i(vs11) i(vs12) i(vs13) i(vs14) i(vs15) i(vs16) i(vs17) i(vs18) i(vs19)
print i(vs20) i(vs21) i(vs22) i(vs23)
.endc
.end
