controls oracle ac-0470
* Generated (plan F2.7, ADR 0012): do not edit; regenerate with `pnpm sim oracle regen`. ac seed 20261031 index 470 nodes 14 elements 22
.options sparse gmin=1e-12 noopac
RG1 1 0 1000000000000
RG2 2 0 1000000000000
RG3 3 0 1000000000000
RG4 4 0 1000000000000
RG5 5 0 1000000000000
RG6 6 0 1000000000000
RG7 7 0 1000000000000
RG8 8 0 1000000000000
RG9 9 0 1000000000000
RG10 10 0 1000000000000
RG11 11 0 1000000000000
RG12 12 0 1000000000000
RG13 13 0 1000000000000
VS0 12 s0 0
R0 s0 6 47e3
VS1 8 s1 0
R1 s1 12 22e2
VS2 12 s2 0
L2 s2 0 12e-4
VS3 3 s3 0
L3 s3 13 27e-2
VS4 9 s4 0
L4 s4 10 18e-3
VS5 6 s5 0
L5 s5 8 56e-4
VS6 5 s6 0
R6 s6 1 56e2
VS7 0 s7 0
R7 s7 2 39e3
VS8 5 s8 0
C8 s8 10 68e-6
VS9 6 s9 0
C9 s9 7 82e-4
VS10 0 s10 0
V10 e10 s10 DC 0 AC 27e1 0
RI10 e10 m10 68e-2
LI10 m10 1 82e-5
VS11 1 s11 0
V11 e11 s11 DC 0 AC 47e1 180
RI11 e11 13 10e-2
VS12 11 s12 0
C12 s12 3 39e-7
VS13 3 s13 0
L13 s13 7 47e-3
VS14 13 s14 0
R14 s14 3 12e1
VS15 3 s15 0
R15 s15 0 47e-1
VS16 9 s16 0
L16 s16 3 10e-4
VS17 13 s17 0
R17 s17 2 68e3
VS18 10 s18 0
C18 s18 2 56e-6
VS19 11 s19 0
V19 e19 s19 DC 0 AC 22e-1 -120
RI19 e19 8 22e-1
VS20 4 s20 0
V20 e20 s20 DC 0 AC 15e-1 180
RI20 e20 13 56e-2
VS21 1 s21 0
L21 s21 4 56e-3
.control
set numdgt=17
ac lin 1 60 60
print v(1) v(2) v(3) v(4) v(5) v(6) v(7) v(8) v(9) v(10)
print v(11) v(12) v(13)
print i(vs0) i(vs1) i(vs2) i(vs3) i(vs4) i(vs5) i(vs6) i(vs7) i(vs8) i(vs9)
print i(vs10) i(vs11) i(vs12) i(vs13) i(vs14) i(vs15) i(vs16) i(vs17) i(vs18) i(vs19)
print i(vs20) i(vs21)
.endc
.end
