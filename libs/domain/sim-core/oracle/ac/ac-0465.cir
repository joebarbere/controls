controls oracle ac-0465
* Generated (plan F2.7, ADR 0012): do not edit; regenerate with `pnpm sim oracle regen`. ac seed 20261031 index 465 nodes 27 elements 42
.options sparse gmin=1e-12 noopac
RG1 1 0 1000000000000
RG2 2 0 1000000000000
RG3 3 0 1000000000000
RG4 4 0 1000000000000
RG5 5 0 1000000000000
RG6 6 0 1000000000000
RG7 7 0 1000000000000
RG8 8 0 1000000000000
RG9 9 0 1000000000000
RG10 10 0 1000000000000
RG11 11 0 1000000000000
RG12 12 0 1000000000000
RG13 13 0 1000000000000
RG14 14 0 1000000000000
RG15 15 0 1000000000000
RG16 16 0 1000000000000
RG17 17 0 1000000000000
RG18 18 0 1000000000000
RG19 19 0 1000000000000
RG20 20 0 1000000000000
RG21 21 0 1000000000000
RG22 22 0 1000000000000
RG23 23 0 1000000000000
RG24 24 0 1000000000000
RG25 25 0 1000000000000
RG26 26 0 1000000000000
VS0 22 s0 0
C0 s0 18 33e-7
VS1 6 s1 0
R1 s1 7 68e-1
VS2 4 s2 0
L2 s2 8 22e-4
VS3 20 s3 0
L3 s3 16 47e-3
VS4 10 s4 0
C4 s4 0 56e-7
VS5 6 s5 0
R5 s5 24 47e2
VS6 0 s6 0
V6 e6 s6 DC 0 AC 15e0 120
RI6 e6 2 15e-2
VS7 14 s7 0
V7 e7 s7 DC 0 AC 39e-1 180
RI7 e7 16 47e-3
VS8 2 s8 0
R8 s8 23 47e0
VS9 20 s9 0
C9 s9 7 12e-7
VS10 10 s10 0
L10 s10 2 18e-2
VS11 10 s11 0
R11 s11 4 12e1
VS12 22 s12 0
C12 s12 6 18e-7
VS13 12 s13 0
R13 s13 2 10e3
VS14 9 s14 0
R14 s14 14 68e0
VS15 22 s15 0
R15 s15 21 56e1
VS16 25 s16 0
C16 s16 23 56e-4
VS17 6 s17 0
C17 s17 26 39e-7
VS18 21 s18 0
R18 s18 17 22e-1
VS19 13 s19 0
L19 s19 1 12e-5
VS20 12 s20 0
R20 s20 15 68e2
VS21 9 s21 0
R21 s21 2 12e-2
VS22 13 s22 0
C22 s22 3 27e-7
VS23 16 s23 0
V23 e23 s23 DC 0 AC 27e0 0
RI23 e23 25 22e-3
VS24 4 s24 0
C24 s24 8 18e-7
VS25 16 s25 0
R25 s25 7 27e1
VS26 21 s26 0
L26 s26 1 18e-4
VS27 5 s27 0
C27 s27 1 33e-5
VS28 2 s28 0
R28 s28 4 22e-2
VS29 18 s29 0
C29 s29 23 22e-6
VS30 21 s30 0
V30 e30 s30 DC 0 AC 27e1 180
RI30 e30 20 47e-3
VS31 18 s31 0
C31 s31 7 39e-4
VS32 21 s32 0
V32 e32 s32 DC 0 AC 33e1 0
RI32 e32 13 33e-1
VS33 21 s33 0
V33 e33 s33 DC 0 AC 18e-1 120
RI33 e33 7 12e-3
VS34 9 s34 0
L34 s34 21 10e-5
VS35 26 s35 0
R35 s35 2 12e0
VS36 8 s36 0
C36 s36 24 27e-7
VS37 23 s37 0
V37 e37 s37 DC 0 AC 18e0 180
RI37 e37 2 22e-2
VS38 24 s38 0
C38 s38 17 15e-5
VS39 13 s39 0
R39 s39 11 47e0
VS40 19 s40 0
R40 s40 23 39e1
VS41 5 s41 0
C41 s41 0 10e-4
.control
set numdgt=17
ac lin 1 60 60
print v(1) v(2) v(3) v(4) v(5) v(6) v(7) v(8) v(9) v(10)
print v(11) v(12) v(13) v(14) v(15) v(16) v(17) v(18) v(19) v(20)
print v(21) v(22) v(23) v(24) v(25) v(26)
print i(vs0) i(vs1) i(vs2) i(vs3) i(vs4) i(vs5) i(vs6) i(vs7) i(vs8) i(vs9)
print i(vs10) i(vs11) i(vs12) i(vs13) i(vs14) i(vs15) i(vs16) i(vs17) i(vs18) i(vs19)
print i(vs20) i(vs21) i(vs22) i(vs23) i(vs24) i(vs25) i(vs26) i(vs27) i(vs28) i(vs29)
print i(vs30) i(vs31) i(vs32) i(vs33) i(vs34) i(vs35) i(vs36) i(vs37) i(vs38) i(vs39)
print i(vs40) i(vs41)
.endc
.end
