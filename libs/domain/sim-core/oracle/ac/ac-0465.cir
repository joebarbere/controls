controls oracle ac-0465
* Generated (plan F2.7, ADR 0012): do not edit; regenerate with `pnpm sim oracle regen`. ac seed 20261031 index 465 nodes 27 elements 53
.options sparse gmin=1e-12 noopac
RG1 1 0 1000000000000
RG2 2 0 1000000000000
RG3 3 0 1000000000000
RG4 4 0 1000000000000
RG5 5 0 1000000000000
RG6 6 0 1000000000000
RG7 7 0 1000000000000
RG8 8 0 1000000000000
RG9 9 0 1000000000000
RG10 10 0 1000000000000
RG11 11 0 1000000000000
RG12 12 0 1000000000000
RG13 13 0 1000000000000
RG14 14 0 1000000000000
RG15 15 0 1000000000000
RG16 16 0 1000000000000
RG17 17 0 1000000000000
RG18 18 0 1000000000000
RG19 19 0 1000000000000
RG20 20 0 1000000000000
RG21 21 0 1000000000000
RG22 22 0 1000000000000
RG23 23 0 1000000000000
RG24 24 0 1000000000000
RG25 25 0 1000000000000
RG26 26 0 1000000000000
VS0 12 s0 0
L0 s0 22 47e-5
VS1 0 s1 0
V1 e1 s1 DC 0 AC 12e0 -120
RI1 e1 m1 56e-3
LI1 m1 3 33e-6
VS2 0 s2 0
V2 e2 s2 DC 0 AC 15e0 120
RI2 e2 m2 15e-2
LI2 m2 2 10e-7
VS3 11 s3 0
C3 s3 15 10e-4
VS4 20 s4 0
C4 s4 19 39e-5
VS5 19 s5 0
R5 s5 13 68e1
VS6 4 s6 0
R6 s6 9 82e-1
VS7 0 s7 0
L7 s7 22 18e-4
VS8 5 s8 0
R8 s8 6 39e-1
VS9 1 s9 0
V9 e9 s9 DC 0 AC 22e0 180
RI9 e9 19 82e-3
VS10 8 s10 0
R10 s10 17 68e2
VS11 9 s11 0
R11 s11 2 12e-2
VS12 21 s12 0
R12 s12 17 22e-1
VS13 26 s13 0
R13 s13 1 18e3
VS14 19 s14 0
R14 s14 6 10e3
VS15 4 s15 0
V15 e15 s15 DC 0 AC 68e0 180
RI15 e15 m15 15e-2
LI15 m15 13 47e-6
VS16 9 s16 0
R16 s16 14 68e0
VS17 17 s17 0
L17 s17 3 12e-5
VS18 18 s18 0
L18 s18 5 56e-3
VS19 19 s19 0
R19 s19 14 33e2
VS20 17 s20 0
L20 s20 7 47e-5
VS21 16 s21 0
R21 s21 21 47e1
VS22 13 s22 0
R22 s22 15 33e-1
VS23 4 s23 0
L23 s23 21 68e-4
VS24 23 s24 0
R24 s24 24 18e-1
VS25 23 s25 0
L25 s25 9 22e-5
VS26 9 s26 0
L26 s26 22 12e-5
VS27 12 s27 0
R27 s27 11 18e1
VS28 2 s28 0
L28 s28 3 15e-3
VS29 23 s29 0
V29 e29 s29 DC 0 AC 18e1 -120
RI29 e29 m29 56e-3
LI29 m29 8 56e-6
VS30 9 s30 0
L30 s30 21 10e-5
VS31 1 s31 0
C31 s31 16 12e-4
VS32 25 s32 0
L32 s32 1 82e-2
VS33 3 s33 0
R33 s33 17 22e0
VS34 11 s34 0
L34 s34 16 82e-5
VS35 13 s35 0
R35 s35 19 15e1
VS36 6 s36 0
V36 e36 s36 DC 0 AC 47e-1 -120
RI36 e36 m36 12e-3
LI36 m36 7 10e-5
VS37 21 s37 0
V37 e37 s37 DC 0 AC 33e1 0
RI37 e37 m37 33e-1
LI37 m37 13 68e-5
VS38 10 s38 0
C38 s38 11 15e-7
VS39 14 s39 0
C39 s39 24 18e-5
VS40 4 s40 0
V40 e40 s40 DC 0 AC 82e0 0
RI40 e40 m40 12e-2
LI40 m40 25 47e-5
VS41 23 s41 0
V41 e41 s41 DC 0 AC 56e0 120
RI41 e41 m41 22e-2
LI41 m41 5 56e-5
VS42 14 s42 0
R42 s42 19 47e1
VS43 20 s43 0
C43 s43 16 56e-6
VS44 13 s44 0
R44 s44 7 27e2
VS45 13 s45 0
R45 s45 26 33e2
VS46 24 s46 0
R46 s46 9 10e2
VS47 2 s47 0
V47 e47 s47 DC 0 AC 18e0 -120
RI47 e47 m47 12e-2
LI47 m47 6 39e-5
VS48 11 s48 0
R48 s48 26 22e2
VS49 7 s49 0
R49 s49 6 12e1
VS50 10 s50 0
L50 s50 21 39e-3
VS51 23 s51 0
V51 e51 s51 DC 0 AC 56e0 -120
RI51 e51 24 27e-2
VS52 0 s52 0
V52 e52 s52 DC 0 AC 68e0 -120
RI52 e52 18 47e-1
.control
set numdgt=17
ac lin 1 60 60
print v(1) v(2) v(3) v(4) v(5) v(6) v(7) v(8) v(9) v(10)
print v(11) v(12) v(13) v(14) v(15) v(16) v(17) v(18) v(19) v(20)
print v(21) v(22) v(23) v(24) v(25) v(26)
print i(vs0) i(vs1) i(vs2) i(vs3) i(vs4) i(vs5) i(vs6) i(vs7) i(vs8) i(vs9)
print i(vs10) i(vs11) i(vs12) i(vs13) i(vs14) i(vs15) i(vs16) i(vs17) i(vs18) i(vs19)
print i(vs20) i(vs21) i(vs22) i(vs23) i(vs24) i(vs25) i(vs26) i(vs27) i(vs28) i(vs29)
print i(vs30) i(vs31) i(vs32) i(vs33) i(vs34) i(vs35) i(vs36) i(vs37) i(vs38) i(vs39)
print i(vs40) i(vs41) i(vs42) i(vs43) i(vs44) i(vs45) i(vs46) i(vs47) i(vs48) i(vs49)
print i(vs50) i(vs51) i(vs52)
.endc
.end
