controls oracle ac-0465
* Generated (plan F2.7, ADR 0012): do not edit; regenerate with `pnpm sim oracle regen`. ac seed 20261031 index 465 nodes 27 elements 46
.options sparse gmin=1e-12 noopac
RG1 1 0 1000000000000
RG2 2 0 1000000000000
RG3 3 0 1000000000000
RG4 4 0 1000000000000
RG5 5 0 1000000000000
RG6 6 0 1000000000000
RG7 7 0 1000000000000
RG8 8 0 1000000000000
RG9 9 0 1000000000000
RG10 10 0 1000000000000
RG11 11 0 1000000000000
RG12 12 0 1000000000000
RG13 13 0 1000000000000
RG14 14 0 1000000000000
RG15 15 0 1000000000000
RG16 16 0 1000000000000
RG17 17 0 1000000000000
RG18 18 0 1000000000000
RG19 19 0 1000000000000
RG20 20 0 1000000000000
RG21 21 0 1000000000000
RG22 22 0 1000000000000
RG23 23 0 1000000000000
RG24 24 0 1000000000000
RG25 25 0 1000000000000
RG26 26 0 1000000000000
VS0 14 s0 0
L0 s0 21 10e-5
VS1 2 s1 0
R1 s1 23 47e0
VS2 14 s2 0
R2 s2 0 68e0
VS3 4 s3 0
C3 s3 8 18e-7
VS4 10 s4 0
C4 s4 9 56e-7
VS5 4 s5 0
L5 s5 8 22e-4
VS6 6 s6 0
C6 s6 26 39e-7
VS7 0 s7 0
V7 e7 s7 DC 0 AC 39e-1 180
RI7 e7 n7 47e-3
H7 n7 h7 VS12 10e-4
ED7 h7 16 d7 0 -33e-6
F7 0 d7 VS12 1
LD7 d7 0 1
VS8 13 s8 0
R8 s8 11 47e0
VS9 22 s9 0
R9 s9 21 56e1
VS10 21 s10 0
R10 s10 17 22e-1
VS11 26 s11 0
R11 s11 2 12e0
VS12 16 s12 0
V12 e12 s12 DC 0 AC 27e0 0
RI12 e12 m12 22e-3
LI12 m12 n12 47e-6
H12 n12 h12 VS7 10e-4
ED12 h12 25 d12 0 -33e-6
F12 0 d12 VS7 1
LD12 d12 0 1
VS13 23 s13 0
C13 s13 11 10e-7
VS14 18 s14 0
C14 s14 23 22e-6
VS15 16 s15 0
R15 s15 7 27e1
VS16 3 s16 0
L16 s16 0 10e-3
VS17 19 s17 0
R17 s17 23 39e1
VS18 23 s18 0
V18 e18 s18 DC 0 AC 18e0 180
RI18 e18 2 22e-2
VS19 5 s19 0
C19 s19 1 33e-5
VS20 24 s20 0
C20 s20 17 15e-5
VS21 5 s21 0
C21 s21 9 10e-4
VS22 18 s22 0
C22 s22 7 39e-4
VS23 25 s23 0
C23 s23 23 56e-4
VS24 6 s24 0
R24 s24 7 68e-1
VS25 21 s25 0
V25 e25 s25 DC 0 AC 18e-1 120
RI25 e25 7 12e-3
VS26 20 s26 0
C26 s26 7 12e-7
VS27 13 s27 0
C27 s27 3 27e-7
VS28 22 s28 0
C28 s28 18 33e-7
VS29 22 s29 0
C29 s29 6 18e-7
VS30 9 s30 0
V30 e30 s30 DC 0 AC 15e0 120
RI30 e30 2 15e-2
VS31 10 s31 0
L31 s31 2 18e-2
VS32 20 s32 0
L32 s32 16 47e-3
VS33 21 s33 0
V33 e33 s33 DC 0 AC 27e1 180
RI33 e33 m33 47e-3
LI33 m33 20 56e-6
VS34 12 s34 0
R34 s34 15 68e2
VS35 19 s35 0
C35 s35 25 47e-4
VS36 21 s36 0
L36 s36 1 18e-4
VS37 6 s37 0
R37 s37 24 47e2
VS38 2 s38 0
R38 s38 4 22e-2
VS39 18 s39 0
L39 s39 15 12e-3
VS40 13 s40 0
L40 s40 1 12e-5
VS41 12 s41 0
R41 s41 2 10e3
VS42 21 s42 0
V42 e42 s42 DC 0 AC 33e1 0
RI42 e42 m42 33e-1
LI42 m42 13 10e-6
VS43 10 s43 0
R43 s43 4 12e1
VS44 14 s44 0
R44 s44 2 12e-2
VS45 8 s45 0
C45 s45 24 27e-7
.control
set numdgt=17
ac lin 1 60 60
print v(1) v(2) v(3) v(4) v(5) v(6) v(7) v(8) v(9) v(10)
print v(11) v(12) v(13) v(14) v(15) v(16) v(17) v(18) v(19) v(20)
print v(21) v(22) v(23) v(24) v(25) v(26)
print i(vs0) i(vs1) i(vs2) i(vs3) i(vs4) i(vs5) i(vs6) i(vs7) i(vs8) i(vs9)
print i(vs10) i(vs11) i(vs12) i(vs13) i(vs14) i(vs15) i(vs16) i(vs17) i(vs18) i(vs19)
print i(vs20) i(vs21) i(vs22) i(vs23) i(vs24) i(vs25) i(vs26) i(vs27) i(vs28) i(vs29)
print i(vs30) i(vs31) i(vs32) i(vs33) i(vs34) i(vs35) i(vs36) i(vs37) i(vs38) i(vs39)
print i(vs40) i(vs41) i(vs42) i(vs43) i(vs44) i(vs45)
.endc
.end
