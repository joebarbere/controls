controls oracle ac-0483
* Generated (plan F2.7, ADR 0012): do not edit; regenerate with `pnpm sim oracle regen`. ac seed 20261031 index 483 nodes 10 elements 15
.options sparse gmin=1e-12 noopac
RG1 1 0 1000000000000
RG2 2 0 1000000000000
RG3 3 0 1000000000000
RG4 4 0 1000000000000
RG5 5 0 1000000000000
RG6 6 0 1000000000000
RG7 7 0 1000000000000
RG8 8 0 1000000000000
RG9 9 0 1000000000000
VS0 5 s0 0
R0 s0 0 27e-2
VS1 2 s1 0
C1 s1 1 18e-7
VS2 7 s2 0
L2 s2 4 82e-4
VS3 2 s3 0
R3 s3 9 82e3
VS4 6 s4 0
L4 s4 1 10e-5
VS5 9 s5 0
C5 s5 0 56e-6
VS6 3 s6 0
R6 s6 9 33e-1
VS7 7 s7 0
C7 s7 9 10e-7
VS8 0 s8 0
V8 e8 s8 DC 0 AC 12e1 180
RI8 e8 n8 22e-3
H8 n8 h8 VS14 18e-4
ED8 h8 6 d8 0 -18e-5
F8 0 d8 VS14 1
LD8 d8 0 1
VS9 8 s9 0
R9 s9 3 10e3
VS10 8 s10 0
R10 s10 5 33e0
VS11 9 s11 0
R11 s11 5 68e-1
VS12 1 s12 0
R12 s12 0 10e1
VS13 0 s13 0
R13 s13 3 68e3
VS14 0 s14 0
V14 e14 s14 DC 0 AC 56e-1 0
RI14 e14 n14 22e-1
H14 n14 h14 VS8 18e-4
ED14 h14 4 d14 0 -18e-5
F14 0 d14 VS8 1
LD14 d14 0 1
.control
set numdgt=17
ac lin 1 60 60
print v(1) v(2) v(3) v(4) v(5) v(6) v(7) v(8) v(9)
print i(vs0) i(vs1) i(vs2) i(vs3) i(vs4) i(vs5) i(vs6) i(vs7) i(vs8) i(vs9)
print i(vs10) i(vs11) i(vs12) i(vs13) i(vs14)
.endc
.end
