controls oracle ac-0483
* Generated (plan F2.7, ADR 0012): do not edit; regenerate with `pnpm sim oracle regen`. ac seed 20261031 index 483 nodes 10 elements 17
.options sparse gmin=1e-12 noopac
RG1 1 0 1000000000000
RG2 2 0 1000000000000
RG3 3 0 1000000000000
RG4 4 0 1000000000000
RG5 5 0 1000000000000
RG6 6 0 1000000000000
RG7 7 0 1000000000000
RG8 8 0 1000000000000
RG9 9 0 1000000000000
VS0 2 s0 0
C0 s0 1 18e-7
VS1 0 s1 0
V1 e1 s1 DC 0 AC 56e-1 0
RI1 e1 4 22e-1
VS2 7 s2 0
C2 s2 9 10e-7
VS3 1 s3 0
L3 s3 2 27e-4
VS4 6 s4 0
V4 e4 s4 DC 0 AC 12e0 180
RI4 e4 5 15e-2
VS5 3 s5 0
V5 e5 s5 DC 0 AC 82e-1 -120
RI5 e5 5 47e-1
VS6 3 s6 0
R6 s6 0 18e3
VS7 4 s7 0
R7 s7 8 39e3
VS8 9 s8 0
C8 s8 0 56e-6
VS9 2 s9 0
C9 s9 7 47e-6
VS10 0 s10 0
R10 s10 3 68e3
VS11 7 s11 0
L11 s11 4 82e-4
VS12 6 s12 0
L12 s12 1 10e-5
VS13 7 s13 0
R13 s13 8 39e2
VS14 2 s14 0
R14 s14 9 82e3
VS15 8 s15 0
R15 s15 5 33e0
VS16 9 s16 0
R16 s16 5 68e-1
.control
set numdgt=17
ac lin 1 60 60
print v(1) v(2) v(3) v(4) v(5) v(6) v(7) v(8) v(9)
print i(vs0) i(vs1) i(vs2) i(vs3) i(vs4) i(vs5) i(vs6) i(vs7) i(vs8) i(vs9)
print i(vs10) i(vs11) i(vs12) i(vs13) i(vs14) i(vs15) i(vs16)
.endc
.end
