controls oracle ac-0394
* Generated (plan F2.7, ADR 0012): do not edit; regenerate with `pnpm sim oracle regen`. ac seed 20261031 index 394 nodes 5 elements 8
.options sparse gmin=1e-12 noopac
RG1 1 0 1000000000000
RG2 2 0 1000000000000
RG3 3 0 1000000000000
RG4 4 0 1000000000000
VS0 0 s0 0
V0 e0 s0 DC 0 AC 27e0 0
RI0 e0 m0 82e-3
LI0 m0 n0 12e-5
H0 n0 h0 VS1 -68e-4
ED0 h0 3 d0 0 -12e-7
F0 0 d0 VS1 1
LD0 d0 0 1
VS1 0 s1 0
V1 e1 s1 DC 0 AC 68e-1 -120
RI1 e1 m1 27e-1
LI1 m1 n1 33e-6
H1 n1 h1 VS0 -68e-4
ED1 h1 2 d1 0 -12e-7
F1 0 d1 VS0 1
LD1 d1 0 1
VS2 1 s2 0
V2 e2 s2 DC 0 AC 82e1 0
RI2 e2 0 82e-2
VS3 4 s3 0
L3 s3 1 56e-5
VS4 3 s4 0
L4 s4 0 56e-3
VS5 0 s5 0
R5 s5 4 15e2
VS6 2 s6 0
L6 s6 4 12e-3
VS7 3 s7 0
R7 s7 2 10e0
.control
set numdgt=17
ac lin 1 60 60
print v(1) v(2) v(3) v(4)
print i(vs0) i(vs1) i(vs2) i(vs3) i(vs4) i(vs5) i(vs6) i(vs7)
.endc
.end
