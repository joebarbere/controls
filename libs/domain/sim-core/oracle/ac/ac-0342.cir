controls oracle ac-0342
* Generated (plan F2.7, ADR 0012): do not edit; regenerate with `pnpm sim oracle regen`. ac seed 20261031 index 342 nodes 17 elements 30
.options sparse gmin=1e-12 noopac
RG1 1 0 1000000000000
RG2 2 0 1000000000000
RG3 3 0 1000000000000
RG4 4 0 1000000000000
RG5 5 0 1000000000000
RG6 6 0 1000000000000
RG7 7 0 1000000000000
RG8 8 0 1000000000000
RG9 9 0 1000000000000
RG10 10 0 1000000000000
RG11 11 0 1000000000000
RG12 12 0 1000000000000
RG13 13 0 1000000000000
RG14 14 0 1000000000000
RG15 15 0 1000000000000
RG16 16 0 1000000000000
VS0 1 s0 0
R0 s0 11 82e0
VS1 15 s1 0
R1 s1 12 68e2
VS2 8 s2 0
R2 s2 1 18e1
VS3 4 s3 0
L3 s3 10 27e-4
VS4 13 s4 0
L4 s4 9 56e-4
VS5 0 s5 0
V5 e5 s5 DC 0 AC 39e1 0
RI5 e5 m5 27e-2
LI5 m5 13 22e-6
VS6 4 s6 0
C6 s6 6 18e-7
VS7 11 s7 0
L7 s7 6 56e-2
VS8 4 s8 0
L8 s8 15 27e-5
VS9 7 s9 0
R9 s9 13 10e-2
VS10 0 s10 0
R10 s10 2 33e2
VS11 2 s11 0
V11 e11 s11 DC 0 AC 39e0 120
RI11 e11 m11 18e-3
LI11 m11 16 22e-5
VS12 7 s12 0
R12 s12 15 39e3
VS13 15 s13 0
R13 s13 10 47e3
VS14 8 s14 0
C14 s14 7 10e-4
VS15 3 s15 0
V15 e15 s15 DC 0 AC 39e1 -120
RI15 e15 15 33e-2
VS16 6 s16 0
R16 s16 7 47e-2
VS17 13 s17 0
R17 s17 7 33e2
VS18 8 s18 0
R18 s18 3 15e2
VS19 6 s19 0
C19 s19 5 18e-6
VS20 6 s20 0
R20 s20 14 82e-2
VS21 6 s21 0
R21 s21 15 15e1
VS22 4 s22 0
R22 s22 10 82e1
VS23 3 s23 0
C23 s23 14 10e-7
VS24 13 s24 0
C24 s24 4 82e-6
VS25 6 s25 0
C25 s25 16 15e-6
VS26 8 s26 0
L26 s26 4 82e-3
VS27 2 s27 0
R27 s27 11 56e2
VS28 5 s28 0
R28 s28 12 56e0
VS29 9 s29 0
V29 e29 s29 DC 0 AC 82e1 -120
RI29 e29 m29 27e-2
LI29 m29 15 33e-5
.control
set numdgt=17
ac lin 1 60 60
print v(1) v(2) v(3) v(4) v(5) v(6) v(7) v(8) v(9) v(10)
print v(11) v(12) v(13) v(14) v(15) v(16)
print i(vs0) i(vs1) i(vs2) i(vs3) i(vs4) i(vs5) i(vs6) i(vs7) i(vs8) i(vs9)
print i(vs10) i(vs11) i(vs12) i(vs13) i(vs14) i(vs15) i(vs16) i(vs17) i(vs18) i(vs19)
print i(vs20) i(vs21) i(vs22) i(vs23) i(vs24) i(vs25) i(vs26) i(vs27) i(vs28) i(vs29)
.endc
.end
