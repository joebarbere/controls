controls oracle ac-0342
* Generated (plan F2.7, ADR 0012): do not edit; regenerate with `pnpm sim oracle regen`. ac seed 20261031 index 342 nodes 17 elements 30
.options sparse gmin=1e-12 noopac
RG1 1 0 1000000000000
RG2 2 0 1000000000000
RG3 3 0 1000000000000
RG4 4 0 1000000000000
RG5 5 0 1000000000000
RG6 6 0 1000000000000
RG7 7 0 1000000000000
RG8 8 0 1000000000000
RG9 9 0 1000000000000
RG10 10 0 1000000000000
RG11 11 0 1000000000000
RG12 12 0 1000000000000
RG13 13 0 1000000000000
RG14 14 0 1000000000000
RG15 15 0 1000000000000
RG16 16 0 1000000000000
VS0 8 s0 0
C0 s0 7 10e-4
VS1 3 s1 0
R1 s1 6 15e-1
VS2 0 s2 0
V2 e2 s2 DC 0 AC 68e1 120
RI2 e2 m2 82e-3
LI2 m2 n2 15e-7
H2 n2 h2 VS6 47e-4
ED2 h2 8 d2 0 15e-6
F2 0 d2 VS6 1
LD2 d2 0 1
VS3 9 s3 0
C3 s3 13 22e-7
VS4 7 s4 0
R4 s4 13 10e-2
VS5 5 s5 0
C5 s5 12 15e-6
VS6 15 s6 0
V6 e6 s6 DC 0 AC 39e1 0
RI6 e6 m6 27e-2
LI6 m6 n6 12e-6
H6 n6 h6 VS2 47e-4
ED6 h6 13 d6 0 15e-6
F6 0 d6 VS2 1
LD6 d6 0 1
VS7 16 s7 0
L7 s7 1 27e-5
VS8 14 s8 0
V8 e8 s8 DC 0 AC 39e1 -120
RI8 e8 5 33e-2
VS9 13 s9 0
R9 s9 9 15e2
VS10 4 s10 0
C10 s10 6 18e-7
VS11 13 s11 0
R11 s11 7 33e2
VS12 6 s12 0
R12 s12 7 47e-2
VS13 11 s13 0
R13 s13 3 22e-2
VS14 8 s14 0
R14 s14 1 18e1
VS15 13 s15 0
L15 s15 5 82e-4
VS16 16 s16 0
R16 s16 10 47e3
VS17 15 s17 0
R17 s17 13 12e-1
VS18 6 s18 0
R18 s18 16 15e1
VS19 13 s19 0
C19 s19 4 82e-6
VS20 2 s20 0
R20 s20 11 56e2
VS21 11 s21 0
L21 s21 6 56e-2
VS22 9 s22 0
R22 s22 11 82e0
VS23 12 s23 0
L23 s23 13 10e-2
VS24 8 s24 0
V24 e24 s24 DC 0 AC 10e1 -120
RI24 e24 5 56e-3
VS25 2 s25 0
V25 e25 s25 DC 0 AC 39e0 120
RI25 e25 0 18e-3
VS26 15 s26 0
R26 s26 2 33e2
VS27 15 s27 0
R27 s27 6 47e2
VS28 4 s28 0
L28 s28 10 27e-4
VS29 6 s29 0
R29 s29 14 82e-2
.control
set numdgt=17
ac lin 1 60 60
print v(1) v(2) v(3) v(4) v(5) v(6) v(7) v(8) v(9) v(10)
print v(11) v(12) v(13) v(14) v(15) v(16)
print i(vs0) i(vs1) i(vs2) i(vs3) i(vs4) i(vs5) i(vs6) i(vs7) i(vs8) i(vs9)
print i(vs10) i(vs11) i(vs12) i(vs13) i(vs14) i(vs15) i(vs16) i(vs17) i(vs18) i(vs19)
print i(vs20) i(vs21) i(vs22) i(vs23) i(vs24) i(vs25) i(vs26) i(vs27) i(vs28) i(vs29)
.endc
.end
