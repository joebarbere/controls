controls oracle ac-0342
* Generated (plan F2.7, ADR 0012): do not edit; regenerate with `pnpm sim oracle regen`. ac seed 20261031 index 342 nodes 17 elements 25
.options sparse gmin=1e-12 noopac
RG1 1 0 1000000000000
RG2 2 0 1000000000000
RG3 3 0 1000000000000
RG4 4 0 1000000000000
RG5 5 0 1000000000000
RG6 6 0 1000000000000
RG7 7 0 1000000000000
RG8 8 0 1000000000000
RG9 9 0 1000000000000
RG10 10 0 1000000000000
RG11 11 0 1000000000000
RG12 12 0 1000000000000
RG13 13 0 1000000000000
RG14 14 0 1000000000000
RG15 15 0 1000000000000
RG16 16 0 1000000000000
VS0 0 s0 0
V0 e0 s0 DC 0 AC 39e1 0
RI0 e0 13 27e-2
VS1 12 s1 0
L1 s1 13 10e-2
VS2 3 s2 0
R2 s2 6 15e-1
VS3 8 s3 0
C3 s3 7 10e-4
VS4 11 s4 0
L4 s4 6 56e-2
VS5 13 s5 0
C5 s5 4 82e-6
VS6 8 s6 0
R6 s6 1 18e1
VS7 4 s7 0
L7 s7 10 27e-4
VS8 0 s8 0
R8 s8 6 47e2
VS9 6 s9 0
R9 s9 7 47e-2
VS10 13 s10 0
R10 s10 7 33e2
VS11 15 s11 0
R11 s11 10 47e3
VS12 13 s12 0
L12 s12 5 82e-4
VS13 0 s13 0
R13 s13 2 33e2
VS14 13 s14 0
R14 s14 9 15e2
VS15 2 s15 0
R15 s15 11 56e2
VS16 2 s16 0
V16 e16 s16 DC 0 AC 39e0 120
RI16 e16 16 18e-3
VS17 0 s17 0
R17 s17 13 12e-1
VS18 6 s18 0
R18 s18 14 82e-2
VS19 16 s19 0
V19 e19 s19 DC 0 AC 68e1 120
RI19 e19 8 82e-3
VS20 7 s20 0
R20 s20 13 10e-2
VS21 9 s21 0
C21 s21 13 22e-7
VS22 8 s22 0
V22 e22 s22 DC 0 AC 10e1 -120
RI22 e22 5 56e-3
VS23 6 s23 0
R23 s23 15 15e1
VS24 4 s24 0
C24 s24 6 18e-7
.control
set numdgt=17
ac lin 1 60 60
print v(1) v(2) v(3) v(4) v(5) v(6) v(7) v(8) v(9) v(10)
print v(11) v(12) v(13) v(14) v(15) v(16)
print i(vs0) i(vs1) i(vs2) i(vs3) i(vs4) i(vs5) i(vs6) i(vs7) i(vs8) i(vs9)
print i(vs10) i(vs11) i(vs12) i(vs13) i(vs14) i(vs15) i(vs16) i(vs17) i(vs18) i(vs19)
print i(vs20) i(vs21) i(vs22) i(vs23) i(vs24)
.endc
.end
