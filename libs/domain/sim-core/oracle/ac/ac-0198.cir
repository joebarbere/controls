controls oracle ac-0198
* Generated (plan F2.7, ADR 0012): do not edit; regenerate with `pnpm sim oracle regen`. ac seed 20261031 index 198 nodes 17 elements 36
.options sparse gmin=1e-12 noopac
RG1 1 0 1000000000000
RG2 2 0 1000000000000
RG3 3 0 1000000000000
RG4 4 0 1000000000000
RG5 5 0 1000000000000
RG6 6 0 1000000000000
RG7 7 0 1000000000000
RG8 8 0 1000000000000
RG9 9 0 1000000000000
RG10 10 0 1000000000000
RG11 11 0 1000000000000
RG12 12 0 1000000000000
RG13 13 0 1000000000000
RG14 14 0 1000000000000
RG15 15 0 1000000000000
RG16 16 0 1000000000000
VS0 10 s0 0
L0 s0 15 56e-5
VS1 2 s1 0
C1 s1 5 12e-5
VS2 0 s2 0
V2 e2 s2 DC 0 AC 15e0 -120
RI2 e2 6 39e-1
VS3 15 s3 0
L3 s3 0 47e-3
VS4 3 s4 0
L4 s4 12 22e-2
VS5 12 s5 0
V5 e5 s5 DC 0 AC 12e-1 -120
RI5 e5 m5 12e-3
LI5 m5 0 47e-6
VS6 2 s6 0
R6 s6 3 15e-1
VS7 7 s7 0
R7 s7 1 15e-2
VS8 4 s8 0
C8 s8 16 82e-5
VS9 10 s9 0
L9 s9 5 10e-2
VS10 15 s10 0
R10 s10 1 68e0
VS11 15 s11 0
R11 s11 12 18e-2
VS12 13 s12 0
R12 s12 5 56e2
VS13 3 s13 0
R13 s13 16 22e1
VS14 5 s14 0
V14 e14 s14 DC 0 AC 15e0 120
RI14 e14 4 12e-2
VS15 8 s15 0
L15 s15 14 12e-5
VS16 2 s16 0
C16 s16 3 27e-7
VS17 10 s17 0
L17 s17 12 56e-2
VS18 13 s18 0
L18 s18 12 33e-5
VS19 4 s19 0
R19 s19 11 39e0
VS20 11 s20 0
C20 s20 13 68e-6
VS21 6 s21 0
R21 s21 8 22e-1
VS22 11 s22 0
L22 s22 3 33e-2
VS23 8 s23 0
R23 s23 11 15e-1
VS24 6 s24 0
R24 s24 15 27e1
VS25 8 s25 0
R25 s25 9 15e1
VS26 9 s26 0
C26 s26 12 22e-5
VS27 14 s27 0
L27 s27 13 22e-3
VS28 15 s28 0
C28 s28 6 47e-6
VS29 3 s29 0
L29 s29 8 68e-4
VS30 3 s30 0
R30 s30 6 18e2
VS31 5 s31 0
V31 e31 s31 DC 0 AC 33e-1 0
RI31 e31 m31 39e-3
LI31 m31 7 68e-5
VS32 12 s32 0
L32 s32 3 22e-4
VS33 12 s33 0
R33 s33 10 15e-2
VS34 13 s34 0
L34 s34 8 47e-5
VS35 6 s35 0
C35 s35 1 68e-5
.control
set numdgt=17
ac lin 1 60 60
print v(1) v(2) v(3) v(4) v(5) v(6) v(7) v(8) v(9) v(10)
print v(11) v(12) v(13) v(14) v(15) v(16)
print i(vs0) i(vs1) i(vs2) i(vs3) i(vs4) i(vs5) i(vs6) i(vs7) i(vs8) i(vs9)
print i(vs10) i(vs11) i(vs12) i(vs13) i(vs14) i(vs15) i(vs16) i(vs17) i(vs18) i(vs19)
print i(vs20) i(vs21) i(vs22) i(vs23) i(vs24) i(vs25) i(vs26) i(vs27) i(vs28) i(vs29)
print i(vs30) i(vs31) i(vs32) i(vs33) i(vs34) i(vs35)
.endc
.end
