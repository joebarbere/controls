controls oracle ac-0198
* Generated (plan F2.7, ADR 0012): do not edit; regenerate with `pnpm sim oracle regen`. ac seed 20261031 index 198 nodes 17 elements 30
.options sparse gmin=1e-12 noopac
RG1 1 0 1000000000000
RG2 2 0 1000000000000
RG3 3 0 1000000000000
RG4 4 0 1000000000000
RG5 5 0 1000000000000
RG6 6 0 1000000000000
RG7 7 0 1000000000000
RG8 8 0 1000000000000
RG9 9 0 1000000000000
RG10 10 0 1000000000000
RG11 11 0 1000000000000
RG12 12 0 1000000000000
RG13 13 0 1000000000000
RG14 14 0 1000000000000
RG15 15 0 1000000000000
RG16 16 0 1000000000000
VS0 8 s0 0
R0 s0 11 15e-1
VS1 3 s1 0
L1 s1 5 22e-2
VS2 2 s2 0
R2 s2 4 15e3
VS3 4 s3 0
R3 s3 11 39e0
VS4 6 s4 0
L4 s4 2 27e-5
VS5 9 s5 0
C5 s5 6 15e-4
VS6 0 s6 0
V6 e6 s6 DC 0 AC 15e0 120
RI6 e6 4 12e-2
VS7 9 s7 0
L7 s7 5 10e-3
VS8 9 s8 0
V8 e8 s8 DC 0 AC 15e1 0
RI8 e8 12 10e-3
VS9 7 s9 0
C9 s9 1 18e-4
VS10 6 s10 0
R10 s10 8 22e-1
VS11 8 s11 0
R11 s11 2 22e-2
VS12 12 s12 0
V12 e12 s12 DC 0 AC 18e1 120
RI12 e12 2 39e-2
VS13 10 s13 0
L13 s13 6 10e-2
VS14 9 s14 0
R14 s14 16 22e1
VS15 7 s15 0
L15 s15 12 27e-3
VS16 8 s16 0
R16 s16 9 15e1
VS17 11 s17 0
V17 e17 s17 DC 0 AC 33e1 180
RI17 e17 14 56e-3
VS18 2 s18 0
R18 s18 13 15e1
VS19 3 s19 0
L19 s19 8 68e-4
VS20 4 s20 0
R20 s20 13 68e-2
VS21 0 s21 0
R21 s21 14 15e2
VS22 0 s22 0
L22 s22 15 47e-4
VS23 16 s23 0
L23 s23 1 56e-3
VS24 2 s24 0
R24 s24 3 15e-1
VS25 1 s25 0
V25 e25 s25 DC 0 AC 39e-1 0
RI25 e25 4 12e-2
VS26 0 s26 0
R26 s26 3 33e-1
VS27 3 s27 0
R27 s27 16 22e1
VS28 5 s28 0
C28 s28 6 82e-7
VS29 2 s29 0
R29 s29 1 39e1
.control
set numdgt=17
ac lin 1 60 60
print v(1) v(2) v(3) v(4) v(5) v(6) v(7) v(8) v(9) v(10)
print v(11) v(12) v(13) v(14) v(15) v(16)
print i(vs0) i(vs1) i(vs2) i(vs3) i(vs4) i(vs5) i(vs6) i(vs7) i(vs8) i(vs9)
print i(vs10) i(vs11) i(vs12) i(vs13) i(vs14) i(vs15) i(vs16) i(vs17) i(vs18) i(vs19)
print i(vs20) i(vs21) i(vs22) i(vs23) i(vs24) i(vs25) i(vs26) i(vs27) i(vs28) i(vs29)
.endc
.end
