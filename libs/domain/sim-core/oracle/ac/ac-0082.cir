controls oracle ac-0082
* Generated (plan F2.7, ADR 0012): do not edit; regenerate with `pnpm sim oracle regen`. ac seed 20261031 index 82 nodes 24 elements 33
.options sparse gmin=1e-12 noopac
RG1 1 0 1000000000000
RG2 2 0 1000000000000
RG3 3 0 1000000000000
RG4 4 0 1000000000000
RG5 5 0 1000000000000
RG6 6 0 1000000000000
RG7 7 0 1000000000000
RG8 8 0 1000000000000
RG9 9 0 1000000000000
RG10 10 0 1000000000000
RG11 11 0 1000000000000
RG12 12 0 1000000000000
RG13 13 0 1000000000000
RG14 14 0 1000000000000
RG15 15 0 1000000000000
RG16 16 0 1000000000000
RG17 17 0 1000000000000
RG18 18 0 1000000000000
RG19 19 0 1000000000000
RG20 20 0 1000000000000
RG21 21 0 1000000000000
RG22 22 0 1000000000000
RG23 23 0 1000000000000
VS0 5 s0 0
C0 s0 3 10e-6
VS1 15 s1 0
R1 s1 23 39e2
VS2 4 s2 0
C2 s2 8 12e-7
VS3 10 s3 0
R3 s3 18 18e2
VS4 23 s4 0
C4 s4 7 18e-4
VS5 1 s5 0
C5 s5 5 56e-6
VS6 23 s6 0
C6 s6 8 18e-7
VS7 14 s7 0
R7 s7 15 82e2
VS8 3 s8 0
C8 s8 21 10e-6
VS9 4 s9 0
L9 s9 12 10e-5
VS10 9 s10 0
R10 s10 13 47e1
VS11 0 s11 0
V11 e11 s11 DC 0 AC 56e1 -120
RI11 e11 17 68e-3
VS12 11 s12 0
C12 s12 10 18e-5
VS13 12 s13 0
V13 e13 s13 DC 0 AC 18e1 180
RI13 e13 16 39e-2
VS14 19 s14 0
C14 s14 3 10e-7
VS15 6 s15 0
V15 e15 s15 DC 0 AC 33e-1 180
RI15 e15 3 12e-2
VS16 14 s16 0
R16 s16 17 27e0
VS17 13 s17 0
C17 s17 11 33e-7
VS18 2 s18 0
R18 s18 6 56e2
VS19 18 s19 0
L19 s19 1 56e-3
VS20 7 s20 0
C20 s20 21 27e-7
VS21 7 s21 0
V21 e21 s21 DC 0 AC 39e1 0
RI21 e21 16 47e-1
VS22 19 s22 0
C22 s22 22 15e-4
VS23 9 s23 0
R23 s23 6 22e3
VS24 20 s24 0
C24 s24 2 56e-7
VS25 22 s25 0
L25 s25 13 12e-3
VS26 8 s26 0
R26 s26 19 12e1
VS27 2 s27 0
C27 s27 15 56e-6
VS28 22 s28 0
L28 s28 18 22e-5
VS29 20 s29 0
V29 e29 s29 DC 0 AC 82e1 180
RI29 e29 1 33e-3
VS30 0 s30 0
L30 s30 23 33e-5
VS31 3 s31 0
L31 s31 8 56e-5
VS32 11 s32 0
C32 s32 22 27e-7
.control
set numdgt=17
ac lin 1 60 60
print v(1) v(2) v(3) v(4) v(5) v(6) v(7) v(8) v(9) v(10)
print v(11) v(12) v(13) v(14) v(15) v(16) v(17) v(18) v(19) v(20)
print v(21) v(22) v(23)
print i(vs0) i(vs1) i(vs2) i(vs3) i(vs4) i(vs5) i(vs6) i(vs7) i(vs8) i(vs9)
print i(vs10) i(vs11) i(vs12) i(vs13) i(vs14) i(vs15) i(vs16) i(vs17) i(vs18) i(vs19)
print i(vs20) i(vs21) i(vs22) i(vs23) i(vs24) i(vs25) i(vs26) i(vs27) i(vs28) i(vs29)
print i(vs30) i(vs31) i(vs32)
.endc
.end
