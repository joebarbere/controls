controls oracle ac-0082
* Generated (plan F2.7, ADR 0012): do not edit; regenerate with `pnpm sim oracle regen`. ac seed 20261031 index 82 nodes 24 elements 29
.options sparse gmin=1e-12 noopac
RG1 1 0 1000000000000
RG2 2 0 1000000000000
RG3 3 0 1000000000000
RG4 4 0 1000000000000
RG5 5 0 1000000000000
RG6 6 0 1000000000000
RG7 7 0 1000000000000
RG8 8 0 1000000000000
RG9 9 0 1000000000000
RG10 10 0 1000000000000
RG11 11 0 1000000000000
RG12 12 0 1000000000000
RG13 13 0 1000000000000
RG14 14 0 1000000000000
RG15 15 0 1000000000000
RG16 16 0 1000000000000
RG17 17 0 1000000000000
RG18 18 0 1000000000000
RG19 19 0 1000000000000
RG20 20 0 1000000000000
RG21 21 0 1000000000000
RG22 22 0 1000000000000
RG23 23 0 1000000000000
VS0 15 s0 0
R0 s0 23 39e2
VS1 18 s1 0
L1 s1 1 56e-3
VS2 22 s2 0
L2 s2 18 22e-5
VS3 13 s3 0
C3 s3 11 33e-7
VS4 10 s4 0
R4 s4 18 18e2
VS5 0 s5 0
C5 s5 21 27e-7
VS6 14 s6 0
R6 s6 17 27e0
VS7 4 s7 0
L7 s7 12 10e-5
VS8 23 s8 0
C8 s8 0 18e-4
VS9 9 s9 0
R9 s9 13 47e1
VS10 0 s10 0
V10 e10 s10 DC 0 AC 39e1 0
RI10 e10 16 47e-1
VS11 9 s11 0
R11 s11 6 22e3
VS12 20 s12 0
V12 e12 s12 DC 0 AC 82e1 180
RI12 e12 1 33e-3
VS13 1 s13 0
C13 s13 5 56e-6
VS14 19 s14 0
C14 s14 3 10e-7
VS15 6 s15 0
V15 e15 s15 DC 0 AC 33e-1 180
RI15 e15 3 12e-2
VS16 8 s16 0
L16 s16 23 33e-5
VS17 11 s17 0
C17 s17 22 27e-7
VS18 12 s18 0
V18 e18 s18 DC 0 AC 18e1 180
RI18 e18 16 39e-2
VS19 5 s19 0
C19 s19 3 10e-6
VS20 19 s20 0
C20 s20 22 15e-4
VS21 3 s21 0
L21 s21 7 56e-5
VS22 8 s22 0
V22 e22 s22 DC 0 AC 56e1 -120
RI22 e22 17 68e-3
VS23 22 s23 0
L23 s23 13 12e-3
VS24 23 s24 0
C24 s24 7 18e-7
VS25 20 s25 0
C25 s25 2 56e-7
VS26 7 s26 0
R26 s26 19 12e1
VS27 2 s27 0
R27 s27 6 56e2
VS28 14 s28 0
R28 s28 15 82e2
.control
set numdgt=17
ac lin 1 60 60
print v(1) v(2) v(3) v(4) v(5) v(6) v(7) v(8) v(9) v(10)
print v(11) v(12) v(13) v(14) v(15) v(16) v(17) v(18) v(19) v(20)
print v(21) v(22) v(23)
print i(vs0) i(vs1) i(vs2) i(vs3) i(vs4) i(vs5) i(vs6) i(vs7) i(vs8) i(vs9)
print i(vs10) i(vs11) i(vs12) i(vs13) i(vs14) i(vs15) i(vs16) i(vs17) i(vs18) i(vs19)
print i(vs20) i(vs21) i(vs22) i(vs23) i(vs24) i(vs25) i(vs26) i(vs27) i(vs28)
.endc
.end
