controls oracle ac-0082
* Generated (plan F2.7, ADR 0012): do not edit; regenerate with `pnpm sim oracle regen`. ac seed 20261031 index 82 nodes 24 elements 44
.options sparse gmin=1e-12 noopac
RG1 1 0 1000000000000
RG2 2 0 1000000000000
RG3 3 0 1000000000000
RG4 4 0 1000000000000
RG5 5 0 1000000000000
RG6 6 0 1000000000000
RG7 7 0 1000000000000
RG8 8 0 1000000000000
RG9 9 0 1000000000000
RG10 10 0 1000000000000
RG11 11 0 1000000000000
RG12 12 0 1000000000000
RG13 13 0 1000000000000
RG14 14 0 1000000000000
RG15 15 0 1000000000000
RG16 16 0 1000000000000
RG17 17 0 1000000000000
RG18 18 0 1000000000000
RG19 19 0 1000000000000
RG20 20 0 1000000000000
RG21 21 0 1000000000000
RG22 22 0 1000000000000
RG23 23 0 1000000000000
VS0 1 s0 0
L0 s0 19 27e-3
VS1 0 s1 0
V1 e1 s1 DC 0 AC 33e-1 180
RI1 e1 3 12e-2
VS2 19 s2 0
C2 s2 3 10e-7
VS3 0 s3 0
C3 s3 15 82e-4
VS4 2 s4 0
R4 s4 5 39e2
VS5 20 s5 0
C5 s5 23 82e-5
VS6 11 s6 0
C6 s6 20 56e-6
VS7 17 s7 0
C7 s7 20 47e-7
VS8 5 s8 0
C8 s8 3 10e-6
VS9 12 s9 0
C9 s9 22 12e-7
VS10 3 s10 0
L10 s10 6 56e-5
VS11 6 s11 0
C11 s11 15 15e-4
VS12 19 s12 0
C12 s12 15 22e-6
VS13 6 s13 0
V13 e13 s13 DC 0 AC 27e-1 180
RI13 e13 m13 18e-1
LI13 m13 21 39e-6
VS14 9 s14 0
R14 s14 7 18e0
VS15 2 s15 0
V15 e15 s15 DC 0 AC 56e1 -120
RI15 e15 22 68e-3
VS16 5 s16 0
C16 s16 15 27e-6
VS17 19 s17 0
C17 s17 23 18e-4
VS18 8 s18 0
R18 s18 15 82e2
VS19 13 s19 0
L19 s19 21 33e-5
VS20 20 s20 0
V20 e20 s20 DC 0 AC 47e-1 0
RI20 e20 3 15e-1
VS21 7 s21 0
V21 e21 s21 DC 0 AC 82e1 180
RI21 e21 9 33e-3
VS22 23 s22 0
R22 s22 13 33e2
VS23 17 s23 0
V23 e23 s23 DC 0 AC 68e0 180
RI23 e23 m23 56e-1
LI23 m23 8 10e-6
VS24 14 s24 0
L24 s24 13 12e-2
VS25 20 s25 0
R25 s25 16 18e3
VS26 1 s26 0
R26 s26 0 47e-2
VS27 19 s27 0
V27 e27 s27 DC 0 AC 27e1 -120
RI27 e27 9 27e-3
VS28 19 s28 0
V28 e28 s28 DC 0 AC 47e-1 180
RI28 e28 4 12e-3
VS29 17 s29 0
R29 s29 19 18e2
VS30 16 s30 0
C30 s30 3 68e-5
VS31 18 s31 0
L31 s31 9 18e-2
VS32 20 s32 0
R32 s32 7 47e1
VS33 4 s33 0
R33 s33 13 33e-1
VS34 4 s34 0
V34 e34 s34 DC 0 AC 10e1 180
RI34 e34 18 82e-3
VS35 4 s35 0
R35 s35 10 56e-2
VS36 1 s36 0
C36 s36 17 56e-4
VS37 18 s37 0
L37 s37 3 10e-5
VS38 5 s38 0
C38 s38 11 27e-7
VS39 5 s39 0
R39 s39 4 47e1
VS40 14 s40 0
V40 e40 s40 DC 0 AC 22e1 -120
RI40 e40 12 22e-3
VS41 3 s41 0
C41 s41 12 56e-7
VS42 5 s42 0
L42 s42 7 47e-2
VS43 13 s43 0
C43 s43 10 22e-5
.control
set numdgt=17
ac lin 1 60 60
print v(1) v(2) v(3) v(4) v(5) v(6) v(7) v(8) v(9) v(10)
print v(11) v(12) v(13) v(14) v(15) v(16) v(17) v(18) v(19) v(20)
print v(21) v(22) v(23)
print i(vs0) i(vs1) i(vs2) i(vs3) i(vs4) i(vs5) i(vs6) i(vs7) i(vs8) i(vs9)
print i(vs10) i(vs11) i(vs12) i(vs13) i(vs14) i(vs15) i(vs16) i(vs17) i(vs18) i(vs19)
print i(vs20) i(vs21) i(vs22) i(vs23) i(vs24) i(vs25) i(vs26) i(vs27) i(vs28) i(vs29)
print i(vs30) i(vs31) i(vs32) i(vs33) i(vs34) i(vs35) i(vs36) i(vs37) i(vs38) i(vs39)
print i(vs40) i(vs41) i(vs42) i(vs43)
.endc
.end
