controls oracle ac-0153
* Generated (plan F2.7, ADR 0012): do not edit; regenerate with `pnpm sim oracle regen`. ac seed 20261031 index 153 nodes 20 elements 31
.options sparse gmin=1e-12 noopac
RG1 1 0 1000000000000
RG2 2 0 1000000000000
RG3 3 0 1000000000000
RG4 4 0 1000000000000
RG5 5 0 1000000000000
RG6 6 0 1000000000000
RG7 7 0 1000000000000
RG8 8 0 1000000000000
RG9 9 0 1000000000000
RG10 10 0 1000000000000
RG11 11 0 1000000000000
RG12 12 0 1000000000000
RG13 13 0 1000000000000
RG14 14 0 1000000000000
RG15 15 0 1000000000000
RG16 16 0 1000000000000
RG17 17 0 1000000000000
RG18 18 0 1000000000000
RG19 19 0 1000000000000
VS0 9 s0 0
R0 s0 2 27e3
VS1 1 s1 0
R1 s1 8 18e2
VS2 15 s2 0
L2 s2 7 27e-2
VS3 7 s3 0
R3 s3 11 82e2
VS4 15 s4 0
L4 s4 17 56e-4
VS5 0 s5 0
V5 e5 s5 DC 0 AC 27e-1 0
RI5 e5 2 39e-2
VS6 12 s6 0
C6 s6 16 56e-5
VS7 5 s7 0
V7 e7 s7 DC 0 AC 12e0 0
RI7 e7 17 15e-3
VS8 16 s8 0
L8 s8 2 39e-5
VS9 1 s9 0
V9 e9 s9 DC 0 AC 56e0 120
RI9 e9 m9 27e-3
LI9 m9 0 22e-5
VS10 1 s10 0
C10 s10 4 56e-4
VS11 3 s11 0
R11 s11 6 39e-1
VS12 2 s12 0
C12 s12 7 56e-4
VS13 19 s13 0
R13 s13 2 47e0
VS14 18 s14 0
V14 e14 s14 DC 0 AC 15e1 120
RI14 e14 m14 18e-2
LI14 m14 14 56e-7
VS15 18 s15 0
C15 s15 2 33e-7
VS16 1 s16 0
R16 s16 2 56e3
VS17 4 s17 0
C17 s17 9 15e-6
VS18 5 s18 0
V18 e18 s18 DC 0 AC 18e0 180
RI18 e18 11 68e-2
VS19 10 s19 0
V19 e19 s19 DC 0 AC 82e0 0
RI19 e19 15 82e-2
VS20 12 s20 0
R20 s20 5 56e0
VS21 18 s21 0
C21 s21 6 27e-4
VS22 6 s22 0
R22 s22 4 82e-1
VS23 11 s23 0
C23 s23 2 18e-7
VS24 19 s24 0
V24 e24 s24 DC 0 AC 22e0 0
RI24 e24 m24 27e-3
LI24 m24 0 33e-7
VS25 3 s25 0
R25 s25 16 56e3
VS26 11 s26 0
C26 s26 6 68e-5
VS27 13 s27 0
L27 s27 18 15e-2
VS28 10 s28 0
R28 s28 7 12e0
VS29 14 s29 0
R29 s29 2 15e3
VS30 8 s30 0
R30 s30 13 56e0
.control
set numdgt=17
ac lin 1 60 60
print v(1) v(2) v(3) v(4) v(5) v(6) v(7) v(8) v(9) v(10)
print v(11) v(12) v(13) v(14) v(15) v(16) v(17) v(18) v(19)
print i(vs0) i(vs1) i(vs2) i(vs3) i(vs4) i(vs5) i(vs6) i(vs7) i(vs8) i(vs9)
print i(vs10) i(vs11) i(vs12) i(vs13) i(vs14) i(vs15) i(vs16) i(vs17) i(vs18) i(vs19)
print i(vs20) i(vs21) i(vs22) i(vs23) i(vs24) i(vs25) i(vs26) i(vs27) i(vs28) i(vs29)
print i(vs30)
.endc
.end
