controls oracle ac-0153
* Generated (plan F2.7, ADR 0012): do not edit; regenerate with `pnpm sim oracle regen`. ac seed 20261031 index 153 nodes 20 elements 38
.options sparse gmin=1e-12 noopac
RG1 1 0 1000000000000
RG2 2 0 1000000000000
RG3 3 0 1000000000000
RG4 4 0 1000000000000
RG5 5 0 1000000000000
RG6 6 0 1000000000000
RG7 7 0 1000000000000
RG8 8 0 1000000000000
RG9 9 0 1000000000000
RG10 10 0 1000000000000
RG11 11 0 1000000000000
RG12 12 0 1000000000000
RG13 13 0 1000000000000
RG14 14 0 1000000000000
RG15 15 0 1000000000000
RG16 16 0 1000000000000
RG17 17 0 1000000000000
RG18 18 0 1000000000000
RG19 19 0 1000000000000
VS0 0 s0 0
V0 e0 s0 DC 0 AC 10e0 0
RI0 e0 12 56e-3
VS1 0 s1 0
R1 s1 11 27e-1
VS2 15 s2 0
L2 s2 18 22e-4
VS3 0 s3 0
C3 s3 5 12e-6
VS4 7 s4 0
L4 s4 10 22e-3
VS5 12 s5 0
R5 s5 0 56e2
VS6 8 s6 0
R6 s6 1 33e0
VS7 8 s7 0
C7 s7 15 33e-4
VS8 9 s8 0
L8 s8 7 56e-4
VS9 1 s9 0
R9 s9 18 56e3
VS10 9 s10 0
C10 s10 13 56e-6
VS11 13 s11 0
L11 s11 0 15e-2
VS12 14 s12 0
V12 e12 s12 DC 0 AC 39e0 120
RI12 e12 3 82e-2
VS13 8 s13 0
V13 e13 s13 DC 0 AC 39e-1 120
RI13 e13 7 27e-3
VS14 11 s14 0
C14 s14 18 18e-7
VS15 1 s15 0
V15 e15 s15 DC 0 AC 56e0 120
RI15 e15 2 27e-3
VS16 1 s16 0
V16 e16 s16 DC 0 AC 82e1 120
RI16 e16 10 22e-1
VS17 15 s17 0
C17 s17 8 47e-7
VS18 17 s18 0
C18 s18 10 18e-5
VS19 2 s19 0
V19 e19 s19 DC 0 AC 27e-1 0
RI19 e19 18 39e-2
VS20 19 s20 0
V20 e20 s20 DC 0 AC 82e1 120
RI20 e20 12 39e-1
VS21 3 s21 0
L21 s21 16 82e-4
VS22 8 s22 0
C22 s22 4 22e-7
VS23 3 s23 0
V23 e23 s23 DC 0 AC 15e0 -120
RI23 e23 6 39e-1
VS24 0 s24 0
L24 s24 5 47e-4
VS25 14 s25 0
C25 s25 13 56e-6
VS26 13 s26 0
R26 s26 18 15e0
VS27 18 s27 0
R27 s27 11 33e-1
VS28 0 s28 0
C28 s28 18 33e-7
VS29 13 s29 0
V29 e29 s29 DC 0 AC 56e-1 120
RI29 e29 15 82e-1
VS30 15 s30 0
L30 s30 2 22e-2
VS31 6 s31 0
R31 s31 2 68e1
VS32 9 s32 0
R32 s32 0 12e0
VS33 16 s33 0
R33 s33 13 56e1
VS34 11 s34 0
R34 s34 6 15e1
VS35 17 s35 0
V35 e35 s35 DC 0 AC 56e-1 -120
RI35 e35 18 27e-1
VS36 18 s36 0
L36 s36 4 56e-4
VS37 12 s37 0
L37 s37 13 27e-2
.control
set numdgt=17
ac lin 1 60 60
print v(1) v(2) v(3) v(4) v(5) v(6) v(7) v(8) v(9) v(10)
print v(11) v(12) v(13) v(14) v(15) v(16) v(17) v(18) v(19)
print i(vs0) i(vs1) i(vs2) i(vs3) i(vs4) i(vs5) i(vs6) i(vs7) i(vs8) i(vs9)
print i(vs10) i(vs11) i(vs12) i(vs13) i(vs14) i(vs15) i(vs16) i(vs17) i(vs18) i(vs19)
print i(vs20) i(vs21) i(vs22) i(vs23) i(vs24) i(vs25) i(vs26) i(vs27) i(vs28) i(vs29)
print i(vs30) i(vs31) i(vs32) i(vs33) i(vs34) i(vs35) i(vs36) i(vs37)
.endc
.end
