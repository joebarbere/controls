controls oracle ac-0269
* Generated (plan F2.7, ADR 0012): do not edit; regenerate with `pnpm sim oracle regen`. ac seed 20261031 index 269 nodes 16 elements 30
.options sparse gmin=1e-12 noopac
RG1 1 0 1000000000000
RG2 2 0 1000000000000
RG3 3 0 1000000000000
RG4 4 0 1000000000000
RG5 5 0 1000000000000
RG6 6 0 1000000000000
RG7 7 0 1000000000000
RG8 8 0 1000000000000
RG9 9 0 1000000000000
RG10 10 0 1000000000000
RG11 11 0 1000000000000
RG12 12 0 1000000000000
RG13 13 0 1000000000000
RG14 14 0 1000000000000
RG15 15 0 1000000000000
VS0 0 s0 0
V0 e0 s0 DC 0 AC 18e0 120
RI0 e0 m0 15e-3
LI0 m0 4 18e-5
VS1 12 s1 0
C1 s1 6 22e-7
VS2 12 s2 0
L2 s2 0 18e-5
VS3 0 s3 0
C3 s3 12 39e-6
VS4 14 s4 0
L4 s4 10 39e-4
VS5 14 s5 0
R5 s5 12 10e0
VS6 11 s6 0
V6 e6 s6 DC 0 AC 27e-1 -120
RI6 e6 9 10e-2
VS7 14 s7 0
V7 e7 s7 DC 0 AC 33e0 -120
RI7 e7 m7 22e-1
LI7 m7 5 39e-5
VS8 12 s8 0
R8 s8 5 15e-2
VS9 1 s9 0
C9 s9 2 33e-6
VS10 0 s10 0
R10 s10 14 39e-1
VS11 4 s11 0
V11 e11 s11 DC 0 AC 47e0 -120
RI11 e11 m11 39e-1
LI11 m11 15 27e-7
VS12 12 s12 0
C12 s12 5 82e-7
VS13 11 s13 0
L13 s13 1 22e-2
VS14 14 s14 0
C14 s14 15 39e-7
VS15 0 s15 0
V15 e15 s15 DC 0 AC 68e-1 180
RI15 e15 6 33e-2
VS16 4 s16 0
V16 e16 s16 DC 0 AC 15e0 180
RI16 e16 7 18e-1
VS17 3 s17 0
R17 s17 8 12e-1
VS18 6 s18 0
R18 s18 11 15e0
VS19 5 s19 0
C19 s19 8 15e-5
VS20 5 s20 0
L20 s20 11 27e-2
VS21 2 s21 0
R21 s21 10 56e-1
VS22 1 s22 0
V22 e22 s22 DC 0 AC 39e0 -120
RI22 e22 m22 22e-2
LI22 m22 5 18e-6
VS23 5 s23 0
C23 s23 9 18e-5
VS24 4 s24 0
C24 s24 10 12e-4
VS25 13 s25 0
R25 s25 3 18e3
VS26 5 s26 0
R26 s26 7 10e1
VS27 0 s27 0
L27 s27 11 56e-3
VS28 11 s28 0
L28 s28 13 15e-3
VS29 11 s29 0
C29 s29 12 33e-4
.control
set numdgt=17
ac lin 1 60 60
print v(1) v(2) v(3) v(4) v(5) v(6) v(7) v(8) v(9) v(10)
print v(11) v(12) v(13) v(14) v(15)
print i(vs0) i(vs1) i(vs2) i(vs3) i(vs4) i(vs5) i(vs6) i(vs7) i(vs8) i(vs9)
print i(vs10) i(vs11) i(vs12) i(vs13) i(vs14) i(vs15) i(vs16) i(vs17) i(vs18) i(vs19)
print i(vs20) i(vs21) i(vs22) i(vs23) i(vs24) i(vs25) i(vs26) i(vs27) i(vs28) i(vs29)
.endc
.end
