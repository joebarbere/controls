controls oracle ac-0269
* Generated (plan F2.7, ADR 0012): do not edit; regenerate with `pnpm sim oracle regen`. ac seed 20261031 index 269 nodes 16 elements 20
.options sparse gmin=1e-12 noopac
RG1 1 0 1000000000000
RG2 2 0 1000000000000
RG3 3 0 1000000000000
RG4 4 0 1000000000000
RG5 5 0 1000000000000
RG6 6 0 1000000000000
RG7 7 0 1000000000000
RG8 8 0 1000000000000
RG9 9 0 1000000000000
RG10 10 0 1000000000000
RG11 11 0 1000000000000
RG12 12 0 1000000000000
RG13 13 0 1000000000000
RG14 14 0 1000000000000
RG15 15 0 1000000000000
VS0 0 s0 0
L0 s0 3 47e-4
VS1 0 s1 0
V1 e1 s1 DC 0 AC 82e0 -120
RI1 e1 3 10e-3
VS2 4 s2 0
L2 s2 10 39e-2
VS3 9 s3 0
L3 s3 1 56e-2
VS4 13 s4 0
L4 s4 7 27e-3
VS5 3 s5 0
C5 s5 14 47e-5
VS6 11 s6 0
V6 e6 s6 DC 0 AC 27e-1 -120
RI6 e6 9 10e-2
VS7 6 s7 0
R7 s7 3 18e-1
VS8 3 s8 0
V8 e8 s8 DC 0 AC 33e0 -120
RI8 e8 15 56e-1
VS9 8 s9 0
V9 e9 s9 DC 0 AC 22e0 180
RI9 e9 7 22e-1
VS10 7 s10 0
V10 e10 s10 DC 0 AC 33e0 -120
RI10 e10 5 22e-1
VS11 11 s11 0
L11 s11 1 22e-2
VS12 1 s12 0
R12 s12 9 15e0
VS13 5 s13 0
C13 s13 1 56e-4
VS14 12 s14 0
C14 s14 5 82e-6
VS15 5 s15 0
R15 s15 15 27e0
VS16 11 s16 0
C16 s16 1 82e-7
VS17 6 s17 0
V17 e17 s17 DC 0 AC 15e0 120
RI17 e17 3 56e-1
VS18 2 s18 0
R18 s18 3 27e-2
VS19 5 s19 0
V19 e19 s19 DC 0 AC 47e1 120
RI19 e19 4 27e-1
.control
set numdgt=17
ac lin 1 60 60
print v(1) v(2) v(3) v(4) v(5) v(6) v(7) v(8) v(9) v(10)
print v(11) v(12) v(13) v(14) v(15)
print i(vs0) i(vs1) i(vs2) i(vs3) i(vs4) i(vs5) i(vs6) i(vs7) i(vs8) i(vs9)
print i(vs10) i(vs11) i(vs12) i(vs13) i(vs14) i(vs15) i(vs16) i(vs17) i(vs18) i(vs19)
.endc
.end
