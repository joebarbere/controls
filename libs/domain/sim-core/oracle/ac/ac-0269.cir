controls oracle ac-0269
* Generated (plan F2.7, ADR 0012): do not edit; regenerate with `pnpm sim oracle regen`. ac seed 20261031 index 269 nodes 16 elements 27
.options sparse gmin=1e-12 noopac
RG1 1 0 1000000000000
RG2 2 0 1000000000000
RG3 3 0 1000000000000
RG4 4 0 1000000000000
RG5 5 0 1000000000000
RG6 6 0 1000000000000
RG7 7 0 1000000000000
RG8 8 0 1000000000000
RG9 9 0 1000000000000
RG10 10 0 1000000000000
RG11 11 0 1000000000000
RG12 12 0 1000000000000
RG13 13 0 1000000000000
RG14 14 0 1000000000000
RG15 15 0 1000000000000
VS0 0 s0 0
V0 e0 s0 DC 0 AC 82e0 -120
RI0 e0 3 10e-3
VS1 11 s1 0
V1 e1 s1 DC 0 AC 27e-1 -120
RI1 e1 9 10e-2
VS2 13 s2 0
L2 s2 7 27e-3
VS3 1 s3 0
V3 e3 s3 DC 0 AC 33e0 -120
RI3 e3 14 27e-2
VS4 9 s4 0
L4 s4 1 56e-2
VS5 5 s5 0
R5 s5 15 27e0
VS6 7 s6 0
V6 e6 s6 DC 0 AC 33e0 -120
RI6 e6 5 22e-1
VS7 3 s7 0
C7 s7 14 47e-5
VS8 1 s8 0
R8 s8 9 15e0
VS9 3 s9 0
V9 e9 s9 DC 0 AC 33e0 -120
RI9 e9 15 56e-1
VS10 2 s10 0
R10 s10 3 27e-2
VS11 8 s11 0
V11 e11 s11 DC 0 AC 22e0 180
RI11 e11 7 22e-1
VS12 2 s12 0
R12 s12 12 22e2
VS13 6 s13 0
V13 e13 s13 DC 0 AC 10e0 0
RI13 e13 12 47e-1
VS14 9 s14 0
C14 s14 10 56e-5
VS15 0 s15 0
R15 s15 7 56e0
VS16 13 s16 0
L16 s16 14 15e-4
VS17 6 s17 0
R17 s17 3 18e-1
VS18 5 s18 0
V18 e18 s18 DC 0 AC 47e1 120
RI18 e18 4 27e-1
VS19 11 s19 0
C19 s19 1 82e-7
VS20 11 s20 0
L20 s20 1 22e-2
VS21 4 s21 0
L21 s21 10 39e-2
VS22 6 s22 0
V22 e22 s22 DC 0 AC 15e0 120
RI22 e22 3 56e-1
VS23 5 s23 0
C23 s23 1 56e-4
VS24 12 s24 0
C24 s24 5 82e-6
VS25 0 s25 0
L25 s25 3 47e-4
VS26 0 s26 0
R26 s26 8 10e1
.control
set numdgt=17
ac lin 1 60 60
print v(1) v(2) v(3) v(4) v(5) v(6) v(7) v(8) v(9) v(10)
print v(11) v(12) v(13) v(14) v(15)
print i(vs0) i(vs1) i(vs2) i(vs3) i(vs4) i(vs5) i(vs6) i(vs7) i(vs8) i(vs9)
print i(vs10) i(vs11) i(vs12) i(vs13) i(vs14) i(vs15) i(vs16) i(vs17) i(vs18) i(vs19)
print i(vs20) i(vs21) i(vs22) i(vs23) i(vs24) i(vs25) i(vs26)
.endc
.end
