controls oracle ac-0359
* Generated (plan F2.7, ADR 0012): do not edit; regenerate with `pnpm sim oracle regen`. ac seed 20261031 index 359 nodes 11 elements 20
.options sparse gmin=1e-12 noopac
RG1 1 0 1000000000000
RG2 2 0 1000000000000
RG3 3 0 1000000000000
RG4 4 0 1000000000000
RG5 5 0 1000000000000
RG6 6 0 1000000000000
RG7 7 0 1000000000000
RG8 8 0 1000000000000
RG9 9 0 1000000000000
RG10 10 0 1000000000000
VS0 3 s0 0
R0 s0 1 22e-1
VS1 0 s1 0
R1 s1 10 10e1
VS2 0 s2 0
R2 s2 9 10e-2
VS3 3 s3 0
R3 s3 10 82e0
VS4 7 s4 0
R4 s4 6 15e-2
VS5 0 s5 0
V5 e5 s5 DC 0 AC 18e0 180
RI5 e5 m5 82e-3
LI5 m5 5 15e-5
VS6 8 s6 0
C6 s6 5 27e-4
VS7 2 s7 0
L7 s7 5 22e-5
VS8 1 s8 0
R8 s8 4 56e2
VS9 7 s9 0
C9 s9 1 33e-4
VS10 5 s10 0
R10 s10 4 82e2
VS11 10 s11 0
V11 e11 s11 DC 0 AC 10e0 -120
RI11 e11 8 18e-2
VS12 7 s12 0
C12 s12 5 27e-6
VS13 4 s13 0
L13 s13 9 47e-4
VS14 3 s14 0
C14 s14 5 68e-4
VS15 10 s15 0
V15 e15 s15 DC 0 AC 12e-1 120
RI15 e15 2 39e-1
VS16 4 s16 0
C16 s16 6 10e-6
VS17 2 s17 0
R17 s17 8 15e2
VS18 6 s18 0
L18 s18 2 68e-4
VS19 0 s19 0
C19 s19 7 33e-5
.control
set numdgt=17
ac lin 1 60 60
print v(1) v(2) v(3) v(4) v(5) v(6) v(7) v(8) v(9) v(10)
print i(vs0) i(vs1) i(vs2) i(vs3) i(vs4) i(vs5) i(vs6) i(vs7) i(vs8) i(vs9)
print i(vs10) i(vs11) i(vs12) i(vs13) i(vs14) i(vs15) i(vs16) i(vs17) i(vs18) i(vs19)
.endc
.end
