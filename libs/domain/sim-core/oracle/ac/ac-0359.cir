controls oracle ac-0359
* Generated (plan F2.7, ADR 0012): do not edit; regenerate with `pnpm sim oracle regen`. ac seed 20261031 index 359 nodes 11 elements 21
.options sparse gmin=1e-12 noopac
RG1 1 0 1000000000000
RG2 2 0 1000000000000
RG3 3 0 1000000000000
RG4 4 0 1000000000000
RG5 5 0 1000000000000
RG6 6 0 1000000000000
RG7 7 0 1000000000000
RG8 8 0 1000000000000
RG9 9 0 1000000000000
RG10 10 0 1000000000000
VS0 0 s0 0
L0 s0 4 10e-4
VS1 1 s1 0
C1 s1 10 15e-5
VS2 2 s2 0
R2 s2 8 22e-1
VS3 0 s3 0
V3 e3 s3 DC 0 AC 82e1 120
RI3 e3 m3 82e-1
LI3 m3 n3 82e-6
H3 n3 h3 VS4 47e-2
ED3 h3 3 d3 0 -18e-7
F3 0 d3 VS4 1
LD3 d3 0 1
VS4 7 s4 0
V4 e4 s4 DC 0 AC 39e-1 -120
RI4 e4 m4 12e-1
LI4 m4 n4 15e-6
H4 n4 h4 VS3 47e-2
ED4 h4 9 d4 0 -18e-7
F4 0 d4 VS3 1
LD4 d4 0 1
VS5 6 s5 0
V5 e5 s5 DC 0 AC 18e0 180
RI5 e5 5 82e-3
VS6 6 s6 0
C6 s6 2 18e-6
VS7 7 s7 0
V7 e7 s7 DC 0 AC 22e1 120
RI7 e7 4 18e-2
VS8 8 s8 0
R8 s8 7 82e1
VS9 8 s9 0
R9 s9 9 12e0
VS10 6 s10 0
L10 s10 4 82e-4
VS11 3 s11 0
R11 s11 4 33e3
VS12 4 s12 0
C12 s12 6 27e-6
VS13 8 s13 0
C13 s13 2 39e-4
VS14 6 s14 0
R14 s14 8 22e-1
VS15 1 s15 0
R15 s15 0 22e-1
VS16 8 s16 0
C16 s16 3 47e-5
VS17 1 s17 0
V17 e17 s17 DC 0 AC 27e-1 180
RI17 e17 m17 18e-3
LI17 m17 3 33e-7
VS18 1 s18 0
R18 s18 6 56e0
VS19 10 s19 0
R19 s19 8 15e0
VS20 10 s20 0
R20 s20 5 27e-2
.control
set numdgt=17
ac lin 1 60 60
print v(1) v(2) v(3) v(4) v(5) v(6) v(7) v(8) v(9) v(10)
print i(vs0) i(vs1) i(vs2) i(vs3) i(vs4) i(vs5) i(vs6) i(vs7) i(vs8) i(vs9)
print i(vs10) i(vs11) i(vs12) i(vs13) i(vs14) i(vs15) i(vs16) i(vs17) i(vs18) i(vs19)
print i(vs20)
.endc
.end
