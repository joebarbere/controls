controls oracle ac-0359
* Generated (plan F2.7, ADR 0012): do not edit; regenerate with `pnpm sim oracle regen`. ac seed 20261031 index 359 nodes 11 elements 20
.options sparse gmin=1e-12 noopac
RG1 1 0 1000000000000
RG2 2 0 1000000000000
RG3 3 0 1000000000000
RG4 4 0 1000000000000
RG5 5 0 1000000000000
RG6 6 0 1000000000000
RG7 7 0 1000000000000
RG8 8 0 1000000000000
RG9 9 0 1000000000000
RG10 10 0 1000000000000
VS0 0 s0 0
L0 s0 4 10e-4
VS1 8 s1 0
C1 s1 2 39e-4
VS2 6 s2 0
L2 s2 4 82e-4
VS3 1 s3 0
R3 s3 6 56e0
VS4 6 s4 0
R4 s4 8 22e-1
VS5 8 s5 0
C5 s5 3 47e-5
VS6 8 s6 0
R6 s6 9 12e0
VS7 1 s7 0
C7 s7 10 15e-5
VS8 2 s8 0
R8 s8 8 22e-1
VS9 10 s9 0
R9 s9 8 15e0
VS10 0 s10 0
V10 e10 s10 DC 0 AC 82e1 120
RI10 e10 3 82e-1
VS11 1 s11 0
R11 s11 0 22e-1
VS12 7 s12 0
V12 e12 s12 DC 0 AC 39e-1 -120
RI12 e12 9 12e-1
VS13 8 s13 0
R13 s13 7 82e1
VS14 4 s14 0
C14 s14 6 27e-6
VS15 6 s15 0
V15 e15 s15 DC 0 AC 18e0 180
RI15 e15 5 82e-3
VS16 6 s16 0
C16 s16 2 18e-6
VS17 10 s17 0
R17 s17 5 27e-2
VS18 3 s18 0
R18 s18 4 33e3
VS19 1 s19 0
V19 e19 s19 DC 0 AC 27e-1 180
RI19 e19 3 18e-3
.control
set numdgt=17
ac lin 1 60 60
print v(1) v(2) v(3) v(4) v(5) v(6) v(7) v(8) v(9) v(10)
print i(vs0) i(vs1) i(vs2) i(vs3) i(vs4) i(vs5) i(vs6) i(vs7) i(vs8) i(vs9)
print i(vs10) i(vs11) i(vs12) i(vs13) i(vs14) i(vs15) i(vs16) i(vs17) i(vs18) i(vs19)
.endc
.end
