controls oracle ac-0102
* Generated (plan F2.7, ADR 0012): do not edit; regenerate with `pnpm sim oracle regen`. ac seed 20261031 index 102 nodes 18 elements 28
.options sparse gmin=1e-12 noopac
RG1 1 0 1000000000000
RG2 2 0 1000000000000
RG3 3 0 1000000000000
RG4 4 0 1000000000000
RG5 5 0 1000000000000
RG6 6 0 1000000000000
RG7 7 0 1000000000000
RG8 8 0 1000000000000
RG9 9 0 1000000000000
RG10 10 0 1000000000000
RG11 11 0 1000000000000
RG12 12 0 1000000000000
RG13 13 0 1000000000000
RG14 14 0 1000000000000
RG15 15 0 1000000000000
RG16 16 0 1000000000000
RG17 17 0 1000000000000
VS0 2 s0 0
R0 s0 7 22e-1
VS1 13 s1 0
R1 s1 11 68e-2
VS2 15 s2 0
R2 s2 17 22e0
VS3 16 s3 0
C3 s3 14 33e-4
VS4 10 s4 0
R4 s4 7 18e-1
VS5 4 s5 0
C5 s5 7 12e-5
VS6 9 s6 0
L6 s6 11 68e-5
VS7 8 s7 0
R7 s7 17 10e-1
VS8 4 s8 0
R8 s8 12 82e3
VS9 1 s9 0
R9 s9 2 68e-1
VS10 7 s10 0
L10 s10 11 39e-3
VS11 5 s11 0
C11 s11 4 39e-6
VS12 12 s12 0
C12 s12 1 68e-5
VS13 14 s13 0
R13 s13 3 10e-2
VS14 6 s14 0
R14 s14 8 56e2
VS15 13 s15 0
L15 s15 6 18e-3
VS16 0 s16 0
V16 e16 s16 DC 0 AC 27e0 -120
RI16 e16 16 10e-2
VS17 11 s17 0
V17 e17 s17 DC 0 AC 18e1 0
RI17 e17 m17 27e-3
LI17 m17 3 15e-5
VS18 10 s18 0
R18 s18 11 15e0
VS19 14 s19 0
R19 s19 17 12e3
VS20 5 s20 0
C20 s20 13 47e-5
VS21 16 s21 0
V21 e21 s21 DC 0 AC 10e0 0
RI21 e21 m21 22e-2
LI21 m21 4 33e-7
VS22 13 s22 0
C22 s22 0 22e-6
VS23 9 s23 0
R23 s23 17 12e0
VS24 6 s24 0
L24 s24 7 10e-5
VS25 14 s25 0
C25 s25 15 33e-6
VS26 11 s26 0
R26 s26 4 27e1
VS27 13 s27 0
L27 s27 12 10e-2
.control
set numdgt=17
ac lin 1 60 60
print v(1) v(2) v(3) v(4) v(5) v(6) v(7) v(8) v(9) v(10)
print v(11) v(12) v(13) v(14) v(15) v(16) v(17)
print i(vs0) i(vs1) i(vs2) i(vs3) i(vs4) i(vs5) i(vs6) i(vs7) i(vs8) i(vs9)
print i(vs10) i(vs11) i(vs12) i(vs13) i(vs14) i(vs15) i(vs16) i(vs17) i(vs18) i(vs19)
print i(vs20) i(vs21) i(vs22) i(vs23) i(vs24) i(vs25) i(vs26) i(vs27)
.endc
.end
