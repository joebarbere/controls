controls oracle ac-0102
* Generated (plan F2.7, ADR 0012): do not edit; regenerate with `pnpm sim oracle regen`. ac seed 20261031 index 102 nodes 18 elements 23
.options sparse gmin=1e-12 noopac
RG1 1 0 1000000000000
RG2 2 0 1000000000000
RG3 3 0 1000000000000
RG4 4 0 1000000000000
RG5 5 0 1000000000000
RG6 6 0 1000000000000
RG7 7 0 1000000000000
RG8 8 0 1000000000000
RG9 9 0 1000000000000
RG10 10 0 1000000000000
RG11 11 0 1000000000000
RG12 12 0 1000000000000
RG13 13 0 1000000000000
RG14 14 0 1000000000000
RG15 15 0 1000000000000
RG16 16 0 1000000000000
RG17 17 0 1000000000000
VS0 3 s0 0
R0 s0 4 18e0
VS1 0 s1 0
R1 s1 12 22e2
VS2 11 s2 0
C2 s2 7 12e-5
VS3 2 s3 0
R3 s3 7 22e-1
VS4 10 s4 0
R4 s4 0 15e0
VS5 0 s5 0
V5 e5 s5 DC 0 AC 18e1 0
RI5 e5 3 27e-3
VS6 7 s6 0
L6 s6 0 39e-3
VS7 12 s7 0
C7 s7 1 68e-5
VS8 11 s8 0
C8 s8 17 10e-4
VS9 5 s9 0
C9 s9 11 39e-6
VS10 13 s10 0
R10 s10 0 68e-2
VS11 3 s11 0
R11 s11 0 39e2
VS12 7 s12 0
R12 s12 5 22e2
VS13 9 s13 0
L13 s13 0 68e-5
VS14 10 s14 0
R14 s14 17 22e-1
VS15 11 s15 0
R15 s15 12 82e3
VS16 11 s16 0
R16 s16 14 68e2
VS17 0 s17 0
R17 s17 11 27e1
VS18 8 s18 0
R18 s18 13 27e3
VS19 1 s19 0
R19 s19 2 68e-1
VS20 16 s20 0
V20 e20 s20 DC 0 AC 39e0 180
RI20 e20 15 33e-2
VS21 6 s21 0
R21 s21 0 47e2
VS22 15 s22 0
R22 s22 11 56e0
.control
set numdgt=17
ac lin 1 60 60
print v(1) v(2) v(3) v(4) v(5) v(6) v(7) v(8) v(9) v(10)
print v(11) v(12) v(13) v(14) v(15) v(16) v(17)
print i(vs0) i(vs1) i(vs2) i(vs3) i(vs4) i(vs5) i(vs6) i(vs7) i(vs8) i(vs9)
print i(vs10) i(vs11) i(vs12) i(vs13) i(vs14) i(vs15) i(vs16) i(vs17) i(vs18) i(vs19)
print i(vs20) i(vs21) i(vs22)
.endc
.end
