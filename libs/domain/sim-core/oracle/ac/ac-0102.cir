controls oracle ac-0102
* Generated (plan F2.7, ADR 0012): do not edit; regenerate with `pnpm sim oracle regen`. ac seed 20261031 index 102 nodes 18 elements 27
.options sparse gmin=1e-12 noopac
RG1 1 0 1000000000000
RG2 2 0 1000000000000
RG3 3 0 1000000000000
RG4 4 0 1000000000000
RG5 5 0 1000000000000
RG6 6 0 1000000000000
RG7 7 0 1000000000000
RG8 8 0 1000000000000
RG9 9 0 1000000000000
RG10 10 0 1000000000000
RG11 11 0 1000000000000
RG12 12 0 1000000000000
RG13 13 0 1000000000000
RG14 14 0 1000000000000
RG15 15 0 1000000000000
RG16 16 0 1000000000000
RG17 17 0 1000000000000
VS0 3 s0 0
R0 s0 4 18e0
VS1 5 s1 0
C1 s1 2 39e-6
VS2 2 s2 0
R2 s2 14 68e2
VS3 7 s3 0
R3 s3 5 22e2
VS4 9 s4 0
L4 s4 11 68e-5
VS5 0 s5 0
R5 s5 7 22e-1
VS6 11 s6 0
R6 s6 2 27e1
VS7 10 s7 0
R7 s7 17 22e-1
VS8 13 s8 0
R8 s8 11 68e-2
VS9 11 s9 0
R9 s9 12 22e2
VS10 12 s10 0
C10 s10 1 68e-5
VS11 7 s11 0
L11 s11 11 39e-3
VS12 10 s12 0
R12 s12 11 15e0
VS13 1 s13 0
R13 s13 0 68e-1
VS14 0 s14 0
V14 e14 s14 DC 0 AC 33e1 0
RI14 e14 n14 56e-2
H14 n14 h14 VS15 15e-3
ED14 h14 4 d14 0 -33e-6
F14 0 d14 VS15 1
LD14 d14 0 1
VS15 16 s15 0
V15 e15 s15 DC 0 AC 39e0 180
RI15 e15 n15 33e-2
H15 n15 h15 VS14 15e-3
ED15 h15 15 d15 0 -33e-6
F15 0 d15 VS14 1
LD15 d15 0 1
VS16 15 s16 0
R16 s16 2 56e0
VS17 6 s17 0
R17 s17 11 47e2
VS18 11 s18 0
V18 e18 s18 DC 0 AC 18e1 0
RI18 e18 m18 27e-3
LI18 m18 3 56e-5
VS19 2 s19 0
C19 s19 7 12e-5
VS20 13 s20 0
R20 s20 14 10e-2
VS21 2 s21 0
C21 s21 17 10e-4
VS22 16 s22 0
C22 s22 6 33e-6
VS23 8 s23 0
V23 e23 s23 DC 0 AC 10e0 0
RI23 e23 m23 22e-2
LI23 m23 2 15e-7
VS24 8 s24 0
R24 s24 13 27e3
VS25 7 s25 0
L25 s25 9 18e-3
VS26 2 s26 0
R26 s26 12 82e3
.control
set numdgt=17
ac lin 1 60 60
print v(1) v(2) v(3) v(4) v(5) v(6) v(7) v(8) v(9) v(10)
print v(11) v(12) v(13) v(14) v(15) v(16) v(17)
print i(vs0) i(vs1) i(vs2) i(vs3) i(vs4) i(vs5) i(vs6) i(vs7) i(vs8) i(vs9)
print i(vs10) i(vs11) i(vs12) i(vs13) i(vs14) i(vs15) i(vs16) i(vs17) i(vs18) i(vs19)
print i(vs20) i(vs21) i(vs22) i(vs23) i(vs24) i(vs25) i(vs26)
.endc
.end
