controls oracle ac-0121
* Generated (plan F2.7, ADR 0012): do not edit; regenerate with `pnpm sim oracle regen`. ac seed 20261031 index 121 nodes 15 elements 20
.options sparse gmin=1e-12 noopac
RG1 1 0 1000000000000
RG2 2 0 1000000000000
RG3 3 0 1000000000000
RG4 4 0 1000000000000
RG5 5 0 1000000000000
RG6 6 0 1000000000000
RG7 7 0 1000000000000
RG8 8 0 1000000000000
RG9 9 0 1000000000000
RG10 10 0 1000000000000
RG11 11 0 1000000000000
RG12 12 0 1000000000000
RG13 13 0 1000000000000
RG14 14 0 1000000000000
VS0 13 s0 0
L0 s0 14 27e-5
VS1 11 s1 0
C1 s1 14 22e-7
VS2 0 s2 0
V2 e2 s2 DC 0 AC 18e0 0
RI2 e2 m2 27e-2
LI2 m2 n2 39e-6
H2 n2 h2 VS12 -68e-3
ED2 h2 6 d2 0 -82e-7
F2 0 d2 VS12 1
LD2 d2 0 1
VS3 1 s3 0
R3 s3 6 47e1
VS4 0 s4 0
R4 s4 10 27e0
VS5 6 s5 0
R5 s5 9 33e-2
VS6 9 s6 0
L6 s6 11 47e-3
VS7 7 s7 0
R7 s7 4 47e-1
VS8 12 s8 0
C8 s8 13 47e-6
VS9 14 s9 0
R9 s9 1 47e1
VS10 12 s10 0
L10 s10 4 33e-4
VS11 5 s11 0
R11 s11 11 39e0
VS12 5 s12 0
V12 e12 s12 DC 0 AC 39e-1 180
RI12 e12 n12 22e-1
H12 n12 h12 VS2 -68e-3
ED12 h12 8 d12 0 -82e-7
F12 0 d12 VS2 1
LD12 d12 0 1
VS13 2 s13 0
R13 s13 14 18e-2
VS14 3 s14 0
R14 s14 11 18e0
VS15 7 s15 0
R15 s15 6 82e-1
VS16 8 s16 0
V16 e16 s16 DC 0 AC 33e0 -120
RI16 e16 2 82e-1
VS17 10 s17 0
R17 s17 9 39e1
VS18 12 s18 0
V18 e18 s18 DC 0 AC 33e-1 -120
RI18 e18 m18 12e-1
LI18 m18 3 27e-7
VS19 2 s19 0
V19 e19 s19 DC 0 AC 10e1 -120
RI19 e19 m19 56e-2
LI19 m19 11 22e-5
.control
set numdgt=17
ac lin 1 60 60
print v(1) v(2) v(3) v(4) v(5) v(6) v(7) v(8) v(9) v(10)
print v(11) v(12) v(13) v(14)
print i(vs0) i(vs1) i(vs2) i(vs3) i(vs4) i(vs5) i(vs6) i(vs7) i(vs8) i(vs9)
print i(vs10) i(vs11) i(vs12) i(vs13) i(vs14) i(vs15) i(vs16) i(vs17) i(vs18) i(vs19)
.endc
.end
