controls oracle ac-0121
* Generated (plan F2.7, ADR 0012): do not edit; regenerate with `pnpm sim oracle regen`. ac seed 20261031 index 121 nodes 15 elements 17
.options sparse gmin=1e-12 noopac
RG1 1 0 1000000000000
RG2 2 0 1000000000000
RG3 3 0 1000000000000
RG4 4 0 1000000000000
RG5 5 0 1000000000000
RG6 6 0 1000000000000
RG7 7 0 1000000000000
RG8 8 0 1000000000000
RG9 9 0 1000000000000
RG10 10 0 1000000000000
RG11 11 0 1000000000000
RG12 12 0 1000000000000
RG13 13 0 1000000000000
RG14 14 0 1000000000000
VS0 1 s0 0
R0 s0 6 47e1
VS1 0 s1 0
V1 e1 s1 DC 0 AC 18e0 0
RI1 e1 6 27e-2
VS2 7 s2 0
R2 s2 4 47e-1
VS3 5 s3 0
V3 e3 s3 DC 0 AC 39e-1 180
RI3 e3 8 22e-1
VS4 3 s4 0
R4 s4 11 18e0
VS5 6 s5 0
R5 s5 9 33e-2
VS6 2 s6 0
R6 s6 14 18e-2
VS7 11 s7 0
C7 s7 14 22e-7
VS8 9 s8 0
L8 s8 11 47e-3
VS9 14 s9 0
R9 s9 1 47e1
VS10 12 s10 0
L10 s10 4 33e-4
VS11 7 s11 0
R11 s11 6 82e-1
VS12 13 s12 0
L12 s12 14 27e-5
VS13 12 s13 0
V13 e13 s13 DC 0 AC 33e-1 -120
RI13 e13 3 12e-1
VS14 10 s14 0
R14 s14 9 39e1
VS15 2 s15 0
V15 e15 s15 DC 0 AC 10e1 -120
RI15 e15 11 56e-2
VS16 8 s16 0
V16 e16 s16 DC 0 AC 33e0 -120
RI16 e16 2 82e-1
.control
set numdgt=17
ac lin 1 60 60
print v(1) v(2) v(3) v(4) v(5) v(6) v(7) v(8) v(9) v(10)
print v(11) v(12) v(13) v(14)
print i(vs0) i(vs1) i(vs2) i(vs3) i(vs4) i(vs5) i(vs6) i(vs7) i(vs8) i(vs9)
print i(vs10) i(vs11) i(vs12) i(vs13) i(vs14) i(vs15) i(vs16)
.endc
.end
