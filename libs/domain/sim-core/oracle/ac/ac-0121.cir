controls oracle ac-0121
* Generated (plan F2.7, ADR 0012): do not edit; regenerate with `pnpm sim oracle regen`. ac seed 20261031 index 121 nodes 15 elements 20
.options sparse gmin=1e-12 noopac
RG1 1 0 1000000000000
RG2 2 0 1000000000000
RG3 3 0 1000000000000
RG4 4 0 1000000000000
RG5 5 0 1000000000000
RG6 6 0 1000000000000
RG7 7 0 1000000000000
RG8 8 0 1000000000000
RG9 9 0 1000000000000
RG10 10 0 1000000000000
RG11 11 0 1000000000000
RG12 12 0 1000000000000
RG13 13 0 1000000000000
RG14 14 0 1000000000000
VS0 6 s0 0
R0 s0 9 33e-2
VS1 2 s1 0
R1 s1 5 18e1
VS2 10 s2 0
R2 s2 9 39e1
VS3 11 s3 0
C3 s3 14 22e-7
VS4 10 s4 0
L4 s4 13 27e-4
VS5 2 s5 0
R5 s5 11 18e0
VS6 5 s6 0
L6 s6 7 12e-5
VS7 1 s7 0
L7 s7 6 47e-4
VS8 9 s8 0
L8 s8 1 33e-4
VS9 8 s9 0
L9 s9 12 10e-2
VS10 4 s10 0
L10 s10 12 22e-3
VS11 7 s11 0
R11 s11 0 12e1
VS12 0 s12 0
V12 e12 s12 DC 0 AC 10e1 -120
RI12 e12 m12 56e-2
LI12 m12 11 47e-7
VS13 14 s13 0
V13 e13 s13 DC 0 AC 39e1 120
RI13 e13 m13 15e-1
LI13 m13 10 33e-6
VS14 9 s14 0
L14 s14 11 47e-3
VS15 3 s15 0
V15 e15 s15 DC 0 AC 18e0 0
RI15 e15 6 27e-2
VS16 4 s16 0
R16 s16 0 47e0
VS17 13 s17 0
R17 s17 3 56e-1
VS18 8 s18 0
C18 s18 9 56e-7
VS19 8 s19 0
L19 s19 11 82e-4
.control
set numdgt=17
ac lin 1 60 60
print v(1) v(2) v(3) v(4) v(5) v(6) v(7) v(8) v(9) v(10)
print v(11) v(12) v(13) v(14)
print i(vs0) i(vs1) i(vs2) i(vs3) i(vs4) i(vs5) i(vs6) i(vs7) i(vs8) i(vs9)
print i(vs10) i(vs11) i(vs12) i(vs13) i(vs14) i(vs15) i(vs16) i(vs17) i(vs18) i(vs19)
.endc
.end
