controls oracle ac-0185
* Generated (plan F2.7, ADR 0012): do not edit; regenerate with `pnpm sim oracle regen`. ac seed 20261031 index 185 nodes 25 elements 41
.options sparse gmin=1e-12 noopac
RG1 1 0 1000000000000
RG2 2 0 1000000000000
RG3 3 0 1000000000000
RG4 4 0 1000000000000
RG5 5 0 1000000000000
RG6 6 0 1000000000000
RG7 7 0 1000000000000
RG8 8 0 1000000000000
RG9 9 0 1000000000000
RG10 10 0 1000000000000
RG11 11 0 1000000000000
RG12 12 0 1000000000000
RG13 13 0 1000000000000
RG14 14 0 1000000000000
RG15 15 0 1000000000000
RG16 16 0 1000000000000
RG17 17 0 1000000000000
RG18 18 0 1000000000000
RG19 19 0 1000000000000
RG20 20 0 1000000000000
RG21 21 0 1000000000000
RG22 22 0 1000000000000
RG23 23 0 1000000000000
RG24 24 0 1000000000000
VS0 11 s0 0
R0 s0 6 56e0
VS1 4 s1 0
L1 s1 13 15e-4
VS2 0 s2 0
V2 e2 s2 DC 0 AC 22e1 180
RI2 e2 m2 33e-1
LI2 m2 n2 10e-5
H2 n2 h2 VS12 -22e-3
ED2 h2 6 d2 0 -33e-6
F2 0 d2 VS12 1
LD2 d2 0 1
VS3 20 s3 0
L3 s3 4 82e-3
VS4 5 s4 0
C4 s4 20 33e-6
VS5 7 s5 0
L5 s5 21 47e-4
VS6 14 s6 0
L6 s6 12 22e-2
VS7 1 s7 0
C7 s7 17 47e-4
VS8 12 s8 0
C8 s8 3 47e-7
VS9 2 s9 0
L9 s9 20 18e-4
VS10 8 s10 0
L10 s10 3 47e-3
VS11 2 s11 0
L11 s11 23 27e-3
VS12 10 s12 0
V12 e12 s12 DC 0 AC 22e-1 180
RI12 e12 m12 12e-2
LI12 m12 n12 39e-6
H12 n12 h12 VS2 -22e-3
ED12 h12 6 d12 0 -33e-6
F12 0 d12 VS2 1
LD12 d12 0 1
VS13 11 s13 0
R13 s13 4 15e-1
VS14 6 s14 0
R14 s14 24 68e1
VS15 5 s15 0
L15 s15 1 82e-2
VS16 1 s16 0
L16 s16 6 15e-5
VS17 9 s17 0
R17 s17 12 47e-1
VS18 17 s18 0
C18 s18 22 39e-4
VS19 22 s19 0
L19 s19 15 12e-4
VS20 14 s20 0
R20 s20 17 12e0
VS21 7 s21 0
L21 s21 17 27e-4
VS22 9 s22 0
V22 e22 s22 DC 0 AC 47e-1 0
RI22 e22 m22 15e-1
LI22 m22 23 68e-5
VS23 10 s23 0
R23 s23 15 12e-1
VS24 3 s24 0
C24 s24 5 12e-7
VS25 11 s25 0
L25 s25 21 39e-2
VS26 0 s26 0
R26 s26 22 68e-2
VS27 2 s27 0
L27 s27 15 27e-5
VS28 18 s28 0
C28 s28 3 33e-5
VS29 2 s29 0
V29 e29 s29 DC 0 AC 68e0 120
RI29 e29 10 47e-3
VS30 0 s30 0
V30 e30 s30 DC 0 AC 39e1 120
RI30 e30 5 82e-3
VS31 24 s31 0
R31 s31 1 18e2
VS32 16 s32 0
L32 s32 19 18e-3
VS33 24 s33 0
C33 s33 22 68e-4
VS34 16 s34 0
L34 s34 18 68e-2
VS35 14 s35 0
R35 s35 19 10e-2
VS36 8 s36 0
C36 s36 23 33e-4
VS37 0 s37 0
R37 s37 19 15e-2
VS38 16 s38 0
R38 s38 18 56e0
VS39 13 s39 0
R39 s39 11 82e1
VS40 1 s40 0
R40 s40 18 33e-2
.control
set numdgt=17
ac lin 1 60 60
print v(1) v(2) v(3) v(4) v(5) v(6) v(7) v(8) v(9) v(10)
print v(11) v(12) v(13) v(14) v(15) v(16) v(17) v(18) v(19) v(20)
print v(21) v(22) v(23) v(24)
print i(vs0) i(vs1) i(vs2) i(vs3) i(vs4) i(vs5) i(vs6) i(vs7) i(vs8) i(vs9)
print i(vs10) i(vs11) i(vs12) i(vs13) i(vs14) i(vs15) i(vs16) i(vs17) i(vs18) i(vs19)
print i(vs20) i(vs21) i(vs22) i(vs23) i(vs24) i(vs25) i(vs26) i(vs27) i(vs28) i(vs29)
print i(vs30) i(vs31) i(vs32) i(vs33) i(vs34) i(vs35) i(vs36) i(vs37) i(vs38) i(vs39)
print i(vs40)
.endc
.end
