controls oracle ac-0185
* Generated (plan F2.7, ADR 0012): do not edit; regenerate with `pnpm sim oracle regen`. ac seed 20261031 index 185 nodes 25 elements 39
.options sparse gmin=1e-12 noopac
RG1 1 0 1000000000000
RG2 2 0 1000000000000
RG3 3 0 1000000000000
RG4 4 0 1000000000000
RG5 5 0 1000000000000
RG6 6 0 1000000000000
RG7 7 0 1000000000000
RG8 8 0 1000000000000
RG9 9 0 1000000000000
RG10 10 0 1000000000000
RG11 11 0 1000000000000
RG12 12 0 1000000000000
RG13 13 0 1000000000000
RG14 14 0 1000000000000
RG15 15 0 1000000000000
RG16 16 0 1000000000000
RG17 17 0 1000000000000
RG18 18 0 1000000000000
RG19 19 0 1000000000000
RG20 20 0 1000000000000
RG21 21 0 1000000000000
RG22 22 0 1000000000000
RG23 23 0 1000000000000
RG24 24 0 1000000000000
VS0 16 s0 0
L0 s0 18 68e-2
VS1 2 s1 0
L1 s1 20 18e-4
VS2 1 s2 0
R2 s2 22 68e-2
VS3 5 s3 0
C3 s3 20 33e-6
VS4 16 s4 0
R4 s4 18 56e0
VS5 1 s5 0
R5 s5 19 15e-2
VS6 0 s6 0
R6 s6 15 12e-1
VS7 24 s7 0
R7 s7 10 18e2
VS8 0 s8 0
V8 e8 s8 DC 0 AC 22e-1 180
RI8 e8 6 12e-2
VS9 2 s9 0
L9 s9 15 27e-5
VS10 8 s10 0
C10 s10 23 33e-4
VS11 13 s11 0
R11 s11 11 82e1
VS12 11 s12 0
R12 s12 6 56e0
VS13 7 s13 0
L13 s13 21 47e-4
VS14 11 s14 0
L14 s14 21 39e-2
VS15 1 s15 0
V15 e15 s15 DC 0 AC 39e1 120
RI15 e15 5 82e-3
VS16 16 s16 0
L16 s16 19 18e-3
VS17 6 s17 0
R17 s17 24 68e1
VS18 5 s18 0
L18 s18 10 82e-2
VS19 14 s19 0
L19 s19 12 22e-2
VS20 2 s20 0
L20 s20 23 27e-3
VS21 3 s21 0
C21 s21 5 12e-7
VS22 24 s22 0
C22 s22 22 68e-4
VS23 17 s23 0
C23 s23 22 39e-4
VS24 10 s24 0
L24 s24 6 15e-5
VS25 10 s25 0
C25 s25 17 47e-4
VS26 10 s26 0
R26 s26 18 33e-2
VS27 9 s27 0
R27 s27 12 47e-1
VS28 4 s28 0
L28 s28 13 15e-4
VS29 1 s29 0
V29 e29 s29 DC 0 AC 22e1 180
RI29 e29 6 33e-1
VS30 22 s30 0
L30 s30 15 12e-4
VS31 18 s31 0
C31 s31 3 33e-5
VS32 14 s32 0
R32 s32 17 12e0
VS33 14 s33 0
R33 s33 19 10e-2
VS34 7 s34 0
L34 s34 17 27e-4
VS35 11 s35 0
R35 s35 4 15e-1
VS36 8 s36 0
L36 s36 3 47e-3
VS37 2 s37 0
V37 e37 s37 DC 0 AC 68e0 120
RI37 e37 0 47e-3
VS38 12 s38 0
C38 s38 3 47e-7
.control
set numdgt=17
ac lin 1 60 60
print v(1) v(2) v(3) v(4) v(5) v(6) v(7) v(8) v(9) v(10)
print v(11) v(12) v(13) v(14) v(15) v(16) v(17) v(18) v(19) v(20)
print v(21) v(22) v(23) v(24)
print i(vs0) i(vs1) i(vs2) i(vs3) i(vs4) i(vs5) i(vs6) i(vs7) i(vs8) i(vs9)
print i(vs10) i(vs11) i(vs12) i(vs13) i(vs14) i(vs15) i(vs16) i(vs17) i(vs18) i(vs19)
print i(vs20) i(vs21) i(vs22) i(vs23) i(vs24) i(vs25) i(vs26) i(vs27) i(vs28) i(vs29)
print i(vs30) i(vs31) i(vs32) i(vs33) i(vs34) i(vs35) i(vs36) i(vs37) i(vs38)
.endc
.end
