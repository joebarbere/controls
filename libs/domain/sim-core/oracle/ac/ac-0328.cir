controls oracle ac-0328
* Generated (plan F2.7, ADR 0012): do not edit; regenerate with `pnpm sim oracle regen`. ac seed 20261031 index 328 nodes 16 elements 19
.options sparse gmin=1e-12 noopac
RG1 1 0 1000000000000
RG2 2 0 1000000000000
RG3 3 0 1000000000000
RG4 4 0 1000000000000
RG5 5 0 1000000000000
RG6 6 0 1000000000000
RG7 7 0 1000000000000
RG8 8 0 1000000000000
RG9 9 0 1000000000000
RG10 10 0 1000000000000
RG11 11 0 1000000000000
RG12 12 0 1000000000000
RG13 13 0 1000000000000
RG14 14 0 1000000000000
RG15 15 0 1000000000000
VS0 7 s0 0
L0 s0 8 82e-4
VS1 0 s1 0
V1 e1 s1 DC 0 AC 33e0 -120
RI1 e1 12 82e-2
VS2 0 s2 0
V2 e2 s2 DC 0 AC 27e-1 -120
RI2 e2 8 39e-3
VS3 6 s3 0
L3 s3 14 33e-5
VS4 11 s4 0
C4 s4 12 47e-4
VS5 12 s5 0
V5 e5 s5 DC 0 AC 82e0 180
RI5 e5 3 15e-2
VS6 15 s6 0
L6 s6 3 15e-5
VS7 12 s7 0
L7 s7 7 82e-5
VS8 0 s8 0
V8 e8 s8 DC 0 AC 15e1 0
RI8 e8 4 27e-2
VS9 14 s9 0
L9 s9 7 56e-4
VS10 14 s10 0
L10 s10 3 15e-2
VS11 9 s11 0
L11 s11 7 27e-3
VS12 6 s12 0
V12 e12 s12 DC 0 AC 10e-1 120
RI12 e12 3 33e-1
VS13 2 s13 0
V13 e13 s13 DC 0 AC 12e1 0
RI13 e13 0 33e-3
VS14 7 s14 0
L14 s14 0 15e-5
VS15 12 s15 0
L15 s15 10 68e-4
VS16 13 s16 0
V16 e16 s16 DC 0 AC 22e-1 120
RI16 e16 8 82e-2
VS17 5 s17 0
R17 s17 13 56e2
VS18 1 s18 0
C18 s18 9 10e-6
.control
set numdgt=17
ac lin 1 60 60
print v(1) v(2) v(3) v(4) v(5) v(6) v(7) v(8) v(9) v(10)
print v(11) v(12) v(13) v(14) v(15)
print i(vs0) i(vs1) i(vs2) i(vs3) i(vs4) i(vs5) i(vs6) i(vs7) i(vs8) i(vs9)
print i(vs10) i(vs11) i(vs12) i(vs13) i(vs14) i(vs15) i(vs16) i(vs17) i(vs18)
.endc
.end
