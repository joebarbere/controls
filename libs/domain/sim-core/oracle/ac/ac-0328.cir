controls oracle ac-0328
* Generated (plan F2.7, ADR 0012): do not edit; regenerate with `pnpm sim oracle regen`. ac seed 20261031 index 328 nodes 16 elements 24
.options sparse gmin=1e-12 noopac
RG1 1 0 1000000000000
RG2 2 0 1000000000000
RG3 3 0 1000000000000
RG4 4 0 1000000000000
RG5 5 0 1000000000000
RG6 6 0 1000000000000
RG7 7 0 1000000000000
RG8 8 0 1000000000000
RG9 9 0 1000000000000
RG10 10 0 1000000000000
RG11 11 0 1000000000000
RG12 12 0 1000000000000
RG13 13 0 1000000000000
RG14 14 0 1000000000000
RG15 15 0 1000000000000
VS0 11 s0 0
C0 s0 12 47e-4
VS1 6 s1 0
C1 s1 1 18e-4
VS2 0 s2 0
V2 e2 s2 DC 0 AC 33e0 -120
RI2 e2 12 82e-2
VS3 12 s3 0
L3 s3 10 68e-4
VS4 12 s4 0
V4 e4 s4 DC 0 AC 82e0 180
RI4 e4 3 15e-2
VS5 14 s5 0
L5 s5 3 15e-2
VS6 1 s6 0
C6 s6 9 10e-6
VS7 10 s7 0
L7 s7 2 39e-4
VS8 15 s8 0
L8 s8 5 22e-2
VS9 14 s9 0
V9 e9 s9 DC 0 AC 68e1 120
RI9 e9 4 15e-3
VS10 7 s10 0
L10 s10 8 82e-4
VS11 2 s11 0
V11 e11 s11 DC 0 AC 12e1 0
RI11 e11 0 33e-3
VS12 6 s12 0
L12 s12 14 33e-5
VS13 7 s13 0
L13 s13 0 15e-5
VS14 6 s14 0
V14 e14 s14 DC 0 AC 10e-1 120
RI14 e14 3 33e-1
VS15 14 s15 0
L15 s15 7 56e-4
VS16 9 s16 0
L16 s16 7 27e-3
VS17 5 s17 0
R17 s17 13 56e2
VS18 12 s18 0
L18 s18 7 82e-5
VS19 15 s19 0
L19 s19 3 15e-5
VS20 13 s20 0
V20 e20 s20 DC 0 AC 22e-1 120
RI20 e20 8 82e-2
VS21 0 s21 0
V21 e21 s21 DC 0 AC 15e1 0
RI21 e21 4 27e-2
VS22 0 s22 0
V22 e22 s22 DC 0 AC 27e-1 -120
RI22 e22 8 39e-3
VS23 9 s23 0
C23 s23 11 56e-5
.control
set numdgt=17
ac lin 1 60 60
print v(1) v(2) v(3) v(4) v(5) v(6) v(7) v(8) v(9) v(10)
print v(11) v(12) v(13) v(14) v(15)
print i(vs0) i(vs1) i(vs2) i(vs3) i(vs4) i(vs5) i(vs6) i(vs7) i(vs8) i(vs9)
print i(vs10) i(vs11) i(vs12) i(vs13) i(vs14) i(vs15) i(vs16) i(vs17) i(vs18) i(vs19)
print i(vs20) i(vs21) i(vs22) i(vs23)
.endc
.end
