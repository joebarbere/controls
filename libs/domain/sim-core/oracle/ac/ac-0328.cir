controls oracle ac-0328
* Generated (plan F2.7, ADR 0012): do not edit; regenerate with `pnpm sim oracle regen`. ac seed 20261031 index 328 nodes 16 elements 23
.options sparse gmin=1e-12 noopac
RG1 1 0 1000000000000
RG2 2 0 1000000000000
RG3 3 0 1000000000000
RG4 4 0 1000000000000
RG5 5 0 1000000000000
RG6 6 0 1000000000000
RG7 7 0 1000000000000
RG8 8 0 1000000000000
RG9 9 0 1000000000000
RG10 10 0 1000000000000
RG11 11 0 1000000000000
RG12 12 0 1000000000000
RG13 13 0 1000000000000
RG14 14 0 1000000000000
RG15 15 0 1000000000000
VS0 7 s0 0
L0 s0 8 82e-4
VS1 1 s1 0
C1 s1 8 12e-7
VS2 7 s2 0
L2 s2 12 15e-5
VS3 0 s3 0
V3 e3 s3 DC 0 AC 22e-1 180
RI3 e3 m3 39e-1
LI3 m3 4 68e-6
VS4 9 s4 0
V4 e4 s4 DC 0 AC 22e-1 120
RI4 e4 m4 15e-3
LI4 m4 10 47e-7
VS5 7 s5 0
L5 s5 15 39e-2
VS6 14 s6 0
R6 s6 2 56e2
VS7 7 s7 0
L7 s7 3 10e-3
VS8 2 s8 0
L8 s8 6 15e-2
VS9 11 s9 0
C9 s9 12 82e-5
VS10 14 s10 0
R10 s10 13 15e1
VS11 10 s11 0
V11 e11 s11 DC 0 AC 27e1 120
RI11 e11 15 47e-1
VS12 5 s12 0
V12 e12 s12 DC 0 AC 10e1 180
RI12 e12 12 39e-2
VS13 6 s13 0
C13 s13 9 56e-5
VS14 3 s14 0
R14 s14 0 39e1
VS15 11 s15 0
C15 s15 10 10e-6
VS16 6 s16 0
C16 s16 5 18e-4
VS17 15 s17 0
C17 s17 6 33e-7
VS18 12 s18 0
V18 e18 s18 DC 0 AC 15e1 0
RI18 e18 1 27e-2
VS19 2 s19 0
R19 s19 4 47e1
VS20 15 s20 0
V20 e20 s20 DC 0 AC 82e0 180
RI20 e20 m20 15e-2
LI20 m20 3 33e-6
VS21 12 s21 0
R21 s21 14 10e0
VS22 13 s22 0
V22 e22 s22 DC 0 AC 22e-1 120
RI22 e22 m22 82e-2
LI22 m22 8 39e-5
.control
set numdgt=17
ac lin 1 60 60
print v(1) v(2) v(3) v(4) v(5) v(6) v(7) v(8) v(9) v(10)
print v(11) v(12) v(13) v(14) v(15)
print i(vs0) i(vs1) i(vs2) i(vs3) i(vs4) i(vs5) i(vs6) i(vs7) i(vs8) i(vs9)
print i(vs10) i(vs11) i(vs12) i(vs13) i(vs14) i(vs15) i(vs16) i(vs17) i(vs18) i(vs19)
print i(vs20) i(vs21) i(vs22)
.endc
.end
