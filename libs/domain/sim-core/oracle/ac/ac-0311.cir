controls oracle ac-0311
* Generated (plan F2.7, ADR 0012): do not edit; regenerate with `pnpm sim oracle regen`. ac seed 20261031 index 311 nodes 9 elements 16
.options sparse gmin=1e-12 noopac
RG1 1 0 1000000000000
RG2 2 0 1000000000000
RG3 3 0 1000000000000
RG4 4 0 1000000000000
RG5 5 0 1000000000000
RG6 6 0 1000000000000
RG7 7 0 1000000000000
RG8 8 0 1000000000000
VS0 3 s0 0
C0 s0 0 18e-4
VS1 0 s1 0
V1 e1 s1 DC 0 AC 39e1 180
RI1 e1 1 47e-2
VS2 7 s2 0
V2 e2 s2 DC 0 AC 18e-1 120
RI2 e2 5 47e-3
VS3 6 s3 0
R3 s3 4 82e-1
VS4 5 s4 0
R4 s4 3 18e1
VS5 5 s5 0
V5 e5 s5 DC 0 AC 33e-1 180
RI5 e5 3 10e-2
VS6 6 s6 0
R6 s6 8 56e0
VS7 0 s7 0
R7 s7 2 56e3
VS8 6 s8 0
R8 s8 7 22e2
VS9 6 s9 0
L9 s9 7 22e-2
VS10 1 s10 0
V10 e10 s10 DC 0 AC 22e0 -120
RI10 e10 7 15e-1
VS11 6 s11 0
R11 s11 0 12e2
VS12 4 s12 0
R12 s12 7 33e0
VS13 0 s13 0
R13 s13 5 12e-1
VS14 8 s14 0
V14 e14 s14 DC 0 AC 18e1 -120
RI14 e14 7 68e-2
VS15 2 s15 0
L15 s15 4 10e-2
.control
set numdgt=17
ac lin 1 60 60
print v(1) v(2) v(3) v(4) v(5) v(6) v(7) v(8)
print i(vs0) i(vs1) i(vs2) i(vs3) i(vs4) i(vs5) i(vs6) i(vs7) i(vs8) i(vs9)
print i(vs10) i(vs11) i(vs12) i(vs13) i(vs14) i(vs15)
.endc
.end
