controls oracle ac-0112
* Generated (plan F2.7, ADR 0012): do not edit; regenerate with `pnpm sim oracle regen`. ac seed 20261031 index 112 nodes 14 elements 27
.options sparse gmin=1e-12 noopac
RG1 1 0 1000000000000
RG2 2 0 1000000000000
RG3 3 0 1000000000000
RG4 4 0 1000000000000
RG5 5 0 1000000000000
RG6 6 0 1000000000000
RG7 7 0 1000000000000
RG8 8 0 1000000000000
RG9 9 0 1000000000000
RG10 10 0 1000000000000
RG11 11 0 1000000000000
RG12 12 0 1000000000000
RG13 13 0 1000000000000
VS0 0 s0 0
V0 e0 s0 DC 0 AC 10e1 0
RI0 e0 m0 18e-1
LI0 m0 n0 22e-6
H0 n0 h0 VS14 -10e-3
ED0 h0 5 d0 0 68e-7
F0 0 d0 VS14 1
LD0 d0 0 1
VS1 11 s1 0
C1 s1 4 68e-6
VS2 1 s2 0
R2 s2 13 27e-2
VS3 11 s3 0
C3 s3 7 47e-5
VS4 12 s4 0
C4 s4 8 10e-7
VS5 9 s5 0
R5 s5 8 27e3
VS6 0 s6 0
L6 s6 2 22e-2
VS7 0 s7 0
C7 s7 1 12e-7
VS8 12 s8 0
R8 s8 2 12e1
VS9 11 s9 0
C9 s9 4 22e-7
VS10 8 s10 0
R10 s10 9 33e1
VS11 6 s11 0
L11 s11 12 56e-5
VS12 13 s12 0
R12 s12 11 10e2
VS13 3 s13 0
L13 s13 5 68e-5
VS14 5 s14 0
V14 e14 s14 DC 0 AC 47e1 180
RI14 e14 n14 56e-2
H14 n14 h14 VS0 -10e-3
ED14 h14 0 d14 0 68e-7
F14 0 d14 VS0 1
LD14 d14 0 1
VS15 8 s15 0
C15 s15 13 33e-5
VS16 6 s16 0
V16 e16 s16 DC 0 AC 82e0 -120
RI16 e16 m16 82e-1
LI16 m16 5 22e-6
VS17 7 s17 0
C17 s17 10 56e-7
VS18 7 s18 0
R18 s18 4 22e2
VS19 5 s19 0
V19 e19 s19 DC 0 AC 47e1 0
RI19 e19 m19 10e-3
LI19 m19 12 10e-7
VS20 2 s20 0
V20 e20 s20 DC 0 AC 39e0 0
RI20 e20 0 18e-3
VS21 10 s21 0
C21 s21 5 39e-6
VS22 9 s22 0
R22 s22 4 27e0
VS23 10 s23 0
L23 s23 0 18e-2
VS24 5 s24 0
R24 s24 11 39e-2
VS25 3 s25 0
C25 s25 8 12e-6
VS26 2 s26 0
R26 s26 8 68e1
.control
set numdgt=17
ac lin 1 60 60
print v(1) v(2) v(3) v(4) v(5) v(6) v(7) v(8) v(9) v(10)
print v(11) v(12) v(13)
print i(vs0) i(vs1) i(vs2) i(vs3) i(vs4) i(vs5) i(vs6) i(vs7) i(vs8) i(vs9)
print i(vs10) i(vs11) i(vs12) i(vs13) i(vs14) i(vs15) i(vs16) i(vs17) i(vs18) i(vs19)
print i(vs20) i(vs21) i(vs22) i(vs23) i(vs24) i(vs25) i(vs26)
.endc
.end
