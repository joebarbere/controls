controls oracle ac-0112
* Generated (plan F2.7, ADR 0012): do not edit; regenerate with `pnpm sim oracle regen`. ac seed 20261031 index 112 nodes 14 elements 25
.options sparse gmin=1e-12 noopac
RG1 1 0 1000000000000
RG2 2 0 1000000000000
RG3 3 0 1000000000000
RG4 4 0 1000000000000
RG5 5 0 1000000000000
RG6 6 0 1000000000000
RG7 7 0 1000000000000
RG8 8 0 1000000000000
RG9 9 0 1000000000000
RG10 10 0 1000000000000
RG11 11 0 1000000000000
RG12 12 0 1000000000000
RG13 13 0 1000000000000
VS0 0 s0 0
V0 e0 s0 DC 0 AC 10e1 0
RI0 e0 5 18e-1
VS1 2 s1 0
R1 s1 8 68e1
VS2 9 s2 0
R2 s2 8 27e3
VS3 13 s3 0
R3 s3 11 10e2
VS4 7 s4 0
C4 s4 10 56e-7
VS5 10 s5 0
C5 s5 5 39e-6
VS6 8 s6 0
R6 s6 9 33e1
VS7 10 s7 0
L7 s7 0 18e-2
VS8 11 s8 0
C8 s8 7 47e-5
VS9 3 s9 0
C9 s9 8 12e-6
VS10 0 s10 0
C10 s10 1 12e-7
VS11 2 s11 0
V11 e11 s11 DC 0 AC 39e0 0
RI11 e11 0 18e-3
VS12 5 s12 0
V12 e12 s12 DC 0 AC 47e1 0
RI12 e12 12 10e-3
VS13 6 s13 0
L13 s13 12 56e-5
VS14 7 s14 0
R14 s14 4 22e2
VS15 8 s15 0
C15 s15 13 33e-5
VS16 3 s16 0
L16 s16 5 68e-5
VS17 11 s17 0
C17 s17 4 68e-6
VS18 11 s18 0
C18 s18 4 22e-7
VS19 6 s19 0
V19 e19 s19 DC 0 AC 82e0 -120
RI19 e19 5 82e-1
VS20 0 s20 0
L20 s20 2 22e-2
VS21 5 s21 0
V21 e21 s21 DC 0 AC 47e1 180
RI21 e21 0 56e-2
VS22 12 s22 0
C22 s22 8 10e-7
VS23 5 s23 0
R23 s23 11 39e-2
VS24 12 s24 0
R24 s24 2 12e1
.control
set numdgt=17
ac lin 1 60 60
print v(1) v(2) v(3) v(4) v(5) v(6) v(7) v(8) v(9) v(10)
print v(11) v(12) v(13)
print i(vs0) i(vs1) i(vs2) i(vs3) i(vs4) i(vs5) i(vs6) i(vs7) i(vs8) i(vs9)
print i(vs10) i(vs11) i(vs12) i(vs13) i(vs14) i(vs15) i(vs16) i(vs17) i(vs18) i(vs19)
print i(vs20) i(vs21) i(vs22) i(vs23) i(vs24)
.endc
.end
