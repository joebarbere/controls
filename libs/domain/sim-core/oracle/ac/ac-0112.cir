controls oracle ac-0112
* Generated (plan F2.7, ADR 0012): do not edit; regenerate with `pnpm sim oracle regen`. ac seed 20261031 index 112 nodes 14 elements 24
.options sparse gmin=1e-12 noopac
RG1 1 0 1000000000000
RG2 2 0 1000000000000
RG3 3 0 1000000000000
RG4 4 0 1000000000000
RG5 5 0 1000000000000
RG6 6 0 1000000000000
RG7 7 0 1000000000000
RG8 8 0 1000000000000
RG9 9 0 1000000000000
RG10 10 0 1000000000000
RG11 11 0 1000000000000
RG12 12 0 1000000000000
RG13 13 0 1000000000000
VS0 4 s0 0
L0 s0 0 15e-4
VS1 2 s1 0
R1 s1 8 56e3
VS2 9 s2 0
L2 s2 13 82e-4
VS3 7 s3 0
L3 s3 13 68e-5
VS4 10 s4 0
L4 s4 8 22e-2
VS5 5 s5 0
C5 s5 11 82e-7
VS6 12 s6 0
R6 s6 11 33e1
VS7 0 s7 0
V7 e7 s7 DC 0 AC 12e1 0
RI7 e7 m7 82e-2
LI7 m7 9 47e-6
VS8 8 s8 0
L8 s8 7 15e-4
VS9 0 s9 0
R9 s9 6 56e1
VS10 1 s10 0
L10 s10 8 10e-2
VS11 2 s11 0
L11 s11 3 56e-3
VS12 5 s12 0
V12 e12 s12 DC 0 AC 47e1 0
RI12 e12 3 10e-3
VS13 6 s13 0
R13 s13 2 47e0
VS14 3 s14 0
V14 e14 s14 DC 0 AC 15e-1 -120
RI14 e14 m14 56e-2
LI14 m14 10 10e-5
VS15 10 s15 0
V15 e15 s15 DC 0 AC 33e0 180
RI15 e15 m15 47e-3
LI15 m15 6 68e-5
VS16 1 s16 0
L16 s16 7 68e-4
VS17 8 s17 0
C17 s17 4 12e-7
VS18 6 s18 0
L18 s18 9 22e-4
VS19 1 s19 0
C19 s19 8 15e-4
VS20 6 s20 0
C20 s20 12 39e-4
VS21 12 s21 0
R21 s21 6 18e-2
VS22 2 s22 0
R22 s22 6 47e1
VS23 11 s23 0
R23 s23 6 33e-1
.control
set numdgt=17
ac lin 1 60 60
print v(1) v(2) v(3) v(4) v(5) v(6) v(7) v(8) v(9) v(10)
print v(11) v(12) v(13)
print i(vs0) i(vs1) i(vs2) i(vs3) i(vs4) i(vs5) i(vs6) i(vs7) i(vs8) i(vs9)
print i(vs10) i(vs11) i(vs12) i(vs13) i(vs14) i(vs15) i(vs16) i(vs17) i(vs18) i(vs19)
print i(vs20) i(vs21) i(vs22) i(vs23)
.endc
.end
