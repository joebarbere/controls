controls oracle ac-0116
* Generated (plan F2.7, ADR 0012): do not edit; regenerate with `pnpm sim oracle regen`. ac seed 20261031 index 116 nodes 8 elements 15
.options sparse gmin=1e-12 noopac
RG1 1 0 1000000000000
RG2 2 0 1000000000000
RG3 3 0 1000000000000
RG4 4 0 1000000000000
RG5 5 0 1000000000000
RG6 6 0 1000000000000
RG7 7 0 1000000000000
VS0 3 s0 0
R0 s0 4 47e-2
VS1 1 s1 0
R1 s1 3 18e1
VS2 2 s2 0
C2 s2 5 33e-7
VS3 2 s3 0
L3 s3 6 10e-4
VS4 7 s4 0
C4 s4 1 10e-5
VS5 0 s5 0
L5 s5 2 68e-3
VS6 6 s6 0
C6 s6 1 15e-4
VS7 1 s7 0
R7 s7 4 10e1
VS8 0 s8 0
V8 e8 s8 DC 0 AC 22e1 180
RI8 e8 5 10e-1
VS9 3 s9 0
V9 e9 s9 DC 0 AC 56e1 120
RI9 e9 m9 68e-1
LI9 m9 2 10e-5
VS10 4 s10 0
L10 s10 0 18e-5
VS11 5 s11 0
R11 s11 1 10e1
VS12 5 s12 0
C12 s12 7 15e-4
VS13 3 s13 0
V13 e13 s13 DC 0 AC 15e1 120
RI13 e13 7 56e-1
VS14 7 s14 0
C14 s14 3 10e-5
.control
set numdgt=17
ac lin 1 60 60
print v(1) v(2) v(3) v(4) v(5) v(6) v(7)
print i(vs0) i(vs1) i(vs2) i(vs3) i(vs4) i(vs5) i(vs6) i(vs7) i(vs8) i(vs9)
print i(vs10) i(vs11) i(vs12) i(vs13) i(vs14)
.endc
.end
