controls oracle ac-0116
* Generated (plan F2.7, ADR 0012): do not edit; regenerate with `pnpm sim oracle regen`. ac seed 20261031 index 116 nodes 8 elements 12
.options sparse gmin=1e-12 noopac
RG1 1 0 1000000000000
RG2 2 0 1000000000000
RG3 3 0 1000000000000
RG4 4 0 1000000000000
RG5 5 0 1000000000000
RG6 6 0 1000000000000
RG7 7 0 1000000000000
VS0 2 s0 0
C0 s0 4 39e-5
VS1 2 s1 0
R1 s1 1 10e1
VS2 0 s2 0
V2 e2 s2 DC 0 AC 10e-1 -120
RI2 e2 m2 15e-2
LI2 m2 n2 18e-6
H2 n2 h2 VS3 10e-3
ED2 h2 6 d2 0 -18e-5
F2 0 d2 VS3 1
LD2 d2 0 1
VS3 2 s3 0
V3 e3 s3 DC 0 AC 56e-1 180
RI3 e3 m3 33e-1
LI3 m3 n3 10e-6
H3 n3 h3 VS2 10e-3
ED3 h3 0 d3 0 -18e-5
F3 0 d3 VS2 1
LD3 d3 0 1
VS4 4 s4 0
L4 s4 5 18e-5
VS5 3 s5 0
L5 s5 2 12e-4
VS6 5 s6 0
R6 s6 6 22e1
VS7 3 s7 0
L7 s7 1 33e-2
VS8 1 s8 0
R8 s8 4 10e1
VS9 7 s9 0
C9 s9 1 10e-5
VS10 3 s10 0
V10 e10 s10 DC 0 AC 15e1 120
RI10 e10 7 56e-1
VS11 6 s11 0
C11 s11 1 15e-4
.control
set numdgt=17
ac lin 1 60 60
print v(1) v(2) v(3) v(4) v(5) v(6) v(7)
print i(vs0) i(vs1) i(vs2) i(vs3) i(vs4) i(vs5) i(vs6) i(vs7) i(vs8) i(vs9)
print i(vs10) i(vs11)
.endc
.end
