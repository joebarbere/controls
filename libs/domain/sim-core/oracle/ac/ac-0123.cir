controls oracle ac-0123
* Generated (plan F2.7, ADR 0012): do not edit; regenerate with `pnpm sim oracle regen`. ac seed 20261031 index 123 nodes 14 elements 25
.options sparse gmin=1e-12 noopac
RG1 1 0 1000000000000
RG2 2 0 1000000000000
RG3 3 0 1000000000000
RG4 4 0 1000000000000
RG5 5 0 1000000000000
RG6 6 0 1000000000000
RG7 7 0 1000000000000
RG8 8 0 1000000000000
RG9 9 0 1000000000000
RG10 10 0 1000000000000
RG11 11 0 1000000000000
RG12 12 0 1000000000000
RG13 13 0 1000000000000
VS0 12 s0 0
R0 s0 1 12e3
VS1 8 s1 0
L1 s1 9 10e-5
VS2 10 s2 0
C2 s2 7 33e-7
VS3 0 s3 0
V3 e3 s3 DC 0 AC 56e-1 0
RI3 e3 n3 82e-2
H3 n3 h3 VS11 -39e-4
ED3 h3 13 d3 0 15e-6
F3 0 d3 VS11 1
LD3 d3 0 1
VS4 11 s4 0
C4 s4 6 82e-5
VS5 1 s5 0
R5 s5 7 47e1
VS6 10 s6 0
R6 s6 11 18e-2
VS7 9 s7 0
C7 s7 11 33e-6
VS8 11 s8 0
R8 s8 4 39e3
VS9 6 s9 0
R9 s9 8 22e1
VS10 1 s10 0
R10 s10 0 22e-2
VS11 11 s11 0
V11 e11 s11 DC 0 AC 12e1 -120
RI11 e11 n11 18e-3
H11 n11 h11 VS3 -39e-4
ED11 h11 10 d11 0 15e-6
F11 0 d11 VS3 1
LD11 d11 0 1
VS12 0 s12 0
R12 s12 3 27e-2
VS13 3 s13 0
L13 s13 2 33e-3
VS14 3 s14 0
C14 s14 2 22e-6
VS15 13 s15 0
R15 s15 6 12e3
VS16 11 s16 0
C16 s16 8 10e-4
VS17 12 s17 0
R17 s17 10 68e2
VS18 4 s18 0
C18 s18 3 15e-6
VS19 7 s19 0
C19 s19 6 10e-7
VS20 5 s20 0
R20 s20 0 22e1
VS21 1 s21 0
R21 s21 3 22e0
VS22 5 s22 0
R22 s22 11 39e-2
VS23 2 s23 0
R23 s23 11 27e0
VS24 1 s24 0
R24 s24 7 12e-2
.control
set numdgt=17
ac lin 1 60 60
print v(1) v(2) v(3) v(4) v(5) v(6) v(7) v(8) v(9) v(10)
print v(11) v(12) v(13)
print i(vs0) i(vs1) i(vs2) i(vs3) i(vs4) i(vs5) i(vs6) i(vs7) i(vs8) i(vs9)
print i(vs10) i(vs11) i(vs12) i(vs13) i(vs14) i(vs15) i(vs16) i(vs17) i(vs18) i(vs19)
print i(vs20) i(vs21) i(vs22) i(vs23) i(vs24)
.endc
.end
