controls oracle ac-0123
* Generated (plan F2.7, ADR 0012): do not edit; regenerate with `pnpm sim oracle regen`. ac seed 20261031 index 123 nodes 14 elements 19
.options sparse gmin=1e-12 noopac
RG1 1 0 1000000000000
RG2 2 0 1000000000000
RG3 3 0 1000000000000
RG4 4 0 1000000000000
RG5 5 0 1000000000000
RG6 6 0 1000000000000
RG7 7 0 1000000000000
RG8 8 0 1000000000000
RG9 9 0 1000000000000
RG10 10 0 1000000000000
RG11 11 0 1000000000000
RG12 12 0 1000000000000
RG13 13 0 1000000000000
VS0 6 s0 0
R0 s0 8 22e1
VS1 1 s1 0
R1 s1 3 22e0
VS2 0 s2 0
V2 e2 s2 DC 0 AC 12e1 -120
RI2 e2 10 18e-3
VS3 7 s3 0
V3 e3 s3 DC 0 AC 82e0 180
RI3 e3 m3 33e-1
LI3 m3 13 82e-7
VS4 2 s4 0
V4 e4 s4 DC 0 AC 33e0 0
RI4 e4 m4 18e-3
LI4 m4 7 22e-5
VS5 5 s5 0
C5 s5 3 10e-6
VS6 12 s6 0
L6 s6 6 82e-5
VS7 0 s7 0
C7 s7 6 82e-5
VS8 6 s8 0
L8 s8 7 56e-5
VS9 11 s9 0
R9 s9 0 27e0
VS10 9 s10 0
C10 s10 0 33e-6
VS11 12 s11 0
R11 s11 1 12e3
VS12 8 s12 0
R12 s12 9 33e0
VS13 13 s13 0
R13 s13 6 12e3
VS14 0 s14 0
R14 s14 4 39e3
VS15 2 s15 0
V15 e15 s15 DC 0 AC 10e1 -120
RI15 e15 5 33e-3
VS16 4 s16 0
R16 s16 8 39e1
VS17 10 s17 0
C17 s17 11 12e-7
VS18 3 s18 0
L18 s18 11 33e-3
.control
set numdgt=17
ac lin 1 60 60
print v(1) v(2) v(3) v(4) v(5) v(6) v(7) v(8) v(9) v(10)
print v(11) v(12) v(13)
print i(vs0) i(vs1) i(vs2) i(vs3) i(vs4) i(vs5) i(vs6) i(vs7) i(vs8) i(vs9)
print i(vs10) i(vs11) i(vs12) i(vs13) i(vs14) i(vs15) i(vs16) i(vs17) i(vs18)
.endc
.end
