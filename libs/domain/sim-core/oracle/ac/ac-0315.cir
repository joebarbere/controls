controls oracle ac-0315
* Generated (plan F2.7, ADR 0012): do not edit; regenerate with `pnpm sim oracle regen`. ac seed 20261031 index 315 nodes 17 elements 26
.options sparse gmin=1e-12 noopac
RG1 1 0 1000000000000
RG2 2 0 1000000000000
RG3 3 0 1000000000000
RG4 4 0 1000000000000
RG5 5 0 1000000000000
RG6 6 0 1000000000000
RG7 7 0 1000000000000
RG8 8 0 1000000000000
RG9 9 0 1000000000000
RG10 10 0 1000000000000
RG11 11 0 1000000000000
RG12 12 0 1000000000000
RG13 13 0 1000000000000
RG14 14 0 1000000000000
RG15 15 0 1000000000000
RG16 16 0 1000000000000
VS0 7 s0 0
R0 s0 10 18e2
VS1 3 s1 0
R1 s1 15 39e-2
VS2 2 s2 0
L2 s2 3 12e-4
VS3 9 s3 0
R3 s3 3 56e3
VS4 15 s4 0
C4 s4 9 82e-6
VS5 0 s5 0
V5 e5 s5 DC 0 AC 10e0 -120
RI5 e5 16 18e-1
VS6 12 s6 0
V6 e6 s6 DC 0 AC 18e-1 180
RI6 e6 7 33e-1
VS7 1 s7 0
L7 s7 12 12e-3
VS8 2 s8 0
V8 e8 s8 DC 0 AC 18e0 0
RI8 e8 10 18e-3
VS9 13 s9 0
C9 s9 2 82e-6
VS10 14 s10 0
R10 s10 12 22e1
VS11 13 s11 0
R11 s11 5 22e3
VS12 5 s12 0
C12 s12 12 33e-5
VS13 16 s13 0
R13 s13 0 56e0
VS14 11 s14 0
C14 s14 1 47e-4
VS15 3 s15 0
V15 e15 s15 DC 0 AC 47e1 180
RI15 e15 6 33e-3
VS16 4 s16 0
R16 s16 15 39e-2
VS17 16 s17 0
V17 e17 s17 DC 0 AC 56e0 180
RI17 e17 15 15e-2
VS18 15 s18 0
R18 s18 1 82e-2
VS19 3 s19 0
C19 s19 8 56e-7
VS20 4 s20 0
C20 s20 1 22e-4
VS21 8 s21 0
L21 s21 1 56e-2
VS22 3 s22 0
L22 s22 1 15e-2
VS23 4 s23 0
R23 s23 12 18e1
VS24 0 s24 0
R24 s24 15 33e-2
VS25 5 s25 0
C25 s25 10 56e-6
.control
set numdgt=17
ac lin 1 60 60
print v(1) v(2) v(3) v(4) v(5) v(6) v(7) v(8) v(9) v(10)
print v(11) v(12) v(13) v(14) v(15) v(16)
print i(vs0) i(vs1) i(vs2) i(vs3) i(vs4) i(vs5) i(vs6) i(vs7) i(vs8) i(vs9)
print i(vs10) i(vs11) i(vs12) i(vs13) i(vs14) i(vs15) i(vs16) i(vs17) i(vs18) i(vs19)
print i(vs20) i(vs21) i(vs22) i(vs23) i(vs24) i(vs25)
.endc
.end
