controls oracle ac-0315
* Generated (plan F2.7, ADR 0012): do not edit; regenerate with `pnpm sim oracle regen`. ac seed 20261031 index 315 nodes 17 elements 32
.options sparse gmin=1e-12 noopac
RG1 1 0 1000000000000
RG2 2 0 1000000000000
RG3 3 0 1000000000000
RG4 4 0 1000000000000
RG5 5 0 1000000000000
RG6 6 0 1000000000000
RG7 7 0 1000000000000
RG8 8 0 1000000000000
RG9 9 0 1000000000000
RG10 10 0 1000000000000
RG11 11 0 1000000000000
RG12 12 0 1000000000000
RG13 13 0 1000000000000
RG14 14 0 1000000000000
RG15 15 0 1000000000000
RG16 16 0 1000000000000
VS0 0 s0 0
R0 s0 15 39e-2
VS1 6 s1 0
L1 s1 16 82e-5
VS2 0 s2 0
V2 e2 s2 DC 0 AC 12e-1 180
RI2 e2 m2 12e-1
LI2 m2 16 22e-7
VS3 4 s3 0
R3 s3 9 68e0
VS4 1 s4 0
R4 s4 11 47e1
VS5 5 s5 0
C5 s5 12 33e-5
VS6 14 s6 0
L6 s6 11 12e-3
VS7 13 s7 0
R7 s7 3 68e-2
VS8 15 s8 0
V8 e8 s8 DC 0 AC 39e1 0
RI8 e8 m8 82e-3
LI8 m8 12 12e-7
VS9 14 s9 0
L9 s9 5 39e-5
VS10 13 s10 0
C10 s10 2 82e-6
VS11 9 s11 0
V11 e11 s11 DC 0 AC 27e0 -120
RI11 e11 0 27e-1
VS12 2 s12 0
L12 s12 0 12e-4
VS13 9 s13 0
L13 s13 0 47e-3
VS14 6 s14 0
R14 s14 0 56e3
VS15 0 s15 0
L15 s15 1 27e-3
VS16 12 s16 0
R16 s16 8 33e2
VS17 4 s17 0
R17 s17 15 39e-2
VS18 7 s18 0
L18 s18 5 56e-2
VS19 13 s19 0
C19 s19 14 56e-4
VS20 13 s20 0
C20 s20 6 18e-5
VS21 8 s21 0
V21 e21 s21 DC 0 AC 27e1 120
RI21 e21 m21 56e-2
LI21 m21 9 15e-6
VS22 10 s22 0
V22 e22 s22 DC 0 AC 56e-1 180
RI22 e22 2 39e-1
VS23 2 s23 0
V23 e23 s23 DC 0 AC 18e0 0
RI23 e23 m23 18e-3
LI23 m23 10 15e-7
VS24 14 s24 0
C24 s24 5 47e-4
VS25 13 s25 0
L25 s25 14 39e-4
VS26 12 s26 0
V26 e26 s26 DC 0 AC 18e-1 180
RI26 e26 7 33e-1
VS27 5 s27 0
L27 s27 1 39e-2
VS28 5 s28 0
C28 s28 10 56e-6
VS29 3 s29 0
V29 e29 s29 DC 0 AC 27e-1 -120
RI29 e29 5 39e-1
VS30 6 s30 0
C30 s30 13 47e-7
VS31 5 s31 0
V31 e31 s31 DC 0 AC 22e-1 -120
RI31 e31 m31 39e-3
LI31 m31 4 10e-7
.control
set numdgt=17
ac lin 1 60 60
print v(1) v(2) v(3) v(4) v(5) v(6) v(7) v(8) v(9) v(10)
print v(11) v(12) v(13) v(14) v(15) v(16)
print i(vs0) i(vs1) i(vs2) i(vs3) i(vs4) i(vs5) i(vs6) i(vs7) i(vs8) i(vs9)
print i(vs10) i(vs11) i(vs12) i(vs13) i(vs14) i(vs15) i(vs16) i(vs17) i(vs18) i(vs19)
print i(vs20) i(vs21) i(vs22) i(vs23) i(vs24) i(vs25) i(vs26) i(vs27) i(vs28) i(vs29)
print i(vs30) i(vs31)
.endc
.end
