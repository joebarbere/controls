controls oracle ac-0315
* Generated (plan F2.7, ADR 0012): do not edit; regenerate with `pnpm sim oracle regen`. ac seed 20261031 index 315 nodes 17 elements 30
.options sparse gmin=1e-12 noopac
RG1 1 0 1000000000000
RG2 2 0 1000000000000
RG3 3 0 1000000000000
RG4 4 0 1000000000000
RG5 5 0 1000000000000
RG6 6 0 1000000000000
RG7 7 0 1000000000000
RG8 8 0 1000000000000
RG9 9 0 1000000000000
RG10 10 0 1000000000000
RG11 11 0 1000000000000
RG12 12 0 1000000000000
RG13 13 0 1000000000000
RG14 14 0 1000000000000
RG15 15 0 1000000000000
RG16 16 0 1000000000000
VS0 0 s0 0
V0 e0 s0 DC 0 AC 18e-1 180
RI0 e0 n0 33e-1
H0 n0 h0 VS5 -39e-2
ED0 h0 7 d0 0 22e-5
F0 0 d0 VS5 1
LD0 d0 0 1
VS1 12 s1 0
C1 s1 8 56e-7
VS2 15 s2 0
C2 s2 9 82e-6
VS3 7 s3 0
R3 s3 10 18e2
VS4 4 s4 0
R4 s4 15 39e-2
VS5 7 s5 0
V5 e5 s5 DC 0 AC 12e1 120
RI5 e5 n5 12e-1
H5 n5 h5 VS0 -39e-2
ED5 h5 16 d5 0 22e-5
F5 0 d5 VS0 1
LD5 d5 0 1
VS6 16 s6 0
R6 s6 3 56e0
VS7 12 s7 0
V7 e7 s7 DC 0 AC 47e1 180
RI7 e7 6 33e-3
VS8 14 s8 0
L8 s8 11 82e-3
VS9 2 s9 0
L9 s9 12 12e-4
VS10 8 s10 0
L10 s10 1 56e-2
VS11 16 s11 0
V11 e11 s11 DC 0 AC 56e0 180
RI11 e11 m11 15e-2
LI11 m11 15 12e-5
VS12 1 s12 0
L12 s12 0 12e-3
VS13 12 s13 0
L13 s13 1 15e-2
VS14 13 s14 0
R14 s14 5 22e3
VS15 5 s15 0
C15 s15 10 56e-6
VS16 3 s16 0
V16 e16 s16 DC 0 AC 10e0 -120
RI16 e16 m16 18e-1
LI16 m16 16 12e-5
VS17 14 s17 0
R17 s17 0 22e1
VS18 11 s18 0
C18 s18 1 47e-4
VS19 4 s19 0
R19 s19 0 18e1
VS20 13 s20 0
C20 s20 2 82e-6
VS21 9 s21 0
R21 s21 12 56e3
VS22 15 s22 0
R22 s22 1 82e-2
VS23 5 s23 0
C23 s23 0 33e-5
VS24 12 s24 0
R24 s24 15 39e-2
VS25 2 s25 0
V25 e25 s25 DC 0 AC 18e0 0
RI25 e25 m25 18e-3
LI25 m25 10 82e-7
VS26 4 s26 0
C26 s26 1 22e-4
VS27 3 s27 0
R27 s27 15 33e-2
VS28 7 s28 0
V28 e28 s28 DC 0 AC 39e0 120
RI28 e28 11 22e-2
VS29 6 s29 0
R29 s29 16 56e2
.control
set numdgt=17
ac lin 1 60 60
print v(1) v(2) v(3) v(4) v(5) v(6) v(7) v(8) v(9) v(10)
print v(11) v(12) v(13) v(14) v(15) v(16)
print i(vs0) i(vs1) i(vs2) i(vs3) i(vs4) i(vs5) i(vs6) i(vs7) i(vs8) i(vs9)
print i(vs10) i(vs11) i(vs12) i(vs13) i(vs14) i(vs15) i(vs16) i(vs17) i(vs18) i(vs19)
print i(vs20) i(vs21) i(vs22) i(vs23) i(vs24) i(vs25) i(vs26) i(vs27) i(vs28) i(vs29)
.endc
.end
