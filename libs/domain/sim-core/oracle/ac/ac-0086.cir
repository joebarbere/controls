controls oracle ac-0086
* Generated (plan F2.7, ADR 0012): do not edit; regenerate with `pnpm sim oracle regen`. ac seed 20261031 index 86 nodes 8 elements 14
.options sparse gmin=1e-12 noopac
RG1 1 0 1000000000000
RG2 2 0 1000000000000
RG3 3 0 1000000000000
RG4 4 0 1000000000000
RG5 5 0 1000000000000
RG6 6 0 1000000000000
RG7 7 0 1000000000000
VS0 3 s0 0
L0 s0 6 12e-2
VS1 1 s1 0
C1 s1 2 68e-6
VS2 1 s2 0
C2 s2 3 10e-4
VS3 4 s3 0
L3 s3 5 18e-2
VS4 3 s4 0
C4 s4 2 33e-6
VS5 5 s5 0
R5 s5 3 10e2
VS6 5 s6 0
L6 s6 0 22e-4
VS7 7 s7 0
R7 s7 2 82e-2
VS8 0 s8 0
V8 e8 s8 DC 0 AC 56e1 0
RI8 e8 m8 33e-1
LI8 m8 2 10e-5
VS9 5 s9 0
L9 s9 7 10e-2
VS10 2 s10 0
R10 s10 6 33e-1
VS11 3 s11 0
L11 s11 1 82e-4
VS12 6 s12 0
V12 e12 s12 DC 0 AC 22e0 -120
RI12 e12 2 39e-3
VS13 4 s13 0
R13 s13 1 27e1
.control
set numdgt=17
ac lin 1 60 60
print v(1) v(2) v(3) v(4) v(5) v(6) v(7)
print i(vs0) i(vs1) i(vs2) i(vs3) i(vs4) i(vs5) i(vs6) i(vs7) i(vs8) i(vs9)
print i(vs10) i(vs11) i(vs12) i(vs13)
.endc
.end
