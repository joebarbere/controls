controls oracle ac-0396
* Generated (plan F2.7, ADR 0012): do not edit; regenerate with `pnpm sim oracle regen`. ac seed 20261031 index 396 nodes 22 elements 41
.options sparse gmin=1e-12 noopac
RG1 1 0 1000000000000
RG2 2 0 1000000000000
RG3 3 0 1000000000000
RG4 4 0 1000000000000
RG5 5 0 1000000000000
RG6 6 0 1000000000000
RG7 7 0 1000000000000
RG8 8 0 1000000000000
RG9 9 0 1000000000000
RG10 10 0 1000000000000
RG11 11 0 1000000000000
RG12 12 0 1000000000000
RG13 13 0 1000000000000
RG14 14 0 1000000000000
RG15 15 0 1000000000000
RG16 16 0 1000000000000
RG17 17 0 1000000000000
RG18 18 0 1000000000000
RG19 19 0 1000000000000
RG20 20 0 1000000000000
RG21 21 0 1000000000000
VS0 17 s0 0
L0 s0 15 82e-2
VS1 15 s1 0
R1 s1 18 47e0
VS2 6 s2 0
R2 s2 20 56e-2
VS3 0 s3 0
V3 e3 s3 DC 0 AC 12e-1 -120
RI3 e3 m3 68e-2
LI3 m3 16 47e-5
VS4 12 s4 0
R4 s4 8 27e-2
VS5 20 s5 0
C5 s5 13 68e-4
VS6 5 s6 0
L6 s6 19 18e-4
VS7 14 s7 0
C7 s7 16 12e-7
VS8 8 s8 0
R8 s8 1 82e-1
VS9 21 s9 0
R9 s9 1 18e-1
VS10 11 s10 0
R10 s10 6 82e0
VS11 14 s11 0
R11 s11 9 82e1
VS12 1 s12 0
L12 s12 10 33e-4
VS13 8 s13 0
R13 s13 20 18e-2
VS14 9 s14 0
V14 e14 s14 DC 0 AC 47e0 180
RI14 e14 m14 10e-1
LI14 m14 8 18e-5
VS15 20 s15 0
V15 e15 s15 DC 0 AC 10e1 0
RI15 e15 m15 22e-3
LI15 m15 12 15e-7
VS16 8 s16 0
R16 s16 0 12e-1
VS17 11 s17 0
L17 s17 17 56e-2
VS18 13 s18 0
R18 s18 18 27e-2
VS19 12 s19 0
R19 s19 8 68e-1
VS20 0 s20 0
L20 s20 16 68e-2
VS21 14 s21 0
V21 e21 s21 DC 0 AC 18e0 120
RI21 e21 m21 12e-1
LI21 m21 8 68e-6
VS22 7 s22 0
L22 s22 4 18e-5
VS23 2 s23 0
L23 s23 16 27e-4
VS24 20 s24 0
V24 e24 s24 DC 0 AC 33e-1 120
RI24 e24 2 56e-1
VS25 13 s25 0
L25 s25 12 56e-5
VS26 7 s26 0
C26 s26 5 15e-6
VS27 13 s27 0
V27 e27 s27 DC 0 AC 33e0 180
RI27 e27 m27 27e-2
LI27 m27 6 82e-7
VS28 13 s28 0
R28 s28 3 33e-1
VS29 10 s29 0
R29 s29 19 15e1
VS30 15 s30 0
R30 s30 7 39e0
VS31 6 s31 0
C31 s31 17 47e-4
VS32 5 s32 0
R32 s32 4 12e3
VS33 18 s33 0
R33 s33 6 27e-2
VS34 18 s34 0
C34 s34 14 27e-4
VS35 16 s35 0
C35 s35 12 39e-4
VS36 13 s36 0
C36 s36 6 56e-5
VS37 6 s37 0
L37 s37 17 22e-2
VS38 15 s38 0
R38 s38 0 22e3
VS39 21 s39 0
R39 s39 12 33e-2
VS40 15 s40 0
C40 s40 3 18e-6
.control
set numdgt=17
ac lin 1 60 60
print v(1) v(2) v(3) v(4) v(5) v(6) v(7) v(8) v(9) v(10)
print v(11) v(12) v(13) v(14) v(15) v(16) v(17) v(18) v(19) v(20)
print v(21)
print i(vs0) i(vs1) i(vs2) i(vs3) i(vs4) i(vs5) i(vs6) i(vs7) i(vs8) i(vs9)
print i(vs10) i(vs11) i(vs12) i(vs13) i(vs14) i(vs15) i(vs16) i(vs17) i(vs18) i(vs19)
print i(vs20) i(vs21) i(vs22) i(vs23) i(vs24) i(vs25) i(vs26) i(vs27) i(vs28) i(vs29)
print i(vs30) i(vs31) i(vs32) i(vs33) i(vs34) i(vs35) i(vs36) i(vs37) i(vs38) i(vs39)
print i(vs40)
.endc
.end
