controls oracle ac-0396
* Generated (plan F2.7, ADR 0012): do not edit; regenerate with `pnpm sim oracle regen`. ac seed 20261031 index 396 nodes 22 elements 33
.options sparse gmin=1e-12 noopac
RG1 1 0 1000000000000
RG2 2 0 1000000000000
RG3 3 0 1000000000000
RG4 4 0 1000000000000
RG5 5 0 1000000000000
RG6 6 0 1000000000000
RG7 7 0 1000000000000
RG8 8 0 1000000000000
RG9 9 0 1000000000000
RG10 10 0 1000000000000
RG11 11 0 1000000000000
RG12 12 0 1000000000000
RG13 13 0 1000000000000
RG14 14 0 1000000000000
RG15 15 0 1000000000000
RG16 16 0 1000000000000
RG17 17 0 1000000000000
RG18 18 0 1000000000000
RG19 19 0 1000000000000
RG20 20 0 1000000000000
RG21 21 0 1000000000000
VS0 20 s0 0
R0 s0 12 15e0
VS1 18 s1 0
C1 s1 14 27e-4
VS2 2 s2 0
L2 s2 16 27e-4
VS3 2 s3 0
L3 s3 14 33e-4
VS4 21 s4 0
L4 s4 17 82e-5
VS5 15 s5 0
L5 s5 6 27e-5
VS6 15 s6 0
R6 s6 7 39e0
VS7 20 s7 0
L7 s7 4 33e-5
VS8 8 s8 0
R8 s8 6 12e-1
VS9 0 s9 0
V9 e9 s9 DC 0 AC 33e0 180
RI9 e9 13 27e-2
VS10 8 s10 0
R10 s10 1 82e-1
VS11 8 s11 0
V11 e11 s11 DC 0 AC 22e-1 120
RI11 e11 m11 18e-1
LI11 m11 19 82e-5
VS12 3 s12 0
R12 s12 5 12e0
VS13 15 s13 0
R13 s13 6 22e3
VS14 11 s14 0
C14 s14 12 47e-7
VS15 6 s15 0
L15 s15 16 68e-2
VS16 21 s16 0
R16 s16 1 82e2
VS17 18 s17 0
C17 s17 0 10e-5
VS18 7 s18 0
C18 s18 5 15e-6
VS19 10 s19 0
R19 s19 20 18e-2
VS20 18 s20 0
R20 s20 13 27e-2
VS21 13 s21 0
L21 s21 17 22e-2
VS22 15 s22 0
C22 s22 3 18e-6
VS23 11 s23 0
R23 s23 13 82e0
VS24 5 s24 0
R24 s24 4 12e3
VS25 12 s25 0
R25 s25 8 68e-1
VS26 19 s26 0
L26 s26 9 12e-2
VS27 5 s27 0
L27 s27 19 18e-4
VS28 13 s28 0
R28 s28 20 56e-2
VS29 21 s29 0
C29 s29 10 56e-6
VS30 15 s30 0
R30 s30 18 47e0
VS31 14 s31 0
R31 s31 9 82e1
VS32 21 s32 0
R32 s32 12 33e-2
.control
set numdgt=17
ac lin 1 60 60
print v(1) v(2) v(3) v(4) v(5) v(6) v(7) v(8) v(9) v(10)
print v(11) v(12) v(13) v(14) v(15) v(16) v(17) v(18) v(19) v(20)
print v(21)
print i(vs0) i(vs1) i(vs2) i(vs3) i(vs4) i(vs5) i(vs6) i(vs7) i(vs8) i(vs9)
print i(vs10) i(vs11) i(vs12) i(vs13) i(vs14) i(vs15) i(vs16) i(vs17) i(vs18) i(vs19)
print i(vs20) i(vs21) i(vs22) i(vs23) i(vs24) i(vs25) i(vs26) i(vs27) i(vs28) i(vs29)
print i(vs30) i(vs31) i(vs32)
.endc
.end
