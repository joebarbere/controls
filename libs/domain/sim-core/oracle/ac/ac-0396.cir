controls oracle ac-0396
* Generated (plan F2.7, ADR 0012): do not edit; regenerate with `pnpm sim oracle regen`. ac seed 20261031 index 396 nodes 22 elements 38
.options sparse gmin=1e-12 noopac
RG1 1 0 1000000000000
RG2 2 0 1000000000000
RG3 3 0 1000000000000
RG4 4 0 1000000000000
RG5 5 0 1000000000000
RG6 6 0 1000000000000
RG7 7 0 1000000000000
RG8 8 0 1000000000000
RG9 9 0 1000000000000
RG10 10 0 1000000000000
RG11 11 0 1000000000000
RG12 12 0 1000000000000
RG13 13 0 1000000000000
RG14 14 0 1000000000000
RG15 15 0 1000000000000
RG16 16 0 1000000000000
RG17 17 0 1000000000000
RG18 18 0 1000000000000
RG19 19 0 1000000000000
RG20 20 0 1000000000000
RG21 21 0 1000000000000
VS0 2 s0 0
L0 s0 16 27e-4
VS1 13 s1 0
R1 s1 3 33e-1
VS2 0 s2 0
V2 e2 s2 DC 0 AC 10e1 0
RI2 e2 12 22e-3
VS3 0 s3 0
C3 s3 13 68e-4
VS4 5 s4 0
R4 s4 4 12e3
VS5 12 s5 0
R5 s5 8 27e-2
VS6 14 s6 0
R6 s6 9 82e1
VS7 8 s7 0
R7 s7 1 82e-1
VS8 11 s8 0
R8 s8 20 82e0
VS9 6 s9 0
L9 s9 16 68e-2
VS10 20 s10 0
R10 s10 0 56e-2
VS11 17 s11 0
L11 s11 15 82e-2
VS12 13 s12 0
L12 s12 12 56e-5
VS13 15 s13 0
R13 s13 7 39e0
VS14 12 s14 0
R14 s14 8 68e-1
VS15 20 s15 0
L15 s15 17 22e-2
VS16 14 s16 0
C16 s16 16 12e-7
VS17 14 s17 0
V17 e17 s17 DC 0 AC 18e0 120
RI17 e17 8 12e-1
VS18 13 s18 0
R18 s18 18 27e-2
VS19 16 s19 0
C19 s19 12 39e-4
VS20 15 s20 0
C20 s20 3 18e-6
VS21 5 s21 0
L21 s21 19 18e-4
VS22 18 s22 0
C22 s22 14 27e-4
VS23 13 s23 0
C23 s23 20 56e-5
VS24 13 s24 0
V24 e24 s24 DC 0 AC 33e0 180
RI24 e24 20 27e-2
VS25 21 s25 0
R25 s25 1 18e-1
VS26 7 s26 0
C26 s26 5 15e-6
VS27 15 s27 0
R27 s27 6 22e3
VS28 6 s28 0
V28 e28 s28 DC 0 AC 12e-1 -120
RI28 e28 16 68e-2
VS29 0 s29 0
V29 e29 s29 DC 0 AC 33e-1 120
RI29 e29 2 56e-1
VS30 21 s30 0
R30 s30 12 33e-2
VS31 8 s31 0
R31 s31 0 18e-2
VS32 18 s32 0
R32 s32 20 27e-2
VS33 20 s33 0
C33 s33 17 47e-4
VS34 8 s34 0
R34 s34 6 12e-1
VS35 1 s35 0
L35 s35 10 33e-4
VS36 10 s36 0
R36 s36 19 15e1
VS37 15 s37 0
R37 s37 18 47e0
.control
set numdgt=17
ac lin 1 60 60
print v(1) v(2) v(3) v(4) v(5) v(6) v(7) v(8) v(9) v(10)
print v(11) v(12) v(13) v(14) v(15) v(16) v(17) v(18) v(19) v(20)
print v(21)
print i(vs0) i(vs1) i(vs2) i(vs3) i(vs4) i(vs5) i(vs6) i(vs7) i(vs8) i(vs9)
print i(vs10) i(vs11) i(vs12) i(vs13) i(vs14) i(vs15) i(vs16) i(vs17) i(vs18) i(vs19)
print i(vs20) i(vs21) i(vs22) i(vs23) i(vs24) i(vs25) i(vs26) i(vs27) i(vs28) i(vs29)
print i(vs30) i(vs31) i(vs32) i(vs33) i(vs34) i(vs35) i(vs36) i(vs37)
.endc
.end
