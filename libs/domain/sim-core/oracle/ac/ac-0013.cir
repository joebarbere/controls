controls oracle ac-0013
* Generated (plan F2.7, ADR 0012): do not edit; regenerate with `pnpm sim oracle regen`. ac seed 20261031 index 13 nodes 19 elements 34
.options sparse gmin=1e-12 noopac
RG1 1 0 1000000000000
RG2 2 0 1000000000000
RG3 3 0 1000000000000
RG4 4 0 1000000000000
RG5 5 0 1000000000000
RG6 6 0 1000000000000
RG7 7 0 1000000000000
RG8 8 0 1000000000000
RG9 9 0 1000000000000
RG10 10 0 1000000000000
RG11 11 0 1000000000000
RG12 12 0 1000000000000
RG13 13 0 1000000000000
RG14 14 0 1000000000000
RG15 15 0 1000000000000
RG16 16 0 1000000000000
RG17 17 0 1000000000000
RG18 18 0 1000000000000
VS0 12 s0 0
R0 s0 5 33e3
VS1 15 s1 0
L1 s1 8 56e-2
VS2 13 s2 0
R2 s2 12 47e3
VS3 6 s3 0
R3 s3 12 33e2
VS4 12 s4 0
L4 s4 8 15e-2
VS5 16 s5 0
L5 s5 12 56e-4
VS6 10 s6 0
C6 s6 5 47e-4
VS7 11 s7 0
R7 s7 7 56e-2
VS8 12 s8 0
R8 s8 0 10e2
VS9 3 s9 0
L9 s9 6 27e-4
VS10 17 s10 0
C10 s10 1 82e-6
VS11 18 s11 0
C11 s11 7 56e-6
VS12 12 s12 0
R12 s12 7 18e1
VS13 0 s13 0
V13 e13 s13 DC 0 AC 18e1 0
RI13 e13 m13 27e-3
LI13 m13 2 33e-5
VS14 12 s14 0
R14 s14 15 56e1
VS15 10 s15 0
R15 s15 8 68e-2
VS16 13 s16 0
R16 s16 10 27e-1
VS17 11 s17 0
R17 s17 6 82e-1
VS18 17 s18 0
V18 e18 s18 DC 0 AC 56e0 -120
RI18 e18 14 27e-2
VS19 11 s19 0
R19 s19 9 18e-2
VS20 3 s20 0
R20 s20 16 12e0
VS21 4 s21 0
L21 s21 11 56e-3
VS22 1 s22 0
R22 s22 11 22e-1
VS23 18 s23 0
L23 s23 11 18e-3
VS24 0 s24 0
L24 s24 9 27e-5
VS25 14 s25 0
R25 s25 16 15e-2
VS26 15 s26 0
R26 s26 4 18e2
VS27 7 s27 0
R27 s27 2 68e2
VS28 3 s28 0
C28 s28 7 22e-6
VS29 7 s29 0
R29 s29 18 22e0
VS30 16 s30 0
V30 e30 s30 DC 0 AC 27e0 180
RI30 e30 m30 27e-3
LI30 m30 2 18e-5
VS31 4 s31 0
C31 s31 10 68e-4
VS32 12 s32 0
V32 e32 s32 DC 0 AC 39e0 0
RI32 e32 m32 47e-2
LI32 m32 2 10e-7
VS33 4 s33 0
R33 s33 1 12e1
.control
set numdgt=17
ac lin 1 60 60
print v(1) v(2) v(3) v(4) v(5) v(6) v(7) v(8) v(9) v(10)
print v(11) v(12) v(13) v(14) v(15) v(16) v(17) v(18)
print i(vs0) i(vs1) i(vs2) i(vs3) i(vs4) i(vs5) i(vs6) i(vs7) i(vs8) i(vs9)
print i(vs10) i(vs11) i(vs12) i(vs13) i(vs14) i(vs15) i(vs16) i(vs17) i(vs18) i(vs19)
print i(vs20) i(vs21) i(vs22) i(vs23) i(vs24) i(vs25) i(vs26) i(vs27) i(vs28) i(vs29)
print i(vs30) i(vs31) i(vs32) i(vs33)
.endc
.end
