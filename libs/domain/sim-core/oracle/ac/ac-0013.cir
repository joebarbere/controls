controls oracle ac-0013
* Generated (plan F2.7, ADR 0012): do not edit; regenerate with `pnpm sim oracle regen`. ac seed 20261031 index 13 nodes 19 elements 37
.options sparse gmin=1e-12 noopac
RG1 1 0 1000000000000
RG2 2 0 1000000000000
RG3 3 0 1000000000000
RG4 4 0 1000000000000
RG5 5 0 1000000000000
RG6 6 0 1000000000000
RG7 7 0 1000000000000
RG8 8 0 1000000000000
RG9 9 0 1000000000000
RG10 10 0 1000000000000
RG11 11 0 1000000000000
RG12 12 0 1000000000000
RG13 13 0 1000000000000
RG14 14 0 1000000000000
RG15 15 0 1000000000000
RG16 16 0 1000000000000
RG17 17 0 1000000000000
RG18 18 0 1000000000000
VS0 18 s0 0
R0 s0 0 33e-1
VS1 12 s1 0
R1 s1 15 56e1
VS2 12 s2 0
R2 s2 5 33e3
VS3 3 s3 0
R3 s3 16 12e0
VS4 3 s4 0
L4 s4 2 27e-4
VS5 0 s5 0
V5 e5 s5 DC 0 AC 15e-1 0
RI5 e5 4 18e-2
VS6 4 s6 0
C6 s6 1 22e-6
VS7 11 s7 0
R7 s7 2 82e-1
VS8 15 s8 0
R8 s8 1 10e3
VS9 13 s9 0
R9 s9 12 47e3
VS10 6 s10 0
V10 e10 s10 DC 0 AC 18e1 0
RI10 e10 0 27e-3
VS11 18 s11 0
L11 s11 11 18e-3
VS12 7 s12 0
C12 s12 5 18e-5
VS13 15 s13 0
L13 s13 16 33e-4
VS14 17 s14 0
V14 e14 s14 DC 0 AC 56e0 -120
RI14 e14 14 27e-2
VS15 1 s15 0
R15 s15 11 22e-1
VS16 4 s16 0
R16 s16 3 56e1
VS17 16 s17 0
R17 s17 2 27e2
VS18 15 s18 0
V18 e18 s18 DC 0 AC 33e-1 120
RI18 e18 12 47e-1
VS19 5 s19 0
V19 e19 s19 DC 0 AC 68e-1 0
RI19 e19 8 47e-3
VS20 17 s20 0
L20 s20 10 82e-3
VS21 4 s21 0
C21 s21 10 68e-4
VS22 15 s22 0
R22 s22 3 27e2
VS23 10 s23 0
L23 s23 12 39e-2
VS24 15 s24 0
R24 s24 10 18e1
VS25 14 s25 0
R25 s25 10 12e-2
VS26 0 s26 0
L26 s26 9 22e-4
VS27 12 s27 0
L27 s27 8 15e-2
VS28 12 s28 0
R28 s28 0 68e2
VS29 0 s29 0
L29 s29 9 39e-4
VS30 2 s30 0
R30 s30 12 33e2
VS31 12 s31 0
V31 e31 s31 DC 0 AC 39e0 0
RI31 e31 0 47e-2
VS32 11 s32 0
R32 s32 7 56e-2
VS33 14 s33 0
R33 s33 1 33e1
VS34 11 s34 0
R34 s34 9 18e-2
VS35 5 s35 0
R35 s35 3 18e2
VS36 11 s36 0
R36 s36 14 18e-1
.control
set numdgt=17
ac lin 1 60 60
print v(1) v(2) v(3) v(4) v(5) v(6) v(7) v(8) v(9) v(10)
print v(11) v(12) v(13) v(14) v(15) v(16) v(17) v(18)
print i(vs0) i(vs1) i(vs2) i(vs3) i(vs4) i(vs5) i(vs6) i(vs7) i(vs8) i(vs9)
print i(vs10) i(vs11) i(vs12) i(vs13) i(vs14) i(vs15) i(vs16) i(vs17) i(vs18) i(vs19)
print i(vs20) i(vs21) i(vs22) i(vs23) i(vs24) i(vs25) i(vs26) i(vs27) i(vs28) i(vs29)
print i(vs30) i(vs31) i(vs32) i(vs33) i(vs34) i(vs35) i(vs36)
.endc
.end
