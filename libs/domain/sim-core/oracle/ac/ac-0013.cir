controls oracle ac-0013
* Generated (plan F2.7, ADR 0012): do not edit; regenerate with `pnpm sim oracle regen`. ac seed 20261031 index 13 nodes 19 elements 39
.options sparse gmin=1e-12 noopac
RG1 1 0 1000000000000
RG2 2 0 1000000000000
RG3 3 0 1000000000000
RG4 4 0 1000000000000
RG5 5 0 1000000000000
RG6 6 0 1000000000000
RG7 7 0 1000000000000
RG8 8 0 1000000000000
RG9 9 0 1000000000000
RG10 10 0 1000000000000
RG11 11 0 1000000000000
RG12 12 0 1000000000000
RG13 13 0 1000000000000
RG14 14 0 1000000000000
RG15 15 0 1000000000000
RG16 16 0 1000000000000
RG17 17 0 1000000000000
RG18 18 0 1000000000000
VS0 3 s0 0
R0 s0 13 15e3
VS1 0 s1 0
V1 e1 s1 DC 0 AC 56e0 -120
RI1 e1 14 27e-2
VS2 12 s2 0
R2 s2 15 56e1
VS3 14 s3 0
R3 s3 1 33e1
VS4 11 s4 0
R4 s4 9 18e-2
VS5 4 s5 0
C5 s5 1 22e-6
VS6 18 s6 0
R6 s6 2 33e-1
VS7 4 s7 0
R7 s7 3 56e1
VS8 15 s8 0
R8 s8 1 10e3
VS9 15 s9 0
V9 e9 s9 DC 0 AC 33e-1 120
RI9 e9 12 47e-1
VS10 14 s10 0
R10 s10 10 12e-2
VS11 12 s11 0
R11 s11 5 33e3
VS12 6 s12 0
C12 s12 14 12e-6
VS13 12 s13 0
V13 e13 s13 DC 0 AC 39e0 0
RI13 e13 2 47e-2
VS14 10 s14 0
L14 s14 12 39e-2
VS15 12 s15 0
L15 s15 8 15e-2
VS16 12 s16 0
R16 s16 2 68e2
VS17 2 s17 0
V17 e17 s17 DC 0 AC 15e-1 0
RI17 e17 4 18e-2
VS18 5 s18 0
R18 s18 3 18e2
VS19 16 s19 0
R19 s19 17 27e2
VS20 5 s20 0
V20 e20 s20 DC 0 AC 68e-1 0
RI20 e20 8 47e-3
VS21 0 s21 0
L21 s21 10 82e-3
VS22 15 s22 0
R22 s22 3 27e2
VS23 6 s23 0
V23 e23 s23 DC 0 AC 18e1 0
RI23 e23 2 27e-3
VS24 17 s24 0
R24 s24 12 33e2
VS25 18 s25 0
L25 s25 11 18e-3
VS26 15 s26 0
R26 s26 10 18e1
VS27 15 s27 0
L27 s27 16 33e-4
VS28 7 s28 0
C28 s28 5 18e-5
VS29 3 s29 0
R29 s29 16 12e0
VS30 2 s30 0
L30 s30 9 22e-4
VS31 2 s31 0
L31 s31 9 39e-4
VS32 11 s32 0
R32 s32 17 82e-1
VS33 4 s33 0
C33 s33 10 68e-4
VS34 11 s34 0
R34 s34 7 56e-2
VS35 1 s35 0
R35 s35 11 22e-1
VS36 11 s36 0
R36 s36 14 18e-1
VS37 3 s37 0
L37 s37 17 27e-4
VS38 13 s38 0
R38 s38 12 47e3
.control
set numdgt=17
ac lin 1 60 60
print v(1) v(2) v(3) v(4) v(5) v(6) v(7) v(8) v(9) v(10)
print v(11) v(12) v(13) v(14) v(15) v(16) v(17) v(18)
print i(vs0) i(vs1) i(vs2) i(vs3) i(vs4) i(vs5) i(vs6) i(vs7) i(vs8) i(vs9)
print i(vs10) i(vs11) i(vs12) i(vs13) i(vs14) i(vs15) i(vs16) i(vs17) i(vs18) i(vs19)
print i(vs20) i(vs21) i(vs22) i(vs23) i(vs24) i(vs25) i(vs26) i(vs27) i(vs28) i(vs29)
print i(vs30) i(vs31) i(vs32) i(vs33) i(vs34) i(vs35) i(vs36) i(vs37) i(vs38)
.endc
.end
