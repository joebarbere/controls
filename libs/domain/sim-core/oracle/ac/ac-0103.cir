controls oracle ac-0103
* Generated (plan F2.7, ADR 0012): do not edit; regenerate with `pnpm sim oracle regen`. ac seed 20261031 index 103 nodes 8 elements 15
.options sparse gmin=1e-12 noopac
RG1 1 0 1000000000000
RG2 2 0 1000000000000
RG3 3 0 1000000000000
RG4 4 0 1000000000000
RG5 5 0 1000000000000
RG6 6 0 1000000000000
RG7 7 0 1000000000000
VS0 5 s0 0
R0 s0 1 15e-2
VS1 1 s1 0
L1 s1 4 27e-5
VS2 0 s2 0
V2 e2 s2 DC 0 AC 82e1 0
RI2 e2 3 27e-3
VS3 4 s3 0
V3 e3 s3 DC 0 AC 33e0 180
RI3 e3 6 22e-1
VS4 7 s4 0
L4 s4 5 82e-5
VS5 7 s5 0
R5 s5 4 15e-1
VS6 3 s6 0
L6 s6 0 15e-3
VS7 4 s7 0
C7 s7 0 56e-6
VS8 4 s8 0
C8 s8 2 10e-6
VS9 1 s9 0
L9 s9 6 18e-2
VS10 5 s10 0
L10 s10 1 56e-3
VS11 1 s11 0
R11 s11 5 18e2
VS12 4 s12 0
L12 s12 3 47e-5
VS13 0 s13 0
V13 e13 s13 DC 0 AC 18e1 180
RI13 e13 5 18e-1
VS14 1 s14 0
C14 s14 0 56e-6
.control
set numdgt=17
ac lin 1 60 60
print v(1) v(2) v(3) v(4) v(5) v(6) v(7)
print i(vs0) i(vs1) i(vs2) i(vs3) i(vs4) i(vs5) i(vs6) i(vs7) i(vs8) i(vs9)
print i(vs10) i(vs11) i(vs12) i(vs13) i(vs14)
.endc
.end
