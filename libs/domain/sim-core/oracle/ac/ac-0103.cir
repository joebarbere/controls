controls oracle ac-0103
* Generated (plan F2.7, ADR 0012): do not edit; regenerate with `pnpm sim oracle regen`. ac seed 20261031 index 103 nodes 8 elements 10
.options sparse gmin=1e-12 noopac
RG1 1 0 1000000000000
RG2 2 0 1000000000000
RG3 3 0 1000000000000
RG4 4 0 1000000000000
RG5 5 0 1000000000000
RG6 6 0 1000000000000
RG7 7 0 1000000000000
VS0 0 s0 0
L0 s0 3 39e-2
VS1 2 s1 0
L1 s1 6 27e-2
VS2 3 s2 0
L2 s2 6 68e-5
VS3 4 s3 0
L3 s3 3 47e-5
VS4 0 s4 0
V4 e4 s4 DC 0 AC 18e1 180
RI4 e4 m4 18e-1
LI4 m4 5 15e-6
VS5 7 s5 0
R5 s5 4 15e-1
VS6 1 s6 0
L6 s6 6 18e-2
VS7 7 s7 0
L7 s7 5 82e-5
VS8 4 s8 0
C8 s8 2 10e-6
VS9 1 s9 0
L9 s9 4 27e-5
.control
set numdgt=17
ac lin 1 60 60
print v(1) v(2) v(3) v(4) v(5) v(6) v(7)
print i(vs0) i(vs1) i(vs2) i(vs3) i(vs4) i(vs5) i(vs6) i(vs7) i(vs8) i(vs9)
.endc
.end
