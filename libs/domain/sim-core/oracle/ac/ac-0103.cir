controls oracle ac-0103
* Generated (plan F2.7, ADR 0012): do not edit; regenerate with `pnpm sim oracle regen`. ac seed 20261031 index 103 nodes 8 elements 16
.options sparse gmin=1e-12 noopac
RG1 1 0 1000000000000
RG2 2 0 1000000000000
RG3 3 0 1000000000000
RG4 4 0 1000000000000
RG5 5 0 1000000000000
RG6 6 0 1000000000000
RG7 7 0 1000000000000
VS0 0 s0 0
V0 e0 s0 DC 0 AC 33e0 180
RI0 e0 n0 22e-1
H0 n0 h0 VS2 47e-2
ED0 h0 4 d0 0 -10e-7
F0 0 d0 VS2 1
LD0 d0 0 1
VS1 7 s1 0
L1 s1 5 82e-5
VS2 6 s2 0
V2 e2 s2 DC 0 AC 18e1 180
RI2 e2 m2 18e-1
LI2 m2 n2 39e-5
H2 n2 h2 VS0 47e-2
ED2 h2 5 d2 0 -10e-7
F2 0 d2 VS0 1
LD2 d2 0 1
VS3 1 s3 0
C3 s3 6 56e-6
VS4 3 s4 0
L4 s4 6 15e-3
VS5 5 s5 0
R5 s5 1 15e-2
VS6 6 s6 0
V6 e6 s6 DC 0 AC 82e1 0
RI6 e6 m6 27e-3
LI6 m6 3 68e-7
VS7 0 s7 0
C7 s7 2 10e-6
VS8 1 s8 0
L8 s8 0 27e-5
VS9 7 s9 0
R9 s9 0 15e-1
VS10 1 s10 0
L10 s10 4 18e-2
VS11 0 s11 0
L11 s11 3 47e-5
VS12 5 s12 0
L12 s12 1 56e-3
VS13 4 s13 0
C13 s13 2 56e-7
VS14 1 s14 0
R14 s14 5 18e2
VS15 0 s15 0
C15 s15 6 56e-6
.control
set numdgt=17
ac lin 1 60 60
print v(1) v(2) v(3) v(4) v(5) v(6) v(7)
print i(vs0) i(vs1) i(vs2) i(vs3) i(vs4) i(vs5) i(vs6) i(vs7) i(vs8) i(vs9)
print i(vs10) i(vs11) i(vs12) i(vs13) i(vs14) i(vs15)
.endc
.end
