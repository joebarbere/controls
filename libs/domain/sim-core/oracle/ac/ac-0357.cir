controls oracle ac-0357
* Generated (plan F2.7, ADR 0012): do not edit; regenerate with `pnpm sim oracle regen`. ac seed 20261031 index 357 nodes 18 elements 36
.options sparse gmin=1e-12 noopac
RG1 1 0 1000000000000
RG2 2 0 1000000000000
RG3 3 0 1000000000000
RG4 4 0 1000000000000
RG5 5 0 1000000000000
RG6 6 0 1000000000000
RG7 7 0 1000000000000
RG8 8 0 1000000000000
RG9 9 0 1000000000000
RG10 10 0 1000000000000
RG11 11 0 1000000000000
RG12 12 0 1000000000000
RG13 13 0 1000000000000
RG14 14 0 1000000000000
RG15 15 0 1000000000000
RG16 16 0 1000000000000
RG17 17 0 1000000000000
VS0 11 s0 0
R0 s0 17 82e1
VS1 5 s1 0
L1 s1 8 12e-4
VS2 0 s2 0
V2 e2 s2 DC 0 AC 82e1 180
RI2 e2 m2 12e-2
LI2 m2 7 22e-6
VS3 2 s3 0
C3 s3 0 10e-6
VS4 15 s4 0
V4 e4 s4 DC 0 AC 27e0 -120
RI4 e4 m4 47e-3
LI4 m4 12 56e-7
VS5 0 s5 0
L5 s5 13 18e-4
VS6 12 s6 0
C6 s6 9 56e-7
VS7 9 s7 0
R7 s7 15 39e-1
VS8 6 s8 0
L8 s8 3 22e-3
VS9 6 s9 0
C9 s9 5 82e-5
VS10 11 s10 0
L10 s10 4 82e-2
VS11 7 s11 0
C11 s11 1 12e-7
VS12 13 s12 0
C12 s12 8 33e-4
VS13 6 s13 0
R13 s13 7 82e2
VS14 15 s14 0
R14 s14 1 15e-1
VS15 10 s15 0
R15 s15 9 27e1
VS16 1 s16 0
L16 s16 6 39e-5
VS17 17 s17 0
V17 e17 s17 DC 0 AC 47e-1 120
RI17 e17 m17 82e-3
LI17 m17 10 56e-5
VS18 2 s18 0
C18 s18 12 39e-4
VS19 16 s19 0
V19 e19 s19 DC 0 AC 68e0 180
RI19 e19 14 22e-3
VS20 8 s20 0
C20 s20 13 39e-6
VS21 15 s21 0
L21 s21 17 82e-2
VS22 12 s22 0
L22 s22 7 27e-5
VS23 13 s23 0
L23 s23 17 33e-4
VS24 9 s24 0
V24 e24 s24 DC 0 AC 12e1 0
RI24 e24 6 22e-2
VS25 17 s25 0
V25 e25 s25 DC 0 AC 47e-1 120
RI25 e25 m25 27e-3
LI25 m25 5 39e-6
VS26 14 s26 0
C26 s26 4 47e-6
VS27 3 s27 0
L27 s27 13 10e-3
VS28 16 s28 0
L28 s28 0 22e-5
VS29 12 s29 0
C29 s29 4 33e-7
VS30 12 s30 0
R30 s30 13 15e1
VS31 10 s31 0
R31 s31 14 27e-1
VS32 2 s32 0
L32 s32 14 15e-3
VS33 2 s33 0
V33 e33 s33 DC 0 AC 56e-1 180
RI33 e33 3 39e-1
VS34 11 s34 0
R34 s34 4 15e0
VS35 15 s35 0
V35 e35 s35 DC 0 AC 12e0 -120
RI35 e35 7 18e-2
.control
set numdgt=17
ac lin 1 60 60
print v(1) v(2) v(3) v(4) v(5) v(6) v(7) v(8) v(9) v(10)
print v(11) v(12) v(13) v(14) v(15) v(16) v(17)
print i(vs0) i(vs1) i(vs2) i(vs3) i(vs4) i(vs5) i(vs6) i(vs7) i(vs8) i(vs9)
print i(vs10) i(vs11) i(vs12) i(vs13) i(vs14) i(vs15) i(vs16) i(vs17) i(vs18) i(vs19)
print i(vs20) i(vs21) i(vs22) i(vs23) i(vs24) i(vs25) i(vs26) i(vs27) i(vs28) i(vs29)
print i(vs30) i(vs31) i(vs32) i(vs33) i(vs34) i(vs35)
.endc
.end
