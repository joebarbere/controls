controls oracle ac-0357
* Generated (plan F2.7, ADR 0012): do not edit; regenerate with `pnpm sim oracle regen`. ac seed 20261031 index 357 nodes 18 elements 36
.options sparse gmin=1e-12 noopac
RG1 1 0 1000000000000
RG2 2 0 1000000000000
RG3 3 0 1000000000000
RG4 4 0 1000000000000
RG5 5 0 1000000000000
RG6 6 0 1000000000000
RG7 7 0 1000000000000
RG8 8 0 1000000000000
RG9 9 0 1000000000000
RG10 10 0 1000000000000
RG11 11 0 1000000000000
RG12 12 0 1000000000000
RG13 13 0 1000000000000
RG14 14 0 1000000000000
RG15 15 0 1000000000000
RG16 16 0 1000000000000
RG17 17 0 1000000000000
VS0 6 s0 0
L0 s0 3 18e-4
VS1 0 s1 0
V1 e1 s1 DC 0 AC 39e0 180
RI1 e1 5 47e-2
VS2 3 s2 0
R2 s2 7 27e3
VS3 15 s3 0
C3 s3 0 10e-5
VS4 11 s4 0
L4 s4 12 39e-2
VS5 13 s5 0
R5 s5 2 27e-2
VS6 4 s6 0
C6 s6 12 56e-5
VS7 14 s7 0
R7 s7 16 39e-1
VS8 4 s8 0
V8 e8 s8 DC 0 AC 56e0 120
RI8 e8 13 12e-1
VS9 7 s9 0
C9 s9 10 82e-6
VS10 14 s10 0
R10 s10 15 18e-2
VS11 1 s11 0
R11 s11 9 33e2
VS12 6 s12 0
V12 e12 s12 DC 0 AC 56e1 0
RI12 e12 13 33e-1
VS13 12 s13 0
R13 s13 7 10e0
VS14 17 s14 0
L14 s14 14 27e-4
VS15 10 s15 0
L15 s15 16 22e-2
VS16 4 s16 0
R16 s16 3 56e0
VS17 7 s17 0
V17 e17 s17 DC 0 AC 27e0 -120
RI17 e17 12 47e-3
VS18 17 s18 0
R18 s18 13 68e1
VS19 13 s19 0
V19 e19 s19 DC 0 AC 12e-1 0
RI19 e19 0 12e-2
VS20 2 s20 0
L20 s20 1 15e-4
VS21 8 s21 0
L21 s21 9 10e-3
VS22 12 s22 0
L22 s22 17 56e-3
VS23 13 s23 0
R23 s23 5 12e2
VS24 3 s24 0
C24 s24 4 22e-5
VS25 13 s25 0
L25 s25 14 56e-5
VS26 17 s26 0
R26 s26 9 68e3
VS27 2 s27 0
V27 e27 s27 DC 0 AC 33e1 120
RI27 e27 14 33e-1
VS28 1 s28 0
R28 s28 15 56e3
VS29 4 s29 0
R29 s29 9 33e-1
VS30 4 s30 0
R30 s30 17 18e-1
VS31 6 s31 0
L31 s31 3 68e-5
VS32 8 s32 0
V32 e32 s32 DC 0 AC 22e-1 -120
RI32 e32 0 15e-1
VS33 1 s33 0
C33 s33 11 82e-7
VS34 10 s34 0
R34 s34 16 47e3
VS35 11 s35 0
V35 e35 s35 DC 0 AC 33e1 180
RI35 e35 9 47e-1
.control
set numdgt=17
ac lin 1 60 60
print v(1) v(2) v(3) v(4) v(5) v(6) v(7) v(8) v(9) v(10)
print v(11) v(12) v(13) v(14) v(15) v(16) v(17)
print i(vs0) i(vs1) i(vs2) i(vs3) i(vs4) i(vs5) i(vs6) i(vs7) i(vs8) i(vs9)
print i(vs10) i(vs11) i(vs12) i(vs13) i(vs14) i(vs15) i(vs16) i(vs17) i(vs18) i(vs19)
print i(vs20) i(vs21) i(vs22) i(vs23) i(vs24) i(vs25) i(vs26) i(vs27) i(vs28) i(vs29)
print i(vs30) i(vs31) i(vs32) i(vs33) i(vs34) i(vs35)
.endc
.end
