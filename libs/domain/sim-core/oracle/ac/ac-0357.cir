controls oracle ac-0357
* Generated (plan F2.7, ADR 0012): do not edit; regenerate with `pnpm sim oracle regen`. ac seed 20261031 index 357 nodes 18 elements 34
.options sparse gmin=1e-12 noopac
RG1 1 0 1000000000000
RG2 2 0 1000000000000
RG3 3 0 1000000000000
RG4 4 0 1000000000000
RG5 5 0 1000000000000
RG6 6 0 1000000000000
RG7 7 0 1000000000000
RG8 8 0 1000000000000
RG9 9 0 1000000000000
RG10 10 0 1000000000000
RG11 11 0 1000000000000
RG12 12 0 1000000000000
RG13 13 0 1000000000000
RG14 14 0 1000000000000
RG15 15 0 1000000000000
RG16 16 0 1000000000000
RG17 17 0 1000000000000
VS0 0 s0 0
C0 s0 10 82e-6
VS1 11 s1 0
L1 s1 12 39e-2
VS2 0 s2 0
V2 e2 s2 DC 0 AC 27e0 -120
RI2 e2 12 47e-3
VS3 13 s3 0
R3 s3 5 12e2
VS4 4 s4 0
V4 e4 s4 DC 0 AC 56e0 120
RI4 e4 13 12e-1
VS5 13 s5 0
L5 s5 14 56e-5
VS6 4 s6 0
R6 s6 17 18e-1
VS7 17 s7 0
R7 s7 13 68e1
VS8 17 s8 0
R8 s8 9 68e3
VS9 13 s9 0
V9 e9 s9 DC 0 AC 12e-1 0
RI9 e9 7 12e-2
VS10 14 s10 0
R10 s10 16 39e-1
VS11 4 s11 0
C11 s11 12 56e-5
VS12 11 s12 0
V12 e12 s12 DC 0 AC 33e1 180
RI12 e12 9 47e-1
VS13 2 s13 0
V13 e13 s13 DC 0 AC 33e1 120
RI13 e13 14 33e-1
VS14 12 s14 0
L14 s14 17 56e-3
VS15 15 s15 0
C15 s15 7 10e-5
VS16 10 s16 0
L16 s16 16 22e-2
VS17 2 s17 0
L17 s17 1 15e-4
VS18 1 s18 0
C18 s18 11 82e-7
VS19 6 s19 0
L19 s19 3 68e-5
VS20 12 s20 0
R20 s20 0 10e0
VS21 3 s21 0
C21 s21 4 22e-5
VS22 8 s22 0
V22 e22 s22 DC 0 AC 22e-1 -120
RI22 e22 7 15e-1
VS23 17 s23 0
L23 s23 14 27e-4
VS24 14 s24 0
R24 s24 15 18e-2
VS25 8 s25 0
L25 s25 9 10e-3
VS26 6 s26 0
L26 s26 3 18e-4
VS27 10 s27 0
R27 s27 16 47e3
VS28 3 s28 0
R28 s28 0 27e3
VS29 13 s29 0
R29 s29 2 27e-2
VS30 1 s30 0
R30 s30 9 33e2
VS31 4 s31 0
R31 s31 9 33e-1
VS32 4 s32 0
R32 s32 3 56e0
VS33 1 s33 0
R33 s33 15 56e3
.control
set numdgt=17
ac lin 1 60 60
print v(1) v(2) v(3) v(4) v(5) v(6) v(7) v(8) v(9) v(10)
print v(11) v(12) v(13) v(14) v(15) v(16) v(17)
print i(vs0) i(vs1) i(vs2) i(vs3) i(vs4) i(vs5) i(vs6) i(vs7) i(vs8) i(vs9)
print i(vs10) i(vs11) i(vs12) i(vs13) i(vs14) i(vs15) i(vs16) i(vs17) i(vs18) i(vs19)
print i(vs20) i(vs21) i(vs22) i(vs23) i(vs24) i(vs25) i(vs26) i(vs27) i(vs28) i(vs29)
print i(vs30) i(vs31) i(vs32) i(vs33)
.endc
.end
