controls oracle ac-0242
* Generated (plan F2.7, ADR 0012): do not edit; regenerate with `pnpm sim oracle regen`. ac seed 20261031 index 242 nodes 12 elements 14
.options sparse gmin=1e-12 noopac
RG1 1 0 1000000000000
RG2 2 0 1000000000000
RG3 3 0 1000000000000
RG4 4 0 1000000000000
RG5 5 0 1000000000000
RG6 6 0 1000000000000
RG7 7 0 1000000000000
RG8 8 0 1000000000000
RG9 9 0 1000000000000
RG10 10 0 1000000000000
RG11 11 0 1000000000000
VS0 0 s0 0
V0 e0 s0 DC 0 AC 47e-1 180
RI0 e0 9 10e-2
VS1 11 s1 0
R1 s1 2 22e-2
VS2 6 s2 0
R2 s2 11 10e-1
VS3 0 s3 0
L3 s3 10 12e-4
VS4 0 s4 0
L4 s4 11 22e-5
VS5 5 s5 0
V5 e5 s5 DC 0 AC 68e-1 120
RI5 e5 11 56e-3
VS6 0 s6 0
L6 s6 3 27e-2
VS7 5 s7 0
L7 s7 7 56e-5
VS8 3 s8 0
R8 s8 0 82e2
VS9 1 s9 0
R9 s9 8 33e1
VS10 6 s10 0
R10 s10 1 22e-1
VS11 6 s11 0
C11 s11 7 15e-4
VS12 5 s12 0
L12 s12 1 47e-5
VS13 3 s13 0
R13 s13 4 33e1
.control
set numdgt=17
ac lin 1 60 60
print v(1) v(2) v(3) v(4) v(5) v(6) v(7) v(8) v(9) v(10)
print v(11)
print i(vs0) i(vs1) i(vs2) i(vs3) i(vs4) i(vs5) i(vs6) i(vs7) i(vs8) i(vs9)
print i(vs10) i(vs11) i(vs12) i(vs13)
.endc
.end
