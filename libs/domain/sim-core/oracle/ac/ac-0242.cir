controls oracle ac-0242
* Generated (plan F2.7, ADR 0012): do not edit; regenerate with `pnpm sim oracle regen`. ac seed 20261031 index 242 nodes 12 elements 20
.options sparse gmin=1e-12 noopac
RG1 1 0 1000000000000
RG2 2 0 1000000000000
RG3 3 0 1000000000000
RG4 4 0 1000000000000
RG5 5 0 1000000000000
RG6 6 0 1000000000000
RG7 7 0 1000000000000
RG8 8 0 1000000000000
RG9 9 0 1000000000000
RG10 10 0 1000000000000
RG11 11 0 1000000000000
VS0 8 s0 0
C0 s0 1 15e-5
VS1 6 s1 0
R1 s1 8 27e2
VS2 5 s2 0
L2 s2 11 22e-5
VS3 1 s3 0
C3 s3 9 33e-5
VS4 0 s4 0
V4 e4 s4 DC 0 AC 68e-1 120
RI4 e4 m4 56e-3
LI4 m4 11 47e-5
VS5 6 s5 0
R5 s5 9 22e0
VS6 1 s6 0
V6 e6 s6 DC 0 AC 12e0 -120
RI6 e6 m6 12e-1
LI6 m6 0 18e-6
VS7 4 s7 0
V7 e7 s7 DC 0 AC 82e1 180
RI7 e7 1 12e-3
VS8 0 s8 0
R8 s8 3 33e1
VS9 5 s9 0
C9 s9 4 15e-4
VS10 0 s10 0
L10 s10 10 47e-4
VS11 7 s11 0
L11 s11 10 56e-2
VS12 7 s12 0
L12 s12 8 39e-4
VS13 11 s13 0
C13 s13 0 82e-4
VS14 4 s14 0
C14 s14 10 56e-5
VS15 8 s15 0
V15 e15 s15 DC 0 AC 68e0 180
RI15 e15 7 12e-2
VS16 11 s16 0
R16 s16 2 22e-2
VS17 6 s17 0
V17 e17 s17 DC 0 AC 10e-1 0
RI17 e17 2 10e-1
VS18 6 s18 0
L18 s18 4 12e-4
VS19 3 s19 0
R19 s19 7 10e-1
.control
set numdgt=17
ac lin 1 60 60
print v(1) v(2) v(3) v(4) v(5) v(6) v(7) v(8) v(9) v(10)
print v(11)
print i(vs0) i(vs1) i(vs2) i(vs3) i(vs4) i(vs5) i(vs6) i(vs7) i(vs8) i(vs9)
print i(vs10) i(vs11) i(vs12) i(vs13) i(vs14) i(vs15) i(vs16) i(vs17) i(vs18) i(vs19)
.endc
.end
