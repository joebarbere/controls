controls oracle ac-0466
* Generated (plan F2.7, ADR 0012): do not edit; regenerate with `pnpm sim oracle regen`. ac seed 20261031 index 466 nodes 15 elements 23
.options sparse gmin=1e-12 noopac
RG1 1 0 1000000000000
RG2 2 0 1000000000000
RG3 3 0 1000000000000
RG4 4 0 1000000000000
RG5 5 0 1000000000000
RG6 6 0 1000000000000
RG7 7 0 1000000000000
RG8 8 0 1000000000000
RG9 9 0 1000000000000
RG10 10 0 1000000000000
RG11 11 0 1000000000000
RG12 12 0 1000000000000
RG13 13 0 1000000000000
RG14 14 0 1000000000000
VS0 11 s0 0
R0 s0 2 47e2
VS1 13 s1 0
C1 s1 3 82e-4
VS2 12 s2 0
C2 s2 1 56e-6
VS3 3 s3 0
C3 s3 12 27e-7
VS4 8 s4 0
R4 s4 11 33e2
VS5 12 s5 0
R5 s5 11 68e1
VS6 12 s6 0
L6 s6 10 56e-3
VS7 0 s7 0
V7 e7 s7 DC 0 AC 18e1 180
RI7 e7 7 47e-2
VS8 7 s8 0
C8 s8 12 82e-7
VS9 10 s9 0
C9 s9 5 18e-7
VS10 12 s10 0
L10 s10 2 12e-4
VS11 4 s11 0
C11 s11 12 10e-5
VS12 0 s12 0
C12 s12 3 27e-5
VS13 13 s13 0
V13 e13 s13 DC 0 AC 39e1 180
RI13 e13 11 39e-3
VS14 3 s14 0
V14 e14 s14 DC 0 AC 27e1 0
RI14 e14 m14 47e-3
LI14 m14 14 15e-7
VS15 9 s15 0
L15 s15 5 82e-2
VS16 10 s16 0
V16 e16 s16 DC 0 AC 27e-1 0
RI16 e16 m16 56e-2
LI16 m16 14 33e-6
VS17 8 s17 0
V17 e17 s17 DC 0 AC 39e-1 -120
RI17 e17 m17 27e-1
LI17 m17 1 22e-5
VS18 14 s18 0
V18 e18 s18 DC 0 AC 15e-1 -120
RI18 e18 9 27e-3
VS19 0 s19 0
V19 e19 s19 DC 0 AC 27e1 -120
RI19 e19 m19 33e-2
LI19 m19 6 82e-7
VS20 0 s20 0
R20 s20 1 18e2
VS21 4 s21 0
R21 s21 7 15e-2
VS22 6 s22 0
L22 s22 5 12e-4
.control
set numdgt=17
ac lin 1 60 60
print v(1) v(2) v(3) v(4) v(5) v(6) v(7) v(8) v(9) v(10)
print v(11) v(12) v(13) v(14)
print i(vs0) i(vs1) i(vs2) i(vs3) i(vs4) i(vs5) i(vs6) i(vs7) i(vs8) i(vs9)
print i(vs10) i(vs11) i(vs12) i(vs13) i(vs14) i(vs15) i(vs16) i(vs17) i(vs18) i(vs19)
print i(vs20) i(vs21) i(vs22)
.endc
.end
