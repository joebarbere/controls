controls oracle ac-0466
* Generated (plan F2.7, ADR 0012): do not edit; regenerate with `pnpm sim oracle regen`. ac seed 20261031 index 466 nodes 15 elements 23
.options sparse gmin=1e-12 noopac
RG1 1 0 1000000000000
RG2 2 0 1000000000000
RG3 3 0 1000000000000
RG4 4 0 1000000000000
RG5 5 0 1000000000000
RG6 6 0 1000000000000
RG7 7 0 1000000000000
RG8 8 0 1000000000000
RG9 9 0 1000000000000
RG10 10 0 1000000000000
RG11 11 0 1000000000000
RG12 12 0 1000000000000
RG13 13 0 1000000000000
RG14 14 0 1000000000000
VS0 3 s0 0
R0 s0 4 27e3
VS1 12 s1 0
L1 s1 2 12e-5
VS2 11 s2 0
C2 s2 0 18e-6
VS3 4 s3 0
L3 s3 8 22e-4
VS4 5 s4 0
C4 s4 14 15e-5
VS5 13 s5 0
R5 s5 2 39e-2
VS6 3 s6 0
C6 s6 1 47e-5
VS7 0 s7 0
V7 e7 s7 DC 0 AC 33e1 180
RI7 e7 m7 33e-2
LI7 m7 10 68e-6
VS8 12 s8 0
C8 s8 11 56e-6
VS9 10 s9 0
C9 s9 13 33e-5
VS10 11 s10 0
V10 e10 s10 DC 0 AC 27e-1 0
RI10 e10 9 56e-2
VS11 0 s11 0
V11 e11 s11 DC 0 AC 27e1 0
RI11 e11 6 47e-3
VS12 1 s12 0
L12 s12 6 27e-3
VS13 5 s13 0
R13 s13 10 15e-1
VS14 8 s14 0
V14 e14 s14 DC 0 AC 39e-1 -120
RI14 e14 m14 27e-1
LI14 m14 11 10e-5
VS15 7 s15 0
R15 s15 12 47e2
VS16 12 s16 0
R16 s16 0 68e1
VS17 9 s17 0
L17 s17 5 82e-2
VS18 11 s18 0
R18 s18 14 22e0
VS19 2 s19 0
R19 s19 4 68e2
VS20 4 s20 0
C20 s20 12 10e-5
VS21 10 s21 0
V21 e21 s21 DC 0 AC 82e0 120
RI21 e21 7 18e-3
VS22 0 s22 0
L22 s22 1 27e-5
.control
set numdgt=17
ac lin 1 60 60
print v(1) v(2) v(3) v(4) v(5) v(6) v(7) v(8) v(9) v(10)
print v(11) v(12) v(13) v(14)
print i(vs0) i(vs1) i(vs2) i(vs3) i(vs4) i(vs5) i(vs6) i(vs7) i(vs8) i(vs9)
print i(vs10) i(vs11) i(vs12) i(vs13) i(vs14) i(vs15) i(vs16) i(vs17) i(vs18) i(vs19)
print i(vs20) i(vs21) i(vs22)
.endc
.end
