controls oracle ac-0466
* Generated (plan F2.7, ADR 0012): do not edit; regenerate with `pnpm sim oracle regen`. ac seed 20261031 index 466 nodes 15 elements 18
.options sparse gmin=1e-12 noopac
RG1 1 0 1000000000000
RG2 2 0 1000000000000
RG3 3 0 1000000000000
RG4 4 0 1000000000000
RG5 5 0 1000000000000
RG6 6 0 1000000000000
RG7 7 0 1000000000000
RG8 8 0 1000000000000
RG9 9 0 1000000000000
RG10 10 0 1000000000000
RG11 11 0 1000000000000
RG12 12 0 1000000000000
RG13 13 0 1000000000000
RG14 14 0 1000000000000
VS0 5 s0 0
C0 s0 14 15e-5
VS1 0 s1 0
V1 e1 s1 DC 0 AC 33e1 180
RI1 e1 10 33e-2
VS2 12 s2 0
C2 s2 11 56e-6
VS3 5 s3 0
R3 s3 10 15e-1
VS4 12 s4 0
L4 s4 2 12e-5
VS5 3 s5 0
C5 s5 1 47e-5
VS6 4 s6 0
C6 s6 12 10e-5
VS7 1 s7 0
L7 s7 6 27e-3
VS8 13 s8 0
R8 s8 2 39e-2
VS9 11 s9 0
V9 e9 s9 DC 0 AC 27e-1 0
RI9 e9 9 56e-2
VS10 10 s10 0
V10 e10 s10 DC 0 AC 82e0 120
RI10 e10 7 18e-3
VS11 10 s11 0
C11 s11 13 33e-5
VS12 8 s12 0
V12 e12 s12 DC 0 AC 39e-1 -120
RI12 e12 11 27e-1
VS13 2 s13 0
R13 s13 4 68e2
VS14 0 s14 0
L14 s14 1 27e-5
VS15 12 s15 0
R15 s15 0 68e1
VS16 11 s16 0
C16 s16 0 18e-6
VS17 9 s17 0
L17 s17 5 82e-2
.control
set numdgt=17
ac lin 1 60 60
print v(1) v(2) v(3) v(4) v(5) v(6) v(7) v(8) v(9) v(10)
print v(11) v(12) v(13) v(14)
print i(vs0) i(vs1) i(vs2) i(vs3) i(vs4) i(vs5) i(vs6) i(vs7) i(vs8) i(vs9)
print i(vs10) i(vs11) i(vs12) i(vs13) i(vs14) i(vs15) i(vs16) i(vs17)
.endc
.end
