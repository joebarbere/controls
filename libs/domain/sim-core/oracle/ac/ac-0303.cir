controls oracle ac-0303
* Generated (plan F2.7, ADR 0012): do not edit; regenerate with `pnpm sim oracle regen`. ac seed 20261031 index 303 nodes 29 elements 34
.options sparse gmin=1e-12 noopac
RG1 1 0 1000000000000
RG2 2 0 1000000000000
RG3 3 0 1000000000000
RG4 4 0 1000000000000
RG5 5 0 1000000000000
RG6 6 0 1000000000000
RG7 7 0 1000000000000
RG8 8 0 1000000000000
RG9 9 0 1000000000000
RG10 10 0 1000000000000
RG11 11 0 1000000000000
RG12 12 0 1000000000000
RG13 13 0 1000000000000
RG14 14 0 1000000000000
RG15 15 0 1000000000000
RG16 16 0 1000000000000
RG17 17 0 1000000000000
RG18 18 0 1000000000000
RG19 19 0 1000000000000
RG20 20 0 1000000000000
RG21 21 0 1000000000000
RG22 22 0 1000000000000
RG23 23 0 1000000000000
RG24 24 0 1000000000000
RG25 25 0 1000000000000
RG26 26 0 1000000000000
RG27 27 0 1000000000000
RG28 28 0 1000000000000
VS0 0 s0 0
V0 e0 s0 DC 0 AC 47e1 120
RI0 e0 10 15e-1
VS1 26 s1 0
V1 e1 s1 DC 0 AC 22e1 180
RI1 e1 13 27e-1
VS2 22 s2 0
L2 s2 26 12e-4
VS3 25 s3 0
R3 s3 27 82e1
VS4 12 s4 0
R4 s4 20 68e0
VS5 1 s5 0
L5 s5 22 82e-2
VS6 19 s6 0
C6 s6 9 27e-4
VS7 19 s7 0
V7 e7 s7 DC 0 AC 27e0 0
RI7 e7 7 56e-2
VS8 20 s8 0
R8 s8 24 68e0
VS9 9 s9 0
C9 s9 11 68e-6
VS10 25 s10 0
L10 s10 15 18e-5
VS11 9 s11 0
V11 e11 s11 DC 0 AC 68e-1 0
RI11 e11 5 33e-2
VS12 27 s12 0
R12 s12 1 39e2
VS13 10 s13 0
V13 e13 s13 DC 0 AC 18e1 0
RI13 e13 12 56e-3
VS14 24 s14 0
L14 s14 0 10e-3
VS15 18 s15 0
L15 s15 22 10e-2
VS16 9 s16 0
L16 s16 10 10e-5
VS17 19 s17 0
L17 s17 21 33e-2
VS18 22 s18 0
R18 s18 7 15e0
VS19 12 s19 0
R19 s19 23 27e3
VS20 15 s20 0
V20 e20 s20 DC 0 AC 39e0 -120
RI20 e20 8 47e-3
VS21 22 s21 0
R21 s21 2 22e0
VS22 23 s22 0
R22 s22 6 27e1
VS23 22 s23 0
C23 s23 9 68e-7
VS24 23 s24 0
R24 s24 3 12e0
VS25 17 s25 0
L25 s25 16 10e-2
VS26 4 s26 0
C26 s26 9 12e-4
VS27 12 s27 0
R27 s27 23 10e0
VS28 4 s28 0
L28 s28 20 39e-4
VS29 16 s29 0
R29 s29 28 56e3
VS30 14 s30 0
V30 e30 s30 DC 0 AC 12e0 0
RI30 e30 10 68e-3
VS31 17 s31 0
C31 s31 9 27e-5
VS32 16 s32 0
C32 s32 9 47e-5
VS33 24 s33 0
R33 s33 8 82e0
.control
set numdgt=17
ac lin 1 60 60
print v(1) v(2) v(3) v(4) v(5) v(6) v(7) v(8) v(9) v(10)
print v(11) v(12) v(13) v(14) v(15) v(16) v(17) v(18) v(19) v(20)
print v(21) v(22) v(23) v(24) v(25) v(26) v(27) v(28)
print i(vs0) i(vs1) i(vs2) i(vs3) i(vs4) i(vs5) i(vs6) i(vs7) i(vs8) i(vs9)
print i(vs10) i(vs11) i(vs12) i(vs13) i(vs14) i(vs15) i(vs16) i(vs17) i(vs18) i(vs19)
print i(vs20) i(vs21) i(vs22) i(vs23) i(vs24) i(vs25) i(vs26) i(vs27) i(vs28) i(vs29)
print i(vs30) i(vs31) i(vs32) i(vs33)
.endc
.end
