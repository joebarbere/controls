controls oracle ac-0482
* Generated (plan F2.7, ADR 0012): do not edit; regenerate with `pnpm sim oracle regen`. ac seed 20261031 index 482 nodes 17 elements 26
.options sparse gmin=1e-12 noopac
RG1 1 0 1000000000000
RG2 2 0 1000000000000
RG3 3 0 1000000000000
RG4 4 0 1000000000000
RG5 5 0 1000000000000
RG6 6 0 1000000000000
RG7 7 0 1000000000000
RG8 8 0 1000000000000
RG9 9 0 1000000000000
RG10 10 0 1000000000000
RG11 11 0 1000000000000
RG12 12 0 1000000000000
RG13 13 0 1000000000000
RG14 14 0 1000000000000
RG15 15 0 1000000000000
RG16 16 0 1000000000000
VS0 4 s0 0
R0 s0 12 10e3
VS1 1 s1 0
C1 s1 7 39e-4
VS2 0 s2 0
V2 e2 s2 DC 0 AC 27e-1 0
RI2 e2 16 18e-1
VS3 8 s3 0
R3 s3 2 68e-1
VS4 14 s4 0
V4 e4 s4 DC 0 AC 56e1 0
RI4 e4 15 15e-3
VS5 1 s5 0
C5 s5 2 33e-4
VS6 3 s6 0
R6 s6 15 68e-2
VS7 10 s7 0
L7 s7 1 18e-2
VS8 13 s8 0
R8 s8 6 12e-1
VS9 9 s9 0
C9 s9 0 27e-4
VS10 8 s10 0
L10 s10 5 12e-2
VS11 4 s11 0
L11 s11 1 18e-5
VS12 0 s12 0
C12 s12 3 12e-7
VS13 15 s13 0
C13 s13 11 27e-6
VS14 13 s14 0
R14 s14 10 12e3
VS15 15 s15 0
R15 s15 9 56e2
VS16 5 s16 0
C16 s16 3 10e-6
VS17 12 s17 0
L17 s17 0 56e-2
VS18 0 s18 0
C18 s18 14 10e-6
VS19 16 s19 0
R19 s19 10 15e3
VS20 15 s20 0
V20 e20 s20 DC 0 AC 56e1 180
RI20 e20 m20 56e-1
LI20 m20 0 27e-6
VS21 4 s21 0
C21 s21 13 27e-6
VS22 7 s22 0
L22 s22 4 22e-5
VS23 14 s23 0
R23 s23 13 27e-2
VS24 6 s24 0
C24 s24 12 56e-5
VS25 11 s25 0
R25 s25 4 22e2
.control
set numdgt=17
ac lin 1 60 60
print v(1) v(2) v(3) v(4) v(5) v(6) v(7) v(8) v(9) v(10)
print v(11) v(12) v(13) v(14) v(15) v(16)
print i(vs0) i(vs1) i(vs2) i(vs3) i(vs4) i(vs5) i(vs6) i(vs7) i(vs8) i(vs9)
print i(vs10) i(vs11) i(vs12) i(vs13) i(vs14) i(vs15) i(vs16) i(vs17) i(vs18) i(vs19)
print i(vs20) i(vs21) i(vs22) i(vs23) i(vs24) i(vs25)
.endc
.end
