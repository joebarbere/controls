controls oracle ac-0482
* Generated (plan F2.7, ADR 0012): do not edit; regenerate with `pnpm sim oracle regen`. ac seed 20261031 index 482 nodes 17 elements 24
.options sparse gmin=1e-12 noopac
RG1 1 0 1000000000000
RG2 2 0 1000000000000
RG3 3 0 1000000000000
RG4 4 0 1000000000000
RG5 5 0 1000000000000
RG6 6 0 1000000000000
RG7 7 0 1000000000000
RG8 8 0 1000000000000
RG9 9 0 1000000000000
RG10 10 0 1000000000000
RG11 11 0 1000000000000
RG12 12 0 1000000000000
RG13 13 0 1000000000000
RG14 14 0 1000000000000
RG15 15 0 1000000000000
RG16 16 0 1000000000000
VS0 15 s0 0
R0 s0 13 22e2
VS1 0 s1 0
V1 e1 s1 DC 0 AC 27e-1 0
RI1 e1 16 18e-1
VS2 7 s2 0
R2 s2 10 18e2
VS3 9 s3 0
C3 s3 0 27e-4
VS4 5 s4 0
V4 e4 s4 DC 0 AC 82e-1 0
RI4 e4 6 56e-3
VS5 11 s5 0
C5 s5 2 39e-6
VS6 16 s6 0
R6 s6 3 82e1
VS7 8 s7 0
C7 s7 15 27e-7
VS8 9 s8 0
V8 e8 s8 DC 0 AC 47e1 -120
RI8 e8 m8 68e-2
LI8 m8 4 82e-6
VS9 4 s9 0
C9 s9 13 27e-6
VS10 10 s10 0
L10 s10 11 68e-2
VS11 14 s11 0
R11 s11 8 12e-1
VS12 3 s12 0
R12 s12 12 39e0
VS13 0 s13 0
C13 s13 3 12e-7
VS14 13 s14 0
R14 s14 6 12e-1
VS15 12 s15 0
L15 s15 0 56e-2
VS16 1 s16 0
R16 s16 7 10e3
VS17 1 s17 0
C17 s17 7 39e-4
VS18 13 s18 0
R18 s18 10 12e3
VS19 4 s19 0
L19 s19 1 18e-5
VS20 14 s20 0
R20 s20 12 33e1
VS21 4 s21 0
R21 s21 12 10e3
VS22 5 s22 0
V22 e22 s22 DC 0 AC 39e1 -120
RI22 e22 m22 18e-2
LI22 m22 1 47e-7
VS23 1 s23 0
C23 s23 2 33e-4
.control
set numdgt=17
ac lin 1 60 60
print v(1) v(2) v(3) v(4) v(5) v(6) v(7) v(8) v(9) v(10)
print v(11) v(12) v(13) v(14) v(15) v(16)
print i(vs0) i(vs1) i(vs2) i(vs3) i(vs4) i(vs5) i(vs6) i(vs7) i(vs8) i(vs9)
print i(vs10) i(vs11) i(vs12) i(vs13) i(vs14) i(vs15) i(vs16) i(vs17) i(vs18) i(vs19)
print i(vs20) i(vs21) i(vs22) i(vs23)
.endc
.end
