controls oracle ac-0177
* Generated (plan F2.7, ADR 0012): do not edit; regenerate with `pnpm sim oracle regen`. ac seed 20261031 index 177 nodes 29 elements 41
.options sparse gmin=1e-12 noopac
RG1 1 0 1000000000000
RG2 2 0 1000000000000
RG3 3 0 1000000000000
RG4 4 0 1000000000000
RG5 5 0 1000000000000
RG6 6 0 1000000000000
RG7 7 0 1000000000000
RG8 8 0 1000000000000
RG9 9 0 1000000000000
RG10 10 0 1000000000000
RG11 11 0 1000000000000
RG12 12 0 1000000000000
RG13 13 0 1000000000000
RG14 14 0 1000000000000
RG15 15 0 1000000000000
RG16 16 0 1000000000000
RG17 17 0 1000000000000
RG18 18 0 1000000000000
RG19 19 0 1000000000000
RG20 20 0 1000000000000
RG21 21 0 1000000000000
RG22 22 0 1000000000000
RG23 23 0 1000000000000
RG24 24 0 1000000000000
RG25 25 0 1000000000000
RG26 26 0 1000000000000
RG27 27 0 1000000000000
RG28 28 0 1000000000000
VS0 19 s0 0
C0 s0 5 82e-7
VS1 0 s1 0
V1 e1 s1 DC 0 AC 27e0 180
RI1 e1 m1 15e-3
LI1 m1 19 18e-7
VS2 16 s2 0
L2 s2 10 82e-2
VS3 16 s3 0
R3 s3 21 39e0
VS4 6 s4 0
C4 s4 25 22e-6
VS5 24 s5 0
L5 s5 4 18e-2
VS6 14 s6 0
C6 s6 21 68e-4
VS7 14 s7 0
L7 s7 10 82e-5
VS8 26 s8 0
C8 s8 27 15e-5
VS9 13 s9 0
C9 s9 26 82e-6
VS10 27 s10 0
C10 s10 17 39e-4
VS11 26 s11 0
V11 e11 s11 DC 0 AC 12e-1 180
RI11 e11 9 22e-3
VS12 3 s12 0
L12 s12 22 33e-2
VS13 14 s13 0
L13 s13 11 15e-2
VS14 0 s14 0
L14 s14 22 22e-2
VS15 9 s15 0
R15 s15 2 18e2
VS16 23 s16 0
C16 s16 28 10e-7
VS17 9 s17 0
V17 e17 s17 DC 0 AC 12e1 180
RI17 e17 21 12e-1
VS18 1 s18 0
C18 s18 26 33e-6
VS19 23 s19 0
C19 s19 8 12e-6
VS20 14 s20 0
C20 s20 22 22e-6
VS21 14 s21 0
L21 s21 6 10e-3
VS22 9 s22 0
L22 s22 8 22e-3
VS23 13 s23 0
V23 e23 s23 DC 0 AC 15e1 -120
RI23 e23 3 10e-2
VS24 12 s24 0
R24 s24 27 68e2
VS25 5 s25 0
R25 s25 26 10e1
VS26 4 s26 0
C26 s26 9 18e-7
VS27 17 s27 0
R27 s27 18 47e-2
VS28 24 s28 0
R28 s28 25 10e-1
VS29 15 s29 0
R29 s29 14 22e3
VS30 23 s30 0
C30 s30 1 56e-7
VS31 7 s31 0
R31 s31 12 56e3
VS32 25 s32 0
C32 s32 1 22e-6
VS33 11 s33 0
R33 s33 12 47e0
VS34 2 s34 0
R34 s34 20 47e1
VS35 16 s35 0
R35 s35 15 10e0
VS36 25 s36 0
L36 s36 4 18e-2
VS37 5 s37 0
R37 s37 20 56e0
VS38 28 s38 0
C38 s38 4 10e-4
VS39 7 s39 0
C39 s39 9 22e-4
VS40 18 s40 0
C40 s40 24 22e-7
.control
set numdgt=17
ac lin 1 60 60
print v(1) v(2) v(3) v(4) v(5) v(6) v(7) v(8) v(9) v(10)
print v(11) v(12) v(13) v(14) v(15) v(16) v(17) v(18) v(19) v(20)
print v(21) v(22) v(23) v(24) v(25) v(26) v(27) v(28)
print i(vs0) i(vs1) i(vs2) i(vs3) i(vs4) i(vs5) i(vs6) i(vs7) i(vs8) i(vs9)
print i(vs10) i(vs11) i(vs12) i(vs13) i(vs14) i(vs15) i(vs16) i(vs17) i(vs18) i(vs19)
print i(vs20) i(vs21) i(vs22) i(vs23) i(vs24) i(vs25) i(vs26) i(vs27) i(vs28) i(vs29)
print i(vs30) i(vs31) i(vs32) i(vs33) i(vs34) i(vs35) i(vs36) i(vs37) i(vs38) i(vs39)
print i(vs40)
.endc
.end
