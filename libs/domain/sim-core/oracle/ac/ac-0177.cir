controls oracle ac-0177
* Generated (plan F2.7, ADR 0012): do not edit; regenerate with `pnpm sim oracle regen`. ac seed 20261031 index 177 nodes 29 elements 54
.options sparse gmin=1e-12 noopac
RG1 1 0 1000000000000
RG2 2 0 1000000000000
RG3 3 0 1000000000000
RG4 4 0 1000000000000
RG5 5 0 1000000000000
RG6 6 0 1000000000000
RG7 7 0 1000000000000
RG8 8 0 1000000000000
RG9 9 0 1000000000000
RG10 10 0 1000000000000
RG11 11 0 1000000000000
RG12 12 0 1000000000000
RG13 13 0 1000000000000
RG14 14 0 1000000000000
RG15 15 0 1000000000000
RG16 16 0 1000000000000
RG17 17 0 1000000000000
RG18 18 0 1000000000000
RG19 19 0 1000000000000
RG20 20 0 1000000000000
RG21 21 0 1000000000000
RG22 22 0 1000000000000
RG23 23 0 1000000000000
RG24 24 0 1000000000000
RG25 25 0 1000000000000
RG26 26 0 1000000000000
RG27 27 0 1000000000000
RG28 28 0 1000000000000
VS0 0 s0 0
V0 e0 s0 DC 0 AC 33e-1 120
RI0 e0 17 18e-1
VS1 10 s1 0
C1 s1 21 18e-7
VS2 1 s2 0
C2 s2 21 33e-6
VS3 18 s3 0
R3 s3 27 56e3
VS4 21 s4 0
C4 s4 27 15e-5
VS5 19 s5 0
C5 s5 12 22e-4
VS6 5 s6 0
R6 s6 23 27e-2
VS7 15 s7 0
R7 s7 22 27e0
VS8 12 s8 0
R8 s8 7 27e1
VS9 26 s9 0
C9 s9 18 47e-5
VS10 21 s10 0
V10 e10 s10 DC 0 AC 39e-1 120
RI10 e10 28 39e-1
VS11 26 s11 0
L11 s11 19 22e-3
VS12 25 s12 0
L12 s12 4 18e-2
VS13 16 s13 0
L13 s13 9 33e-4
VS14 5 s14 0
L14 s14 28 68e-2
VS15 19 s15 0
R15 s15 21 27e0
VS16 25 s16 0
R16 s16 11 68e-2
VS17 25 s17 0
R17 s17 27 27e2
VS18 2 s18 0
L18 s18 9 12e-4
VS19 26 s19 0
L19 s19 22 22e-2
VS20 24 s20 0
L20 s20 20 82e-5
VS21 21 s21 0
V21 e21 s21 DC 0 AC 12e-1 180
RI21 e21 9 22e-3
VS22 18 s22 0
C22 s22 24 12e-6
VS23 14 s23 0
C23 s23 22 22e-6
VS24 12 s24 0
C24 s24 9 56e-5
VS25 17 s25 0
R25 s25 27 18e3
VS26 14 s26 0
L26 s26 6 10e-3
VS27 14 s27 0
C27 s27 0 18e-4
VS28 18 s28 0
R28 s28 14 47e-2
VS29 16 s29 0
L29 s29 10 82e-2
VS30 21 s30 0
R30 s30 6 10e0
VS31 9 s31 0
C31 s31 26 22e-7
VS32 8 s32 0
R32 s32 26 56e0
VS33 12 s33 0
L33 s33 4 15e-2
VS34 16 s34 0
C34 s34 9 82e-7
VS35 8 s35 0
L35 s35 27 10e-4
VS36 2 s36 0
V36 e36 s36 DC 0 AC 22e0 0
RI36 e36 13 15e-1
VS37 8 s37 0
R37 s37 11 15e0
VS38 8 s38 0
C38 s38 24 39e-4
VS39 20 s39 0
C39 s39 4 10e-5
VS40 13 s40 0
V40 e40 s40 DC 0 AC 27e0 180
RI40 e40 1 15e-3
VS41 1 s41 0
C41 s41 6 27e-7
VS42 2 s42 0
C42 s42 10 10e-7
VS43 3 s43 0
C43 s43 28 68e-7
VS44 28 s44 0
R44 s44 12 18e2
VS45 10 s45 0
L45 s45 13 27e-4
VS46 7 s46 0
R46 s46 0 10e-1
VS47 17 s47 0
R47 s47 0 39e0
VS48 21 s48 0
V48 e48 s48 DC 0 AC 33e-1 120
RI48 e48 22 18e-1
VS49 20 s49 0
C49 s49 7 18e-4
VS50 28 s50 0
C50 s50 13 68e-5
VS51 25 s51 0
R51 s51 23 39e1
VS52 0 s52 0
R52 s52 8 68e-1
VS53 4 s53 0
C53 s53 0 68e-4
.control
set numdgt=17
ac lin 1 60 60
print v(1) v(2) v(3) v(4) v(5) v(6) v(7) v(8) v(9) v(10)
print v(11) v(12) v(13) v(14) v(15) v(16) v(17) v(18) v(19) v(20)
print v(21) v(22) v(23) v(24) v(25) v(26) v(27) v(28)
print i(vs0) i(vs1) i(vs2) i(vs3) i(vs4) i(vs5) i(vs6) i(vs7) i(vs8) i(vs9)
print i(vs10) i(vs11) i(vs12) i(vs13) i(vs14) i(vs15) i(vs16) i(vs17) i(vs18) i(vs19)
print i(vs20) i(vs21) i(vs22) i(vs23) i(vs24) i(vs25) i(vs26) i(vs27) i(vs28) i(vs29)
print i(vs30) i(vs31) i(vs32) i(vs33) i(vs34) i(vs35) i(vs36) i(vs37) i(vs38) i(vs39)
print i(vs40) i(vs41) i(vs42) i(vs43) i(vs44) i(vs45) i(vs46) i(vs47) i(vs48) i(vs49)
print i(vs50) i(vs51) i(vs52) i(vs53)
.endc
.end
