controls oracle ac-0177
* Generated (plan F2.7, ADR 0012): do not edit; regenerate with `pnpm sim oracle regen`. ac seed 20261031 index 177 nodes 29 elements 56
.options sparse gmin=1e-12 noopac
RG1 1 0 1000000000000
RG2 2 0 1000000000000
RG3 3 0 1000000000000
RG4 4 0 1000000000000
RG5 5 0 1000000000000
RG6 6 0 1000000000000
RG7 7 0 1000000000000
RG8 8 0 1000000000000
RG9 9 0 1000000000000
RG10 10 0 1000000000000
RG11 11 0 1000000000000
RG12 12 0 1000000000000
RG13 13 0 1000000000000
RG14 14 0 1000000000000
RG15 15 0 1000000000000
RG16 16 0 1000000000000
RG17 17 0 1000000000000
RG18 18 0 1000000000000
RG19 19 0 1000000000000
RG20 20 0 1000000000000
RG21 21 0 1000000000000
RG22 22 0 1000000000000
RG23 23 0 1000000000000
RG24 24 0 1000000000000
RG25 25 0 1000000000000
RG26 26 0 1000000000000
RG27 27 0 1000000000000
RG28 28 0 1000000000000
VS0 8 s0 0
R0 s0 11 15e0
VS1 1 s1 0
C1 s1 21 33e-6
VS2 10 s2 0
C2 s2 21 18e-7
VS3 25 s3 0
R3 s3 11 68e-2
VS4 26 s4 0
L4 s4 22 22e-2
VS5 0 s5 0
V5 e5 s5 DC 0 AC 33e-1 120
RI5 e5 17 18e-1
VS6 9 s6 0
C6 s6 26 22e-7
VS7 18 s7 0
C7 s7 24 12e-6
VS8 20 s8 0
C8 s8 7 18e-4
VS9 17 s9 0
R9 s9 0 39e0
VS10 2 s10 0
V10 e10 s10 DC 0 AC 22e0 0
RI10 e10 13 15e-1
VS11 8 s11 0
L11 s11 27 10e-4
VS12 21 s12 0
C12 s12 27 15e-5
VS13 18 s13 0
R13 s13 27 56e3
VS14 0 s14 0
R14 s14 8 68e-1
VS15 14 s15 0
C15 s15 22 22e-6
VS16 21 s16 0
V16 e16 s16 DC 0 AC 39e-1 120
RI16 e16 m16 39e-1
LI16 m16 28 15e-5
VS17 16 s17 0
L17 s17 9 33e-4
VS18 2 s18 0
L18 s18 9 12e-4
VS19 12 s19 0
L19 s19 4 15e-2
VS20 20 s20 0
C20 s20 4 10e-5
VS21 24 s21 0
L21 s21 20 82e-5
VS22 12 s22 0
C22 s22 9 56e-5
VS23 14 s23 0
C23 s23 0 18e-4
VS24 19 s24 0
R24 s24 21 27e0
VS25 25 s25 0
R25 s25 27 27e2
VS26 25 s26 0
L26 s26 4 18e-2
VS27 5 s27 0
R27 s27 23 27e-2
VS28 28 s28 0
C28 s28 13 68e-5
VS29 21 s29 0
V29 e29 s29 DC 0 AC 33e-1 120
RI29 e29 m29 18e-1
LI29 m29 22 47e-5
VS30 5 s30 0
L30 s30 28 68e-2
VS31 2 s31 0
C31 s31 10 10e-7
VS32 16 s32 0
C32 s32 9 82e-7
VS33 26 s33 0
C33 s33 18 47e-5
VS34 15 s34 0
R34 s34 22 27e0
VS35 17 s35 0
R35 s35 27 18e3
VS36 28 s36 0
R36 s36 12 18e2
VS37 10 s37 0
L37 s37 13 27e-4
VS38 3 s38 0
C38 s38 28 68e-7
VS39 8 s39 0
C39 s39 24 39e-4
VS40 4 s40 0
C40 s40 0 68e-4
VS41 13 s41 0
V41 e41 s41 DC 0 AC 27e0 180
RI41 e41 m41 15e-3
LI41 m41 1 56e-7
VS42 8 s42 0
R42 s42 26 56e0
VS43 3 s43 0
R43 s43 18 22e2
VS44 26 s44 0
L44 s44 19 22e-3
VS45 14 s45 0
L45 s45 6 10e-3
VS46 21 s46 0
V46 e46 s46 DC 0 AC 12e-1 180
RI46 e46 m46 22e-3
LI46 m46 9 10e-7
VS47 25 s47 0
R47 s47 23 39e1
VS48 16 s48 0
L48 s48 10 82e-2
VS49 7 s49 0
R49 s49 0 10e-1
VS50 12 s50 0
R50 s50 7 27e1
VS51 18 s51 0
R51 s51 14 47e-2
VS52 15 s52 0
V52 e52 s52 DC 0 AC 15e1 0
RI52 e52 5 18e-1
VS53 19 s53 0
C53 s53 12 22e-4
VS54 1 s54 0
C54 s54 6 27e-7
VS55 21 s55 0
R55 s55 6 10e0
.control
set numdgt=17
ac lin 1 60 60
print v(1) v(2) v(3) v(4) v(5) v(6) v(7) v(8) v(9) v(10)
print v(11) v(12) v(13) v(14) v(15) v(16) v(17) v(18) v(19) v(20)
print v(21) v(22) v(23) v(24) v(25) v(26) v(27) v(28)
print i(vs0) i(vs1) i(vs2) i(vs3) i(vs4) i(vs5) i(vs6) i(vs7) i(vs8) i(vs9)
print i(vs10) i(vs11) i(vs12) i(vs13) i(vs14) i(vs15) i(vs16) i(vs17) i(vs18) i(vs19)
print i(vs20) i(vs21) i(vs22) i(vs23) i(vs24) i(vs25) i(vs26) i(vs27) i(vs28) i(vs29)
print i(vs30) i(vs31) i(vs32) i(vs33) i(vs34) i(vs35) i(vs36) i(vs37) i(vs38) i(vs39)
print i(vs40) i(vs41) i(vs42) i(vs43) i(vs44) i(vs45) i(vs46) i(vs47) i(vs48) i(vs49)
print i(vs50) i(vs51) i(vs52) i(vs53) i(vs54) i(vs55)
.endc
.end
