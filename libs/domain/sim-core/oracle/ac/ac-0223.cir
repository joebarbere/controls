controls oracle ac-0223
* Generated (plan F2.7, ADR 0012): do not edit; regenerate with `pnpm sim oracle regen`. ac seed 20261031 index 223 nodes 18 elements 36
.options sparse gmin=1e-12 noopac
RG1 1 0 1000000000000
RG2 2 0 1000000000000
RG3 3 0 1000000000000
RG4 4 0 1000000000000
RG5 5 0 1000000000000
RG6 6 0 1000000000000
RG7 7 0 1000000000000
RG8 8 0 1000000000000
RG9 9 0 1000000000000
RG10 10 0 1000000000000
RG11 11 0 1000000000000
RG12 12 0 1000000000000
RG13 13 0 1000000000000
RG14 14 0 1000000000000
RG15 15 0 1000000000000
RG16 16 0 1000000000000
RG17 17 0 1000000000000
VS0 8 s0 0
R0 s0 2 33e-2
VS1 6 s1 0
L1 s1 11 82e-2
VS2 8 s2 0
L2 s2 11 68e-4
VS3 4 s3 0
R3 s3 13 39e1
VS4 0 s4 0
R4 s4 7 12e-1
VS5 4 s5 0
L5 s5 2 22e-2
VS6 17 s6 0
R6 s6 16 47e-2
VS7 4 s7 0
L7 s7 1 18e-3
VS8 0 s8 0
V8 e8 s8 DC 0 AC 12e0 120
RI8 e8 m8 27e-3
LI8 m8 11 10e-6
VS9 11 s9 0
C9 s9 7 12e-6
VS10 6 s10 0
V10 e10 s10 DC 0 AC 18e-1 180
RI10 e10 m10 10e-3
LI10 m10 3 15e-6
VS11 13 s11 0
R11 s11 9 18e1
VS12 12 s12 0
R12 s12 1 18e-1
VS13 1 s13 0
R13 s13 7 56e0
VS14 0 s14 0
V14 e14 s14 DC 0 AC 15e1 180
RI14 e14 17 56e-3
VS15 10 s15 0
R15 s15 16 12e2
VS16 6 s16 0
L16 s16 4 27e-5
VS17 5 s17 0
L17 s17 0 39e-2
VS18 7 s18 0
R18 s18 14 22e-1
VS19 5 s19 0
R19 s19 16 15e-2
VS20 0 s20 0
V20 e20 s20 DC 0 AC 12e1 120
RI20 e20 6 10e-2
VS21 15 s21 0
L21 s21 10 33e-4
VS22 5 s22 0
R22 s22 3 27e0
VS23 13 s23 0
L23 s23 7 18e-4
VS24 14 s24 0
L24 s24 1 82e-4
VS25 16 s25 0
C25 s25 9 15e-6
VS26 11 s26 0
R26 s26 5 68e-2
VS27 4 s27 0
R27 s27 10 27e0
VS28 7 s28 0
R28 s28 17 15e3
VS29 7 s29 0
L29 s29 6 22e-5
VS30 15 s30 0
L30 s30 12 15e-4
VS31 7 s31 0
L31 s31 2 39e-3
VS32 4 s32 0
R32 s32 17 10e-1
VS33 12 s33 0
V33 e33 s33 DC 0 AC 27e-1 180
RI33 e33 m33 56e-1
LI33 m33 7 22e-7
VS34 15 s34 0
C34 s34 0 15e-5
VS35 5 s35 0
C35 s35 1 56e-5
.control
set numdgt=17
ac lin 1 60 60
print v(1) v(2) v(3) v(4) v(5) v(6) v(7) v(8) v(9) v(10)
print v(11) v(12) v(13) v(14) v(15) v(16) v(17)
print i(vs0) i(vs1) i(vs2) i(vs3) i(vs4) i(vs5) i(vs6) i(vs7) i(vs8) i(vs9)
print i(vs10) i(vs11) i(vs12) i(vs13) i(vs14) i(vs15) i(vs16) i(vs17) i(vs18) i(vs19)
print i(vs20) i(vs21) i(vs22) i(vs23) i(vs24) i(vs25) i(vs26) i(vs27) i(vs28) i(vs29)
print i(vs30) i(vs31) i(vs32) i(vs33) i(vs34) i(vs35)
.endc
.end
