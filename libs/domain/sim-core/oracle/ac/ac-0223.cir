controls oracle ac-0223
* Generated (plan F2.7, ADR 0012): do not edit; regenerate with `pnpm sim oracle regen`. ac seed 20261031 index 223 nodes 18 elements 39
.options sparse gmin=1e-12 noopac
RG1 1 0 1000000000000
RG2 2 0 1000000000000
RG3 3 0 1000000000000
RG4 4 0 1000000000000
RG5 5 0 1000000000000
RG6 6 0 1000000000000
RG7 7 0 1000000000000
RG8 8 0 1000000000000
RG9 9 0 1000000000000
RG10 10 0 1000000000000
RG11 11 0 1000000000000
RG12 12 0 1000000000000
RG13 13 0 1000000000000
RG14 14 0 1000000000000
RG15 15 0 1000000000000
RG16 16 0 1000000000000
RG17 17 0 1000000000000
VS0 15 s0 0
L0 s0 5 47e-2
VS1 10 s1 0
R1 s1 16 12e2
VS2 0 s2 0
V2 e2 s2 DC 0 AC 39e-1 120
RI2 e2 m2 22e-2
LI2 m2 n2 68e-7
H2 n2 h2 VS4 -56e-4
ED2 h2 10 d2 0 33e-5
F2 0 d2 VS4 1
LD2 d2 0 1
VS3 8 s3 0
L3 s3 11 68e-4
VS4 17 s4 0
V4 e4 s4 DC 0 AC 15e1 180
RI4 e4 n4 56e-3
H4 n4 h4 VS2 -56e-4
ED4 h4 4 d4 0 33e-5
F4 0 d4 VS2 1
LD4 d4 0 1
VS5 7 s5 0
R5 s5 4 15e3
VS6 0 s6 0
V6 e6 s6 DC 0 AC 68e0 -120
RI6 e6 1 56e-1
VS7 15 s7 0
L7 s7 10 33e-4
VS8 13 s8 0
L8 s8 7 18e-4
VS9 4 s9 0
L9 s9 2 10e-2
VS10 13 s10 0
C10 s10 14 33e-6
VS11 15 s11 0
L11 s11 6 56e-4
VS12 11 s12 0
C12 s12 7 12e-6
VS13 17 s13 0
R13 s13 7 12e-1
VS14 11 s14 0
R14 s14 16 12e3
VS15 12 s15 0
R15 s15 1 18e-1
VS16 6 s16 0
V16 e16 s16 DC 0 AC 18e-1 180
RI16 e16 3 10e-3
VS17 12 s17 0
V17 e17 s17 DC 0 AC 27e-1 180
RI17 e17 7 56e-1
VS18 17 s18 0
V18 e18 s18 DC 0 AC 12e0 120
RI18 e18 m18 27e-3
LI18 m18 11 39e-7
VS19 15 s19 0
L19 s19 12 15e-4
VS20 6 s20 0
C20 s20 15 15e-7
VS21 0 s21 0
R21 s21 10 27e0
VS22 5 s22 0
R22 s22 3 27e0
VS23 11 s23 0
R23 s23 5 68e-2
VS24 6 s24 0
R24 s24 17 12e-1
VS25 0 s25 0
L25 s25 2 22e-2
VS26 6 s26 0
L26 s26 11 82e-2
VS27 7 s27 0
L27 s27 6 22e-5
VS28 1 s28 0
R28 s28 14 82e3
VS29 17 s29 0
C29 s29 9 33e-5
VS30 5 s30 0
L30 s30 17 39e-2
VS31 14 s31 0
L31 s31 1 82e-4
VS32 8 s32 0
R32 s32 17 15e0
VS33 16 s33 0
V33 e33 s33 DC 0 AC 15e-1 -120
RI33 e33 m33 39e-3
LI33 m33 13 27e-7
VS34 5 s34 0
C34 s34 1 56e-5
VS35 0 s35 0
C35 s35 6 47e-7
VS36 0 s36 0
R36 s36 4 10e-1
VS37 15 s37 0
C37 s37 17 15e-5
VS38 13 s38 0
R38 s38 9 18e1
.control
set numdgt=17
ac lin 1 60 60
print v(1) v(2) v(3) v(4) v(5) v(6) v(7) v(8) v(9) v(10)
print v(11) v(12) v(13) v(14) v(15) v(16) v(17)
print i(vs0) i(vs1) i(vs2) i(vs3) i(vs4) i(vs5) i(vs6) i(vs7) i(vs8) i(vs9)
print i(vs10) i(vs11) i(vs12) i(vs13) i(vs14) i(vs15) i(vs16) i(vs17) i(vs18) i(vs19)
print i(vs20) i(vs21) i(vs22) i(vs23) i(vs24) i(vs25) i(vs26) i(vs27) i(vs28) i(vs29)
print i(vs30) i(vs31) i(vs32) i(vs33) i(vs34) i(vs35) i(vs36) i(vs37) i(vs38)
.endc
.end
