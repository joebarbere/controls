controls oracle ac-0223
* Generated (plan F2.7, ADR 0012): do not edit; regenerate with `pnpm sim oracle regen`. ac seed 20261031 index 223 nodes 18 elements 35
.options sparse gmin=1e-12 noopac
RG1 1 0 1000000000000
RG2 2 0 1000000000000
RG3 3 0 1000000000000
RG4 4 0 1000000000000
RG5 5 0 1000000000000
RG6 6 0 1000000000000
RG7 7 0 1000000000000
RG8 8 0 1000000000000
RG9 9 0 1000000000000
RG10 10 0 1000000000000
RG11 11 0 1000000000000
RG12 12 0 1000000000000
RG13 13 0 1000000000000
RG14 14 0 1000000000000
RG15 15 0 1000000000000
RG16 16 0 1000000000000
RG17 17 0 1000000000000
VS0 4 s0 0
C0 s0 0 47e-7
VS1 11 s1 0
C1 s1 7 12e-6
VS2 0 s2 0
V2 e2 s2 DC 0 AC 18e-1 180
RI2 e2 3 10e-3
VS3 11 s3 0
R3 s3 16 12e3
VS4 4 s4 0
V4 e4 s4 DC 0 AC 68e0 -120
RI4 e4 1 56e-1
VS5 4 s5 0
R5 s5 10 27e0
VS6 14 s6 0
L6 s6 1 82e-4
VS7 12 s7 0
R7 s7 1 18e-1
VS8 10 s8 0
R8 s8 16 12e2
VS9 5 s9 0
L9 s9 17 39e-2
VS10 15 s10 0
L10 s10 10 33e-4
VS11 17 s11 0
V11 e11 s11 DC 0 AC 15e1 180
RI11 e11 6 56e-3
VS12 5 s12 0
R12 s12 3 27e0
VS13 0 s13 0
R13 s13 17 12e-1
VS14 17 s14 0
V14 e14 s14 DC 0 AC 12e0 120
RI14 e14 11 27e-3
VS15 15 s15 0
C15 s15 17 15e-5
VS16 4 s16 0
L16 s16 2 22e-2
VS17 12 s17 0
V17 e17 s17 DC 0 AC 27e-1 180
RI17 e17 7 56e-1
VS18 16 s18 0
V18 e18 s18 DC 0 AC 15e-1 -120
RI18 e18 13 39e-3
VS19 1 s19 0
R19 s19 14 82e3
VS20 4 s20 0
R20 s20 6 10e-1
VS21 0 s21 0
L21 s21 11 82e-2
VS22 8 s22 0
L22 s22 11 68e-4
VS23 5 s23 0
C23 s23 1 56e-5
VS24 13 s24 0
R24 s24 9 18e1
VS25 13 s25 0
L25 s25 7 18e-4
VS26 15 s26 0
L26 s26 5 47e-2
VS27 0 s27 0
C27 s27 15 15e-7
VS28 7 s28 0
L28 s28 0 22e-5
VS29 11 s29 0
R29 s29 5 68e-2
VS30 4 s30 0
V30 e30 s30 DC 0 AC 39e-1 120
RI30 e30 10 22e-2
VS31 17 s31 0
R31 s31 7 12e-1
VS32 15 s32 0
L32 s32 0 56e-4
VS33 15 s33 0
L33 s33 12 15e-4
VS34 7 s34 0
R34 s34 6 15e3
.control
set numdgt=17
ac lin 1 60 60
print v(1) v(2) v(3) v(4) v(5) v(6) v(7) v(8) v(9) v(10)
print v(11) v(12) v(13) v(14) v(15) v(16) v(17)
print i(vs0) i(vs1) i(vs2) i(vs3) i(vs4) i(vs5) i(vs6) i(vs7) i(vs8) i(vs9)
print i(vs10) i(vs11) i(vs12) i(vs13) i(vs14) i(vs15) i(vs16) i(vs17) i(vs18) i(vs19)
print i(vs20) i(vs21) i(vs22) i(vs23) i(vs24) i(vs25) i(vs26) i(vs27) i(vs28) i(vs29)
print i(vs30) i(vs31) i(vs32) i(vs33) i(vs34)
.endc
.end
