controls oracle ac-0025
* Generated (plan F2.7, ADR 0012): do not edit; regenerate with `pnpm sim oracle regen`. ac seed 20261031 index 25 nodes 4 elements 4
.options sparse gmin=1e-12 noopac
RG1 1 0 1000000000000
RG2 2 0 1000000000000
RG3 3 0 1000000000000
VS0 0 s0 0
V0 e0 s0 DC 0 AC 39e0 -120
RI0 e0 m0 39e-1
LI0 m0 2 47e-6
VS1 2 s1 0
V1 e1 s1 DC 0 AC 27e1 180
RI1 e1 m1 27e-3
LI1 m1 3 15e-7
VS2 3 s2 0
V2 e2 s2 DC 0 AC 82e-1 120
RI2 e2 m2 27e-1
LI2 m2 1 27e-5
VS3 0 s3 0
R3 s3 1 27e3
.control
set numdgt=17
ac lin 1 60 60
print v(1) v(2) v(3)
print i(vs0) i(vs1) i(vs2) i(vs3)
.endc
.end
