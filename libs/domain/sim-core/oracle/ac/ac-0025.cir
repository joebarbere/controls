controls oracle ac-0025
* Generated (plan F2.7, ADR 0012): do not edit; regenerate with `pnpm sim oracle regen`. ac seed 20261031 index 25 nodes 4 elements 7
.options sparse gmin=1e-12 noopac
RG1 1 0 1000000000000
RG2 2 0 1000000000000
RG3 3 0 1000000000000
VS0 0 s0 0
V0 e0 s0 DC 0 AC 56e-1 120
RI0 e0 m0 68e-2
LI0 m0 2 15e-6
VS1 3 s1 0
V1 e1 s1 DC 0 AC 82e-1 120
RI1 e1 1 27e-1
VS2 2 s2 0
R2 s2 1 27e3
VS3 3 s3 0
C3 s3 1 47e-7
VS4 0 s4 0
C4 s4 1 68e-4
VS5 2 s5 0
R5 s5 1 18e0
VS6 3 s6 0
R6 s6 2 47e-2
.control
set numdgt=17
ac lin 1 60 60
print v(1) v(2) v(3)
print i(vs0) i(vs1) i(vs2) i(vs3) i(vs4) i(vs5) i(vs6)
.endc
.end
