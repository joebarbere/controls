controls oracle ac-0249
* Generated (plan F2.7, ADR 0012): do not edit; regenerate with `pnpm sim oracle regen`. ac seed 20261031 index 249 nodes 15 elements 23
.options sparse gmin=1e-12 noopac
RG1 1 0 1000000000000
RG2 2 0 1000000000000
RG3 3 0 1000000000000
RG4 4 0 1000000000000
RG5 5 0 1000000000000
RG6 6 0 1000000000000
RG7 7 0 1000000000000
RG8 8 0 1000000000000
RG9 9 0 1000000000000
RG10 10 0 1000000000000
RG11 11 0 1000000000000
RG12 12 0 1000000000000
RG13 13 0 1000000000000
RG14 14 0 1000000000000
VS0 14 s0 0
C0 s0 10 18e-7
VS1 0 s1 0
V1 e1 s1 DC 0 AC 27e0 0
RI1 e1 10 68e-3
VS2 13 s2 0
R2 s2 2 22e1
VS3 5 s3 0
C3 s3 7 10e-7
VS4 13 s4 0
C4 s4 11 56e-5
VS5 6 s5 0
R5 s5 7 68e-1
VS6 7 s6 0
V6 e6 s6 DC 0 AC 12e1 -120
RI6 e6 0 10e-2
VS7 14 s7 0
R7 s7 7 22e-2
VS8 11 s8 0
V8 e8 s8 DC 0 AC 10e-1 180
RI8 e8 10 68e-1
VS9 11 s9 0
V9 e9 s9 DC 0 AC 56e0 180
RI9 e9 14 82e-3
VS10 1 s10 0
V10 e10 s10 DC 0 AC 15e0 120
RI10 e10 7 39e-3
VS11 6 s11 0
V11 e11 s11 DC 0 AC 47e0 -120
RI11 e11 4 82e-1
VS12 5 s12 0
R12 s12 12 33e-1
VS13 0 s13 0
V13 e13 s13 DC 0 AC 10e0 120
RI13 e13 1 10e-1
VS14 11 s14 0
R14 s14 9 10e1
VS15 2 s15 0
C15 s15 12 68e-4
VS16 7 s16 0
R16 s16 9 82e0
VS17 13 s17 0
C17 s17 3 12e-4
VS18 13 s18 0
C18 s18 8 56e-7
VS19 12 s19 0
R19 s19 3 39e-1
VS20 4 s20 0
C20 s20 13 47e-4
VS21 8 s21 0
L21 s21 2 47e-5
VS22 5 s22 0
R22 s22 2 56e2
.control
set numdgt=17
ac lin 1 60 60
print v(1) v(2) v(3) v(4) v(5) v(6) v(7) v(8) v(9) v(10)
print v(11) v(12) v(13) v(14)
print i(vs0) i(vs1) i(vs2) i(vs3) i(vs4) i(vs5) i(vs6) i(vs7) i(vs8) i(vs9)
print i(vs10) i(vs11) i(vs12) i(vs13) i(vs14) i(vs15) i(vs16) i(vs17) i(vs18) i(vs19)
print i(vs20) i(vs21) i(vs22)
.endc
.end
