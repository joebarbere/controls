controls oracle ac-0249
* Generated (plan F2.7, ADR 0012): do not edit; regenerate with `pnpm sim oracle regen`. ac seed 20261031 index 249 nodes 15 elements 22
.options sparse gmin=1e-12 noopac
RG1 1 0 1000000000000
RG2 2 0 1000000000000
RG3 3 0 1000000000000
RG4 4 0 1000000000000
RG5 5 0 1000000000000
RG6 6 0 1000000000000
RG7 7 0 1000000000000
RG8 8 0 1000000000000
RG9 9 0 1000000000000
RG10 10 0 1000000000000
RG11 11 0 1000000000000
RG12 12 0 1000000000000
RG13 13 0 1000000000000
RG14 14 0 1000000000000
VS0 0 s0 0
V0 e0 s0 DC 0 AC 10e-1 180
RI0 e0 10 68e-1
VS1 8 s1 0
V1 e1 s1 DC 0 AC 47e0 180
RI1 e1 m1 47e-3
LI1 m1 12 27e-5
VS2 5 s2 0
L2 s2 11 47e-2
VS3 5 s3 0
V3 e3 s3 DC 0 AC 22e-1 120
RI3 e3 4 39e-1
VS4 11 s4 0
C4 s4 7 10e-7
VS5 1 s5 0
V5 e5 s5 DC 0 AC 15e0 120
RI5 e5 m5 39e-3
LI5 m5 7 27e-6
VS6 10 s6 0
R6 s6 3 22e-2
VS7 2 s7 0
R7 s7 3 56e-1
VS8 9 s8 0
L8 s8 11 15e-5
VS9 4 s9 0
L9 s9 8 56e-4
VS10 0 s10 0
C10 s10 2 82e-7
VS11 1 s11 0
R11 s11 4 82e1
VS12 9 s12 0
L12 s12 6 82e-2
VS13 14 s13 0
R13 s13 7 22e-2
VS14 4 s14 0
L14 s14 0 33e-5
VS15 12 s15 0
R15 s15 3 39e-1
VS16 7 s16 0
R16 s16 13 10e1
VS17 11 s17 0
R17 s17 2 56e2
VS18 6 s18 0
L18 s18 14 10e-5
VS19 13 s19 0
C19 s19 0 56e-5
VS20 12 s20 0
R20 s20 7 56e1
VS21 12 s21 0
C21 s21 6 39e-4
.control
set numdgt=17
ac lin 1 60 60
print v(1) v(2) v(3) v(4) v(5) v(6) v(7) v(8) v(9) v(10)
print v(11) v(12) v(13) v(14)
print i(vs0) i(vs1) i(vs2) i(vs3) i(vs4) i(vs5) i(vs6) i(vs7) i(vs8) i(vs9)
print i(vs10) i(vs11) i(vs12) i(vs13) i(vs14) i(vs15) i(vs16) i(vs17) i(vs18) i(vs19)
print i(vs20) i(vs21)
.endc
.end
