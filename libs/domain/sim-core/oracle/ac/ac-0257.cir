controls oracle ac-0257
* Generated (plan F2.7, ADR 0012): do not edit; regenerate with `pnpm sim oracle regen`. ac seed 20261031 index 257 nodes 19 elements 34
.options sparse gmin=1e-12 noopac
RG1 1 0 1000000000000
RG2 2 0 1000000000000
RG3 3 0 1000000000000
RG4 4 0 1000000000000
RG5 5 0 1000000000000
RG6 6 0 1000000000000
RG7 7 0 1000000000000
RG8 8 0 1000000000000
RG9 9 0 1000000000000
RG10 10 0 1000000000000
RG11 11 0 1000000000000
RG12 12 0 1000000000000
RG13 13 0 1000000000000
RG14 14 0 1000000000000
RG15 15 0 1000000000000
RG16 16 0 1000000000000
RG17 17 0 1000000000000
RG18 18 0 1000000000000
VS0 10 s0 0
R0 s0 13 56e-2
VS1 9 s1 0
C1 s1 14 18e-4
VS2 11 s2 0
C2 s2 1 18e-7
VS3 17 s3 0
C3 s3 0 56e-5
VS4 0 s4 0
V4 e4 s4 DC 0 AC 68e0 -120
RI4 e4 18 22e-3
VS5 17 s5 0
L5 s5 18 12e-4
VS6 0 s6 0
V6 e6 s6 DC 0 AC 10e-1 -120
RI6 e6 7 15e-1
VS7 5 s7 0
R7 s7 10 39e1
VS8 14 s8 0
R8 s8 15 10e-2
VS9 6 s9 0
L9 s9 15 10e-3
VS10 14 s10 0
V10 e10 s10 DC 0 AC 12e-1 -120
RI10 e10 1 15e-2
VS11 3 s11 0
V11 e11 s11 DC 0 AC 33e0 0
RI11 e11 9 56e-2
VS12 14 s12 0
C12 s12 6 18e-6
VS13 11 s13 0
L13 s13 16 47e-4
VS14 18 s14 0
R14 s14 8 27e3
VS15 16 s15 0
R15 s15 1 82e1
VS16 8 s16 0
V16 e16 s16 DC 0 AC 10e-1 120
RI16 e16 10 12e-2
VS17 7 s17 0
L17 s17 16 22e-3
VS18 0 s18 0
R18 s18 7 39e-1
VS19 1 s19 0
L19 s19 17 15e-5
VS20 4 s20 0
R20 s20 11 15e-1
VS21 11 s21 0
R21 s21 5 15e2
VS22 14 s22 0
V22 e22 s22 DC 0 AC 15e1 0
RI22 e22 18 22e-2
VS23 11 s23 0
R23 s23 7 27e1
VS24 3 s24 0
R24 s24 6 56e-2
VS25 18 s25 0
V25 e25 s25 DC 0 AC 15e0 180
RI25 e25 16 56e-2
VS26 18 s26 0
C26 s26 10 22e-7
VS27 3 s27 0
L27 s27 13 56e-4
VS28 2 s28 0
V28 e28 s28 DC 0 AC 27e-1 120
RI28 e28 1 10e-1
VS29 12 s29 0
R29 s29 11 68e1
VS30 13 s30 0
R30 s30 6 39e3
VS31 16 s31 0
R31 s31 4 56e0
VS32 12 s32 0
L32 s32 1 12e-2
VS33 15 s33 0
C33 s33 0 82e-5
.control
set numdgt=17
ac lin 1 60 60
print v(1) v(2) v(3) v(4) v(5) v(6) v(7) v(8) v(9) v(10)
print v(11) v(12) v(13) v(14) v(15) v(16) v(17) v(18)
print i(vs0) i(vs1) i(vs2) i(vs3) i(vs4) i(vs5) i(vs6) i(vs7) i(vs8) i(vs9)
print i(vs10) i(vs11) i(vs12) i(vs13) i(vs14) i(vs15) i(vs16) i(vs17) i(vs18) i(vs19)
print i(vs20) i(vs21) i(vs22) i(vs23) i(vs24) i(vs25) i(vs26) i(vs27) i(vs28) i(vs29)
print i(vs30) i(vs31) i(vs32) i(vs33)
.endc
.end
