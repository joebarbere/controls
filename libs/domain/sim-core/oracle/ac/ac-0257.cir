controls oracle ac-0257
* Generated (plan F2.7, ADR 0012): do not edit; regenerate with `pnpm sim oracle regen`. ac seed 20261031 index 257 nodes 19 elements 35
.options sparse gmin=1e-12 noopac
RG1 1 0 1000000000000
RG2 2 0 1000000000000
RG3 3 0 1000000000000
RG4 4 0 1000000000000
RG5 5 0 1000000000000
RG6 6 0 1000000000000
RG7 7 0 1000000000000
RG8 8 0 1000000000000
RG9 9 0 1000000000000
RG10 10 0 1000000000000
RG11 11 0 1000000000000
RG12 12 0 1000000000000
RG13 13 0 1000000000000
RG14 14 0 1000000000000
RG15 15 0 1000000000000
RG16 16 0 1000000000000
RG17 17 0 1000000000000
RG18 18 0 1000000000000
VS0 18 s0 0
R0 s0 8 27e3
VS1 11 s1 0
R1 s1 7 39e-1
VS2 0 s2 0
V2 e2 s2 DC 0 AC 33e0 0
RI2 e2 n2 56e-2
H2 n2 h2 VS6 82e-3
ED2 h2 9 d2 0 10e-7
F2 0 d2 VS6 1
LD2 d2 0 1
VS3 7 s3 0
L3 s3 16 22e-3
VS4 3 s4 0
R4 s4 7 27e1
VS5 14 s5 0
C5 s5 6 18e-6
VS6 18 s6 0
V6 e6 s6 DC 0 AC 15e0 180
RI6 e6 m6 56e-2
LI6 m6 n6 10e-7
H6 n6 h6 VS2 82e-3
ED6 h6 16 d6 0 10e-7
F6 0 d6 VS2 1
LD6 d6 0 1
VS7 18 s7 0
C7 s7 10 22e-7
VS8 16 s8 0
R8 s8 4 56e0
VS9 3 s9 0
R9 s9 5 15e2
VS10 11 s10 0
V10 e10 s10 DC 0 AC 10e-1 -120
RI10 e10 7 15e-1
VS11 3 s11 0
C11 s11 1 18e-7
VS12 14 s12 0
V12 e12 s12 DC 0 AC 15e1 0
RI12 e12 m12 22e-2
LI12 m12 18 39e-6
VS13 6 s13 0
L13 s13 15 10e-3
VS14 14 s14 0
V14 e14 s14 DC 0 AC 12e-1 -120
RI14 e14 m14 15e-2
LI14 m14 1 33e-6
VS15 4 s15 0
R15 s15 3 15e-1
VS16 5 s16 0
R16 s16 10 39e1
VS17 11 s17 0
V17 e17 s17 DC 0 AC 68e0 -120
RI17 e17 18 22e-3
VS18 2 s18 0
C18 s18 9 39e-6
VS19 15 s19 0
C19 s19 11 82e-5
VS20 9 s20 0
C20 s20 14 18e-4
VS21 17 s21 0
C21 s21 11 56e-5
VS22 14 s22 0
R22 s22 15 10e-2
VS23 17 s23 0
L23 s23 18 12e-4
VS24 12 s24 0
L24 s24 1 12e-2
VS25 10 s25 0
R25 s25 13 56e-2
VS26 8 s26 0
V26 e26 s26 DC 0 AC 10e-1 120
RI26 e26 10 12e-2
VS27 12 s27 0
R27 s27 3 68e1
VS28 16 s28 0
R28 s28 1 82e1
VS29 0 s29 0
L29 s29 13 56e-4
VS30 3 s30 0
L30 s30 16 47e-4
VS31 0 s31 0
R31 s31 6 56e-2
VS32 13 s32 0
R32 s32 6 39e3
VS33 1 s33 0
L33 s33 17 15e-5
VS34 2 s34 0
V34 e34 s34 DC 0 AC 27e-1 120
RI34 e34 m34 10e-1
LI34 m34 1 82e-7
.control
set numdgt=17
ac lin 1 60 60
print v(1) v(2) v(3) v(4) v(5) v(6) v(7) v(8) v(9) v(10)
print v(11) v(12) v(13) v(14) v(15) v(16) v(17) v(18)
print i(vs0) i(vs1) i(vs2) i(vs3) i(vs4) i(vs5) i(vs6) i(vs7) i(vs8) i(vs9)
print i(vs10) i(vs11) i(vs12) i(vs13) i(vs14) i(vs15) i(vs16) i(vs17) i(vs18) i(vs19)
print i(vs20) i(vs21) i(vs22) i(vs23) i(vs24) i(vs25) i(vs26) i(vs27) i(vs28) i(vs29)
print i(vs30) i(vs31) i(vs32) i(vs33) i(vs34)
.endc
.end
