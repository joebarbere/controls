controls oracle ac-0118
* Generated (plan F2.7, ADR 0012): do not edit; regenerate with `pnpm sim oracle regen`. ac seed 20261031 index 118 nodes 26 elements 42
.options sparse gmin=1e-12 noopac
RG1 1 0 1000000000000
RG2 2 0 1000000000000
RG3 3 0 1000000000000
RG4 4 0 1000000000000
RG5 5 0 1000000000000
RG6 6 0 1000000000000
RG7 7 0 1000000000000
RG8 8 0 1000000000000
RG9 9 0 1000000000000
RG10 10 0 1000000000000
RG11 11 0 1000000000000
RG12 12 0 1000000000000
RG13 13 0 1000000000000
RG14 14 0 1000000000000
RG15 15 0 1000000000000
RG16 16 0 1000000000000
RG17 17 0 1000000000000
RG18 18 0 1000000000000
RG19 19 0 1000000000000
RG20 20 0 1000000000000
RG21 21 0 1000000000000
RG22 22 0 1000000000000
RG23 23 0 1000000000000
RG24 24 0 1000000000000
RG25 25 0 1000000000000
VS0 1 s0 0
L0 s0 13 33e-4
VS1 14 s1 0
C1 s1 12 18e-6
VS2 3 s2 0
C2 s2 15 15e-7
VS3 19 s3 0
R3 s3 5 56e1
VS4 17 s4 0
L4 s4 12 22e-3
VS5 0 s5 0
V5 e5 s5 DC 0 AC 27e-1 180
RI5 e5 22 56e-3
VS6 24 s6 0
V6 e6 s6 DC 0 AC 22e-1 120
RI6 e6 22 56e-2
VS7 0 s7 0
L7 s7 24 47e-4
VS8 1 s8 0
R8 s8 18 12e0
VS9 23 s9 0
C9 s9 8 10e-7
VS10 1 s10 0
L10 s10 20 68e-2
VS11 10 s11 0
R11 s11 9 10e2
VS12 7 s12 0
R12 s12 2 33e-2
VS13 1 s13 0
L13 s13 9 10e-5
VS14 15 s14 0
R14 s14 0 10e-2
VS15 25 s15 0
C15 s15 16 22e-5
VS16 10 s16 0
C16 s16 23 15e-6
VS17 5 s17 0
R17 s17 7 47e-1
VS18 11 s18 0
R18 s18 8 10e0
VS19 3 s19 0
L19 s19 16 39e-5
VS20 11 s20 0
C20 s20 24 15e-4
VS21 11 s21 0
C21 s21 21 18e-4
VS22 3 s22 0
R22 s22 18 47e-2
VS23 21 s23 0
R23 s23 20 22e-2
VS24 5 s24 0
L24 s24 2 56e-4
VS25 13 s25 0
C25 s25 12 33e-6
VS26 17 s26 0
V26 e26 s26 DC 0 AC 68e-1 180
RI26 e26 m26 27e-1
LI26 m26 7 15e-5
VS27 2 s27 0
V27 e27 s27 DC 0 AC 47e0 0
RI27 e27 10 18e-3
VS28 25 s28 0
C28 s28 21 39e-5
VS29 13 s29 0
L29 s29 11 82e-3
VS30 4 s30 0
R30 s30 1 27e2
VS31 15 s31 0
R31 s31 1 12e2
VS32 6 s32 0
R32 s32 15 12e1
VS33 19 s33 0
R33 s33 24 47e0
VS34 6 s34 0
V34 e34 s34 DC 0 AC 22e1 0
RI34 e34 m34 33e-3
LI34 m34 12 47e-7
VS35 16 s35 0
L35 s35 13 47e-2
VS36 22 s36 0
R36 s36 14 27e3
VS37 24 s37 0
C37 s37 25 56e-4
VS38 0 s38 0
L38 s38 8 27e-4
VS39 0 s39 0
V39 e39 s39 DC 0 AC 47e-1 180
RI39 e39 m39 27e-2
LI39 m39 4 10e-6
VS40 22 s40 0
V40 e40 s40 DC 0 AC 15e0 -120
RI40 e40 12 33e-3
VS41 11 s41 0
V41 e41 s41 DC 0 AC 56e0 0
RI41 e41 m41 68e-2
LI41 m41 5 22e-7
.control
set numdgt=17
ac lin 1 60 60
print v(1) v(2) v(3) v(4) v(5) v(6) v(7) v(8) v(9) v(10)
print v(11) v(12) v(13) v(14) v(15) v(16) v(17) v(18) v(19) v(20)
print v(21) v(22) v(23) v(24) v(25)
print i(vs0) i(vs1) i(vs2) i(vs3) i(vs4) i(vs5) i(vs6) i(vs7) i(vs8) i(vs9)
print i(vs10) i(vs11) i(vs12) i(vs13) i(vs14) i(vs15) i(vs16) i(vs17) i(vs18) i(vs19)
print i(vs20) i(vs21) i(vs22) i(vs23) i(vs24) i(vs25) i(vs26) i(vs27) i(vs28) i(vs29)
print i(vs30) i(vs31) i(vs32) i(vs33) i(vs34) i(vs35) i(vs36) i(vs37) i(vs38) i(vs39)
print i(vs40) i(vs41)
.endc
.end
