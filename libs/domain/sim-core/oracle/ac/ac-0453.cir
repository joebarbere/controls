controls oracle ac-0453
* Generated (plan F2.7, ADR 0012): do not edit; regenerate with `pnpm sim oracle regen`. ac seed 20261031 index 453 nodes 24 elements 44
.options sparse gmin=1e-12 noopac
RG1 1 0 1000000000000
RG2 2 0 1000000000000
RG3 3 0 1000000000000
RG4 4 0 1000000000000
RG5 5 0 1000000000000
RG6 6 0 1000000000000
RG7 7 0 1000000000000
RG8 8 0 1000000000000
RG9 9 0 1000000000000
RG10 10 0 1000000000000
RG11 11 0 1000000000000
RG12 12 0 1000000000000
RG13 13 0 1000000000000
RG14 14 0 1000000000000
RG15 15 0 1000000000000
RG16 16 0 1000000000000
RG17 17 0 1000000000000
RG18 18 0 1000000000000
RG19 19 0 1000000000000
RG20 20 0 1000000000000
RG21 21 0 1000000000000
RG22 22 0 1000000000000
RG23 23 0 1000000000000
VS0 1 s0 0
R0 s0 2 68e0
VS1 0 s1 0
V1 e1 s1 DC 0 AC 68e0 0
RI1 e1 m1 68e-1
LI1 m1 6 68e-6
VS2 10 s2 0
V2 e2 s2 DC 0 AC 33e0 180
RI2 e2 m2 33e-1
LI2 m2 20 82e-7
VS3 9 s3 0
C3 s3 13 27e-4
VS4 22 s4 0
V4 e4 s4 DC 0 AC 56e0 -120
RI4 e4 12 10e-2
VS5 18 s5 0
C5 s5 12 33e-7
VS6 23 s6 0
V6 e6 s6 DC 0 AC 27e0 -120
RI6 e6 m6 82e-2
LI6 m6 20 22e-6
VS7 16 s7 0
L7 s7 9 22e-4
VS8 8 s8 0
V8 e8 s8 DC 0 AC 82e0 0
RI8 e8 m8 47e-1
LI8 m8 18 56e-7
VS9 1 s9 0
R9 s9 20 56e-1
VS10 6 s10 0
L10 s10 13 39e-4
VS11 18 s11 0
L11 s11 10 15e-4
VS12 17 s12 0
L12 s12 5 12e-4
VS13 13 s13 0
V13 e13 s13 DC 0 AC 22e0 0
RI13 e13 m13 12e-3
LI13 m13 18 27e-5
VS14 5 s14 0
C14 s14 21 82e-5
VS15 21 s15 0
C15 s15 8 68e-6
VS16 20 s16 0
V16 e16 s16 DC 0 AC 56e1 0
RI16 e16 11 10e-3
VS17 9 s17 0
C17 s17 1 33e-5
VS18 15 s18 0
R18 s18 7 82e-1
VS19 3 s19 0
C19 s19 10 12e-7
VS20 15 s20 0
L20 s20 16 47e-5
VS21 21 s21 0
L21 s21 6 15e-3
VS22 21 s22 0
R22 s22 11 33e-2
VS23 12 s23 0
L23 s23 9 82e-3
VS24 4 s24 0
C24 s24 12 56e-5
VS25 2 s25 0
R25 s25 17 56e2
VS26 13 s26 0
C26 s26 23 18e-7
VS27 10 s27 0
C27 s27 12 12e-6
VS28 6 s28 0
C28 s28 7 18e-6
VS29 12 s29 0
R29 s29 3 12e3
VS30 14 s30 0
R30 s30 1 68e-2
VS31 19 s31 0
R31 s31 11 56e0
VS32 2 s32 0
L32 s32 16 68e-3
VS33 13 s33 0
R33 s33 22 22e-1
VS34 5 s34 0
R34 s34 12 18e3
VS35 14 s35 0
V35 e35 s35 DC 0 AC 33e-1 -120
RI35 e35 m35 10e-3
LI35 m35 5 47e-7
VS36 4 s36 0
C36 s36 19 68e-7
VS37 3 s37 0
L37 s37 14 82e-2
VS38 19 s38 0
R38 s38 14 82e0
VS39 20 s39 0
C39 s39 0 68e-4
VS40 0 s40 0
R40 s40 14 47e-1
VS41 1 s41 0
L41 s41 4 10e-3
VS42 18 s42 0
L42 s42 17 18e-3
VS43 19 s43 0
L43 s43 23 39e-4
.control
set numdgt=17
ac lin 1 60 60
print v(1) v(2) v(3) v(4) v(5) v(6) v(7) v(8) v(9) v(10)
print v(11) v(12) v(13) v(14) v(15) v(16) v(17) v(18) v(19) v(20)
print v(21) v(22) v(23)
print i(vs0) i(vs1) i(vs2) i(vs3) i(vs4) i(vs5) i(vs6) i(vs7) i(vs8) i(vs9)
print i(vs10) i(vs11) i(vs12) i(vs13) i(vs14) i(vs15) i(vs16) i(vs17) i(vs18) i(vs19)
print i(vs20) i(vs21) i(vs22) i(vs23) i(vs24) i(vs25) i(vs26) i(vs27) i(vs28) i(vs29)
print i(vs30) i(vs31) i(vs32) i(vs33) i(vs34) i(vs35) i(vs36) i(vs37) i(vs38) i(vs39)
print i(vs40) i(vs41) i(vs42) i(vs43)
.endc
.end
