controls oracle ac-0453
* Generated (plan F2.7, ADR 0012): do not edit; regenerate with `pnpm sim oracle regen`. ac seed 20261031 index 453 nodes 24 elements 32
.options sparse gmin=1e-12 noopac
RG1 1 0 1000000000000
RG2 2 0 1000000000000
RG3 3 0 1000000000000
RG4 4 0 1000000000000
RG5 5 0 1000000000000
RG6 6 0 1000000000000
RG7 7 0 1000000000000
RG8 8 0 1000000000000
RG9 9 0 1000000000000
RG10 10 0 1000000000000
RG11 11 0 1000000000000
RG12 12 0 1000000000000
RG13 13 0 1000000000000
RG14 14 0 1000000000000
RG15 15 0 1000000000000
RG16 16 0 1000000000000
RG17 17 0 1000000000000
RG18 18 0 1000000000000
RG19 19 0 1000000000000
RG20 20 0 1000000000000
RG21 21 0 1000000000000
RG22 22 0 1000000000000
RG23 23 0 1000000000000
VS0 3 s0 0
R0 s0 12 10e2
VS1 12 s1 0
L1 s1 17 82e-3
VS2 14 s2 0
C2 s2 17 47e-6
VS3 6 s3 0
R3 s3 20 82e-2
VS4 0 s4 0
V4 e4 s4 DC 0 AC 39e1 180
RI4 e4 m4 27e-3
LI4 m4 n4 82e-5
H4 n4 h4 VS13 27e-4
ED4 h4 21 d4 0 -47e-7
F4 0 d4 VS13 1
LD4 d4 0 1
VS5 17 s5 0
R5 s5 18 18e1
VS6 21 s6 0
L6 s6 3 33e-4
VS7 15 s7 0
R7 s7 7 68e0
VS8 1 s8 0
L8 s8 22 15e-2
VS9 16 s9 0
C9 s9 21 22e-4
VS10 18 s10 0
R10 s10 13 82e-1
VS11 0 s11 0
R11 s11 9 12e-2
VS12 2 s12 0
L12 s12 11 18e-4
VS13 7 s13 0
V13 e13 s13 DC 0 AC 27e-1 0
RI13 e13 n13 22e-1
H13 n13 h13 VS4 27e-4
ED13 h13 23 d13 0 -47e-7
F13 0 d13 VS4 1
LD13 d13 0 1
VS14 4 s14 0
L14 s14 18 82e-3
VS15 4 s15 0
V15 e15 s15 DC 0 AC 15e-1 180
RI15 e15 15 47e-3
VS16 9 s16 0
R16 s16 16 18e0
VS17 23 s17 0
L17 s17 20 10e-5
VS18 1 s18 0
L18 s18 5 22e-5
VS19 14 s19 0
L19 s19 13 47e-4
VS20 18 s20 0
V20 e20 s20 DC 0 AC 33e-1 -120
RI20 e20 5 10e-3
VS21 10 s21 0
R21 s21 8 68e-2
VS22 17 s22 0
R22 s22 20 22e3
VS23 5 s23 0
L23 s23 2 12e-2
VS24 21 s24 0
R24 s24 1 82e-1
VS25 19 s25 0
L25 s25 22 10e-3
VS26 19 s26 0
R26 s26 5 47e-2
VS27 8 s27 0
L27 s27 20 82e-2
VS28 6 s28 0
C28 s28 15 39e-6
VS29 22 s29 0
R29 s29 7 18e1
VS30 9 s30 0
C30 s30 3 82e-7
VS31 11 s31 0
C31 s31 10 15e-7
.control
set numdgt=17
ac lin 1 60 60
print v(1) v(2) v(3) v(4) v(5) v(6) v(7) v(8) v(9) v(10)
print v(11) v(12) v(13) v(14) v(15) v(16) v(17) v(18) v(19) v(20)
print v(21) v(22) v(23)
print i(vs0) i(vs1) i(vs2) i(vs3) i(vs4) i(vs5) i(vs6) i(vs7) i(vs8) i(vs9)
print i(vs10) i(vs11) i(vs12) i(vs13) i(vs14) i(vs15) i(vs16) i(vs17) i(vs18) i(vs19)
print i(vs20) i(vs21) i(vs22) i(vs23) i(vs24) i(vs25) i(vs26) i(vs27) i(vs28) i(vs29)
print i(vs30) i(vs31)
.endc
.end
