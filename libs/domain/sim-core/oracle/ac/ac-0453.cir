controls oracle ac-0453
* Generated (plan F2.7, ADR 0012): do not edit; regenerate with `pnpm sim oracle regen`. ac seed 20261031 index 453 nodes 24 elements 27
.options sparse gmin=1e-12 noopac
RG1 1 0 1000000000000
RG2 2 0 1000000000000
RG3 3 0 1000000000000
RG4 4 0 1000000000000
RG5 5 0 1000000000000
RG6 6 0 1000000000000
RG7 7 0 1000000000000
RG8 8 0 1000000000000
RG9 9 0 1000000000000
RG10 10 0 1000000000000
RG11 11 0 1000000000000
RG12 12 0 1000000000000
RG13 13 0 1000000000000
RG14 14 0 1000000000000
RG15 15 0 1000000000000
RG16 16 0 1000000000000
RG17 17 0 1000000000000
RG18 18 0 1000000000000
RG19 19 0 1000000000000
RG20 20 0 1000000000000
RG21 21 0 1000000000000
RG22 22 0 1000000000000
RG23 23 0 1000000000000
VS0 19 s0 0
L0 s0 22 10e-3
VS1 22 s1 0
R1 s1 7 18e1
VS2 1 s2 0
L2 s2 5 22e-5
VS3 6 s3 0
R3 s3 20 82e-2
VS4 0 s4 0
R4 s4 9 12e-2
VS5 5 s5 0
L5 s5 2 12e-2
VS6 15 s6 0
R6 s6 7 68e0
VS7 21 s7 0
L7 s7 3 33e-4
VS8 8 s8 0
L8 s8 20 82e-2
VS9 19 s9 0
R9 s9 5 47e-2
VS10 16 s10 0
C10 s10 21 22e-4
VS11 0 s11 0
V11 e11 s11 DC 0 AC 39e1 180
RI11 e11 21 27e-3
VS12 11 s12 0
C12 s12 10 15e-7
VS13 17 s13 0
R13 s13 18 18e1
VS14 6 s14 0
C14 s14 15 39e-6
VS15 18 s15 0
V15 e15 s15 DC 0 AC 33e-1 -120
RI15 e15 5 10e-3
VS16 17 s16 0
R16 s16 20 22e3
VS17 10 s17 0
R17 s17 8 68e-2
VS18 4 s18 0
L18 s18 18 82e-3
VS19 18 s19 0
R19 s19 13 82e-1
VS20 3 s20 0
R20 s20 12 10e2
VS21 9 s21 0
R21 s21 16 18e0
VS22 12 s22 0
L22 s22 17 82e-3
VS23 14 s23 0
L23 s23 13 47e-4
VS24 1 s24 0
L24 s24 22 15e-2
VS25 23 s25 0
L25 s25 20 10e-5
VS26 21 s26 0
R26 s26 1 82e-1
.control
set numdgt=17
ac lin 1 60 60
print v(1) v(2) v(3) v(4) v(5) v(6) v(7) v(8) v(9) v(10)
print v(11) v(12) v(13) v(14) v(15) v(16) v(17) v(18) v(19) v(20)
print v(21) v(22) v(23)
print i(vs0) i(vs1) i(vs2) i(vs3) i(vs4) i(vs5) i(vs6) i(vs7) i(vs8) i(vs9)
print i(vs10) i(vs11) i(vs12) i(vs13) i(vs14) i(vs15) i(vs16) i(vs17) i(vs18) i(vs19)
print i(vs20) i(vs21) i(vs22) i(vs23) i(vs24) i(vs25) i(vs26)
.endc
.end
