controls oracle ac-0100
* Generated (plan F2.7, ADR 0012): do not edit; regenerate with `pnpm sim oracle regen`. ac seed 20261031 index 100 nodes 4 elements 5
.options sparse gmin=1e-12 noopac
RG1 1 0 1000000000000
RG2 2 0 1000000000000
RG3 3 0 1000000000000
VS0 2 s0 0
C0 s0 0 10e-7
VS1 0 s1 0
V1 e1 s1 DC 0 AC 18e-1 -120
RI1 e1 m1 10e-3
LI1 m1 1 10e-6
VS2 0 s2 0
L2 s2 3 56e-4
VS3 1 s3 0
C3 s3 3 10e-6
VS4 3 s4 0
R4 s4 2 22e1
.control
set numdgt=17
ac lin 1 60 60
print v(1) v(2) v(3)
print i(vs0) i(vs1) i(vs2) i(vs3) i(vs4)
.endc
.end
