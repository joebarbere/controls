controls oracle ac-0100
* Generated (plan F2.7, ADR 0012): do not edit; regenerate with `pnpm sim oracle regen`. ac seed 20261031 index 100 nodes 4 elements 5
.options sparse gmin=1e-12 noopac
RG1 1 0 1000000000000
RG2 2 0 1000000000000
RG3 3 0 1000000000000
VS0 2 s0 0
C0 s0 0 10e-7
VS1 1 s1 0
C1 s1 3 10e-6
VS2 0 s2 0
V2 e2 s2 DC 0 AC 18e-1 -120
RI2 e2 1 10e-3
VS3 0 s3 0
L3 s3 3 56e-4
VS4 2 s4 0
L4 s4 1 56e-4
.control
set numdgt=17
ac lin 1 60 60
print v(1) v(2) v(3)
print i(vs0) i(vs1) i(vs2) i(vs3) i(vs4)
.endc
.end
