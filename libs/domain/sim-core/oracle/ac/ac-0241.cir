controls oracle ac-0241
* Generated (plan F2.7, ADR 0012): do not edit; regenerate with `pnpm sim oracle regen`. ac seed 20261031 index 241 nodes 30 elements 50
.options sparse gmin=1e-12 noopac
RG1 1 0 1000000000000
RG2 2 0 1000000000000
RG3 3 0 1000000000000
RG4 4 0 1000000000000
RG5 5 0 1000000000000
RG6 6 0 1000000000000
RG7 7 0 1000000000000
RG8 8 0 1000000000000
RG9 9 0 1000000000000
RG10 10 0 1000000000000
RG11 11 0 1000000000000
RG12 12 0 1000000000000
RG13 13 0 1000000000000
RG14 14 0 1000000000000
RG15 15 0 1000000000000
RG16 16 0 1000000000000
RG17 17 0 1000000000000
RG18 18 0 1000000000000
RG19 19 0 1000000000000
RG20 20 0 1000000000000
RG21 21 0 1000000000000
RG22 22 0 1000000000000
RG23 23 0 1000000000000
RG24 24 0 1000000000000
RG25 25 0 1000000000000
RG26 26 0 1000000000000
RG27 27 0 1000000000000
RG28 28 0 1000000000000
RG29 29 0 1000000000000
VS0 0 s0 0
V0 e0 s0 DC 0 AC 15e-1 180
RI0 e0 m0 18e-1
LI0 m0 n0 82e-7
H0 n0 h0 VS13 68e-3
ED0 h0 8 d0 0 -22e-7
F0 0 d0 VS13 1
LD0 d0 0 1
VS1 18 s1 0
R1 s1 6 68e-1
VS2 28 s2 0
L2 s2 17 10e-4
VS3 18 s3 0
C3 s3 13 15e-7
VS4 1 s4 0
C4 s4 12 18e-4
VS5 5 s5 0
R5 s5 9 47e2
VS6 11 s6 0
C6 s6 9 56e-7
VS7 26 s7 0
R7 s7 25 27e0
VS8 25 s8 0
L8 s8 19 68e-3
VS9 20 s9 0
C9 s9 14 56e-6
VS10 19 s10 0
C10 s10 5 10e-5
VS11 19 s11 0
L11 s11 0 15e-5
VS12 6 s12 0
L12 s12 0 27e-5
VS13 27 s13 0
V13 e13 s13 DC 0 AC 47e-1 -120
RI13 e13 n13 39e-2
H13 n13 h13 VS0 68e-3
ED13 h13 1 d13 0 -22e-7
F13 0 d13 VS0 1
LD13 d13 0 1
VS14 10 s14 0
L14 s14 16 33e-2
VS15 28 s15 0
R15 s15 25 15e-1
VS16 3 s16 0
R16 s16 11 68e0
VS17 18 s17 0
R17 s17 19 10e3
VS18 14 s18 0
V18 e18 s18 DC 0 AC 22e0 120
RI18 e18 13 33e-3
VS19 23 s19 0
C19 s19 22 33e-5
VS20 2 s20 0
R20 s20 15 12e-1
VS21 7 s21 0
V21 e21 s21 DC 0 AC 82e0 -120
RI21 e21 m21 68e-1
LI21 m21 3 39e-6
VS22 26 s22 0
R22 s22 22 10e1
VS23 28 s23 0
C23 s23 17 15e-5
VS24 29 s24 0
C24 s24 20 47e-4
VS25 28 s25 0
V25 e25 s25 DC 0 AC 12e0 120
RI25 e25 13 68e-1
VS26 18 s26 0
R26 s26 1 47e-1
VS27 21 s27 0
R27 s27 20 82e-2
VS28 9 s28 0
L28 s28 23 12e-4
VS29 23 s29 0
L29 s29 18 56e-3
VS30 14 s30 0
L30 s30 9 33e-5
VS31 4 s31 0
R31 s31 1 82e3
VS32 28 s32 0
R32 s32 9 56e0
VS33 11 s33 0
C33 s33 28 82e-4
VS34 16 s34 0
C34 s34 12 12e-7
VS35 9 s35 0
L35 s35 17 82e-5
VS36 15 s36 0
R36 s36 13 12e0
VS37 27 s37 0
V37 e37 s37 DC 0 AC 15e1 -120
RI37 e37 2 27e-3
VS38 18 s38 0
V38 e38 s38 DC 0 AC 47e1 -120
RI38 e38 4 27e-3
VS39 17 s39 0
C39 s39 13 12e-7
VS40 8 s40 0
L40 s40 17 33e-4
VS41 15 s41 0
C41 s41 16 27e-5
VS42 13 s42 0
V42 e42 s42 DC 0 AC 22e1 0
RI42 e42 m42 15e-1
LI42 m42 24 27e-5
VS43 6 s43 0
R43 s43 1 47e0
VS44 1 s44 0
R44 s44 24 68e-2
VS45 7 s45 0
L45 s45 27 47e-4
VS46 10 s46 0
C46 s46 1 10e-5
VS47 29 s47 0
R47 s47 11 18e0
VS48 28 s48 0
V48 e48 s48 DC 0 AC 56e-1 -120
RI48 e48 m48 56e-1
LI48 m48 21 68e-6
VS49 15 s49 0
C49 s49 26 47e-6
.control
set numdgt=17
ac lin 1 60 60
print v(1) v(2) v(3) v(4) v(5) v(6) v(7) v(8) v(9) v(10)
print v(11) v(12) v(13) v(14) v(15) v(16) v(17) v(18) v(19) v(20)
print v(21) v(22) v(23) v(24) v(25) v(26) v(27) v(28) v(29)
print i(vs0) i(vs1) i(vs2) i(vs3) i(vs4) i(vs5) i(vs6) i(vs7) i(vs8) i(vs9)
print i(vs10) i(vs11) i(vs12) i(vs13) i(vs14) i(vs15) i(vs16) i(vs17) i(vs18) i(vs19)
print i(vs20) i(vs21) i(vs22) i(vs23) i(vs24) i(vs25) i(vs26) i(vs27) i(vs28) i(vs29)
print i(vs30) i(vs31) i(vs32) i(vs33) i(vs34) i(vs35) i(vs36) i(vs37) i(vs38) i(vs39)
print i(vs40) i(vs41) i(vs42) i(vs43) i(vs44) i(vs45) i(vs46) i(vs47) i(vs48) i(vs49)
.endc
.end
