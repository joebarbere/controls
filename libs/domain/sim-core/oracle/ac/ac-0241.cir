controls oracle ac-0241
* Generated (plan F2.7, ADR 0012): do not edit; regenerate with `pnpm sim oracle regen`. ac seed 20261031 index 241 nodes 30 elements 46
.options sparse gmin=1e-12 noopac
RG1 1 0 1000000000000
RG2 2 0 1000000000000
RG3 3 0 1000000000000
RG4 4 0 1000000000000
RG5 5 0 1000000000000
RG6 6 0 1000000000000
RG7 7 0 1000000000000
RG8 8 0 1000000000000
RG9 9 0 1000000000000
RG10 10 0 1000000000000
RG11 11 0 1000000000000
RG12 12 0 1000000000000
RG13 13 0 1000000000000
RG14 14 0 1000000000000
RG15 15 0 1000000000000
RG16 16 0 1000000000000
RG17 17 0 1000000000000
RG18 18 0 1000000000000
RG19 19 0 1000000000000
RG20 20 0 1000000000000
RG21 21 0 1000000000000
RG22 22 0 1000000000000
RG23 23 0 1000000000000
RG24 24 0 1000000000000
RG25 25 0 1000000000000
RG26 26 0 1000000000000
RG27 27 0 1000000000000
RG28 28 0 1000000000000
RG29 29 0 1000000000000
VS0 11 s0 0
C0 s0 27 56e-7
VS1 5 s1 0
R1 s1 27 47e2
VS2 23 s2 0
C2 s2 22 33e-5
VS3 0 s3 0
V3 e3 s3 DC 0 AC 47e-1 -120
RI3 e3 1 39e-2
VS4 28 s4 0
L4 s4 17 10e-4
VS5 6 s5 0
R5 s5 1 47e0
VS6 27 s6 0
L6 s6 17 82e-5
VS7 23 s7 0
L7 s7 18 56e-3
VS8 18 s8 0
R8 s8 6 68e-1
VS9 7 s9 0
L9 s9 0 47e-4
VS10 17 s10 0
C10 s10 13 12e-7
VS11 29 s11 0
C11 s11 20 47e-4
VS12 15 s12 0
R12 s12 13 12e0
VS13 29 s13 0
R13 s13 11 18e0
VS14 18 s14 0
V14 e14 s14 DC 0 AC 47e1 -120
RI14 e14 4 27e-3
VS15 18 s15 0
R15 s15 19 10e3
VS16 25 s16 0
L16 s16 19 68e-3
VS17 14 s17 0
L17 s17 27 33e-5
VS18 18 s18 0
R18 s18 1 47e-1
VS19 1 s19 0
C19 s19 12 18e-4
VS20 28 s20 0
R20 s20 25 15e-1
VS21 19 s21 0
L21 s21 9 15e-5
VS22 15 s22 0
C22 s22 16 27e-5
VS23 14 s23 0
V23 e23 s23 DC 0 AC 22e0 120
RI23 e23 13 33e-3
VS24 21 s24 0
R24 s24 20 82e-2
VS25 28 s25 0
R25 s25 27 56e0
VS26 20 s26 0
C26 s26 14 56e-6
VS27 26 s27 0
R27 s27 25 27e0
VS28 27 s28 0
L28 s28 23 12e-4
VS29 8 s29 0
L29 s29 17 33e-4
VS30 11 s30 0
C30 s30 28 82e-4
VS31 0 s31 0
V31 e31 s31 DC 0 AC 15e1 -120
RI31 e31 2 27e-3
VS32 7 s32 0
V32 e32 s32 DC 0 AC 82e0 -120
RI32 e32 3 68e-1
VS33 28 s33 0
V33 e33 s33 DC 0 AC 56e-1 -120
RI33 e33 21 56e-1
VS34 10 s34 0
L34 s34 16 33e-2
VS35 18 s35 0
C35 s35 13 15e-7
VS36 28 s36 0
V36 e36 s36 DC 0 AC 12e0 120
RI36 e36 13 68e-1
VS37 3 s37 0
R37 s37 11 68e0
VS38 15 s38 0
C38 s38 26 47e-6
VS39 28 s39 0
C39 s39 17 15e-5
VS40 10 s40 0
C40 s40 1 10e-5
VS41 26 s41 0
R41 s41 22 10e1
VS42 2 s42 0
R42 s42 15 12e-1
VS43 6 s43 0
L43 s43 9 27e-5
VS44 4 s44 0
R44 s44 1 82e3
VS45 1 s45 0
R45 s45 24 68e-2
.control
set numdgt=17
ac lin 1 60 60
print v(1) v(2) v(3) v(4) v(5) v(6) v(7) v(8) v(9) v(10)
print v(11) v(12) v(13) v(14) v(15) v(16) v(17) v(18) v(19) v(20)
print v(21) v(22) v(23) v(24) v(25) v(26) v(27) v(28) v(29)
print i(vs0) i(vs1) i(vs2) i(vs3) i(vs4) i(vs5) i(vs6) i(vs7) i(vs8) i(vs9)
print i(vs10) i(vs11) i(vs12) i(vs13) i(vs14) i(vs15) i(vs16) i(vs17) i(vs18) i(vs19)
print i(vs20) i(vs21) i(vs22) i(vs23) i(vs24) i(vs25) i(vs26) i(vs27) i(vs28) i(vs29)
print i(vs30) i(vs31) i(vs32) i(vs33) i(vs34) i(vs35) i(vs36) i(vs37) i(vs38) i(vs39)
print i(vs40) i(vs41) i(vs42) i(vs43) i(vs44) i(vs45)
.endc
.end
