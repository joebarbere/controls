controls oracle ac-0241
* Generated (plan F2.7, ADR 0012): do not edit; regenerate with `pnpm sim oracle regen`. ac seed 20261031 index 241 nodes 30 elements 60
.options sparse gmin=1e-12 noopac
RG1 1 0 1000000000000
RG2 2 0 1000000000000
RG3 3 0 1000000000000
RG4 4 0 1000000000000
RG5 5 0 1000000000000
RG6 6 0 1000000000000
RG7 7 0 1000000000000
RG8 8 0 1000000000000
RG9 9 0 1000000000000
RG10 10 0 1000000000000
RG11 11 0 1000000000000
RG12 12 0 1000000000000
RG13 13 0 1000000000000
RG14 14 0 1000000000000
RG15 15 0 1000000000000
RG16 16 0 1000000000000
RG17 17 0 1000000000000
RG18 18 0 1000000000000
RG19 19 0 1000000000000
RG20 20 0 1000000000000
RG21 21 0 1000000000000
RG22 22 0 1000000000000
RG23 23 0 1000000000000
RG24 24 0 1000000000000
RG25 25 0 1000000000000
RG26 26 0 1000000000000
RG27 27 0 1000000000000
RG28 28 0 1000000000000
RG29 29 0 1000000000000
VS0 11 s0 0
L0 s0 28 10e-5
VS1 22 s1 0
L1 s1 15 68e-2
VS2 1 s2 0
C2 s2 17 39e-4
VS3 25 s3 0
C3 s3 13 47e-4
VS4 17 s4 0
C4 s4 21 33e-7
VS5 3 s5 0
R5 s5 16 10e1
VS6 4 s6 0
R6 s6 14 22e-2
VS7 20 s7 0
C7 s7 14 56e-5
VS8 14 s8 0
R8 s8 5 82e-2
VS9 12 s9 0
C9 s9 6 22e-5
VS10 11 s10 0
L10 s10 10 27e-3
VS11 27 s11 0
R11 s11 17 39e-2
VS12 7 s12 0
L12 s12 11 33e-2
VS13 1 s13 0
L13 s13 25 10e-3
VS14 4 s14 0
R14 s14 3 82e-2
VS15 28 s15 0
R15 s15 22 15e-2
VS16 11 s16 0
C16 s16 24 56e-7
VS17 5 s17 0
L17 s17 3 27e-2
VS18 17 s18 0
C18 s18 27 15e-5
VS19 3 s19 0
C19 s19 24 82e-7
VS20 0 s20 0
V20 e20 s20 DC 0 AC 82e-1 -120
RI20 e20 11 39e-1
VS21 28 s21 0
V21 e21 s21 DC 0 AC 15e1 180
RI21 e21 29 27e-3
VS22 28 s22 0
C22 s22 27 68e-6
VS23 16 s23 0
R23 s23 1 27e2
VS24 23 s24 0
C24 s24 26 10e-4
VS25 19 s25 0
V25 e25 s25 DC 0 AC 12e0 120
RI25 e25 m25 68e-1
LI25 m25 23 47e-6
VS26 8 s26 0
R26 s26 12 15e2
VS27 19 s27 0
R27 s27 22 68e3
VS28 12 s28 0
L28 s28 15 22e-2
VS29 8 s29 0
C29 s29 12 27e-7
VS30 5 s30 0
V30 e30 s30 DC 0 AC 18e-1 -120
RI30 e30 m30 39e-3
LI30 m30 10 12e-5
VS31 24 s31 0
R31 s31 15 82e-2
VS32 8 s32 0
V32 e32 s32 DC 0 AC 27e-1 0
RI32 e32 11 10e-2
VS33 29 s33 0
L33 s33 20 33e-4
VS34 26 s34 0
V34 e34 s34 DC 0 AC 82e1 120
RI34 e34 20 27e-2
VS35 29 s35 0
R35 s35 9 12e-2
VS36 24 s36 0
R36 s36 3 47e1
VS37 2 s37 0
L37 s37 27 56e-2
VS38 15 s38 0
R38 s38 14 15e3
VS39 21 s39 0
C39 s39 12 12e-7
VS40 3 s40 0
C40 s40 0 10e-7
VS41 18 s41 0
L41 s41 16 47e-5
VS42 24 s42 0
R42 s42 1 39e-2
VS43 9 s43 0
C43 s43 3 22e-4
VS44 15 s44 0
R44 s44 5 10e3
VS45 12 s45 0
R45 s45 17 15e1
VS46 3 s46 0
L46 s46 14 47e-3
VS47 6 s47 0
L47 s47 15 15e-5
VS48 2 s48 0
V48 e48 s48 DC 0 AC 68e-1 120
RI48 e48 1 15e-3
VS49 21 s49 0
C49 s49 4 47e-5
VS50 7 s50 0
R50 s50 0 47e3
VS51 14 s51 0
L51 s51 24 33e-5
VS52 13 s52 0
R52 s52 11 18e3
VS53 2 s53 0
L53 s53 13 39e-3
VS54 20 s54 0
C54 s54 13 39e-6
VS55 10 s55 0
C55 s55 28 10e-5
VS56 12 s56 0
C56 s56 18 27e-7
VS57 2 s57 0
R57 s57 18 22e-1
VS58 14 s58 0
V58 e58 s58 DC 0 AC 22e0 120
RI58 e58 13 33e-3
VS59 23 s59 0
V59 e59 s59 DC 0 AC 33e1 180
RI59 e59 13 15e-2
.control
set numdgt=17
ac lin 1 60 60
print v(1) v(2) v(3) v(4) v(5) v(6) v(7) v(8) v(9) v(10)
print v(11) v(12) v(13) v(14) v(15) v(16) v(17) v(18) v(19) v(20)
print v(21) v(22) v(23) v(24) v(25) v(26) v(27) v(28) v(29)
print i(vs0) i(vs1) i(vs2) i(vs3) i(vs4) i(vs5) i(vs6) i(vs7) i(vs8) i(vs9)
print i(vs10) i(vs11) i(vs12) i(vs13) i(vs14) i(vs15) i(vs16) i(vs17) i(vs18) i(vs19)
print i(vs20) i(vs21) i(vs22) i(vs23) i(vs24) i(vs25) i(vs26) i(vs27) i(vs28) i(vs29)
print i(vs30) i(vs31) i(vs32) i(vs33) i(vs34) i(vs35) i(vs36) i(vs37) i(vs38) i(vs39)
print i(vs40) i(vs41) i(vs42) i(vs43) i(vs44) i(vs45) i(vs46) i(vs47) i(vs48) i(vs49)
print i(vs50) i(vs51) i(vs52) i(vs53) i(vs54) i(vs55) i(vs56) i(vs57) i(vs58) i(vs59)
.endc
.end
