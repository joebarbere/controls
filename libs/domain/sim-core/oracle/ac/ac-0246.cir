controls oracle ac-0246
* Generated (plan F2.7, ADR 0012): do not edit; regenerate with `pnpm sim oracle regen`. ac seed 20261031 index 246 nodes 24 elements 37
.options sparse gmin=1e-12 noopac
RG1 1 0 1000000000000
RG2 2 0 1000000000000
RG3 3 0 1000000000000
RG4 4 0 1000000000000
RG5 5 0 1000000000000
RG6 6 0 1000000000000
RG7 7 0 1000000000000
RG8 8 0 1000000000000
RG9 9 0 1000000000000
RG10 10 0 1000000000000
RG11 11 0 1000000000000
RG12 12 0 1000000000000
RG13 13 0 1000000000000
RG14 14 0 1000000000000
RG15 15 0 1000000000000
RG16 16 0 1000000000000
RG17 17 0 1000000000000
RG18 18 0 1000000000000
RG19 19 0 1000000000000
RG20 20 0 1000000000000
RG21 21 0 1000000000000
RG22 22 0 1000000000000
RG23 23 0 1000000000000
VS0 4 s0 0
C0 s0 10 15e-4
VS1 0 s1 0
V1 e1 s1 DC 0 AC 15e0 -120
RI1 e1 m1 39e-3
LI1 m1 n1 47e-6
H1 n1 h1 VS2 -33e-4
ED1 h1 3 d1 0 18e-5
F1 0 d1 VS2 1
LD1 d1 0 1
VS2 13 s2 0
V2 e2 s2 DC 0 AC 12e-1 -120
RI2 e2 m2 12e-3
LI2 m2 n2 39e-6
H2 n2 h2 VS1 -33e-4
ED2 h2 22 d2 0 18e-5
F2 0 d2 VS1 1
LD2 d2 0 1
VS3 5 s3 0
C3 s3 1 56e-4
VS4 23 s4 0
R4 s4 21 47e0
VS5 18 s5 0
L5 s5 2 22e-5
VS6 12 s6 0
R6 s6 6 82e3
VS7 14 s7 0
L7 s7 16 27e-5
VS8 17 s8 0
V8 e8 s8 DC 0 AC 22e1 180
RI8 e8 9 15e-2
VS9 13 s9 0
V9 e9 s9 DC 0 AC 10e1 0
RI9 e9 14 10e-1
VS10 13 s10 0
V10 e10 s10 DC 0 AC 33e-1 0
RI10 e10 15 27e-3
VS11 21 s11 0
R11 s11 9 82e2
VS12 10 s12 0
L12 s12 19 10e-4
VS13 8 s13 0
R13 s13 5 39e2
VS14 22 s14 0
L14 s14 11 10e-3
VS15 19 s15 0
L15 s15 8 56e-4
VS16 13 s16 0
V16 e16 s16 DC 0 AC 12e-1 180
RI16 e16 19 15e-2
VS17 10 s17 0
L17 s17 23 68e-5
VS18 0 s18 0
V18 e18 s18 DC 0 AC 47e0 180
RI18 e18 1 68e-2
VS19 19 s19 0
R19 s19 23 27e1
VS20 17 s20 0
L20 s20 13 27e-2
VS21 12 s21 0
L21 s21 0 18e-3
VS22 19 s22 0
L22 s22 11 22e-5
VS23 20 s23 0
C23 s23 5 39e-4
VS24 22 s24 0
R24 s24 6 47e-1
VS25 13 s25 0
L25 s25 5 39e-2
VS26 2 s26 0
L26 s26 4 10e-3
VS27 10 s27 0
C27 s27 6 22e-4
VS28 15 s28 0
L28 s28 22 22e-3
VS29 18 s29 0
L29 s29 10 12e-5
VS30 11 s30 0
R30 s30 7 47e2
VS31 6 s31 0
C31 s31 10 47e-7
VS32 11 s32 0
L32 s32 16 12e-5
VS33 7 s33 0
R33 s33 4 12e-2
VS34 13 s34 0
L34 s34 0 18e-4
VS35 3 s35 0
R35 s35 12 22e-1
VS36 19 s36 0
C36 s36 20 56e-7
.control
set numdgt=17
ac lin 1 60 60
print v(1) v(2) v(3) v(4) v(5) v(6) v(7) v(8) v(9) v(10)
print v(11) v(12) v(13) v(14) v(15) v(16) v(17) v(18) v(19) v(20)
print v(21) v(22) v(23)
print i(vs0) i(vs1) i(vs2) i(vs3) i(vs4) i(vs5) i(vs6) i(vs7) i(vs8) i(vs9)
print i(vs10) i(vs11) i(vs12) i(vs13) i(vs14) i(vs15) i(vs16) i(vs17) i(vs18) i(vs19)
print i(vs20) i(vs21) i(vs22) i(vs23) i(vs24) i(vs25) i(vs26) i(vs27) i(vs28) i(vs29)
print i(vs30) i(vs31) i(vs32) i(vs33) i(vs34) i(vs35) i(vs36)
.endc
.end
