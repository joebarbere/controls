controls oracle ac-0246
* Generated (plan F2.7, ADR 0012): do not edit; regenerate with `pnpm sim oracle regen`. ac seed 20261031 index 246 nodes 24 elements 47
.options sparse gmin=1e-12 noopac
RG1 1 0 1000000000000
RG2 2 0 1000000000000
RG3 3 0 1000000000000
RG4 4 0 1000000000000
RG5 5 0 1000000000000
RG6 6 0 1000000000000
RG7 7 0 1000000000000
RG8 8 0 1000000000000
RG9 9 0 1000000000000
RG10 10 0 1000000000000
RG11 11 0 1000000000000
RG12 12 0 1000000000000
RG13 13 0 1000000000000
RG14 14 0 1000000000000
RG15 15 0 1000000000000
RG16 16 0 1000000000000
RG17 17 0 1000000000000
RG18 18 0 1000000000000
RG19 19 0 1000000000000
RG20 20 0 1000000000000
RG21 21 0 1000000000000
RG22 22 0 1000000000000
RG23 23 0 1000000000000
VS0 12 s0 0
L0 s0 18 12e-5
VS1 21 s1 0
L1 s1 8 33e-3
VS2 22 s2 0
R2 s2 6 33e3
VS3 4 s3 0
C3 s3 1 10e-4
VS4 4 s4 0
R4 s4 3 39e2
VS5 9 s5 0
L5 s5 14 39e-5
VS6 0 s6 0
L6 s6 11 10e-4
VS7 15 s7 0
C7 s7 5 33e-7
VS8 4 s8 0
C8 s8 19 10e-5
VS9 6 s9 0
L9 s9 9 12e-3
VS10 14 s10 0
R10 s10 13 33e0
VS11 13 s11 0
R11 s11 11 47e0
VS12 11 s12 0
R12 s12 18 82e-2
VS13 0 s13 0
V13 e13 s13 DC 0 AC 22e0 120
RI13 e13 m13 33e-2
LI13 m13 2 15e-6
VS14 5 s14 0
R14 s14 20 82e2
VS15 11 s15 0
L15 s15 13 10e-5
VS16 14 s16 0
V16 e16 s16 DC 0 AC 27e-1 180
RI16 e16 15 47e-1
VS17 10 s17 0
L17 s17 5 33e-5
VS18 17 s18 0
R18 s18 21 18e3
VS19 12 s19 0
R19 s19 11 18e0
VS20 8 s20 0
C20 s20 9 39e-7
VS21 12 s21 0
R21 s21 3 68e0
VS22 20 s22 0
C22 s22 17 10e-7
VS23 4 s23 0
L23 s23 0 10e-2
VS24 21 s24 0
L24 s24 15 33e-4
VS25 19 s25 0
C25 s25 22 47e-6
VS26 22 s26 0
L26 s26 1 47e-5
VS27 23 s27 0
R27 s27 8 12e1
VS28 17 s28 0
C28 s28 14 18e-6
VS29 3 s29 0
L29 s29 8 39e-2
VS30 23 s30 0
L30 s30 22 18e-3
VS31 7 s31 0
L31 s31 8 12e-4
VS32 16 s32 0
L32 s32 18 12e-5
VS33 23 s33 0
L33 s33 3 56e-4
VS34 3 s34 0
C34 s34 16 18e-5
VS35 15 s35 0
R35 s35 20 33e3
VS36 16 s36 0
V36 e36 s36 DC 0 AC 12e-1 180
RI36 e36 m36 15e-2
LI36 m36 19 12e-7
VS37 2 s37 0
R37 s37 23 82e3
VS38 20 s38 0
R38 s38 21 47e3
VS39 3 s39 0
C39 s39 9 27e-6
VS40 5 s40 0
V40 e40 s40 DC 0 AC 82e1 120
RI40 e40 m40 15e-3
LI40 m40 0 22e-5
VS41 17 s41 0
L41 s41 21 22e-5
VS42 16 s42 0
L42 s42 7 22e-2
VS43 10 s43 0
R43 s43 20 68e2
VS44 16 s44 0
V44 e44 s44 DC 0 AC 10e1 0
RI44 e44 m44 10e-1
LI44 m44 14 15e-5
VS45 3 s45 0
R45 s45 15 18e1
VS46 22 s46 0
L46 s46 16 12e-5
.control
set numdgt=17
ac lin 1 60 60
print v(1) v(2) v(3) v(4) v(5) v(6) v(7) v(8) v(9) v(10)
print v(11) v(12) v(13) v(14) v(15) v(16) v(17) v(18) v(19) v(20)
print v(21) v(22) v(23)
print i(vs0) i(vs1) i(vs2) i(vs3) i(vs4) i(vs5) i(vs6) i(vs7) i(vs8) i(vs9)
print i(vs10) i(vs11) i(vs12) i(vs13) i(vs14) i(vs15) i(vs16) i(vs17) i(vs18) i(vs19)
print i(vs20) i(vs21) i(vs22) i(vs23) i(vs24) i(vs25) i(vs26) i(vs27) i(vs28) i(vs29)
print i(vs30) i(vs31) i(vs32) i(vs33) i(vs34) i(vs35) i(vs36) i(vs37) i(vs38) i(vs39)
print i(vs40) i(vs41) i(vs42) i(vs43) i(vs44) i(vs45) i(vs46)
.endc
.end
