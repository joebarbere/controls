controls oracle ac-0246
* Generated (plan F2.7, ADR 0012): do not edit; regenerate with `pnpm sim oracle regen`. ac seed 20261031 index 246 nodes 24 elements 33
.options sparse gmin=1e-12 noopac
RG1 1 0 1000000000000
RG2 2 0 1000000000000
RG3 3 0 1000000000000
RG4 4 0 1000000000000
RG5 5 0 1000000000000
RG6 6 0 1000000000000
RG7 7 0 1000000000000
RG8 8 0 1000000000000
RG9 9 0 1000000000000
RG10 10 0 1000000000000
RG11 11 0 1000000000000
RG12 12 0 1000000000000
RG13 13 0 1000000000000
RG14 14 0 1000000000000
RG15 15 0 1000000000000
RG16 16 0 1000000000000
RG17 17 0 1000000000000
RG18 18 0 1000000000000
RG19 19 0 1000000000000
RG20 20 0 1000000000000
RG21 21 0 1000000000000
RG22 22 0 1000000000000
RG23 23 0 1000000000000
VS0 11 s0 0
L0 s0 16 12e-5
VS1 3 s1 0
R1 s1 12 22e-1
VS2 10 s2 0
C2 s2 6 22e-4
VS3 0 s3 0
V3 e3 s3 DC 0 AC 47e0 180
RI3 e3 1 68e-2
VS4 19 s4 0
L4 s4 11 22e-5
VS5 8 s5 0
R5 s5 5 39e2
VS6 15 s6 0
L6 s6 22 22e-3
VS7 21 s7 0
R7 s7 9 82e2
VS8 12 s8 0
R8 s8 6 82e3
VS9 13 s9 0
V9 e9 s9 DC 0 AC 10e1 0
RI9 e9 14 10e-1
VS10 18 s10 0
L10 s10 2 22e-5
VS11 12 s11 0
L11 s11 0 18e-3
VS12 5 s12 0
C12 s12 1 56e-4
VS13 13 s13 0
V13 e13 s13 DC 0 AC 12e-1 180
RI13 e13 19 15e-2
VS14 13 s14 0
L14 s14 0 18e-4
VS15 13 s15 0
V15 e15 s15 DC 0 AC 33e-1 0
RI15 e15 15 27e-3
VS16 6 s16 0
C16 s16 10 47e-7
VS17 19 s17 0
R17 s17 23 27e1
VS18 11 s18 0
R18 s18 7 47e2
VS19 17 s19 0
V19 e19 s19 DC 0 AC 22e1 180
RI19 e19 9 15e-2
VS20 0 s20 0
V20 e20 s20 DC 0 AC 15e0 -120
RI20 e20 3 39e-3
VS21 13 s21 0
L21 s21 5 39e-2
VS22 10 s22 0
L22 s22 19 10e-4
VS23 22 s23 0
L23 s23 11 10e-3
VS24 18 s24 0
L24 s24 10 12e-5
VS25 13 s25 0
V25 e25 s25 DC 0 AC 12e-1 -120
RI25 e25 22 12e-3
VS26 22 s26 0
R26 s26 6 47e-1
VS27 17 s27 0
L27 s27 13 27e-2
VS28 19 s28 0
L28 s28 8 56e-4
VS29 19 s29 0
C29 s29 20 56e-7
VS30 4 s30 0
C30 s30 10 15e-4
VS31 7 s31 0
R31 s31 4 12e-2
VS32 2 s32 0
L32 s32 4 10e-3
.control
set numdgt=17
ac lin 1 60 60
print v(1) v(2) v(3) v(4) v(5) v(6) v(7) v(8) v(9) v(10)
print v(11) v(12) v(13) v(14) v(15) v(16) v(17) v(18) v(19) v(20)
print v(21) v(22) v(23)
print i(vs0) i(vs1) i(vs2) i(vs3) i(vs4) i(vs5) i(vs6) i(vs7) i(vs8) i(vs9)
print i(vs10) i(vs11) i(vs12) i(vs13) i(vs14) i(vs15) i(vs16) i(vs17) i(vs18) i(vs19)
print i(vs20) i(vs21) i(vs22) i(vs23) i(vs24) i(vs25) i(vs26) i(vs27) i(vs28) i(vs29)
print i(vs30) i(vs31) i(vs32)
.endc
.end
