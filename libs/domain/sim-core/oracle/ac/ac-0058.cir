controls oracle ac-0058
* Generated (plan F2.7, ADR 0012): do not edit; regenerate with `pnpm sim oracle regen`. ac seed 20261031 index 58 nodes 15 elements 21
.options sparse gmin=1e-12 noopac
RG1 1 0 1000000000000
RG2 2 0 1000000000000
RG3 3 0 1000000000000
RG4 4 0 1000000000000
RG5 5 0 1000000000000
RG6 6 0 1000000000000
RG7 7 0 1000000000000
RG8 8 0 1000000000000
RG9 9 0 1000000000000
RG10 10 0 1000000000000
RG11 11 0 1000000000000
RG12 12 0 1000000000000
RG13 13 0 1000000000000
RG14 14 0 1000000000000
VS0 10 s0 0
R0 s0 8 10e0
VS1 13 s1 0
C1 s1 3 33e-7
VS2 0 s2 0
V2 e2 s2 DC 0 AC 27e1 120
RI2 e2 m2 15e-3
LI2 m2 5 18e-6
VS3 11 s3 0
R3 s3 1 68e-2
VS4 9 s4 0
L4 s4 2 12e-2
VS5 6 s5 0
L5 s5 8 47e-3
VS6 11 s6 0
C6 s6 13 33e-6
VS7 1 s7 0
L7 s7 7 68e-4
VS8 6 s8 0
R8 s8 2 82e-2
VS9 0 s9 0
L9 s9 12 15e-3
VS10 3 s10 0
R10 s10 7 82e-1
VS11 14 s11 0
C11 s11 0 68e-7
VS12 4 s12 0
R12 s12 14 39e3
VS13 13 s13 0
C13 s13 10 33e-7
VS14 12 s14 0
C14 s14 4 68e-6
VS15 9 s15 0
L15 s15 14 18e-4
VS16 13 s16 0
V16 e16 s16 DC 0 AC 12e1 180
RI16 e16 m16 82e-3
LI16 m16 2 27e-5
VS17 14 s17 0
C17 s17 13 56e-4
VS18 5 s18 0
R18 s18 7 47e3
VS19 12 s19 0
R19 s19 7 12e1
VS20 0 s20 0
R20 s20 3 82e1
.control
set numdgt=17
ac lin 1 60 60
print v(1) v(2) v(3) v(4) v(5) v(6) v(7) v(8) v(9) v(10)
print v(11) v(12) v(13) v(14)
print i(vs0) i(vs1) i(vs2) i(vs3) i(vs4) i(vs5) i(vs6) i(vs7) i(vs8) i(vs9)
print i(vs10) i(vs11) i(vs12) i(vs13) i(vs14) i(vs15) i(vs16) i(vs17) i(vs18) i(vs19)
print i(vs20)
.endc
.end
