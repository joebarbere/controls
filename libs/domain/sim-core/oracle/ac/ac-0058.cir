controls oracle ac-0058
* Generated (plan F2.7, ADR 0012): do not edit; regenerate with `pnpm sim oracle regen`. ac seed 20261031 index 58 nodes 15 elements 15
.options sparse gmin=1e-12 noopac
RG1 1 0 1000000000000
RG2 2 0 1000000000000
RG3 3 0 1000000000000
RG4 4 0 1000000000000
RG5 5 0 1000000000000
RG6 6 0 1000000000000
RG7 7 0 1000000000000
RG8 8 0 1000000000000
RG9 9 0 1000000000000
RG10 10 0 1000000000000
RG11 11 0 1000000000000
RG12 12 0 1000000000000
RG13 13 0 1000000000000
RG14 14 0 1000000000000
VS0 1 s0 0
L0 s0 9 56e-2
VS1 8 s1 0
R1 s1 6 82e-1
VS2 6 s2 0
R2 s2 11 12e2
VS3 4 s3 0
R3 s3 14 22e-1
VS4 0 s4 0
V4 e4 s4 DC 0 AC 12e1 180
RI4 e4 2 82e-3
VS5 12 s5 0
R5 s5 0 56e-1
VS6 2 s6 0
R6 s6 3 10e-1
VS7 11 s7 0
L7 s7 14 82e-3
VS8 11 s8 0
V8 e8 s8 DC 0 AC 12e1 0
RI8 e8 7 12e-3
VS9 2 s9 0
R9 s9 10 18e2
VS10 3 s10 0
L10 s10 9 33e-5
VS11 2 s11 0
L11 s11 0 33e-3
VS12 13 s12 0
C12 s12 0 33e-6
VS13 2 s13 0
R13 s13 6 68e2
VS14 11 s14 0
V14 e14 s14 DC 0 AC 27e1 120
RI14 e14 5 15e-3
.control
set numdgt=17
ac lin 1 60 60
print v(1) v(2) v(3) v(4) v(5) v(6) v(7) v(8) v(9) v(10)
print v(11) v(12) v(13) v(14)
print i(vs0) i(vs1) i(vs2) i(vs3) i(vs4) i(vs5) i(vs6) i(vs7) i(vs8) i(vs9)
print i(vs10) i(vs11) i(vs12) i(vs13) i(vs14)
.endc
.end
