controls oracle ac-0058
* Generated (plan F2.7, ADR 0012): do not edit; regenerate with `pnpm sim oracle regen`. ac seed 20261031 index 58 nodes 15 elements 21
.options sparse gmin=1e-12 noopac
RG1 1 0 1000000000000
RG2 2 0 1000000000000
RG3 3 0 1000000000000
RG4 4 0 1000000000000
RG5 5 0 1000000000000
RG6 6 0 1000000000000
RG7 7 0 1000000000000
RG8 8 0 1000000000000
RG9 9 0 1000000000000
RG10 10 0 1000000000000
RG11 11 0 1000000000000
RG12 12 0 1000000000000
RG13 13 0 1000000000000
RG14 14 0 1000000000000
VS0 11 s0 0
L0 s0 10 15e-3
VS1 3 s1 0
R1 s1 1 27e3
VS2 0 s2 0
L2 s2 14 82e-3
VS3 1 s3 0
L3 s3 9 56e-2
VS4 0 s4 0
V4 e4 s4 DC 0 AC 12e1 0
RI4 e4 7 12e-3
VS5 0 s5 0
V5 e5 s5 DC 0 AC 27e1 120
RI5 e5 5 15e-3
VS6 8 s6 0
C6 s6 13 27e-6
VS7 11 s7 0
C7 s7 13 33e-6
VS8 2 s8 0
R8 s8 6 68e2
VS9 2 s9 0
R9 s9 3 10e-1
VS10 2 s10 0
R10 s10 10 18e2
VS11 13 s11 0
V11 e11 s11 DC 0 AC 12e1 180
RI11 e11 2 82e-3
VS12 9 s12 0
R12 s12 7 27e-1
VS13 10 s13 0
R13 s13 4 27e2
VS14 12 s14 0
R14 s14 13 56e-1
VS15 4 s15 0
R15 s15 14 22e-1
VS16 8 s16 0
R16 s16 6 82e-1
VS17 6 s17 0
R17 s17 0 12e2
VS18 9 s18 0
R18 s18 12 22e3
VS19 3 s19 0
L19 s19 9 33e-5
VS20 13 s20 0
R20 s20 5 82e0
.control
set numdgt=17
ac lin 1 60 60
print v(1) v(2) v(3) v(4) v(5) v(6) v(7) v(8) v(9) v(10)
print v(11) v(12) v(13) v(14)
print i(vs0) i(vs1) i(vs2) i(vs3) i(vs4) i(vs5) i(vs6) i(vs7) i(vs8) i(vs9)
print i(vs10) i(vs11) i(vs12) i(vs13) i(vs14) i(vs15) i(vs16) i(vs17) i(vs18) i(vs19)
print i(vs20)
.endc
.end
