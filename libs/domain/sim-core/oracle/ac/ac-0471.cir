controls oracle ac-0471
* Generated (plan F2.7, ADR 0012): do not edit; regenerate with `pnpm sim oracle regen`. ac seed 20261031 index 471 nodes 10 elements 10
.options sparse gmin=1e-12 noopac
RG1 1 0 1000000000000
RG2 2 0 1000000000000
RG3 3 0 1000000000000
RG4 4 0 1000000000000
RG5 5 0 1000000000000
RG6 6 0 1000000000000
RG7 7 0 1000000000000
RG8 8 0 1000000000000
RG9 9 0 1000000000000
VS0 0 s0 0
V0 e0 s0 DC 0 AC 56e0 120
RI0 e0 2 22e-2
VS1 9 s1 0
C1 s1 2 39e-7
VS2 8 s2 0
V2 e2 s2 DC 0 AC 56e1 -120
RI2 e2 5 56e-1
VS3 6 s3 0
V3 e3 s3 DC 0 AC 68e1 120
RI3 e3 1 82e-1
VS4 4 s4 0
C4 s4 5 56e-4
VS5 7 s5 0
R5 s5 8 56e0
VS6 3 s6 0
V6 e6 s6 DC 0 AC 47e1 180
RI6 e6 8 22e-1
VS7 1 s7 0
C7 s7 4 27e-6
VS8 9 s8 0
V8 e8 s8 DC 0 AC 68e1 0
RI8 e8 8 22e-2
VS9 6 s9 0
L9 s9 8 22e-3
.control
set numdgt=17
ac lin 1 60 60
print v(1) v(2) v(3) v(4) v(5) v(6) v(7) v(8) v(9)
print i(vs0) i(vs1) i(vs2) i(vs3) i(vs4) i(vs5) i(vs6) i(vs7) i(vs8) i(vs9)
.endc
.end
