controls oracle ac-0227
* Generated (plan F2.7, ADR 0012): do not edit; regenerate with `pnpm sim oracle regen`. ac seed 20261031 index 227 nodes 13 elements 22
.options sparse gmin=1e-12 noopac
RG1 1 0 1000000000000
RG2 2 0 1000000000000
RG3 3 0 1000000000000
RG4 4 0 1000000000000
RG5 5 0 1000000000000
RG6 6 0 1000000000000
RG7 7 0 1000000000000
RG8 8 0 1000000000000
RG9 9 0 1000000000000
RG10 10 0 1000000000000
RG11 11 0 1000000000000
RG12 12 0 1000000000000
VS0 10 s0 0
L0 s0 1 12e-3
VS1 0 s1 0
V1 e1 s1 DC 0 AC 56e1 120
RI1 e1 8 12e-3
VS2 0 s2 0
R2 s2 10 68e3
VS3 11 s3 0
R3 s3 2 15e3
VS4 3 s4 0
V4 e4 s4 DC 0 AC 18e0 120
RI4 e4 10 33e-2
VS5 12 s5 0
V5 e5 s5 DC 0 AC 10e0 120
RI5 e5 5 82e-1
VS6 11 s6 0
C6 s6 9 68e-4
VS7 11 s7 0
R7 s7 4 47e-2
VS8 8 s8 0
V8 e8 s8 DC 0 AC 15e1 -120
RI8 e8 4 68e-3
VS9 1 s9 0
C9 s9 8 47e-7
VS10 2 s10 0
L10 s10 9 22e-3
VS11 1 s11 0
V11 e11 s11 DC 0 AC 33e1 -120
RI11 e11 6 56e-2
VS12 6 s12 0
R12 s12 11 18e0
VS13 4 s13 0
R13 s13 1 10e2
VS14 2 s14 0
R14 s14 12 18e3
VS15 10 s15 0
V15 e15 s15 DC 0 AC 82e-1 120
RI15 e15 2 82e-1
VS16 11 s16 0
C16 s16 7 68e-5
VS17 7 s17 0
L17 s17 6 10e-5
VS18 1 s18 0
V18 e18 s18 DC 0 AC 15e-1 -120
RI18 e18 10 15e-3
VS19 3 s19 0
V19 e19 s19 DC 0 AC 10e0 120
RI19 e19 0 68e-2
VS20 4 s20 0
V20 e20 s20 DC 0 AC 10e-1 180
RI20 e20 2 33e-1
VS21 1 s21 0
V21 e21 s21 DC 0 AC 68e0 0
RI21 e21 12 47e-3
.control
set numdgt=17
ac lin 1 60 60
print v(1) v(2) v(3) v(4) v(5) v(6) v(7) v(8) v(9) v(10)
print v(11) v(12)
print i(vs0) i(vs1) i(vs2) i(vs3) i(vs4) i(vs5) i(vs6) i(vs7) i(vs8) i(vs9)
print i(vs10) i(vs11) i(vs12) i(vs13) i(vs14) i(vs15) i(vs16) i(vs17) i(vs18) i(vs19)
print i(vs20) i(vs21)
.endc
.end
