controls oracle ac-0227
* Generated (plan F2.7, ADR 0012): do not edit; regenerate with `pnpm sim oracle regen`. ac seed 20261031 index 227 nodes 13 elements 23
.options sparse gmin=1e-12 noopac
RG1 1 0 1000000000000
RG2 2 0 1000000000000
RG3 3 0 1000000000000
RG4 4 0 1000000000000
RG5 5 0 1000000000000
RG6 6 0 1000000000000
RG7 7 0 1000000000000
RG8 8 0 1000000000000
RG9 9 0 1000000000000
RG10 10 0 1000000000000
RG11 11 0 1000000000000
RG12 12 0 1000000000000
VS0 0 s0 0
V0 e0 s0 DC 0 AC 27e0 -120
RI0 e0 11 68e-3
VS1 2 s1 0
R1 s1 12 18e3
VS2 12 s2 0
V2 e2 s2 DC 0 AC 10e0 120
RI2 e2 0 82e-1
VS3 1 s3 0
V3 e3 s3 DC 0 AC 33e1 -120
RI3 e3 6 56e-2
VS4 10 s4 0
L4 s4 1 12e-3
VS5 11 s5 0
R5 s5 10 68e3
VS6 3 s6 0
V6 e6 s6 DC 0 AC 18e0 120
RI6 e6 10 33e-2
VS7 2 s7 0
L7 s7 9 22e-3
VS8 4 s8 0
V8 e8 s8 DC 0 AC 10e-1 180
RI8 e8 2 33e-1
VS9 3 s9 0
V9 e9 s9 DC 0 AC 10e0 120
RI9 e9 11 68e-2
VS10 1 s10 0
C10 s10 8 47e-7
VS11 4 s11 0
R11 s11 1 10e2
VS12 5 s12 0
R12 s12 4 47e-2
VS13 1 s13 0
V13 e13 s13 DC 0 AC 68e0 0
RI13 e13 12 47e-3
VS14 7 s14 0
L14 s14 6 10e-5
VS15 5 s15 0
R15 s15 2 15e3
VS16 5 s16 0
C16 s16 9 68e-4
VS17 8 s17 0
V17 e17 s17 DC 0 AC 15e1 -120
RI17 e17 4 68e-3
VS18 5 s18 0
C18 s18 7 68e-5
VS19 6 s19 0
R19 s19 5 18e0
VS20 11 s20 0
V20 e20 s20 DC 0 AC 56e1 120
RI20 e20 8 12e-3
VS21 10 s21 0
V21 e21 s21 DC 0 AC 82e-1 120
RI21 e21 2 82e-1
VS22 1 s22 0
V22 e22 s22 DC 0 AC 15e-1 -120
RI22 e22 10 15e-3
.control
set numdgt=17
ac lin 1 60 60
print v(1) v(2) v(3) v(4) v(5) v(6) v(7) v(8) v(9) v(10)
print v(11) v(12)
print i(vs0) i(vs1) i(vs2) i(vs3) i(vs4) i(vs5) i(vs6) i(vs7) i(vs8) i(vs9)
print i(vs10) i(vs11) i(vs12) i(vs13) i(vs14) i(vs15) i(vs16) i(vs17) i(vs18) i(vs19)
print i(vs20) i(vs21) i(vs22)
.endc
.end
