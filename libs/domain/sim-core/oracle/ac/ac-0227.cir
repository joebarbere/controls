controls oracle ac-0227
* Generated (plan F2.7, ADR 0012): do not edit; regenerate with `pnpm sim oracle regen`. ac seed 20261031 index 227 nodes 13 elements 24
.options sparse gmin=1e-12 noopac
RG1 1 0 1000000000000
RG2 2 0 1000000000000
RG3 3 0 1000000000000
RG4 4 0 1000000000000
RG5 5 0 1000000000000
RG6 6 0 1000000000000
RG7 7 0 1000000000000
RG8 8 0 1000000000000
RG9 9 0 1000000000000
RG10 10 0 1000000000000
RG11 11 0 1000000000000
RG12 12 0 1000000000000
VS0 0 s0 0
V0 e0 s0 DC 0 AC 33e1 180
RI0 e0 m0 15e-1
LI0 m0 1 33e-6
VS1 9 s1 0
R1 s1 7 15e0
VS2 10 s2 0
R2 s2 4 47e-2
VS3 8 s3 0
C3 s3 7 39e-4
VS4 7 s4 0
V4 e4 s4 DC 0 AC 39e0 0
RI4 e4 m4 15e-3
LI4 m4 12 47e-5
VS5 4 s5 0
V5 e5 s5 DC 0 AC 10e-1 180
RI5 e5 2 33e-1
VS6 1 s6 0
R6 s6 12 47e-2
VS7 1 s7 0
C7 s7 8 47e-7
VS8 7 s8 0
L8 s8 10 12e-5
VS9 11 s9 0
C9 s9 10 22e-7
VS10 11 s10 0
R10 s10 0 68e3
VS11 10 s11 0
C11 s11 7 68e-5
VS12 8 s12 0
V12 e12 s12 DC 0 AC 82e1 -120
RI12 e12 2 82e-1
VS13 1 s13 0
L13 s13 5 82e-3
VS14 8 s14 0
V14 e14 s14 DC 0 AC 15e1 -120
RI14 e14 4 68e-3
VS15 1 s15 0
V15 e15 s15 DC 0 AC 33e1 -120
RI15 e15 m15 56e-2
LI15 m15 6 82e-6
VS16 3 s16 0
V16 e16 s16 DC 0 AC 33e-1 0
RI16 e16 10 56e-1
VS17 6 s17 0
R17 s17 10 18e0
VS18 9 s18 0
L18 s18 0 47e-4
VS19 1 s19 0
R19 s19 8 68e0
VS20 3 s20 0
R20 s20 1 68e3
VS21 10 s21 0
C21 s21 9 68e-4
VS22 9 s22 0
C22 s22 2 56e-4
VS23 9 s23 0
V23 e23 s23 DC 0 AC 18e0 0
RI23 e23 5 68e-3
.control
set numdgt=17
ac lin 1 60 60
print v(1) v(2) v(3) v(4) v(5) v(6) v(7) v(8) v(9) v(10)
print v(11) v(12)
print i(vs0) i(vs1) i(vs2) i(vs3) i(vs4) i(vs5) i(vs6) i(vs7) i(vs8) i(vs9)
print i(vs10) i(vs11) i(vs12) i(vs13) i(vs14) i(vs15) i(vs16) i(vs17) i(vs18) i(vs19)
print i(vs20) i(vs21) i(vs22) i(vs23)
.endc
.end
