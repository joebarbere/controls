controls oracle ac-0260
* Generated (plan F2.7, ADR 0012): do not edit; regenerate with `pnpm sim oracle regen`. ac seed 20261031 index 260 nodes 14 elements 20
.options sparse gmin=1e-12 noopac
RG1 1 0 1000000000000
RG2 2 0 1000000000000
RG3 3 0 1000000000000
RG4 4 0 1000000000000
RG5 5 0 1000000000000
RG6 6 0 1000000000000
RG7 7 0 1000000000000
RG8 8 0 1000000000000
RG9 9 0 1000000000000
RG10 10 0 1000000000000
RG11 11 0 1000000000000
RG12 12 0 1000000000000
RG13 13 0 1000000000000
VS0 2 s0 0
L0 s0 9 68e-4
VS1 0 s1 0
V1 e1 s1 DC 0 AC 10e0 180
RI1 e1 m1 10e-2
LI1 m1 11 47e-7
VS2 6 s2 0
V2 e2 s2 DC 0 AC 12e-1 180
RI2 e2 8 68e-1
VS3 7 s3 0
V3 e3 s3 DC 0 AC 15e-1 0
RI3 e3 m3 27e-2
LI3 m3 11 27e-7
VS4 3 s4 0
R4 s4 13 82e3
VS5 6 s5 0
R5 s5 5 56e-1
VS6 7 s6 0
R6 s6 2 68e0
VS7 4 s7 0
R7 s7 1 56e-1
VS8 2 s8 0
L8 s8 4 12e-5
VS9 4 s9 0
L9 s9 6 82e-3
VS10 10 s10 0
R10 s10 1 47e-1
VS11 5 s11 0
C11 s11 4 15e-7
VS12 8 s12 0
L12 s12 12 27e-4
VS13 12 s13 0
R13 s13 3 22e2
VS14 11 s14 0
R14 s14 13 56e3
VS15 10 s15 0
L15 s15 13 10e-2
VS16 0 s16 0
C16 s16 7 15e-7
VS17 9 s17 0
R17 s17 8 27e3
VS18 3 s18 0
V18 e18 s18 DC 0 AC 15e1 180
RI18 e18 11 56e-1
VS19 4 s19 0
L19 s19 7 12e-3
.control
set numdgt=17
ac lin 1 60 60
print v(1) v(2) v(3) v(4) v(5) v(6) v(7) v(8) v(9) v(10)
print v(11) v(12) v(13)
print i(vs0) i(vs1) i(vs2) i(vs3) i(vs4) i(vs5) i(vs6) i(vs7) i(vs8) i(vs9)
print i(vs10) i(vs11) i(vs12) i(vs13) i(vs14) i(vs15) i(vs16) i(vs17) i(vs18) i(vs19)
.endc
.end
