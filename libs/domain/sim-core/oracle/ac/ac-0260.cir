controls oracle ac-0260
* Generated (plan F2.7, ADR 0012): do not edit; regenerate with `pnpm sim oracle regen`. ac seed 20261031 index 260 nodes 14 elements 22
.options sparse gmin=1e-12 noopac
RG1 1 0 1000000000000
RG2 2 0 1000000000000
RG3 3 0 1000000000000
RG4 4 0 1000000000000
RG5 5 0 1000000000000
RG6 6 0 1000000000000
RG7 7 0 1000000000000
RG8 8 0 1000000000000
RG9 9 0 1000000000000
RG10 10 0 1000000000000
RG11 11 0 1000000000000
RG12 12 0 1000000000000
RG13 13 0 1000000000000
VS0 0 s0 0
V0 e0 s0 DC 0 AC 27e-1 180
RI0 e0 n0 33e-3
H0 n0 h0 VS3 68e-4
ED0 h0 8 d0 0 22e-5
F0 0 d0 VS3 1
LD0 d0 0 1
VS1 12 s1 0
L1 s1 5 18e-5
VS2 2 s2 0
R2 s2 0 33e1
VS3 7 s3 0
V3 e3 s3 DC 0 AC 15e-1 0
RI3 e3 n3 27e-2
H3 n3 h3 VS0 68e-4
ED3 h3 11 d3 0 22e-5
F3 0 d3 VS0 1
LD3 d3 0 1
VS4 6 s4 0
L4 s4 10 10e-5
VS5 2 s5 0
V5 e5 s5 DC 0 AC 12e-1 -120
RI5 e5 4 18e-2
VS6 12 s6 0
C6 s6 2 15e-6
VS7 5 s7 0
L7 s7 6 82e-3
VS8 0 s8 0
L8 s8 3 15e-2
VS9 13 s9 0
L9 s9 8 39e-4
VS10 11 s10 0
R10 s10 5 39e-1
VS11 3 s11 0
C11 s11 1 47e-4
VS12 0 s12 0
C12 s12 5 15e-7
VS13 9 s13 0
R13 s13 11 27e1
VS14 6 s14 0
R14 s14 9 82e1
VS15 5 s15 0
L15 s15 7 12e-3
VS16 1 s16 0
V16 e16 s16 DC 0 AC 56e-1 120
RI16 e16 7 56e-2
VS17 9 s17 0
L17 s17 3 39e-3
VS18 13 s18 0
R18 s18 5 56e-1
VS19 4 s19 0
V19 e19 s19 DC 0 AC 10e0 180
RI19 e19 11 10e-2
VS20 1 s20 0
L20 s20 12 33e-4
VS21 10 s21 0
R21 s21 8 47e1
.control
set numdgt=17
ac lin 1 60 60
print v(1) v(2) v(3) v(4) v(5) v(6) v(7) v(8) v(9) v(10)
print v(11) v(12) v(13)
print i(vs0) i(vs1) i(vs2) i(vs3) i(vs4) i(vs5) i(vs6) i(vs7) i(vs8) i(vs9)
print i(vs10) i(vs11) i(vs12) i(vs13) i(vs14) i(vs15) i(vs16) i(vs17) i(vs18) i(vs19)
print i(vs20) i(vs21)
.endc
.end
