controls oracle ac-0267
* Generated (plan F2.7, ADR 0012): do not edit; regenerate with `pnpm sim oracle regen`. ac seed 20261031 index 267 nodes 18 elements 27
.options sparse gmin=1e-12 noopac
RG1 1 0 1000000000000
RG2 2 0 1000000000000
RG3 3 0 1000000000000
RG4 4 0 1000000000000
RG5 5 0 1000000000000
RG6 6 0 1000000000000
RG7 7 0 1000000000000
RG8 8 0 1000000000000
RG9 9 0 1000000000000
RG10 10 0 1000000000000
RG11 11 0 1000000000000
RG12 12 0 1000000000000
RG13 13 0 1000000000000
RG14 14 0 1000000000000
RG15 15 0 1000000000000
RG16 16 0 1000000000000
RG17 17 0 1000000000000
VS0 0 s0 0
V0 e0 s0 DC 0 AC 22e0 180
RI0 e0 14 10e-1
VS1 7 s1 0
R1 s1 13 22e0
VS2 3 s2 0
C2 s2 6 33e-5
VS3 7 s3 0
V3 e3 s3 DC 0 AC 68e1 120
RI3 e3 m3 39e-3
LI3 m3 5 39e-6
VS4 2 s4 0
L4 s4 13 33e-5
VS5 6 s5 0
L5 s5 8 18e-3
VS6 1 s6 0
V6 e6 s6 DC 0 AC 18e-1 0
RI6 e6 13 33e-1
VS7 6 s7 0
C7 s7 9 82e-6
VS8 15 s8 0
L8 s8 2 33e-5
VS9 16 s9 0
R9 s9 4 12e-1
VS10 9 s10 0
L10 s10 17 27e-4
VS11 11 s11 0
R11 s11 2 18e0
VS12 6 s12 0
C12 s12 12 12e-4
VS13 14 s13 0
V13 e13 s13 DC 0 AC 15e1 180
RI13 e13 2 15e-2
VS14 15 s14 0
V14 e14 s14 DC 0 AC 56e0 180
RI14 e14 4 82e-3
VS15 16 s15 0
R15 s15 8 82e-2
VS16 10 s16 0
C16 s16 13 12e-6
VS17 6 s17 0
R17 s17 2 82e-2
VS18 12 s18 0
R18 s18 5 47e0
VS19 17 s19 0
L19 s19 7 10e-3
VS20 17 s20 0
L20 s20 1 39e-5
VS21 5 s21 0
R21 s21 16 27e-2
VS22 14 s22 0
R22 s22 3 12e1
VS23 5 s23 0
R23 s23 11 39e1
VS24 9 s24 0
R24 s24 0 33e1
VS25 13 s25 0
V25 e25 s25 DC 0 AC 47e1 0
RI25 e25 m25 68e-3
LI25 m25 16 15e-5
VS26 10 s26 0
R26 s26 7 47e-1
.control
set numdgt=17
ac lin 1 60 60
print v(1) v(2) v(3) v(4) v(5) v(6) v(7) v(8) v(9) v(10)
print v(11) v(12) v(13) v(14) v(15) v(16) v(17)
print i(vs0) i(vs1) i(vs2) i(vs3) i(vs4) i(vs5) i(vs6) i(vs7) i(vs8) i(vs9)
print i(vs10) i(vs11) i(vs12) i(vs13) i(vs14) i(vs15) i(vs16) i(vs17) i(vs18) i(vs19)
print i(vs20) i(vs21) i(vs22) i(vs23) i(vs24) i(vs25) i(vs26)
.endc
.end
