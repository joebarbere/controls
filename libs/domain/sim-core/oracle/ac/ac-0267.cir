controls oracle ac-0267
* Generated (plan F2.7, ADR 0012): do not edit; regenerate with `pnpm sim oracle regen`. ac seed 20261031 index 267 nodes 18 elements 28
.options sparse gmin=1e-12 noopac
RG1 1 0 1000000000000
RG2 2 0 1000000000000
RG3 3 0 1000000000000
RG4 4 0 1000000000000
RG5 5 0 1000000000000
RG6 6 0 1000000000000
RG7 7 0 1000000000000
RG8 8 0 1000000000000
RG9 9 0 1000000000000
RG10 10 0 1000000000000
RG11 11 0 1000000000000
RG12 12 0 1000000000000
RG13 13 0 1000000000000
RG14 14 0 1000000000000
RG15 15 0 1000000000000
RG16 16 0 1000000000000
RG17 17 0 1000000000000
VS0 3 s0 0
R0 s0 7 39e2
VS1 12 s1 0
L1 s1 4 12e-5
VS2 10 s2 0
C2 s2 13 12e-6
VS3 16 s3 0
L3 s3 8 18e-3
VS4 16 s4 0
C4 s4 9 82e-6
VS5 0 s5 0
R5 s5 7 18e2
VS6 9 s6 0
L6 s6 17 27e-4
VS7 11 s7 0
R7 s7 2 18e0
VS8 12 s8 0
C8 s8 6 56e-5
VS9 0 s9 0
L9 s9 5 68e-3
VS10 12 s10 0
L10 s10 14 22e-3
VS11 15 s11 0
L11 s11 1 82e-3
VS12 5 s12 0
R12 s12 0 27e-2
VS13 5 s13 0
R13 s13 11 39e1
VS14 9 s14 0
R14 s14 6 33e1
VS15 12 s15 0
R15 s15 5 47e0
VS16 11 s16 0
R16 s16 1 12e3
VS17 1 s17 0
R17 s17 13 18e0
VS18 14 s18 0
L18 s18 2 39e-3
VS19 14 s19 0
C19 s19 16 82e-5
VS20 0 s20 0
V20 e20 s20 DC 0 AC 10e-1 120
RI20 e20 2 22e-2
VS21 15 s21 0
R21 s21 7 27e-2
VS22 16 s22 0
L22 s22 0 39e-3
VS23 6 s23 0
V23 e23 s23 DC 0 AC 56e0 120
RI23 e23 11 82e-1
VS24 1 s24 0
V24 e24 s24 DC 0 AC 18e-1 0
RI24 e24 13 33e-1
VS25 16 s25 0
R25 s25 2 82e-2
VS26 2 s26 0
L26 s26 13 33e-5
VS27 3 s27 0
C27 s27 16 33e-5
.control
set numdgt=17
ac lin 1 60 60
print v(1) v(2) v(3) v(4) v(5) v(6) v(7) v(8) v(9) v(10)
print v(11) v(12) v(13) v(14) v(15) v(16) v(17)
print i(vs0) i(vs1) i(vs2) i(vs3) i(vs4) i(vs5) i(vs6) i(vs7) i(vs8) i(vs9)
print i(vs10) i(vs11) i(vs12) i(vs13) i(vs14) i(vs15) i(vs16) i(vs17) i(vs18) i(vs19)
print i(vs20) i(vs21) i(vs22) i(vs23) i(vs24) i(vs25) i(vs26) i(vs27)
.endc
.end
