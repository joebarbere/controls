controls oracle ac-0267
* Generated (plan F2.7, ADR 0012): do not edit; regenerate with `pnpm sim oracle regen`. ac seed 20261031 index 267 nodes 18 elements 32
.options sparse gmin=1e-12 noopac
RG1 1 0 1000000000000
RG2 2 0 1000000000000
RG3 3 0 1000000000000
RG4 4 0 1000000000000
RG5 5 0 1000000000000
RG6 6 0 1000000000000
RG7 7 0 1000000000000
RG8 8 0 1000000000000
RG9 9 0 1000000000000
RG10 10 0 1000000000000
RG11 11 0 1000000000000
RG12 12 0 1000000000000
RG13 13 0 1000000000000
RG14 14 0 1000000000000
RG15 15 0 1000000000000
RG16 16 0 1000000000000
RG17 17 0 1000000000000
VS0 12 s0 0
C0 s0 6 56e-5
VS1 1 s1 0
L1 s1 8 18e-3
VS2 13 s2 0
R2 s2 4 22e-2
VS3 11 s3 0
R3 s3 2 18e0
VS4 12 s4 0
L4 s4 14 22e-3
VS5 16 s5 0
L5 s5 5 68e-3
VS6 0 s6 0
V6 e6 s6 DC 0 AC 18e-1 0
RI6 e6 13 33e-1
VS7 3 s7 0
R7 s7 7 39e2
VS8 0 s8 0
R8 s8 13 18e0
VS9 15 s9 0
R9 s9 7 27e-2
VS10 10 s10 0
C10 s10 13 12e-6
VS11 9 s11 0
L11 s11 17 27e-4
VS12 16 s12 0
V12 e12 s12 DC 0 AC 10e-1 120
RI12 e12 2 22e-2
VS13 2 s13 0
L13 s13 13 33e-5
VS14 15 s14 0
L14 s14 0 82e-3
VS15 5 s15 0
R15 s15 11 39e1
VS16 1 s16 0
R16 s16 2 82e-2
VS17 9 s17 0
R17 s17 6 33e1
VS18 6 s18 0
V18 e18 s18 DC 0 AC 56e0 120
RI18 e18 11 82e-1
VS19 17 s19 0
R19 s19 15 33e-1
VS20 0 s20 0
R20 s20 10 68e-1
VS21 12 s21 0
L21 s21 4 12e-5
VS22 1 s22 0
L22 s22 16 39e-3
VS23 1 s23 0
C23 s23 9 82e-6
VS24 3 s24 0
L24 s24 8 10e-3
VS25 12 s25 0
R25 s25 5 47e0
VS26 11 s26 0
R26 s26 0 12e3
VS27 16 s27 0
R27 s27 7 18e2
VS28 3 s28 0
C28 s28 1 33e-5
VS29 5 s29 0
R29 s29 16 27e-2
VS30 14 s30 0
C30 s30 1 82e-5
VS31 14 s31 0
L31 s31 2 39e-3
.control
set numdgt=17
ac lin 1 60 60
print v(1) v(2) v(3) v(4) v(5) v(6) v(7) v(8) v(9) v(10)
print v(11) v(12) v(13) v(14) v(15) v(16) v(17)
print i(vs0) i(vs1) i(vs2) i(vs3) i(vs4) i(vs5) i(vs6) i(vs7) i(vs8) i(vs9)
print i(vs10) i(vs11) i(vs12) i(vs13) i(vs14) i(vs15) i(vs16) i(vs17) i(vs18) i(vs19)
print i(vs20) i(vs21) i(vs22) i(vs23) i(vs24) i(vs25) i(vs26) i(vs27) i(vs28) i(vs29)
print i(vs30) i(vs31)
.endc
.end
