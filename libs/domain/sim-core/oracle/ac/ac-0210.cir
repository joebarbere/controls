controls oracle ac-0210
* Generated (plan F2.7, ADR 0012): do not edit; regenerate with `pnpm sim oracle regen`. ac seed 20261031 index 210 nodes 6 elements 11
.options sparse gmin=1e-12 noopac
RG1 1 0 1000000000000
RG2 2 0 1000000000000
RG3 3 0 1000000000000
RG4 4 0 1000000000000
RG5 5 0 1000000000000
VS0 0 s0 0
V0 e0 s0 DC 0 AC 18e-1 180
RI0 e0 3 56e-1
VS1 4 s1 0
R1 s1 1 68e2
VS2 1 s2 0
L2 s2 2 10e-4
VS3 0 s3 0
R3 s3 3 22e-1
VS4 0 s4 0
L4 s4 5 47e-2
VS5 1 s5 0
R5 s5 5 33e0
VS6 0 s6 0
V6 e6 s6 DC 0 AC 56e1 120
RI6 e6 3 39e-1
VS7 3 s7 0
L7 s7 0 10e-5
VS8 2 s8 0
C8 s8 4 33e-7
VS9 4 s9 0
C9 s9 0 22e-5
VS10 1 s10 0
C10 s10 3 10e-5
.control
set numdgt=17
ac lin 1 60 60
print v(1) v(2) v(3) v(4) v(5)
print i(vs0) i(vs1) i(vs2) i(vs3) i(vs4) i(vs5) i(vs6) i(vs7) i(vs8) i(vs9)
print i(vs10)
.endc
.end
