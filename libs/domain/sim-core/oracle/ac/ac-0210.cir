controls oracle ac-0210
* Generated (plan F2.7, ADR 0012): do not edit; regenerate with `pnpm sim oracle regen`. ac seed 20261031 index 210 nodes 6 elements 8
.options sparse gmin=1e-12 noopac
RG1 1 0 1000000000000
RG2 2 0 1000000000000
RG3 3 0 1000000000000
RG4 4 0 1000000000000
RG5 5 0 1000000000000
VS0 1 s0 0
L0 s0 2 10e-4
VS1 4 s1 0
R1 s1 1 68e2
VS2 3 s2 0
L2 s2 0 10e-5
VS3 0 s3 0
V3 e3 s3 DC 0 AC 56e1 120
RI3 e3 3 39e-1
VS4 0 s4 0
V4 e4 s4 DC 0 AC 18e-1 180
RI4 e4 3 56e-1
VS5 0 s5 0
L5 s5 5 47e-2
VS6 0 s6 0
R6 s6 3 22e-1
VS7 4 s7 0
C7 s7 0 22e-5
.control
set numdgt=17
ac lin 1 60 60
print v(1) v(2) v(3) v(4) v(5)
print i(vs0) i(vs1) i(vs2) i(vs3) i(vs4) i(vs5) i(vs6) i(vs7)
.endc
.end
