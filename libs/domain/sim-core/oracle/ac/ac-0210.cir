controls oracle ac-0210
* Generated (plan F2.7, ADR 0012): do not edit; regenerate with `pnpm sim oracle regen`. ac seed 20261031 index 210 nodes 6 elements 9
.options sparse gmin=1e-12 noopac
RG1 1 0 1000000000000
RG2 2 0 1000000000000
RG3 3 0 1000000000000
RG4 4 0 1000000000000
RG5 5 0 1000000000000
VS0 3 s0 0
L0 s0 1 56e-4
VS1 1 s1 0
L1 s1 2 12e-5
VS2 4 s2 0
R2 s2 1 68e2
VS3 0 s3 0
R3 s3 5 18e2
VS4 4 s4 0
C4 s4 0 22e-5
VS5 5 s5 0
R5 s5 2 82e3
VS6 0 s6 0
V6 e6 s6 DC 0 AC 56e1 120
RI6 e6 3 39e-1
VS7 3 s7 0
R7 s7 4 47e-2
VS8 1 s8 0
V8 e8 s8 DC 0 AC 10e1 0
RI8 e8 3 12e-1
.control
set numdgt=17
ac lin 1 60 60
print v(1) v(2) v(3) v(4) v(5)
print i(vs0) i(vs1) i(vs2) i(vs3) i(vs4) i(vs5) i(vs6) i(vs7) i(vs8)
.endc
.end
