controls oracle ac-0207
* Generated (plan F2.7, ADR 0012): do not edit; regenerate with `pnpm sim oracle regen`. ac seed 20261031 index 207 nodes 26 elements 52
.options sparse gmin=1e-12 noopac
RG1 1 0 1000000000000
RG2 2 0 1000000000000
RG3 3 0 1000000000000
RG4 4 0 1000000000000
RG5 5 0 1000000000000
RG6 6 0 1000000000000
RG7 7 0 1000000000000
RG8 8 0 1000000000000
RG9 9 0 1000000000000
RG10 10 0 1000000000000
RG11 11 0 1000000000000
RG12 12 0 1000000000000
RG13 13 0 1000000000000
RG14 14 0 1000000000000
RG15 15 0 1000000000000
RG16 16 0 1000000000000
RG17 17 0 1000000000000
RG18 18 0 1000000000000
RG19 19 0 1000000000000
RG20 20 0 1000000000000
RG21 21 0 1000000000000
RG22 22 0 1000000000000
RG23 23 0 1000000000000
RG24 24 0 1000000000000
RG25 25 0 1000000000000
VS0 18 s0 0
R0 s0 9 82e-1
VS1 0 s1 0
V1 e1 s1 DC 0 AC 68e1 180
RI1 e1 9 12e-3
VS2 23 s2 0
L2 s2 2 18e-4
VS3 13 s3 0
C3 s3 0 68e-6
VS4 4 s4 0
C4 s4 2 22e-7
VS5 6 s5 0
L5 s5 10 82e-5
VS6 19 s6 0
V6 e6 s6 DC 0 AC 12e0 0
RI6 e6 m6 27e-2
LI6 m6 23 33e-7
VS7 9 s7 0
C7 s7 17 39e-7
VS8 2 s8 0
V8 e8 s8 DC 0 AC 68e-1 -120
RI8 e8 1 47e-1
VS9 0 s9 0
R9 s9 8 15e3
VS10 0 s10 0
R10 s10 18 18e-2
VS11 20 s11 0
C11 s11 9 10e-6
VS12 9 s12 0
R12 s12 19 15e3
VS13 16 s13 0
L13 s13 0 33e-4
VS14 23 s14 0
L14 s14 24 22e-3
VS15 11 s15 0
R15 s15 21 82e3
VS16 21 s16 0
R16 s16 20 10e-2
VS17 12 s17 0
C17 s17 10 15e-7
VS18 9 s18 0
R18 s18 8 27e-2
VS19 13 s19 0
L19 s19 3 33e-2
VS20 24 s20 0
R20 s20 8 27e2
VS21 14 s21 0
L21 s21 17 33e-4
VS22 15 s22 0
C22 s22 4 82e-6
VS23 21 s23 0
C23 s23 4 47e-6
VS24 7 s24 0
R24 s24 15 33e2
VS25 12 s25 0
V25 e25 s25 DC 0 AC 12e0 0
RI25 e25 0 56e-1
VS26 12 s26 0
V26 e26 s26 DC 0 AC 10e1 180
RI26 e26 m26 39e-2
LI26 m26 9 33e-5
VS27 2 s27 0
C27 s27 0 47e-6
VS28 18 s28 0
L28 s28 7 33e-4
VS29 4 s29 0
R29 s29 21 82e2
VS30 12 s30 0
L30 s30 2 33e-3
VS31 4 s31 0
L31 s31 6 18e-2
VS32 24 s32 0
R32 s32 11 15e3
VS33 22 s33 0
R33 s33 12 33e-2
VS34 14 s34 0
L34 s34 13 18e-2
VS35 10 s35 0
C35 s35 7 68e-5
VS36 10 s36 0
V36 e36 s36 DC 0 AC 47e0 0
RI36 e36 m36 10e-2
LI36 m36 21 39e-5
VS37 4 s37 0
V37 e37 s37 DC 0 AC 82e0 180
RI37 e37 22 39e-1
VS38 2 s38 0
R38 s38 8 33e-2
VS39 1 s39 0
R39 s39 9 10e-1
VS40 8 s40 0
R40 s40 16 15e3
VS41 7 s41 0
L41 s41 6 39e-3
VS42 0 s42 0
L42 s42 10 12e-5
VS43 7 s43 0
R43 s43 2 27e2
VS44 10 s44 0
V44 e44 s44 DC 0 AC 22e1 0
RI44 e44 16 39e-3
VS45 20 s45 0
L45 s45 4 56e-4
VS46 11 s46 0
V46 e46 s46 DC 0 AC 39e1 180
RI46 e46 m46 18e-1
LI46 m46 12 39e-7
VS47 8 s47 0
C47 s47 5 56e-6
VS48 10 s48 0
C48 s48 25 27e-4
VS49 20 s49 0
V49 e49 s49 DC 0 AC 68e-1 -120
RI49 e49 3 27e-3
VS50 17 s50 0
R50 s50 25 82e1
VS51 5 s51 0
R51 s51 22 39e-1
.control
set numdgt=17
ac lin 1 60 60
print v(1) v(2) v(3) v(4) v(5) v(6) v(7) v(8) v(9) v(10)
print v(11) v(12) v(13) v(14) v(15) v(16) v(17) v(18) v(19) v(20)
print v(21) v(22) v(23) v(24) v(25)
print i(vs0) i(vs1) i(vs2) i(vs3) i(vs4) i(vs5) i(vs6) i(vs7) i(vs8) i(vs9)
print i(vs10) i(vs11) i(vs12) i(vs13) i(vs14) i(vs15) i(vs16) i(vs17) i(vs18) i(vs19)
print i(vs20) i(vs21) i(vs22) i(vs23) i(vs24) i(vs25) i(vs26) i(vs27) i(vs28) i(vs29)
print i(vs30) i(vs31) i(vs32) i(vs33) i(vs34) i(vs35) i(vs36) i(vs37) i(vs38) i(vs39)
print i(vs40) i(vs41) i(vs42) i(vs43) i(vs44) i(vs45) i(vs46) i(vs47) i(vs48) i(vs49)
print i(vs50) i(vs51)
.endc
.end
