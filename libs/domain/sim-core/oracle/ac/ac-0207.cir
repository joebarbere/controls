controls oracle ac-0207
* Generated (plan F2.7, ADR 0012): do not edit; regenerate with `pnpm sim oracle regen`. ac seed 20261031 index 207 nodes 26 elements 51
.options sparse gmin=1e-12 noopac
RG1 1 0 1000000000000
RG2 2 0 1000000000000
RG3 3 0 1000000000000
RG4 4 0 1000000000000
RG5 5 0 1000000000000
RG6 6 0 1000000000000
RG7 7 0 1000000000000
RG8 8 0 1000000000000
RG9 9 0 1000000000000
RG10 10 0 1000000000000
RG11 11 0 1000000000000
RG12 12 0 1000000000000
RG13 13 0 1000000000000
RG14 14 0 1000000000000
RG15 15 0 1000000000000
RG16 16 0 1000000000000
RG17 17 0 1000000000000
RG18 18 0 1000000000000
RG19 19 0 1000000000000
RG20 20 0 1000000000000
RG21 21 0 1000000000000
RG22 22 0 1000000000000
RG23 23 0 1000000000000
RG24 24 0 1000000000000
RG25 25 0 1000000000000
VS0 0 s0 0
V0 e0 s0 DC 0 AC 22e1 0
RI0 e0 n0 39e-3
H0 n0 h0 VS4 82e-4
ED0 h0 18 d0 0 82e-7
F0 0 d0 VS4 1
LD0 d0 0 1
VS1 21 s1 0
R1 s1 20 10e-2
VS2 13 s2 0
L2 s2 10 56e-2
VS3 8 s3 0
R3 s3 10 22e1
VS4 8 s4 0
V4 e4 s4 DC 0 AC 18e1 120
RI4 e4 m4 82e-2
LI4 m4 n4 22e-7
H4 n4 h4 VS0 82e-4
ED4 h4 3 d4 0 82e-7
F4 0 d4 VS0 1
LD4 d4 0 1
VS5 8 s5 0
R5 s5 0 18e-1
VS6 12 s6 0
V6 e6 s6 DC 0 AC 12e0 0
RI6 e6 11 56e-1
VS7 17 s7 0
R7 s7 25 82e1
VS8 11 s8 0
L8 s8 23 33e-4
VS9 12 s9 0
C9 s9 4 47e-5
VS10 10 s10 0
R10 s10 2 68e2
VS11 10 s11 0
V11 e11 s11 DC 0 AC 15e1 0
RI11 e11 m11 68e-3
LI11 m11 11 39e-6
VS12 23 s12 0
V12 e12 s12 DC 0 AC 82e1 -120
RI12 e12 15 39e-1
VS13 20 s13 0
C13 s13 13 15e-4
VS14 15 s14 0
C14 s14 4 82e-6
VS15 24 s15 0
C15 s15 6 33e-6
VS16 16 s16 0
L16 s16 11 33e-4
VS17 17 s17 0
V17 e17 s17 DC 0 AC 39e-1 120
RI17 e17 15 47e-1
VS18 18 s18 0
R18 s18 9 82e-1
VS19 15 s19 0
L19 s19 19 82e-2
VS20 5 s20 0
R20 s20 2 18e-2
VS21 12 s21 0
V21 e21 s21 DC 0 AC 10e1 180
RI21 e21 9 39e-2
VS22 6 s22 0
L22 s22 10 82e-5
VS23 20 s23 0
L23 s23 4 56e-4
VS24 23 s24 0
R24 s24 12 10e-2
VS25 25 s25 0
C25 s25 21 39e-7
VS26 17 s26 0
V26 e26 s26 DC 0 AC 39e-1 -120
RI26 e26 m26 27e-2
LI26 m26 24 47e-6
VS27 11 s27 0
C27 s27 16 39e-7
VS28 2 s28 0
C28 s28 11 47e-6
VS29 11 s29 0
L29 s29 10 12e-5
VS30 4 s30 0
L30 s30 19 56e-5
VS31 25 s31 0
R31 s31 4 82e2
VS32 22 s32 0
R32 s32 7 47e-1
VS33 7 s33 0
L33 s33 8 18e-5
VS34 4 s34 0
L34 s34 6 18e-2
VS35 14 s35 0
C35 s35 16 82e-6
VS36 14 s36 0
R36 s36 18 27e-1
VS37 2 s37 0
V37 e37 s37 DC 0 AC 68e-1 -120
RI37 e37 1 47e-1
VS38 23 s38 0
L38 s38 12 27e-4
VS39 9 s39 0
R39 s39 8 27e-2
VS40 22 s40 0
C40 s40 2 27e-6
VS41 5 s41 0
V41 e41 s41 DC 0 AC 39e1 -120
RI41 e41 m41 10e-1
LI41 m41 3 18e-7
VS42 6 s42 0
R42 s42 14 47e-2
VS43 2 s43 0
L43 s43 24 10e-5
VS44 10 s44 0
R44 s44 9 12e-1
VS45 1 s45 0
L45 s45 13 18e-4
VS46 10 s46 0
C46 s46 7 68e-5
VS47 1 s47 0
C47 s47 5 56e-7
VS48 11 s48 0
R48 s48 18 18e-2
VS49 24 s49 0
R49 s49 0 15e3
VS50 21 s50 0
C50 s50 4 47e-6
.control
set numdgt=17
ac lin 1 60 60
print v(1) v(2) v(3) v(4) v(5) v(6) v(7) v(8) v(9) v(10)
print v(11) v(12) v(13) v(14) v(15) v(16) v(17) v(18) v(19) v(20)
print v(21) v(22) v(23) v(24) v(25)
print i(vs0) i(vs1) i(vs2) i(vs3) i(vs4) i(vs5) i(vs6) i(vs7) i(vs8) i(vs9)
print i(vs10) i(vs11) i(vs12) i(vs13) i(vs14) i(vs15) i(vs16) i(vs17) i(vs18) i(vs19)
print i(vs20) i(vs21) i(vs22) i(vs23) i(vs24) i(vs25) i(vs26) i(vs27) i(vs28) i(vs29)
print i(vs30) i(vs31) i(vs32) i(vs33) i(vs34) i(vs35) i(vs36) i(vs37) i(vs38) i(vs39)
print i(vs40) i(vs41) i(vs42) i(vs43) i(vs44) i(vs45) i(vs46) i(vs47) i(vs48) i(vs49)
print i(vs50)
.endc
.end
