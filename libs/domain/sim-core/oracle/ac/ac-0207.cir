controls oracle ac-0207
* Generated (plan F2.7, ADR 0012): do not edit; regenerate with `pnpm sim oracle regen`. ac seed 20261031 index 207 nodes 26 elements 48
.options sparse gmin=1e-12 noopac
RG1 1 0 1000000000000
RG2 2 0 1000000000000
RG3 3 0 1000000000000
RG4 4 0 1000000000000
RG5 5 0 1000000000000
RG6 6 0 1000000000000
RG7 7 0 1000000000000
RG8 8 0 1000000000000
RG9 9 0 1000000000000
RG10 10 0 1000000000000
RG11 11 0 1000000000000
RG12 12 0 1000000000000
RG13 13 0 1000000000000
RG14 14 0 1000000000000
RG15 15 0 1000000000000
RG16 16 0 1000000000000
RG17 17 0 1000000000000
RG18 18 0 1000000000000
RG19 19 0 1000000000000
RG20 20 0 1000000000000
RG21 21 0 1000000000000
RG22 22 0 1000000000000
RG23 23 0 1000000000000
RG24 24 0 1000000000000
RG25 25 0 1000000000000
VS0 23 s0 0
R0 s0 12 10e-2
VS1 0 s1 0
V1 e1 s1 DC 0 AC 39e-1 120
RI1 e1 15 47e-1
VS2 17 s2 0
C2 s2 16 39e-7
VS3 15 s3 0
C3 s3 4 82e-6
VS4 10 s4 0
C4 s4 7 68e-5
VS5 23 s5 0
L5 s5 12 27e-4
VS6 6 s6 0
L6 s6 10 82e-5
VS7 12 s7 0
V7 e7 s7 DC 0 AC 10e1 180
RI7 e7 9 39e-2
VS8 17 s8 0
R8 s8 18 18e-2
VS9 6 s9 0
R9 s9 14 47e-2
VS10 8 s10 0
R10 s10 11 18e-1
VS11 1 s11 0
L11 s11 13 18e-4
VS12 5 s12 0
V12 e12 s12 DC 0 AC 39e1 -120
RI12 e12 3 10e-1
VS13 22 s13 0
C13 s13 2 27e-6
VS14 10 s14 0
R14 s14 2 68e2
VS15 22 s15 0
R15 s15 7 47e-1
VS16 20 s16 0
C16 s16 13 15e-4
VS17 12 s17 0
V17 e17 s17 DC 0 AC 12e0 0
RI17 e17 17 56e-1
VS18 4 s18 0
L18 s18 6 18e-2
VS19 9 s19 0
R19 s19 8 27e-2
VS20 8 s20 0
R20 s20 10 22e1
VS21 25 s21 0
C21 s21 21 39e-7
VS22 21 s22 0
R22 s22 20 10e-2
VS23 23 s23 0
V23 e23 s23 DC 0 AC 82e1 -120
RI23 e23 15 39e-1
VS24 17 s24 0
L24 s24 10 12e-5
VS25 18 s25 0
R25 s25 9 82e-1
VS26 2 s26 0
L26 s26 24 10e-5
VS27 8 s27 0
V27 e27 s27 DC 0 AC 18e1 120
RI27 e27 3 82e-2
VS28 12 s28 0
C28 s28 4 47e-5
VS29 11 s29 0
V29 e29 s29 DC 0 AC 22e1 0
RI29 e29 18 39e-3
VS30 16 s30 0
L30 s30 17 33e-4
VS31 0 s31 0
V31 e31 s31 DC 0 AC 39e-1 -120
RI31 e31 24 27e-2
VS32 13 s32 0
L32 s32 10 56e-2
VS33 5 s33 0
R33 s33 2 18e-2
VS34 10 s34 0
R34 s34 9 12e-1
VS35 24 s35 0
C35 s35 6 33e-6
VS36 4 s36 0
L36 s36 19 56e-5
VS37 17 s37 0
L37 s37 23 33e-4
VS38 2 s38 0
V38 e38 s38 DC 0 AC 68e-1 -120
RI38 e38 1 47e-1
VS39 20 s39 0
L39 s39 4 56e-4
VS40 7 s40 0
L40 s40 8 18e-5
VS41 0 s41 0
R41 s41 25 82e1
VS42 21 s42 0
C42 s42 4 47e-6
VS43 24 s43 0
R43 s43 11 15e3
VS44 10 s44 0
V44 e44 s44 DC 0 AC 15e1 0
RI44 e44 17 68e-3
VS45 25 s45 0
R45 s45 4 82e2
VS46 1 s46 0
C46 s46 5 56e-7
VS47 2 s47 0
C47 s47 17 47e-6
.control
set numdgt=17
ac lin 1 60 60
print v(1) v(2) v(3) v(4) v(5) v(6) v(7) v(8) v(9) v(10)
print v(11) v(12) v(13) v(14) v(15) v(16) v(17) v(18) v(19) v(20)
print v(21) v(22) v(23) v(24) v(25)
print i(vs0) i(vs1) i(vs2) i(vs3) i(vs4) i(vs5) i(vs6) i(vs7) i(vs8) i(vs9)
print i(vs10) i(vs11) i(vs12) i(vs13) i(vs14) i(vs15) i(vs16) i(vs17) i(vs18) i(vs19)
print i(vs20) i(vs21) i(vs22) i(vs23) i(vs24) i(vs25) i(vs26) i(vs27) i(vs28) i(vs29)
print i(vs30) i(vs31) i(vs32) i(vs33) i(vs34) i(vs35) i(vs36) i(vs37) i(vs38) i(vs39)
print i(vs40) i(vs41) i(vs42) i(vs43) i(vs44) i(vs45) i(vs46) i(vs47)
.endc
.end
