controls oracle ac-0310
* Generated (plan F2.7, ADR 0012): do not edit; regenerate with `pnpm sim oracle regen`. ac seed 20261031 index 310 nodes 27 elements 49
.options sparse gmin=1e-12 noopac
RG1 1 0 1000000000000
RG2 2 0 1000000000000
RG3 3 0 1000000000000
RG4 4 0 1000000000000
RG5 5 0 1000000000000
RG6 6 0 1000000000000
RG7 7 0 1000000000000
RG8 8 0 1000000000000
RG9 9 0 1000000000000
RG10 10 0 1000000000000
RG11 11 0 1000000000000
RG12 12 0 1000000000000
RG13 13 0 1000000000000
RG14 14 0 1000000000000
RG15 15 0 1000000000000
RG16 16 0 1000000000000
RG17 17 0 1000000000000
RG18 18 0 1000000000000
RG19 19 0 1000000000000
RG20 20 0 1000000000000
RG21 21 0 1000000000000
RG22 22 0 1000000000000
RG23 23 0 1000000000000
RG24 24 0 1000000000000
RG25 25 0 1000000000000
RG26 26 0 1000000000000
VS0 0 s0 0
V0 e0 s0 DC 0 AC 10e1 120
RI0 e0 m0 10e-3
LI0 m0 25 39e-6
VS1 13 s1 0
R1 s1 24 10e0
VS2 21 s2 0
L2 s2 8 15e-2
VS3 21 s3 0
V3 e3 s3 DC 0 AC 10e1 0
RI3 e3 m3 15e-1
LI3 m3 15 82e-7
VS4 26 s4 0
L4 s4 24 22e-5
VS5 14 s5 0
C5 s5 25 56e-4
VS6 3 s6 0
C6 s6 16 22e-6
VS7 4 s7 0
V7 e7 s7 DC 0 AC 33e0 0
RI7 e7 2 22e-1
VS8 8 s8 0
C8 s8 20 10e-6
VS9 7 s9 0
R9 s9 22 10e2
VS10 2 s10 0
R10 s10 20 18e-2
VS11 24 s11 0
C11 s11 1 82e-7
VS12 16 s12 0
L12 s12 22 39e-2
VS13 20 s13 0
R13 s13 17 68e2
VS14 3 s14 0
R14 s14 23 39e1
VS15 17 s15 0
C15 s15 23 68e-5
VS16 24 s16 0
L16 s16 18 56e-4
VS17 3 s17 0
V17 e17 s17 DC 0 AC 82e-1 0
RI17 e17 m17 10e-1
LI17 m17 12 27e-7
VS18 5 s18 0
R18 s18 0 15e3
VS19 22 s19 0
V19 e19 s19 DC 0 AC 15e0 120
RI19 e19 m19 18e-3
LI19 m19 0 39e-7
VS20 10 s20 0
V20 e20 s20 DC 0 AC 33e-1 0
RI20 e20 m20 18e-1
LI20 m20 20 10e-7
VS21 25 s21 0
V21 e21 s21 DC 0 AC 10e0 120
RI21 e21 18 68e-1
VS22 6 s22 0
L22 s22 24 56e-4
VS23 3 s23 0
L23 s23 5 47e-3
VS24 22 s24 0
V24 e24 s24 DC 0 AC 56e0 -120
RI24 e24 m24 33e-2
LI24 m24 3 39e-5
VS25 22 s25 0
C25 s25 14 33e-4
VS26 13 s26 0
L26 s26 19 15e-4
VS27 9 s27 0
R27 s27 22 22e1
VS28 11 s28 0
L28 s28 16 27e-3
VS29 8 s29 0
C29 s29 26 33e-7
VS30 6 s30 0
V30 e30 s30 DC 0 AC 10e0 -120
RI30 e30 7 18e-2
VS31 12 s31 0
R31 s31 24 10e-1
VS32 6 s32 0
L32 s32 8 47e-4
VS33 21 s33 0
V33 e33 s33 DC 0 AC 47e-1 180
RI33 e33 13 56e-1
VS34 26 s34 0
R34 s34 9 47e-1
VS35 24 s35 0
L35 s35 16 47e-2
VS36 21 s36 0
V36 e36 s36 DC 0 AC 56e0 120
RI36 e36 m36 68e-3
LI36 m36 23 82e-5
VS37 4 s37 0
R37 s37 16 68e-1
VS38 4 s38 0
L38 s38 10 68e-2
VS39 19 s39 0
C39 s39 16 18e-7
VS40 21 s40 0
R40 s40 1 15e-1
VS41 7 s41 0
V41 e41 s41 DC 0 AC 82e0 120
RI41 e41 m41 18e-1
LI41 m41 0 18e-6
VS42 23 s42 0
R42 s42 24 10e1
VS43 24 s43 0
R43 s43 15 18e-2
VS44 12 s44 0
R44 s44 18 82e2
VS45 7 s45 0
R45 s45 16 22e3
VS46 5 s46 0
R46 s46 21 82e1
VS47 11 s47 0
R47 s47 14 27e-2
VS48 14 s48 0
C48 s48 18 27e-4
.control
set numdgt=17
ac lin 1 60 60
print v(1) v(2) v(3) v(4) v(5) v(6) v(7) v(8) v(9) v(10)
print v(11) v(12) v(13) v(14) v(15) v(16) v(17) v(18) v(19) v(20)
print v(21) v(22) v(23) v(24) v(25) v(26)
print i(vs0) i(vs1) i(vs2) i(vs3) i(vs4) i(vs5) i(vs6) i(vs7) i(vs8) i(vs9)
print i(vs10) i(vs11) i(vs12) i(vs13) i(vs14) i(vs15) i(vs16) i(vs17) i(vs18) i(vs19)
print i(vs20) i(vs21) i(vs22) i(vs23) i(vs24) i(vs25) i(vs26) i(vs27) i(vs28) i(vs29)
print i(vs30) i(vs31) i(vs32) i(vs33) i(vs34) i(vs35) i(vs36) i(vs37) i(vs38) i(vs39)
print i(vs40) i(vs41) i(vs42) i(vs43) i(vs44) i(vs45) i(vs46) i(vs47) i(vs48)
.endc
.end
