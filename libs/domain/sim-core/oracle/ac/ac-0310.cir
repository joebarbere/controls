controls oracle ac-0310
* Generated (plan F2.7, ADR 0012): do not edit; regenerate with `pnpm sim oracle regen`. ac seed 20261031 index 310 nodes 27 elements 41
.options sparse gmin=1e-12 noopac
RG1 1 0 1000000000000
RG2 2 0 1000000000000
RG3 3 0 1000000000000
RG4 4 0 1000000000000
RG5 5 0 1000000000000
RG6 6 0 1000000000000
RG7 7 0 1000000000000
RG8 8 0 1000000000000
RG9 9 0 1000000000000
RG10 10 0 1000000000000
RG11 11 0 1000000000000
RG12 12 0 1000000000000
RG13 13 0 1000000000000
RG14 14 0 1000000000000
RG15 15 0 1000000000000
RG16 16 0 1000000000000
RG17 17 0 1000000000000
RG18 18 0 1000000000000
RG19 19 0 1000000000000
RG20 20 0 1000000000000
RG21 21 0 1000000000000
RG22 22 0 1000000000000
RG23 23 0 1000000000000
RG24 24 0 1000000000000
RG25 25 0 1000000000000
RG26 26 0 1000000000000
VS0 0 s0 0
V0 e0 s0 DC 0 AC 33e-1 120
RI0 e0 17 22e-3
VS1 3 s1 0
R1 s1 10 56e0
VS2 25 s2 0
C2 s2 3 18e-6
VS3 5 s3 0
V3 e3 s3 DC 0 AC 33e0 0
RI3 e3 22 18e-1
VS4 9 s4 0
R4 s4 22 12e-1
VS5 19 s5 0
R5 s5 23 68e-1
VS6 24 s6 0
V6 e6 s6 DC 0 AC 15e-1 0
RI6 e6 10 22e-3
VS7 26 s7 0
R7 s7 11 15e1
VS8 14 s8 0
L8 s8 18 39e-5
VS9 23 s9 0
L9 s9 8 39e-5
VS10 8 s10 0
R10 s10 9 18e3
VS11 6 s11 0
R11 s11 19 39e3
VS12 20 s12 0
V12 e12 s12 DC 0 AC 10e1 0
RI12 e12 8 15e-2
VS13 18 s13 0
L13 s13 22 15e-4
VS14 2 s14 0
C14 s14 24 68e-4
VS15 26 s15 0
L15 s15 15 15e-3
VS16 24 s16 0
C16 s16 11 47e-5
VS17 20 s17 0
R17 s17 22 33e2
VS18 10 s18 0
R18 s18 6 68e-1
VS19 16 s19 0
R19 s19 23 22e3
VS20 25 s20 0
L20 s20 16 56e-3
VS21 7 s21 0
C21 s21 18 18e-7
VS22 17 s22 0
V22 e22 s22 DC 0 AC 33e0 0
RI22 e22 12 22e-1
VS23 23 s23 0
L23 s23 1 56e-5
VS24 2 s24 0
R24 s24 12 47e3
VS25 18 s25 0
R25 s25 13 22e-2
VS26 21 s26 0
V26 e26 s26 DC 0 AC 56e0 120
RI26 e26 23 68e-3
VS27 15 s27 0
C27 s27 3 22e-6
VS28 21 s28 0
V28 e28 s28 DC 0 AC 82e0 120
RI28 e28 m28 18e-1
LI28 m28 4 15e-5
VS29 8 s29 0
R29 s29 7 15e1
VS30 21 s30 0
V30 e30 s30 DC 0 AC 39e-1 180
RI30 e30 m30 12e-3
LI30 m30 4 56e-7
VS31 15 s31 0
R31 s31 0 39e1
VS32 24 s32 0
V32 e32 s32 DC 0 AC 82e1 120
RI32 e32 4 18e-3
VS33 5 s33 0
L33 s33 15 12e-4
VS34 0 s34 0
L34 s34 18 56e-4
VS35 8 s35 0
V35 e35 s35 DC 0 AC 56e0 0
RI35 e35 m35 10e-3
LI35 m35 2 15e-7
VS36 9 s36 0
C36 s36 11 22e-7
VS37 1 s37 0
C37 s37 14 22e-7
VS38 23 s38 0
R38 s38 0 10e1
VS39 10 s39 0
R39 s39 13 10e1
VS40 25 s40 0
R40 s40 15 39e0
.control
set numdgt=17
ac lin 1 60 60
print v(1) v(2) v(3) v(4) v(5) v(6) v(7) v(8) v(9) v(10)
print v(11) v(12) v(13) v(14) v(15) v(16) v(17) v(18) v(19) v(20)
print v(21) v(22) v(23) v(24) v(25) v(26)
print i(vs0) i(vs1) i(vs2) i(vs3) i(vs4) i(vs5) i(vs6) i(vs7) i(vs8) i(vs9)
print i(vs10) i(vs11) i(vs12) i(vs13) i(vs14) i(vs15) i(vs16) i(vs17) i(vs18) i(vs19)
print i(vs20) i(vs21) i(vs22) i(vs23) i(vs24) i(vs25) i(vs26) i(vs27) i(vs28) i(vs29)
print i(vs30) i(vs31) i(vs32) i(vs33) i(vs34) i(vs35) i(vs36) i(vs37) i(vs38) i(vs39)
print i(vs40)
.endc
.end
