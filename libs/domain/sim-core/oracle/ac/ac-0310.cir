controls oracle ac-0310
* Generated (plan F2.7, ADR 0012): do not edit; regenerate with `pnpm sim oracle regen`. ac seed 20261031 index 310 nodes 27 elements 48
.options sparse gmin=1e-12 noopac
RG1 1 0 1000000000000
RG2 2 0 1000000000000
RG3 3 0 1000000000000
RG4 4 0 1000000000000
RG5 5 0 1000000000000
RG6 6 0 1000000000000
RG7 7 0 1000000000000
RG8 8 0 1000000000000
RG9 9 0 1000000000000
RG10 10 0 1000000000000
RG11 11 0 1000000000000
RG12 12 0 1000000000000
RG13 13 0 1000000000000
RG14 14 0 1000000000000
RG15 15 0 1000000000000
RG16 16 0 1000000000000
RG17 17 0 1000000000000
RG18 18 0 1000000000000
RG19 19 0 1000000000000
RG20 20 0 1000000000000
RG21 21 0 1000000000000
RG22 22 0 1000000000000
RG23 23 0 1000000000000
RG24 24 0 1000000000000
RG25 25 0 1000000000000
RG26 26 0 1000000000000
VS0 3 s0 0
L0 s0 5 47e-3
VS1 8 s1 0
C1 s1 20 10e-6
VS2 0 s2 0
V2 e2 s2 DC 0 AC 82e0 120
RI2 e2 24 18e-1
VS3 22 s3 0
V3 e3 s3 DC 0 AC 15e0 120
RI3 e3 24 18e-3
VS4 21 s4 0
R4 s4 1 15e-1
VS5 5 s5 0
R5 s5 24 15e3
VS6 7 s6 0
L6 s6 16 47e-2
VS7 3 s7 0
V7 e7 s7 DC 0 AC 82e-1 0
RI7 e7 12 10e-1
VS8 26 s8 0
L8 s8 7 22e-5
VS9 6 s9 0
V9 e9 s9 DC 0 AC 10e0 -120
RI9 e9 0 18e-2
VS10 22 s10 0
C10 s10 14 33e-4
VS11 7 s11 0
C11 s11 1 82e-7
VS12 21 s12 0
V12 e12 s12 DC 0 AC 10e1 0
RI12 e12 15 15e-1
VS13 23 s13 0
R13 s13 7 10e1
VS14 4 s14 0
R14 s14 16 68e-1
VS15 8 s15 0
C15 s15 26 33e-7
VS16 25 s16 0
V16 e16 s16 DC 0 AC 10e0 120
RI16 e16 18 68e-1
VS17 20 s17 0
R17 s17 17 68e2
VS18 11 s18 0
R18 s18 14 27e-2
VS19 7 s19 0
R19 s19 15 18e-2
VS20 21 s20 0
V20 e20 s20 DC 0 AC 56e0 120
RI20 e20 23 68e-3
VS21 12 s21 0
R21 s21 18 82e2
VS22 0 s22 0
R22 s22 22 10e2
VS23 13 s23 0
R23 s23 7 10e0
VS24 0 s24 0
R24 s24 16 22e3
VS25 4 s25 0
L25 s25 10 68e-2
VS26 14 s26 0
C26 s26 25 56e-4
VS27 16 s27 0
L27 s27 22 39e-2
VS28 12 s28 0
R28 s28 7 10e-1
VS29 21 s29 0
V29 e29 s29 DC 0 AC 47e-1 180
RI29 e29 13 56e-1
VS30 22 s30 0
V30 e30 s30 DC 0 AC 56e0 -120
RI30 e30 3 33e-2
VS31 11 s31 0
L31 s31 16 27e-3
VS32 17 s32 0
C32 s32 23 68e-5
VS33 21 s33 0
L33 s33 8 15e-2
VS34 5 s34 0
R34 s34 21 82e1
VS35 7 s35 0
L35 s35 18 56e-4
VS36 14 s36 0
C36 s36 18 27e-4
VS37 6 s37 0
L37 s37 8 47e-4
VS38 2 s38 0
R38 s38 20 18e-2
VS39 3 s39 0
R39 s39 23 39e1
VS40 26 s40 0
R40 s40 9 47e-1
VS41 13 s41 0
L41 s41 19 15e-4
VS42 4 s42 0
V42 e42 s42 DC 0 AC 33e0 0
RI42 e42 2 22e-1
VS43 24 s43 0
V43 e43 s43 DC 0 AC 10e1 120
RI43 e43 25 10e-3
VS44 9 s44 0
R44 s44 22 22e1
VS45 3 s45 0
C45 s45 16 22e-6
VS46 19 s46 0
C46 s46 16 18e-7
VS47 6 s47 0
L47 s47 7 56e-4
.control
set numdgt=17
ac lin 1 60 60
print v(1) v(2) v(3) v(4) v(5) v(6) v(7) v(8) v(9) v(10)
print v(11) v(12) v(13) v(14) v(15) v(16) v(17) v(18) v(19) v(20)
print v(21) v(22) v(23) v(24) v(25) v(26)
print i(vs0) i(vs1) i(vs2) i(vs3) i(vs4) i(vs5) i(vs6) i(vs7) i(vs8) i(vs9)
print i(vs10) i(vs11) i(vs12) i(vs13) i(vs14) i(vs15) i(vs16) i(vs17) i(vs18) i(vs19)
print i(vs20) i(vs21) i(vs22) i(vs23) i(vs24) i(vs25) i(vs26) i(vs27) i(vs28) i(vs29)
print i(vs30) i(vs31) i(vs32) i(vs33) i(vs34) i(vs35) i(vs36) i(vs37) i(vs38) i(vs39)
print i(vs40) i(vs41) i(vs42) i(vs43) i(vs44) i(vs45) i(vs46) i(vs47)
.endc
.end
