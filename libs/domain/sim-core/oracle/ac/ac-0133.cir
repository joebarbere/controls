controls oracle ac-0133
* Generated (plan F2.7, ADR 0012): do not edit; regenerate with `pnpm sim oracle regen`. ac seed 20261031 index 133 nodes 14 elements 23
.options sparse gmin=1e-12 noopac
RG1 1 0 1000000000000
RG2 2 0 1000000000000
RG3 3 0 1000000000000
RG4 4 0 1000000000000
RG5 5 0 1000000000000
RG6 6 0 1000000000000
RG7 7 0 1000000000000
RG8 8 0 1000000000000
RG9 9 0 1000000000000
RG10 10 0 1000000000000
RG11 11 0 1000000000000
RG12 12 0 1000000000000
RG13 13 0 1000000000000
VS0 12 s0 0
R0 s0 4 56e2
VS1 2 s1 0
R1 s1 6 33e-1
VS2 5 s2 0
R2 s2 4 33e0
VS3 8 s3 0
R3 s3 5 15e-2
VS4 6 s4 0
R4 s4 3 15e0
VS5 4 s5 0
R5 s5 11 47e1
VS6 6 s6 0
R6 s6 13 22e3
VS7 13 s7 0
R7 s7 11 47e1
VS8 10 s8 0
R8 s8 2 22e-1
VS9 13 s9 0
C9 s9 1 15e-6
VS10 8 s10 0
R10 s10 11 27e2
VS11 9 s11 0
L11 s11 4 12e-3
VS12 13 s12 0
L12 s12 5 33e-4
VS13 4 s13 0
C13 s13 12 68e-5
VS14 3 s14 0
L14 s14 7 82e-5
VS15 0 s15 0
V15 e15 s15 DC 0 AC 82e0 -120
RI15 e15 12 82e-2
VS16 0 s16 0
C16 s16 1 10e-7
VS17 0 s17 0
L17 s17 13 15e-2
VS18 10 s18 0
L18 s18 6 82e-4
VS19 2 s19 0
R19 s19 7 15e-2
VS20 4 s20 0
V20 e20 s20 DC 0 AC 68e0 120
RI20 e20 3 10e-3
VS21 6 s21 0
L21 s21 2 39e-2
VS22 9 s22 0
R22 s22 0 56e1
.control
set numdgt=17
ac lin 1 60 60
print v(1) v(2) v(3) v(4) v(5) v(6) v(7) v(8) v(9) v(10)
print v(11) v(12) v(13)
print i(vs0) i(vs1) i(vs2) i(vs3) i(vs4) i(vs5) i(vs6) i(vs7) i(vs8) i(vs9)
print i(vs10) i(vs11) i(vs12) i(vs13) i(vs14) i(vs15) i(vs16) i(vs17) i(vs18) i(vs19)
print i(vs20) i(vs21) i(vs22)
.endc
.end
