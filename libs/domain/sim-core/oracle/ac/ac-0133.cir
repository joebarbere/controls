controls oracle ac-0133
* Generated (plan F2.7, ADR 0012): do not edit; regenerate with `pnpm sim oracle regen`. ac seed 20261031 index 133 nodes 14 elements 24
.options sparse gmin=1e-12 noopac
RG1 1 0 1000000000000
RG2 2 0 1000000000000
RG3 3 0 1000000000000
RG4 4 0 1000000000000
RG5 5 0 1000000000000
RG6 6 0 1000000000000
RG7 7 0 1000000000000
RG8 8 0 1000000000000
RG9 9 0 1000000000000
RG10 10 0 1000000000000
RG11 11 0 1000000000000
RG12 12 0 1000000000000
RG13 13 0 1000000000000
VS0 5 s0 0
R0 s0 2 22e-1
VS1 0 s1 0
C1 s1 12 68e-5
VS2 13 s2 0
R2 s2 4 47e1
VS3 9 s3 0
L3 s3 0 12e-3
VS4 10 s4 0
L4 s4 6 82e-4
VS5 12 s5 0
R5 s5 0 56e2
VS6 5 s6 0
R6 s6 0 33e0
VS7 8 s7 0
R7 s7 4 27e2
VS8 6 s8 0
R8 s8 3 15e0
VS9 0 s9 0
V9 e9 s9 DC 0 AC 68e0 120
RI9 e9 m9 10e-3
LI9 m9 3 12e-6
VS10 3 s10 0
L10 s10 7 82e-5
VS11 13 s11 0
C11 s11 1 15e-6
VS12 0 s12 0
R12 s12 11 15e-2
VS13 6 s13 0
R13 s13 13 22e3
VS14 2 s14 0
R14 s14 6 33e-1
VS15 8 s15 0
R15 s15 9 12e-2
VS16 9 s16 0
R16 s16 10 56e1
VS17 7 s17 0
C17 s17 1 10e-7
VS18 9 s18 0
L18 s18 12 33e-4
VS19 11 s19 0
L19 s19 13 15e-2
VS20 6 s20 0
L20 s20 2 39e-2
VS21 2 s21 0
R21 s21 7 15e-2
VS22 0 s22 0
R22 s22 4 47e1
VS23 7 s23 0
L23 s23 6 82e-4
.control
set numdgt=17
ac lin 1 60 60
print v(1) v(2) v(3) v(4) v(5) v(6) v(7) v(8) v(9) v(10)
print v(11) v(12) v(13)
print i(vs0) i(vs1) i(vs2) i(vs3) i(vs4) i(vs5) i(vs6) i(vs7) i(vs8) i(vs9)
print i(vs10) i(vs11) i(vs12) i(vs13) i(vs14) i(vs15) i(vs16) i(vs17) i(vs18) i(vs19)
print i(vs20) i(vs21) i(vs22) i(vs23)
.endc
.end
