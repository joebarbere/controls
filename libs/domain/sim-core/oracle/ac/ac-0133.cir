controls oracle ac-0133
* Generated (plan F2.7, ADR 0012): do not edit; regenerate with `pnpm sim oracle regen`. ac seed 20261031 index 133 nodes 14 elements 18
.options sparse gmin=1e-12 noopac
RG1 1 0 1000000000000
RG2 2 0 1000000000000
RG3 3 0 1000000000000
RG4 4 0 1000000000000
RG5 5 0 1000000000000
RG6 6 0 1000000000000
RG7 7 0 1000000000000
RG8 8 0 1000000000000
RG9 9 0 1000000000000
RG10 10 0 1000000000000
RG11 11 0 1000000000000
RG12 12 0 1000000000000
RG13 13 0 1000000000000
VS0 0 s0 0
V0 e0 s0 DC 0 AC 68e0 120
RI0 e0 3 10e-3
VS1 3 s1 0
L1 s1 7 82e-5
VS2 2 s2 0
R2 s2 7 15e-2
VS3 0 s3 0
R3 s3 4 47e1
VS4 0 s4 0
C4 s4 12 68e-5
VS5 13 s5 0
R5 s5 4 47e1
VS6 8 s6 0
R6 s6 4 27e2
VS7 5 s7 0
R7 s7 0 33e0
VS8 2 s8 0
R8 s8 6 33e-1
VS9 6 s9 0
R9 s9 13 22e3
VS10 11 s10 0
V10 e10 s10 DC 0 AC 82e0 -120
RI10 e10 12 82e-2
VS11 11 s11 0
L11 s11 13 15e-2
VS12 9 s12 0
L12 s12 0 12e-3
VS13 6 s13 0
L13 s13 2 39e-2
VS14 12 s14 0
R14 s14 0 56e2
VS15 10 s15 0
L15 s15 6 82e-4
VS16 13 s16 0
C16 s16 1 15e-6
VS17 6 s17 0
R17 s17 3 15e0
.control
set numdgt=17
ac lin 1 60 60
print v(1) v(2) v(3) v(4) v(5) v(6) v(7) v(8) v(9) v(10)
print v(11) v(12) v(13)
print i(vs0) i(vs1) i(vs2) i(vs3) i(vs4) i(vs5) i(vs6) i(vs7) i(vs8) i(vs9)
print i(vs10) i(vs11) i(vs12) i(vs13) i(vs14) i(vs15) i(vs16) i(vs17)
.endc
.end
