controls oracle ac-0053
* Generated (plan F2.7, ADR 0012): do not edit; regenerate with `pnpm sim oracle regen`. ac seed 20261031 index 53 nodes 2 elements 4
.options sparse gmin=1e-12 noopac
RG1 1 0 1000000000000
VS0 0 s0 0
V0 e0 s0 DC 0 AC 22e-1 -120
RI0 e0 1 15e-3
VS1 0 s1 0
R1 s1 1 12e-2
VS2 1 s2 0
R2 s2 0 10e3
VS3 1 s3 0
L3 s3 0 47e-3
.control
set numdgt=17
ac lin 1 60 60
print v(1)
print i(vs0) i(vs1) i(vs2) i(vs3)
.endc
.end
