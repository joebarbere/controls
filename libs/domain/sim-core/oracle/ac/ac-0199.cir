controls oracle ac-0199
* Generated (plan F2.7, ADR 0012): do not edit; regenerate with `pnpm sim oracle regen`. ac seed 20261031 index 199 nodes 29 elements 30
.options sparse gmin=1e-12 noopac
RG1 1 0 1000000000000
RG2 2 0 1000000000000
RG3 3 0 1000000000000
RG4 4 0 1000000000000
RG5 5 0 1000000000000
RG6 6 0 1000000000000
RG7 7 0 1000000000000
RG8 8 0 1000000000000
RG9 9 0 1000000000000
RG10 10 0 1000000000000
RG11 11 0 1000000000000
RG12 12 0 1000000000000
RG13 13 0 1000000000000
RG14 14 0 1000000000000
RG15 15 0 1000000000000
RG16 16 0 1000000000000
RG17 17 0 1000000000000
RG18 18 0 1000000000000
RG19 19 0 1000000000000
RG20 20 0 1000000000000
RG21 21 0 1000000000000
RG22 22 0 1000000000000
RG23 23 0 1000000000000
RG24 24 0 1000000000000
RG25 25 0 1000000000000
RG26 26 0 1000000000000
RG27 27 0 1000000000000
RG28 28 0 1000000000000
VS0 10 s0 0
L0 s0 18 15e-5
VS1 14 s1 0
R1 s1 26 68e1
VS2 23 s2 0
L2 s2 5 10e-3
VS3 0 s3 0
V3 e3 s3 DC 0 AC 47e1 0
RI3 e3 19 56e-2
VS4 25 s4 0
C4 s4 14 15e-7
VS5 18 s5 0
R5 s5 2 33e0
VS6 2 s6 0
L6 s6 22 68e-4
VS7 2 s7 0
V7 e7 s7 DC 0 AC 56e-1 180
RI7 e7 24 39e-2
VS8 27 s8 0
C8 s8 11 22e-5
VS9 13 s9 0
R9 s9 6 10e-1
VS10 24 s10 0
C10 s10 3 56e-7
VS11 2 s11 0
R11 s11 14 68e2
VS12 14 s12 0
L12 s12 21 39e-4
VS13 10 s13 0
L13 s13 9 82e-4
VS14 2 s14 0
R14 s14 20 39e-1
VS15 23 s15 0
L15 s15 7 22e-4
VS16 12 s16 0
L16 s16 25 12e-5
VS17 22 s17 0
V17 e17 s17 DC 0 AC 18e-1 -120
RI17 e17 19 12e-2
VS18 15 s18 0
L18 s18 18 12e-3
VS19 11 s19 0
L19 s19 20 33e-4
VS20 21 s20 0
L20 s20 28 56e-2
VS21 14 s21 0
V21 e21 s21 DC 0 AC 39e-1 -120
RI21 e21 5 68e-3
VS22 4 s22 0
V22 e22 s22 DC 0 AC 39e0 -120
RI22 e22 8 68e-3
VS23 10 s23 0
L23 s23 16 68e-3
VS24 0 s24 0
C24 s24 23 18e-5
VS25 17 s25 0
C25 s25 26 27e-5
VS26 14 s26 0
L26 s26 13 33e-2
VS27 4 s27 0
R27 s27 5 47e2
VS28 14 s28 0
C28 s28 1 12e-5
VS29 4 s29 0
V29 e29 s29 DC 0 AC 82e-1 120
RI29 e29 3 39e-2
.control
set numdgt=17
ac lin 1 60 60
print v(1) v(2) v(3) v(4) v(5) v(6) v(7) v(8) v(9) v(10)
print v(11) v(12) v(13) v(14) v(15) v(16) v(17) v(18) v(19) v(20)
print v(21) v(22) v(23) v(24) v(25) v(26) v(27) v(28)
print i(vs0) i(vs1) i(vs2) i(vs3) i(vs4) i(vs5) i(vs6) i(vs7) i(vs8) i(vs9)
print i(vs10) i(vs11) i(vs12) i(vs13) i(vs14) i(vs15) i(vs16) i(vs17) i(vs18) i(vs19)
print i(vs20) i(vs21) i(vs22) i(vs23) i(vs24) i(vs25) i(vs26) i(vs27) i(vs28) i(vs29)
.endc
.end
