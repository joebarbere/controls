controls oracle ac-0199
* Generated (plan F2.7, ADR 0012): do not edit; regenerate with `pnpm sim oracle regen`. ac seed 20261031 index 199 nodes 29 elements 48
.options sparse gmin=1e-12 noopac
RG1 1 0 1000000000000
RG2 2 0 1000000000000
RG3 3 0 1000000000000
RG4 4 0 1000000000000
RG5 5 0 1000000000000
RG6 6 0 1000000000000
RG7 7 0 1000000000000
RG8 8 0 1000000000000
RG9 9 0 1000000000000
RG10 10 0 1000000000000
RG11 11 0 1000000000000
RG12 12 0 1000000000000
RG13 13 0 1000000000000
RG14 14 0 1000000000000
RG15 15 0 1000000000000
RG16 16 0 1000000000000
RG17 17 0 1000000000000
RG18 18 0 1000000000000
RG19 19 0 1000000000000
RG20 20 0 1000000000000
RG21 21 0 1000000000000
RG22 22 0 1000000000000
RG23 23 0 1000000000000
RG24 24 0 1000000000000
RG25 25 0 1000000000000
RG26 26 0 1000000000000
RG27 27 0 1000000000000
RG28 28 0 1000000000000
VS0 8 s0 0
R0 s0 11 18e-1
VS1 25 s1 0
R1 s1 3 68e0
VS2 0 s2 0
V2 e2 s2 DC 0 AC 56e1 -120
RI2 e2 m2 10e-1
LI2 m2 21 22e-7
VS3 8 s3 0
L3 s3 13 56e-2
VS4 6 s4 0
R4 s4 5 82e1
VS5 16 s5 0
L5 s5 14 10e-2
VS6 21 s6 0
C6 s6 13 12e-7
VS7 13 s7 0
R7 s7 18 33e0
VS8 20 s8 0
R8 s8 3 12e-1
VS9 4 s9 0
R9 s9 1 47e0
VS10 23 s10 0
R10 s10 9 56e3
VS11 6 s11 0
V11 e11 s11 DC 0 AC 22e-1 0
RI11 e11 m11 10e-2
LI11 m11 16 27e-5
VS12 25 s12 0
V12 e12 s12 DC 0 AC 10e0 -120
RI12 e12 m12 12e-3
LI12 m12 15 47e-6
VS13 17 s13 0
R13 s13 13 82e1
VS14 15 s14 0
V14 e14 s14 DC 0 AC 39e-1 -120
RI14 e14 m14 68e-3
LI14 m14 5 47e-7
VS15 24 s15 0
C15 s15 11 56e-7
VS16 7 s16 0
R16 s16 0 33e1
VS17 15 s17 0
R17 s17 4 47e-2
VS18 16 s18 0
R18 s18 27 56e1
VS19 5 s19 0
R19 s19 7 27e-1
VS20 1 s20 0
R20 s20 10 56e-1
VS21 19 s21 0
L21 s21 9 82e-3
VS22 20 s22 0
V22 e22 s22 DC 0 AC 22e1 -120
RI22 e22 m22 33e-1
LI22 m22 12 12e-6
VS23 2 s23 0
R23 s23 22 39e3
VS24 13 s24 0
L24 s24 16 22e-3
VS25 14 s25 0
R25 s25 17 12e0
VS26 25 s26 0
R26 s26 20 82e-2
VS27 7 s27 0
C27 s27 10 39e-7
VS28 3 s28 0
L28 s28 28 22e-3
VS29 15 s29 0
C29 s29 2 47e-6
VS30 13 s30 0
R30 s30 8 22e-1
VS31 28 s31 0
C31 s31 23 33e-7
VS32 24 s32 0
C32 s32 12 39e-6
VS33 2 s33 0
C33 s33 21 10e-5
VS34 11 s34 0
R34 s34 2 39e-1
VS35 4 s35 0
R35 s35 18 27e1
VS36 26 s36 0
L36 s36 20 12e-5
VS37 27 s37 0
V37 e37 s37 DC 0 AC 27e0 120
RI37 e37 7 56e-1
VS38 18 s38 0
C38 s38 24 18e-5
VS39 19 s39 0
R39 s39 25 82e-2
VS40 2 s40 0
R40 s40 1 82e1
VS41 22 s41 0
R41 s41 9 27e2
VS42 20 s42 0
L42 s42 5 47e-3
VS43 4 s43 0
R43 s43 23 18e3
VS44 24 s44 0
V44 e44 s44 DC 0 AC 10e-1 -120
RI44 e44 m44 22e-3
LI44 m44 10 18e-6
VS45 15 s45 0
R45 s45 26 56e3
VS46 18 s46 0
L46 s46 2 47e-5
VS47 0 s47 0
V47 e47 s47 DC 0 AC 56e0 -120
RI47 e47 m47 33e-2
LI47 m47 17 56e-5
.control
set numdgt=17
ac lin 1 60 60
print v(1) v(2) v(3) v(4) v(5) v(6) v(7) v(8) v(9) v(10)
print v(11) v(12) v(13) v(14) v(15) v(16) v(17) v(18) v(19) v(20)
print v(21) v(22) v(23) v(24) v(25) v(26) v(27) v(28)
print i(vs0) i(vs1) i(vs2) i(vs3) i(vs4) i(vs5) i(vs6) i(vs7) i(vs8) i(vs9)
print i(vs10) i(vs11) i(vs12) i(vs13) i(vs14) i(vs15) i(vs16) i(vs17) i(vs18) i(vs19)
print i(vs20) i(vs21) i(vs22) i(vs23) i(vs24) i(vs25) i(vs26) i(vs27) i(vs28) i(vs29)
print i(vs30) i(vs31) i(vs32) i(vs33) i(vs34) i(vs35) i(vs36) i(vs37) i(vs38) i(vs39)
print i(vs40) i(vs41) i(vs42) i(vs43) i(vs44) i(vs45) i(vs46) i(vs47)
.endc
.end
