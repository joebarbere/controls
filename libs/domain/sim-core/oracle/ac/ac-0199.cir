controls oracle ac-0199
* Generated (plan F2.7, ADR 0012): do not edit; regenerate with `pnpm sim oracle regen`. ac seed 20261031 index 199 nodes 29 elements 40
.options sparse gmin=1e-12 noopac
RG1 1 0 1000000000000
RG2 2 0 1000000000000
RG3 3 0 1000000000000
RG4 4 0 1000000000000
RG5 5 0 1000000000000
RG6 6 0 1000000000000
RG7 7 0 1000000000000
RG8 8 0 1000000000000
RG9 9 0 1000000000000
RG10 10 0 1000000000000
RG11 11 0 1000000000000
RG12 12 0 1000000000000
RG13 13 0 1000000000000
RG14 14 0 1000000000000
RG15 15 0 1000000000000
RG16 16 0 1000000000000
RG17 17 0 1000000000000
RG18 18 0 1000000000000
RG19 19 0 1000000000000
RG20 20 0 1000000000000
RG21 21 0 1000000000000
RG22 22 0 1000000000000
RG23 23 0 1000000000000
RG24 24 0 1000000000000
RG25 25 0 1000000000000
RG26 26 0 1000000000000
RG27 27 0 1000000000000
RG28 28 0 1000000000000
VS0 24 s0 0
C0 s0 3 56e-7
VS1 13 s1 0
R1 s1 6 10e-1
VS2 25 s2 0
R2 s2 8 82e1
VS3 9 s3 0
C3 s3 1 10e-6
VS4 12 s4 0
L4 s4 4 18e-2
VS5 10 s5 0
L5 s5 18 15e-5
VS6 18 s6 0
R6 s6 2 33e0
VS7 0 s7 0
V7 e7 s7 DC 0 AC 56e1 120
RI7 e7 m7 10e-3
LI7 m7 n7 56e-6
H7 n7 h7 VS13 18e-4
ED7 h7 27 d7 0 56e-7
F7 0 d7 VS13 1
LD7 d7 0 1
VS8 11 s8 0
L8 s8 20 33e-4
VS9 23 s9 0
L9 s9 7 22e-4
VS10 21 s10 0
L10 s10 0 56e-2
VS11 17 s11 0
C11 s11 26 27e-5
VS12 23 s12 0
L12 s12 5 10e-3
VS13 6 s13 0
V13 e13 s13 DC 0 AC 18e0 -120
RI13 e13 n13 12e-3
H13 n13 h13 VS7 18e-4
ED13 h13 15 d13 0 56e-7
F13 0 d13 VS7 1
LD13 d13 0 1
VS14 12 s14 0
L14 s14 25 12e-5
VS15 28 s15 0
R15 s15 26 68e1
VS16 28 s16 0
C16 s16 1 12e-5
VS17 27 s17 0
C17 s17 11 22e-5
VS18 9 s18 0
V18 e18 s18 DC 0 AC 22e1 -120
RI18 e18 m18 33e-1
LI18 m18 23 10e-6
VS19 7 s19 0
C19 s19 20 39e-4
VS20 2 s20 0
R20 s20 28 68e2
VS21 16 s21 0
R21 s21 5 27e1
VS22 10 s22 0
L22 s22 9 82e-4
VS23 2 s23 0
V23 e23 s23 DC 0 AC 56e-1 180
RI23 e23 m23 39e-2
LI23 m23 24 22e-6
VS24 2 s24 0
L24 s24 22 68e-4
VS25 22 s25 0
V25 e25 s25 DC 0 AC 18e-1 -120
RI25 e25 19 12e-2
VS26 10 s26 0
L26 s26 16 68e-3
VS27 14 s27 0
C27 s27 23 18e-5
VS28 12 s28 0
R28 s28 17 56e1
VS29 28 s29 0
V29 e29 s29 DC 0 AC 39e-1 -120
RI29 e29 5 68e-3
VS30 2 s30 0
R30 s30 20 39e-1
VS31 4 s31 0
R31 s31 5 47e2
VS32 4 s32 0
V32 e32 s32 DC 0 AC 82e-1 120
RI32 e32 3 39e-2
VS33 14 s33 0
V33 e33 s33 DC 0 AC 47e1 0
RI33 e33 m33 56e-2
LI33 m33 19 47e-5
VS34 25 s34 0
C34 s34 28 15e-7
VS35 15 s35 0
L35 s35 18 12e-3
VS36 28 s36 0
L36 s36 21 39e-4
VS37 17 s37 0
V37 e37 s37 DC 0 AC 10e0 0
RI37 e37 m37 39e-1
LI37 m37 28 22e-6
VS38 28 s38 0
L38 s38 13 33e-2
VS39 4 s39 0
V39 e39 s39 DC 0 AC 39e0 -120
RI39 e39 m39 68e-3
LI39 m39 8 33e-6
.control
set numdgt=17
ac lin 1 60 60
print v(1) v(2) v(3) v(4) v(5) v(6) v(7) v(8) v(9) v(10)
print v(11) v(12) v(13) v(14) v(15) v(16) v(17) v(18) v(19) v(20)
print v(21) v(22) v(23) v(24) v(25) v(26) v(27) v(28)
print i(vs0) i(vs1) i(vs2) i(vs3) i(vs4) i(vs5) i(vs6) i(vs7) i(vs8) i(vs9)
print i(vs10) i(vs11) i(vs12) i(vs13) i(vs14) i(vs15) i(vs16) i(vs17) i(vs18) i(vs19)
print i(vs20) i(vs21) i(vs22) i(vs23) i(vs24) i(vs25) i(vs26) i(vs27) i(vs28) i(vs29)
print i(vs30) i(vs31) i(vs32) i(vs33) i(vs34) i(vs35) i(vs36) i(vs37) i(vs38) i(vs39)
.endc
.end
