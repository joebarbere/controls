controls oracle ac-0251
* Generated (plan F2.7, ADR 0012): do not edit; regenerate with `pnpm sim oracle regen`. ac seed 20261031 index 251 nodes 8 elements 13
.options sparse gmin=1e-12 noopac
RG1 1 0 1000000000000
RG2 2 0 1000000000000
RG3 3 0 1000000000000
RG4 4 0 1000000000000
RG5 5 0 1000000000000
RG6 6 0 1000000000000
RG7 7 0 1000000000000
VS0 7 s0 0
R0 s0 2 27e3
VS1 5 s1 0
C1 s1 0 18e-4
VS2 0 s2 0
V2 e2 s2 DC 0 AC 68e0 120
RI2 e2 1 82e-3
VS3 6 s3 0
R3 s3 3 12e3
VS4 2 s4 0
C4 s4 1 22e-7
VS5 0 s5 0
R5 s5 4 68e-2
VS6 7 s6 0
V6 e6 s6 DC 0 AC 18e0 120
RI6 e6 m6 15e-2
LI6 m6 4 10e-5
VS7 3 s7 0
C7 s7 1 47e-4
VS8 6 s8 0
C8 s8 1 47e-7
VS9 2 s9 0
V9 e9 s9 DC 0 AC 47e-1 0
RI9 e9 5 22e-1
VS10 0 s10 0
R10 s10 1 12e-2
VS11 1 s11 0
C11 s11 2 22e-6
VS12 0 s12 0
C12 s12 3 12e-6
.control
set numdgt=17
ac lin 1 60 60
print v(1) v(2) v(3) v(4) v(5) v(6) v(7)
print i(vs0) i(vs1) i(vs2) i(vs3) i(vs4) i(vs5) i(vs6) i(vs7) i(vs8) i(vs9)
print i(vs10) i(vs11) i(vs12)
.endc
.end
