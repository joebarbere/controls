controls oracle ac-0251
* Generated (plan F2.7, ADR 0012): do not edit; regenerate with `pnpm sim oracle regen`. ac seed 20261031 index 251 nodes 8 elements 11
.options sparse gmin=1e-12 noopac
RG1 1 0 1000000000000
RG2 2 0 1000000000000
RG3 3 0 1000000000000
RG4 4 0 1000000000000
RG5 5 0 1000000000000
RG6 6 0 1000000000000
RG7 7 0 1000000000000
VS0 1 s0 0
C0 s0 2 22e-6
VS1 6 s1 0
C1 s1 1 47e-7
VS2 7 s2 0
R2 s2 2 27e3
VS3 0 s3 0
V3 e3 s3 DC 0 AC 68e0 120
RI3 e3 1 82e-3
VS4 6 s4 0
R4 s4 3 12e3
VS5 0 s5 0
C5 s5 3 12e-6
VS6 0 s6 0
R6 s6 1 12e-2
VS7 7 s7 0
V7 e7 s7 DC 0 AC 18e0 120
RI7 e7 4 15e-2
VS8 2 s8 0
C8 s8 1 22e-7
VS9 3 s9 0
C9 s9 1 47e-4
VS10 2 s10 0
V10 e10 s10 DC 0 AC 47e-1 0
RI10 e10 5 22e-1
.control
set numdgt=17
ac lin 1 60 60
print v(1) v(2) v(3) v(4) v(5) v(6) v(7)
print i(vs0) i(vs1) i(vs2) i(vs3) i(vs4) i(vs5) i(vs6) i(vs7) i(vs8) i(vs9)
print i(vs10)
.endc
.end
