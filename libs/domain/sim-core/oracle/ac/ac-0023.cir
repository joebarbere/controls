controls oracle ac-0023
* Generated (plan F2.7, ADR 0012): do not edit; regenerate with `pnpm sim oracle regen`. ac seed 20261031 index 23 nodes 24 elements 47
.options sparse gmin=1e-12 noopac
RG1 1 0 1000000000000
RG2 2 0 1000000000000
RG3 3 0 1000000000000
RG4 4 0 1000000000000
RG5 5 0 1000000000000
RG6 6 0 1000000000000
RG7 7 0 1000000000000
RG8 8 0 1000000000000
RG9 9 0 1000000000000
RG10 10 0 1000000000000
RG11 11 0 1000000000000
RG12 12 0 1000000000000
RG13 13 0 1000000000000
RG14 14 0 1000000000000
RG15 15 0 1000000000000
RG16 16 0 1000000000000
RG17 17 0 1000000000000
RG18 18 0 1000000000000
RG19 19 0 1000000000000
RG20 20 0 1000000000000
RG21 21 0 1000000000000
RG22 22 0 1000000000000
RG23 23 0 1000000000000
VS0 0 s0 0
V0 e0 s0 DC 0 AC 68e1 -120
RI0 e0 18 18e-3
VS1 21 s1 0
L1 s1 2 56e-4
VS2 15 s2 0
R2 s2 0 27e0
VS3 16 s3 0
R3 s3 7 82e-2
VS4 16 s4 0
L4 s4 14 18e-3
VS5 12 s5 0
L5 s5 9 56e-5
VS6 2 s6 0
V6 e6 s6 DC 0 AC 18e1 -120
RI6 e6 8 82e-3
VS7 8 s7 0
C7 s7 9 15e-6
VS8 9 s8 0
V8 e8 s8 DC 0 AC 27e-1 0
RI8 e8 16 33e-2
VS9 10 s9 0
R9 s9 4 22e-1
VS10 20 s10 0
L10 s10 10 12e-3
VS11 14 s11 0
R11 s11 22 12e1
VS12 18 s12 0
V12 e12 s12 DC 0 AC 12e1 180
RI12 e12 11 56e-1
VS13 20 s13 0
L13 s13 18 10e-5
VS14 18 s14 0
L14 s14 19 33e-4
VS15 5 s15 0
C15 s15 10 12e-7
VS16 18 s16 0
R16 s16 23 39e2
VS17 17 s17 0
C17 s17 10 33e-5
VS18 14 s18 0
R18 s18 13 82e-2
VS19 1 s19 0
V19 e19 s19 DC 0 AC 39e0 120
RI19 e19 9 27e-3
VS20 0 s20 0
L20 s20 6 10e-3
VS21 9 s21 0
L21 s21 8 33e-5
VS22 21 s22 0
R22 s22 3 82e-2
VS23 2 s23 0
C23 s23 21 27e-6
VS24 19 s24 0
L24 s24 18 27e-4
VS25 5 s25 0
R25 s25 3 56e-2
VS26 12 s26 0
V26 e26 s26 DC 0 AC 68e-1 -120
RI26 e26 11 18e-1
VS27 14 s27 0
C27 s27 7 18e-7
VS28 5 s28 0
R28 s28 17 68e0
VS29 7 s29 0
R29 s29 16 12e-1
VS30 17 s30 0
R30 s30 10 10e-1
VS31 17 s31 0
V31 e31 s31 DC 0 AC 39e1 -120
RI31 e31 11 22e-3
VS32 11 s32 0
R32 s32 17 22e-1
VS33 7 s33 0
L33 s33 8 39e-4
VS34 9 s34 0
L34 s34 12 18e-2
VS35 8 s35 0
C35 s35 23 12e-4
VS36 10 s36 0
C36 s36 11 56e-7
VS37 7 s37 0
R37 s37 6 56e-1
VS38 8 s38 0
C38 s38 12 10e-4
VS39 7 s39 0
V39 e39 s39 DC 0 AC 18e0 120
RI39 e39 10 68e-2
VS40 8 s40 0
C40 s40 23 82e-4
VS41 11 s41 0
V41 e41 s41 DC 0 AC 33e-1 120
RI41 e41 1 33e-1
VS42 13 s42 0
L42 s42 1 12e-4
VS43 9 s43 0
R43 s43 10 27e2
VS44 22 s44 0
L44 s44 8 22e-4
VS45 3 s45 0
C45 s45 6 27e-5
VS46 4 s46 0
R46 s46 12 82e-1
.control
set numdgt=17
ac lin 1 60 60
print v(1) v(2) v(3) v(4) v(5) v(6) v(7) v(8) v(9) v(10)
print v(11) v(12) v(13) v(14) v(15) v(16) v(17) v(18) v(19) v(20)
print v(21) v(22) v(23)
print i(vs0) i(vs1) i(vs2) i(vs3) i(vs4) i(vs5) i(vs6) i(vs7) i(vs8) i(vs9)
print i(vs10) i(vs11) i(vs12) i(vs13) i(vs14) i(vs15) i(vs16) i(vs17) i(vs18) i(vs19)
print i(vs20) i(vs21) i(vs22) i(vs23) i(vs24) i(vs25) i(vs26) i(vs27) i(vs28) i(vs29)
print i(vs30) i(vs31) i(vs32) i(vs33) i(vs34) i(vs35) i(vs36) i(vs37) i(vs38) i(vs39)
print i(vs40) i(vs41) i(vs42) i(vs43) i(vs44) i(vs45) i(vs46)
.endc
.end
