controls oracle ac-0023
* Generated (plan F2.7, ADR 0012): do not edit; regenerate with `pnpm sim oracle regen`. ac seed 20261031 index 23 nodes 24 elements 49
.options sparse gmin=1e-12 noopac
RG1 1 0 1000000000000
RG2 2 0 1000000000000
RG3 3 0 1000000000000
RG4 4 0 1000000000000
RG5 5 0 1000000000000
RG6 6 0 1000000000000
RG7 7 0 1000000000000
RG8 8 0 1000000000000
RG9 9 0 1000000000000
RG10 10 0 1000000000000
RG11 11 0 1000000000000
RG12 12 0 1000000000000
RG13 13 0 1000000000000
RG14 14 0 1000000000000
RG15 15 0 1000000000000
RG16 16 0 1000000000000
RG17 17 0 1000000000000
RG18 18 0 1000000000000
RG19 19 0 1000000000000
RG20 20 0 1000000000000
RG21 21 0 1000000000000
RG22 22 0 1000000000000
RG23 23 0 1000000000000
VS0 5 s0 0
C0 s0 10 12e-7
VS1 21 s1 0
L1 s1 2 56e-4
VS2 14 s2 0
R2 s2 22 12e1
VS3 5 s3 0
R3 s3 3 56e-2
VS4 0 s4 0
V4 e4 s4 DC 0 AC 12e1 180
RI4 e4 n4 56e-1
H4 n4 h4 VS6 -15e-4
ED4 h4 11 d4 0 82e-6
F4 0 d4 VS6 1
LD4 d4 0 1
VS5 16 s5 0
R5 s5 18 82e-2
VS6 7 s6 0
V6 e6 s6 DC 0 AC 68e1 -120
RI6 e6 n6 18e-3
H6 n6 h6 VS4 -15e-4
ED6 h6 0 d6 0 82e-6
F6 0 d6 VS4 1
LD6 d6 0 1
VS7 12 s7 0
V7 e7 s7 DC 0 AC 68e-1 -120
RI7 e7 m7 18e-1
LI7 m7 11 15e-6
VS8 10 s8 0
R8 s8 4 22e-1
VS9 9 s9 0
V9 e9 s9 DC 0 AC 27e-1 0
RI9 e9 16 33e-2
VS10 2 s10 0
C10 s10 21 27e-6
VS11 10 s11 0
C11 s11 11 56e-7
VS12 7 s12 0
L12 s12 6 10e-3
VS13 11 s13 0
V13 e13 s13 DC 0 AC 33e-1 120
RI13 e13 1 33e-1
VS14 18 s14 0
L14 s14 8 39e-4
VS15 4 s15 0
R15 s15 12 82e-1
VS16 8 s16 0
C16 s16 9 15e-6
VS17 17 s17 0
C17 s17 10 33e-5
VS18 9 s18 0
R18 s18 10 27e2
VS19 0 s19 0
R19 s19 23 39e2
VS20 5 s20 0
R20 s20 17 68e0
VS21 16 s21 0
L21 s21 14 18e-3
VS22 17 s22 0
V22 e22 s22 DC 0 AC 39e1 -120
RI22 e22 m22 22e-3
LI22 m22 11 68e-7
VS23 17 s23 0
R23 s23 10 10e-1
VS24 13 s24 0
L24 s24 1 12e-4
VS25 23 s25 0
R25 s25 15 10e0
VS26 1 s26 0
V26 e26 s26 DC 0 AC 39e0 120
RI26 e26 9 27e-3
VS27 14 s27 0
C27 s27 18 18e-7
VS28 19 s28 0
R28 s28 17 18e-1
VS29 2 s29 0
V29 e29 s29 DC 0 AC 18e1 -120
RI29 e29 m29 82e-3
LI29 m29 8 56e-7
VS30 8 s30 0
C30 s30 12 10e-4
VS31 20 s31 0
L31 s31 0 10e-5
VS32 19 s32 0
L32 s32 0 27e-4
VS33 8 s33 0
C33 s33 23 82e-4
VS34 21 s34 0
R34 s34 3 82e-2
VS35 9 s35 0
L35 s35 8 33e-5
VS36 12 s36 0
L36 s36 9 56e-5
VS37 14 s37 0
R37 s37 13 82e-2
VS38 18 s38 0
V38 e38 s38 DC 0 AC 18e0 120
RI38 e38 10 68e-2
VS39 22 s39 0
L39 s39 8 22e-4
VS40 8 s40 0
C40 s40 23 12e-4
VS41 9 s41 0
L41 s41 12 18e-2
VS42 20 s42 0
L42 s42 10 12e-3
VS43 18 s43 0
R43 s43 16 12e-1
VS44 15 s44 0
R44 s44 7 27e0
VS45 3 s45 0
C45 s45 6 27e-5
VS46 0 s46 0
L46 s46 19 33e-4
VS47 11 s47 0
R47 s47 17 22e-1
VS48 18 s48 0
R48 s48 6 56e-1
.control
set numdgt=17
ac lin 1 60 60
print v(1) v(2) v(3) v(4) v(5) v(6) v(7) v(8) v(9) v(10)
print v(11) v(12) v(13) v(14) v(15) v(16) v(17) v(18) v(19) v(20)
print v(21) v(22) v(23)
print i(vs0) i(vs1) i(vs2) i(vs3) i(vs4) i(vs5) i(vs6) i(vs7) i(vs8) i(vs9)
print i(vs10) i(vs11) i(vs12) i(vs13) i(vs14) i(vs15) i(vs16) i(vs17) i(vs18) i(vs19)
print i(vs20) i(vs21) i(vs22) i(vs23) i(vs24) i(vs25) i(vs26) i(vs27) i(vs28) i(vs29)
print i(vs30) i(vs31) i(vs32) i(vs33) i(vs34) i(vs35) i(vs36) i(vs37) i(vs38) i(vs39)
print i(vs40) i(vs41) i(vs42) i(vs43) i(vs44) i(vs45) i(vs46) i(vs47) i(vs48)
.endc
.end
