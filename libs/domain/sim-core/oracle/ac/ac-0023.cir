controls oracle ac-0023
* Generated (plan F2.7, ADR 0012): do not edit; regenerate with `pnpm sim oracle regen`. ac seed 20261031 index 23 nodes 24 elements 34
.options sparse gmin=1e-12 noopac
RG1 1 0 1000000000000
RG2 2 0 1000000000000
RG3 3 0 1000000000000
RG4 4 0 1000000000000
RG5 5 0 1000000000000
RG6 6 0 1000000000000
RG7 7 0 1000000000000
RG8 8 0 1000000000000
RG9 9 0 1000000000000
RG10 10 0 1000000000000
RG11 11 0 1000000000000
RG12 12 0 1000000000000
RG13 13 0 1000000000000
RG14 14 0 1000000000000
RG15 15 0 1000000000000
RG16 16 0 1000000000000
RG17 17 0 1000000000000
RG18 18 0 1000000000000
RG19 19 0 1000000000000
RG20 20 0 1000000000000
RG21 21 0 1000000000000
RG22 22 0 1000000000000
RG23 23 0 1000000000000
VS0 10 s0 0
L0 s0 20 15e-4
VS1 6 s1 0
L1 s1 15 33e-4
VS2 5 s2 0
R2 s2 1 18e3
VS3 22 s3 0
L3 s3 8 22e-4
VS4 16 s4 0
L4 s4 5 27e-3
VS5 17 s5 0
C5 s5 8 39e-4
VS6 0 s6 0
V6 e6 s6 DC 0 AC 39e0 120
RI6 e6 9 27e-3
VS7 13 s7 0
R7 s7 6 27e0
VS8 1 s8 0
R8 s8 11 12e3
VS9 2 s9 0
R9 s9 8 82e-2
VS10 1 s10 0
R10 s10 6 56e-1
VS11 19 s11 0
R11 s11 23 82e-1
VS12 19 s12 0
L12 s12 12 12e-4
VS13 4 s13 0
L13 s13 12 39e-4
VS14 23 s14 0
L14 s14 17 39e-4
VS15 3 s15 0
R15 s15 15 10e0
VS16 11 s16 0
R16 s16 14 68e2
VS17 3 s17 0
V17 e17 s17 DC 0 AC 15e-1 0
RI17 e17 m17 68e-2
LI17 m17 0 22e-6
VS18 18 s18 0
V18 e18 s18 DC 0 AC 68e1 180
RI18 e18 12 27e-1
VS19 15 s19 0
R19 s19 22 12e1
VS20 18 s20 0
R20 s20 21 68e-1
VS21 1 s21 0
L21 s21 8 39e-4
VS22 16 s22 0
C22 s22 4 39e-7
VS23 23 s23 0
R23 s23 7 82e0
VS24 16 s24 0
R24 s24 1 82e-2
VS25 1 s25 0
V25 e25 s25 DC 0 AC 18e0 120
RI25 e25 m25 68e-2
LI25 m25 10 27e-6
VS26 21 s26 0
L26 s26 2 56e-4
VS27 14 s27 0
C27 s27 7 47e-4
VS28 13 s28 0
V28 e28 s28 DC 0 AC 15e1 -120
RI28 e28 m28 10e-1
LI28 m28 4 33e-6
VS29 16 s29 0
L29 s29 14 18e-3
VS30 4 s30 0
R30 s30 13 82e-2
VS31 3 s31 0
R31 s31 16 68e0
VS32 16 s32 0
C32 s32 20 18e-6
VS33 9 s33 0
R33 s33 10 27e2
.control
set numdgt=17
ac lin 1 60 60
print v(1) v(2) v(3) v(4) v(5) v(6) v(7) v(8) v(9) v(10)
print v(11) v(12) v(13) v(14) v(15) v(16) v(17) v(18) v(19) v(20)
print v(21) v(22) v(23)
print i(vs0) i(vs1) i(vs2) i(vs3) i(vs4) i(vs5) i(vs6) i(vs7) i(vs8) i(vs9)
print i(vs10) i(vs11) i(vs12) i(vs13) i(vs14) i(vs15) i(vs16) i(vs17) i(vs18) i(vs19)
print i(vs20) i(vs21) i(vs22) i(vs23) i(vs24) i(vs25) i(vs26) i(vs27) i(vs28) i(vs29)
print i(vs30) i(vs31) i(vs32) i(vs33)
.endc
.end
