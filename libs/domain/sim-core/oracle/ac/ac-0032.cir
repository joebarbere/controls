controls oracle ac-0032
* Generated (plan F2.7, ADR 0012): do not edit; regenerate with `pnpm sim oracle regen`. ac seed 20261031 index 32 nodes 28 elements 56
.options sparse gmin=1e-12 noopac
RG1 1 0 1000000000000
RG2 2 0 1000000000000
RG3 3 0 1000000000000
RG4 4 0 1000000000000
RG5 5 0 1000000000000
RG6 6 0 1000000000000
RG7 7 0 1000000000000
RG8 8 0 1000000000000
RG9 9 0 1000000000000
RG10 10 0 1000000000000
RG11 11 0 1000000000000
RG12 12 0 1000000000000
RG13 13 0 1000000000000
RG14 14 0 1000000000000
RG15 15 0 1000000000000
RG16 16 0 1000000000000
RG17 17 0 1000000000000
RG18 18 0 1000000000000
RG19 19 0 1000000000000
RG20 20 0 1000000000000
RG21 21 0 1000000000000
RG22 22 0 1000000000000
RG23 23 0 1000000000000
RG24 24 0 1000000000000
RG25 25 0 1000000000000
RG26 26 0 1000000000000
RG27 27 0 1000000000000
VS0 12 s0 0
L0 s0 25 22e-3
VS1 14 s1 0
C1 s1 16 22e-7
VS2 0 s2 0
V2 e2 s2 DC 0 AC 39e-1 180
RI2 e2 n2 18e-3
H2 n2 h2 VS4 22e-4
ED2 h2 25 d2 0 -22e-6
F2 0 d2 VS4 1
LD2 d2 0 1
VS3 16 s3 0
R3 s3 5 27e1
VS4 15 s4 0
V4 e4 s4 DC 0 AC 27e0 120
RI4 e4 m4 15e-3
LI4 m4 n4 15e-7
H4 n4 h4 VS2 22e-4
ED4 h4 20 d4 0 -22e-6
F4 0 d4 VS2 1
LD4 d4 0 1
VS5 7 s5 0
R5 s5 8 33e3
VS6 9 s6 0
L6 s6 8 15e-3
VS7 21 s7 0
L7 s7 8 18e-3
VS8 26 s8 0
L8 s8 12 15e-4
VS9 17 s9 0
R9 s9 8 18e-2
VS10 22 s10 0
L10 s10 8 39e-5
VS11 10 s11 0
V11 e11 s11 DC 0 AC 56e1 120
RI11 e11 m11 33e-1
LI11 m11 21 10e-5
VS12 15 s12 0
C12 s12 17 18e-6
VS13 0 s13 0
L13 s13 16 10e-2
VS14 23 s14 0
L14 s14 11 33e-2
VS15 23 s15 0
L15 s15 3 27e-5
VS16 5 s16 0
R16 s16 26 56e-2
VS17 22 s17 0
R17 s17 26 33e-1
VS18 16 s18 0
L18 s18 22 47e-3
VS19 21 s19 0
C19 s19 18 82e-7
VS20 4 s20 0
V20 e20 s20 DC 0 AC 56e-1 120
RI20 e20 3 10e-2
VS21 7 s21 0
L21 s21 22 47e-3
VS22 17 s22 0
C22 s22 24 68e-5
VS23 6 s23 0
V23 e23 s23 DC 0 AC 18e-1 -120
RI23 e23 5 47e-3
VS24 9 s24 0
L24 s24 20 27e-4
VS25 5 s25 0
R25 s25 21 39e1
VS26 14 s26 0
R26 s26 27 47e3
VS27 5 s27 0
L27 s27 2 56e-5
VS28 5 s28 0
L28 s28 2 12e-5
VS29 6 s29 0
C29 s29 1 47e-6
VS30 11 s30 0
R30 s30 4 27e3
VS31 27 s31 0
R31 s31 22 56e2
VS32 25 s32 0
R32 s32 2 18e-2
VS33 27 s33 0
L33 s33 25 68e-5
VS34 21 s34 0
R34 s34 24 39e1
VS35 17 s35 0
V35 e35 s35 DC 0 AC 33e-1 180
RI35 e35 12 56e-3
VS36 5 s36 0
R36 s36 23 68e-2
VS37 27 s37 0
R37 s37 19 33e1
VS38 4 s38 0
R38 s38 17 39e0
VS39 4 s39 0
L39 s39 9 56e-3
VS40 5 s40 0
L40 s40 17 18e-2
VS41 21 s41 0
R41 s41 14 10e-2
VS42 22 s42 0
V42 e42 s42 DC 0 AC 56e1 0
RI42 e42 m42 82e-2
LI42 m42 5 15e-5
VS43 17 s43 0
V43 e43 s43 DC 0 AC 22e0 120
RI43 e43 8 82e-1
VS44 1 s44 0
V44 e44 s44 DC 0 AC 68e0 -120
RI44 e44 m44 18e-1
LI44 m44 0 15e-5
VS45 24 s45 0
R45 s45 2 68e3
VS46 9 s46 0
R46 s46 20 39e-1
VS47 23 s47 0
R47 s47 21 82e-1
VS48 21 s48 0
C48 s48 22 27e-6
VS49 25 s49 0
V49 e49 s49 DC 0 AC 10e1 120
RI49 e49 m49 22e-1
LI49 m49 5 33e-6
VS50 12 s50 0
C50 s50 6 12e-5
VS51 27 s51 0
L51 s51 13 27e-3
VS52 2 s52 0
R52 s52 13 68e1
VS53 22 s53 0
C53 s53 18 68e-5
VS54 24 s54 0
C54 s54 19 56e-6
VS55 10 s55 0
L55 s55 2 12e-2
.control
set numdgt=17
ac lin 1 60 60
print v(1) v(2) v(3) v(4) v(5) v(6) v(7) v(8) v(9) v(10)
print v(11) v(12) v(13) v(14) v(15) v(16) v(17) v(18) v(19) v(20)
print v(21) v(22) v(23) v(24) v(25) v(26) v(27)
print i(vs0) i(vs1) i(vs2) i(vs3) i(vs4) i(vs5) i(vs6) i(vs7) i(vs8) i(vs9)
print i(vs10) i(vs11) i(vs12) i(vs13) i(vs14) i(vs15) i(vs16) i(vs17) i(vs18) i(vs19)
print i(vs20) i(vs21) i(vs22) i(vs23) i(vs24) i(vs25) i(vs26) i(vs27) i(vs28) i(vs29)
print i(vs30) i(vs31) i(vs32) i(vs33) i(vs34) i(vs35) i(vs36) i(vs37) i(vs38) i(vs39)
print i(vs40) i(vs41) i(vs42) i(vs43) i(vs44) i(vs45) i(vs46) i(vs47) i(vs48) i(vs49)
print i(vs50) i(vs51) i(vs52) i(vs53) i(vs54) i(vs55)
.endc
.end
