controls oracle ac-0032
* Generated (plan F2.7, ADR 0012): do not edit; regenerate with `pnpm sim oracle regen`. ac seed 20261031 index 32 nodes 28 elements 52
.options sparse gmin=1e-12 noopac
RG1 1 0 1000000000000
RG2 2 0 1000000000000
RG3 3 0 1000000000000
RG4 4 0 1000000000000
RG5 5 0 1000000000000
RG6 6 0 1000000000000
RG7 7 0 1000000000000
RG8 8 0 1000000000000
RG9 9 0 1000000000000
RG10 10 0 1000000000000
RG11 11 0 1000000000000
RG12 12 0 1000000000000
RG13 13 0 1000000000000
RG14 14 0 1000000000000
RG15 15 0 1000000000000
RG16 16 0 1000000000000
RG17 17 0 1000000000000
RG18 18 0 1000000000000
RG19 19 0 1000000000000
RG20 20 0 1000000000000
RG21 21 0 1000000000000
RG22 22 0 1000000000000
RG23 23 0 1000000000000
RG24 24 0 1000000000000
RG25 25 0 1000000000000
RG26 26 0 1000000000000
RG27 27 0 1000000000000
VS0 6 s0 0
R0 s0 26 56e-2
VS1 0 s1 0
V1 e1 s1 DC 0 AC 18e-1 -120
RI1 e1 6 47e-3
VS2 14 s2 0
R2 s2 27 47e3
VS3 27 s3 0
L3 s3 25 68e-5
VS4 24 s4 0
R4 s4 2 68e3
VS5 6 s5 0
R5 s5 23 68e-2
VS6 16 s6 0
L6 s6 22 47e-3
VS7 4 s7 0
V7 e7 s7 DC 0 AC 56e-1 120
RI7 e7 3 10e-2
VS8 17 s8 0
R8 s8 8 18e-2
VS9 27 s9 0
R9 s9 19 33e1
VS10 21 s10 0
R10 s10 14 10e-2
VS11 9 s11 0
L11 s11 8 15e-3
VS12 17 s12 0
C12 s12 24 68e-5
VS13 25 s13 0
R13 s13 2 18e-2
VS14 0 s14 0
C14 s14 1 47e-6
VS15 12 s15 0
C15 s15 0 12e-5
VS16 27 s16 0
R16 s16 22 56e2
VS17 14 s17 0
C17 s17 16 22e-7
VS18 9 s18 0
L18 s18 20 27e-4
VS19 23 s19 0
L19 s19 3 27e-5
VS20 26 s20 0
L20 s20 12 15e-4
VS21 6 s21 0
L21 s21 17 18e-2
VS22 12 s22 0
L22 s22 25 22e-3
VS23 4 s23 0
L23 s23 9 56e-3
VS24 21 s24 0
L24 s24 8 18e-3
VS25 22 s25 0
C25 s25 18 68e-5
VS26 4 s26 0
R26 s26 17 39e0
VS27 22 s27 0
R27 s27 26 33e-1
VS28 24 s28 0
C28 s28 19 56e-6
VS29 17 s29 0
V29 e29 s29 DC 0 AC 22e0 120
RI29 e29 8 82e-1
VS30 1 s30 0
V30 e30 s30 DC 0 AC 68e0 -120
RI30 e30 5 18e-1
VS31 11 s31 0
R31 s31 4 27e3
VS32 27 s32 0
L32 s32 13 27e-3
VS33 21 s33 0
C33 s33 18 82e-7
VS34 22 s34 0
V34 e34 s34 DC 0 AC 56e1 0
RI34 e34 6 82e-2
VS35 7 s35 0
R35 s35 8 33e3
VS36 5 s36 0
V36 e36 s36 DC 0 AC 39e-1 180
RI36 e36 25 18e-3
VS37 22 s37 0
L37 s37 8 39e-5
VS38 10 s38 0
V38 e38 s38 DC 0 AC 56e1 120
RI38 e38 21 33e-1
VS39 17 s39 0
V39 e39 s39 DC 0 AC 33e-1 180
RI39 e39 12 56e-3
VS40 5 s40 0
L40 s40 16 10e-2
VS41 23 s41 0
R41 s41 21 82e-1
VS42 21 s42 0
C42 s42 22 27e-6
VS43 25 s43 0
V43 e43 s43 DC 0 AC 10e1 120
RI43 e43 6 22e-1
VS44 6 s44 0
L44 s44 2 12e-5
VS45 15 s45 0
C45 s45 17 18e-6
VS46 21 s46 0
R46 s46 24 39e1
VS47 6 s47 0
L47 s47 2 56e-5
VS48 16 s48 0
R48 s48 6 27e1
VS49 15 s49 0
V49 e49 s49 DC 0 AC 27e0 120
RI49 e49 20 15e-3
VS50 9 s50 0
R50 s50 20 39e-1
VS51 6 s51 0
R51 s51 21 39e1
.control
set numdgt=17
ac lin 1 60 60
print v(1) v(2) v(3) v(4) v(5) v(6) v(7) v(8) v(9) v(10)
print v(11) v(12) v(13) v(14) v(15) v(16) v(17) v(18) v(19) v(20)
print v(21) v(22) v(23) v(24) v(25) v(26) v(27)
print i(vs0) i(vs1) i(vs2) i(vs3) i(vs4) i(vs5) i(vs6) i(vs7) i(vs8) i(vs9)
print i(vs10) i(vs11) i(vs12) i(vs13) i(vs14) i(vs15) i(vs16) i(vs17) i(vs18) i(vs19)
print i(vs20) i(vs21) i(vs22) i(vs23) i(vs24) i(vs25) i(vs26) i(vs27) i(vs28) i(vs29)
print i(vs30) i(vs31) i(vs32) i(vs33) i(vs34) i(vs35) i(vs36) i(vs37) i(vs38) i(vs39)
print i(vs40) i(vs41) i(vs42) i(vs43) i(vs44) i(vs45) i(vs46) i(vs47) i(vs48) i(vs49)
print i(vs50) i(vs51)
.endc
.end
