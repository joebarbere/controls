controls oracle ac-0032
* Generated (plan F2.7, ADR 0012): do not edit; regenerate with `pnpm sim oracle regen`. ac seed 20261031 index 32 nodes 28 elements 56
.options sparse gmin=1e-12 noopac
RG1 1 0 1000000000000
RG2 2 0 1000000000000
RG3 3 0 1000000000000
RG4 4 0 1000000000000
RG5 5 0 1000000000000
RG6 6 0 1000000000000
RG7 7 0 1000000000000
RG8 8 0 1000000000000
RG9 9 0 1000000000000
RG10 10 0 1000000000000
RG11 11 0 1000000000000
RG12 12 0 1000000000000
RG13 13 0 1000000000000
RG14 14 0 1000000000000
RG15 15 0 1000000000000
RG16 16 0 1000000000000
RG17 17 0 1000000000000
RG18 18 0 1000000000000
RG19 19 0 1000000000000
RG20 20 0 1000000000000
RG21 21 0 1000000000000
RG22 22 0 1000000000000
RG23 23 0 1000000000000
RG24 24 0 1000000000000
RG25 25 0 1000000000000
RG26 26 0 1000000000000
RG27 27 0 1000000000000
VS0 6 s0 0
R0 s0 14 47e-2
VS1 23 s1 0
C1 s1 5 47e-7
VS2 0 s2 0
V2 e2 s2 DC 0 AC 27e0 120
RI2 e2 m2 15e-3
LI2 m2 10 12e-5
VS3 24 s3 0
R3 s3 3 27e1
VS4 22 s4 0
R4 s4 26 33e-1
VS5 17 s5 0
R5 s5 23 82e2
VS6 17 s6 0
V6 e6 s6 DC 0 AC 15e-1 180
RI6 e6 m6 15e-1
LI6 m6 20 82e-6
VS7 2 s7 0
C7 s7 20 56e-4
VS8 4 s8 0
L8 s8 25 12e-5
VS9 25 s9 0
V9 e9 s9 DC 0 AC 10e1 120
RI9 e9 23 22e-1
VS10 8 s10 0
R10 s10 11 12e-2
VS11 22 s11 0
L11 s11 8 39e-5
VS12 2 s12 0
V12 e12 s12 DC 0 AC 12e1 0
RI12 e12 m12 39e-1
LI12 m12 27 10e-5
VS13 6 s13 0
L13 s13 23 56e-2
VS14 1 s14 0
R14 s14 2 82e1
VS15 17 s15 0
V15 e15 s15 DC 0 AC 47e0 180
RI15 e15 26 68e-1
VS16 8 s16 0
C16 s16 17 10e-5
VS17 25 s17 0
V17 e17 s17 DC 0 AC 68e0 180
RI17 e17 m17 47e-1
LI17 m17 7 82e-7
VS18 2 s18 0
L18 s18 14 18e-2
VS19 19 s19 0
C19 s19 7 27e-7
VS20 16 s20 0
V20 e20 s20 DC 0 AC 47e0 120
RI20 e20 25 68e-3
VS21 1 s21 0
L21 s21 11 18e-4
VS22 8 s22 0
L22 s22 18 12e-5
VS23 13 s23 0
R23 s23 24 22e3
VS24 13 s24 0
R24 s24 19 33e1
VS25 27 s25 0
C25 s25 9 15e-7
VS26 14 s26 0
R26 s26 20 68e0
VS27 22 s27 0
R27 s27 7 15e0
VS28 25 s28 0
C28 s28 8 33e-5
VS29 20 s29 0
R29 s29 26 33e2
VS30 0 s30 0
R30 s30 13 27e3
VS31 12 s31 0
R31 s31 7 56e-2
VS32 20 s32 0
C32 s32 11 10e-7
VS33 21 s33 0
R33 s33 22 56e2
VS34 3 s34 0
L34 s34 27 82e-5
VS35 27 s35 0
R35 s35 19 33e1
VS36 24 s36 0
R36 s36 15 39e-2
VS37 14 s37 0
C37 s37 16 22e-7
VS38 10 s38 0
L38 s38 27 27e-3
VS39 12 s39 0
L39 s39 11 18e-4
VS40 10 s40 0
V40 e40 s40 DC 0 AC 22e0 120
RI40 e40 24 56e-2
VS41 15 s41 0
L41 s41 25 18e-3
VS42 15 s42 0
C42 s42 18 18e-6
VS43 6 s43 0
R43 s43 11 39e-2
VS44 22 s44 0
L44 s44 14 27e-5
VS45 8 s45 0
L45 s45 13 12e-3
VS46 4 s46 0
R46 s46 27 82e-1
VS47 11 s47 0
V47 e47 s47 DC 0 AC 18e-1 -120
RI47 e47 22 47e-3
VS48 5 s48 0
R48 s48 13 68e2
VS49 22 s49 0
V49 e49 s49 DC 0 AC 56e1 0
RI49 e49 23 82e-2
VS50 15 s50 0
L50 s50 24 22e-3
VS51 27 s51 0
R51 s51 17 22e2
VS52 27 s52 0
R52 s52 10 82e1
VS53 21 s53 0
R53 s53 24 39e1
VS54 8 s54 0
L54 s54 9 15e-3
VS55 8 s55 0
L55 s55 12 47e-5
.control
set numdgt=17
ac lin 1 60 60
print v(1) v(2) v(3) v(4) v(5) v(6) v(7) v(8) v(9) v(10)
print v(11) v(12) v(13) v(14) v(15) v(16) v(17) v(18) v(19) v(20)
print v(21) v(22) v(23) v(24) v(25) v(26) v(27)
print i(vs0) i(vs1) i(vs2) i(vs3) i(vs4) i(vs5) i(vs6) i(vs7) i(vs8) i(vs9)
print i(vs10) i(vs11) i(vs12) i(vs13) i(vs14) i(vs15) i(vs16) i(vs17) i(vs18) i(vs19)
print i(vs20) i(vs21) i(vs22) i(vs23) i(vs24) i(vs25) i(vs26) i(vs27) i(vs28) i(vs29)
print i(vs30) i(vs31) i(vs32) i(vs33) i(vs34) i(vs35) i(vs36) i(vs37) i(vs38) i(vs39)
print i(vs40) i(vs41) i(vs42) i(vs43) i(vs44) i(vs45) i(vs46) i(vs47) i(vs48) i(vs49)
print i(vs50) i(vs51) i(vs52) i(vs53) i(vs54) i(vs55)
.endc
.end
