controls oracle ac-0281
* Generated (plan F2.7, ADR 0012): do not edit; regenerate with `pnpm sim oracle regen`. ac seed 20261031 index 281 nodes 12 elements 25
.options sparse gmin=1e-12 noopac
RG1 1 0 1000000000000
RG2 2 0 1000000000000
RG3 3 0 1000000000000
RG4 4 0 1000000000000
RG5 5 0 1000000000000
RG6 6 0 1000000000000
RG7 7 0 1000000000000
RG8 8 0 1000000000000
RG9 9 0 1000000000000
RG10 10 0 1000000000000
RG11 11 0 1000000000000
VS0 0 s0 0
C0 s0 8 12e-5
VS1 10 s1 0
R1 s1 7 22e-2
VS2 0 s2 0
V2 e2 s2 DC 0 AC 10e1 -120
RI2 e2 5 68e-1
VS3 8 s3 0
R3 s3 5 39e-2
VS4 4 s4 0
C4 s4 0 56e-7
VS5 8 s5 0
R5 s5 9 12e2
VS6 6 s6 0
L6 s6 5 33e-3
VS7 0 s7 0
C7 s7 1 18e-7
VS8 0 s8 0
R8 s8 11 27e-1
VS9 3 s9 0
V9 e9 s9 DC 0 AC 56e1 180
RI9 e9 m9 47e-2
LI9 m9 4 12e-6
VS10 2 s10 0
R10 s10 1 12e-1
VS11 8 s11 0
V11 e11 s11 DC 0 AC 68e0 -120
RI11 e11 9 27e-2
VS12 6 s12 0
R12 s12 5 56e0
VS13 7 s13 0
L13 s13 6 82e-2
VS14 8 s14 0
R14 s14 3 82e-1
VS15 9 s15 0
R15 s15 0 68e-2
VS16 3 s16 0
C16 s16 5 10e-6
VS17 9 s17 0
V17 e17 s17 DC 0 AC 82e1 120
RI17 e17 11 15e-1
VS18 11 s18 0
V18 e18 s18 DC 0 AC 39e-1 0
RI18 e18 m18 39e-2
LI18 m18 1 82e-5
VS19 10 s19 0
R19 s19 4 68e-2
VS20 11 s20 0
L20 s20 1 39e-3
VS21 9 s21 0
C21 s21 0 18e-7
VS22 8 s22 0
R22 s22 5 56e3
VS23 5 s23 0
C23 s23 4 15e-6
VS24 2 s24 0
R24 s24 0 10e1
.control
set numdgt=17
ac lin 1 60 60
print v(1) v(2) v(3) v(4) v(5) v(6) v(7) v(8) v(9) v(10)
print v(11)
print i(vs0) i(vs1) i(vs2) i(vs3) i(vs4) i(vs5) i(vs6) i(vs7) i(vs8) i(vs9)
print i(vs10) i(vs11) i(vs12) i(vs13) i(vs14) i(vs15) i(vs16) i(vs17) i(vs18) i(vs19)
print i(vs20) i(vs21) i(vs22) i(vs23) i(vs24)
.endc
.end
