controls oracle ac-0281
* Generated (plan F2.7, ADR 0012): do not edit; regenerate with `pnpm sim oracle regen`. ac seed 20261031 index 281 nodes 12 elements 16
.options sparse gmin=1e-12 noopac
RG1 1 0 1000000000000
RG2 2 0 1000000000000
RG3 3 0 1000000000000
RG4 4 0 1000000000000
RG5 5 0 1000000000000
RG6 6 0 1000000000000
RG7 7 0 1000000000000
RG8 8 0 1000000000000
RG9 9 0 1000000000000
RG10 10 0 1000000000000
RG11 11 0 1000000000000
VS0 0 s0 0
V0 e0 s0 DC 0 AC 10e1 -120
RI0 e0 8 33e-3
VS1 3 s1 0
R1 s1 0 15e-1
VS2 10 s2 0
V2 e2 s2 DC 0 AC 68e1 120
RI2 e2 9 27e-1
VS3 1 s3 0
R3 s3 5 56e3
VS4 5 s4 0
R4 s4 6 56e2
VS5 9 s5 0
R5 s5 8 12e0
VS6 5 s6 0
R6 s6 10 33e0
VS7 4 s7 0
V7 e7 s7 DC 0 AC 68e-1 120
RI7 e7 8 56e-1
VS8 1 s8 0
R8 s8 3 82e-1
VS9 6 s9 0
R9 s9 7 15e0
VS10 2 s10 0
R10 s10 5 56e-2
VS11 10 s11 0
V11 e11 s11 DC 0 AC 10e0 -120
RI11 e11 0 10e-3
VS12 9 s12 0
R12 s12 11 12e-1
VS13 11 s13 0
V13 e13 s13 DC 0 AC 47e1 180
RI13 e13 5 68e-1
VS14 2 s14 0
C14 s14 6 15e-6
VS15 8 s15 0
V15 e15 s15 DC 0 AC 10e1 -120
RI15 e15 5 68e-1
.control
set numdgt=17
ac lin 1 60 60
print v(1) v(2) v(3) v(4) v(5) v(6) v(7) v(8) v(9) v(10)
print v(11)
print i(vs0) i(vs1) i(vs2) i(vs3) i(vs4) i(vs5) i(vs6) i(vs7) i(vs8) i(vs9)
print i(vs10) i(vs11) i(vs12) i(vs13) i(vs14) i(vs15)
.endc
.end
