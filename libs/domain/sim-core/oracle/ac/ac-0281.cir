controls oracle ac-0281
* Generated (plan F2.7, ADR 0012): do not edit; regenerate with `pnpm sim oracle regen`. ac seed 20261031 index 281 nodes 12 elements 18
.options sparse gmin=1e-12 noopac
RG1 1 0 1000000000000
RG2 2 0 1000000000000
RG3 3 0 1000000000000
RG4 4 0 1000000000000
RG5 5 0 1000000000000
RG6 6 0 1000000000000
RG7 7 0 1000000000000
RG8 8 0 1000000000000
RG9 9 0 1000000000000
RG10 10 0 1000000000000
RG11 11 0 1000000000000
VS0 5 s0 0
R0 s0 6 56e2
VS1 6 s1 0
R1 s1 7 15e0
VS2 0 s2 0
V2 e2 s2 DC 0 AC 47e1 180
RI2 e2 5 68e-1
VS3 4 s3 0
V3 e3 s3 DC 0 AC 68e-1 120
RI3 e3 8 56e-1
VS4 11 s4 0
R4 s4 3 82e-1
VS5 1 s5 0
V5 e5 s5 DC 0 AC 10e1 -120
RI5 e5 8 33e-3
VS6 11 s6 0
R6 s6 5 56e3
VS7 2 s7 0
C7 s7 6 15e-6
VS8 9 s8 0
R8 s8 8 12e0
VS9 10 s9 0
V9 e9 s9 DC 0 AC 10e0 -120
RI9 e9 m9 10e-3
LI9 m9 1 27e-5
VS10 2 s10 0
R10 s10 5 56e-2
VS11 3 s11 0
R11 s11 1 15e-1
VS12 10 s12 0
V12 e12 s12 DC 0 AC 68e1 120
RI12 e12 9 27e-1
VS13 5 s13 0
R13 s13 10 33e0
VS14 8 s14 0
V14 e14 s14 DC 0 AC 10e1 -120
RI14 e14 m14 68e-1
LI14 m14 5 47e-7
VS15 5 s15 0
L15 s15 4 39e-3
VS16 7 s16 0
R16 s16 4 82e2
VS17 9 s17 0
R17 s17 0 12e-1
.control
set numdgt=17
ac lin 1 60 60
print v(1) v(2) v(3) v(4) v(5) v(6) v(7) v(8) v(9) v(10)
print v(11)
print i(vs0) i(vs1) i(vs2) i(vs3) i(vs4) i(vs5) i(vs6) i(vs7) i(vs8) i(vs9)
print i(vs10) i(vs11) i(vs12) i(vs13) i(vs14) i(vs15) i(vs16) i(vs17)
.endc
.end
