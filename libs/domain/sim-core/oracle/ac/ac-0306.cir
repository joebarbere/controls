controls oracle ac-0306
* Generated (plan F2.7, ADR 0012): do not edit; regenerate with `pnpm sim oracle regen`. ac seed 20261031 index 306 nodes 7 elements 8
.options sparse gmin=1e-12 noopac
RG1 1 0 1000000000000
RG2 2 0 1000000000000
RG3 3 0 1000000000000
RG4 4 0 1000000000000
RG5 5 0 1000000000000
RG6 6 0 1000000000000
VS0 5 s0 0
R0 s0 4 56e-1
VS1 3 s1 0
L1 s1 1 18e-3
VS2 6 s2 0
C2 s2 1 68e-6
VS3 0 s3 0
V3 e3 s3 DC 0 AC 10e1 120
RI3 e3 5 47e-3
VS4 5 s4 0
L4 s4 6 33e-2
VS5 2 s5 0
R5 s5 4 12e2
VS6 2 s6 0
R6 s6 3 15e2
VS7 4 s7 0
R7 s7 0 68e2
.control
set numdgt=17
ac lin 1 60 60
print v(1) v(2) v(3) v(4) v(5) v(6)
print i(vs0) i(vs1) i(vs2) i(vs3) i(vs4) i(vs5) i(vs6) i(vs7)
.endc
.end
