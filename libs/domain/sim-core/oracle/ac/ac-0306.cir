controls oracle ac-0306
* Generated (plan F2.7, ADR 0012): do not edit; regenerate with `pnpm sim oracle regen`. ac seed 20261031 index 306 nodes 7 elements 7
.options sparse gmin=1e-12 noopac
RG1 1 0 1000000000000
RG2 2 0 1000000000000
RG3 3 0 1000000000000
RG4 4 0 1000000000000
RG5 5 0 1000000000000
RG6 6 0 1000000000000
VS0 2 s0 0
R0 s0 4 12e2
VS1 3 s1 0
L1 s1 1 18e-3
VS2 0 s2 0
V2 e2 s2 DC 0 AC 10e1 120
RI2 e2 5 47e-3
VS3 5 s3 0
L3 s3 6 33e-2
VS4 5 s4 0
C4 s4 0 27e-5
VS5 6 s5 0
C5 s5 1 68e-6
VS6 2 s6 0
R6 s6 3 15e2
.control
set numdgt=17
ac lin 1 60 60
print v(1) v(2) v(3) v(4) v(5) v(6)
print i(vs0) i(vs1) i(vs2) i(vs3) i(vs4) i(vs5) i(vs6)
.endc
.end
