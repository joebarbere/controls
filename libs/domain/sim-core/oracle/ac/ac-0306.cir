controls oracle ac-0306
* Generated (plan F2.7, ADR 0012): do not edit; regenerate with `pnpm sim oracle regen`. ac seed 20261031 index 306 nodes 7 elements 9
.options sparse gmin=1e-12 noopac
RG1 1 0 1000000000000
RG2 2 0 1000000000000
RG3 3 0 1000000000000
RG4 4 0 1000000000000
RG5 5 0 1000000000000
RG6 6 0 1000000000000
VS0 0 s0 0
C0 s0 3 39e-4
VS1 0 s1 0
V1 e1 s1 DC 0 AC 68e-1 -120
RI1 e1 4 68e-2
VS2 3 s2 0
L2 s2 0 18e-3
VS3 2 s3 0
R3 s3 4 12e2
VS4 1 s4 0
C4 s4 4 10e-5
VS5 2 s5 0
R5 s5 3 15e2
VS6 5 s6 0
L6 s6 6 33e-2
VS7 6 s7 0
C7 s7 0 68e-6
VS8 1 s8 0
V8 e8 s8 DC 0 AC 10e1 120
RI8 e8 5 47e-3
.control
set numdgt=17
ac lin 1 60 60
print v(1) v(2) v(3) v(4) v(5) v(6)
print i(vs0) i(vs1) i(vs2) i(vs3) i(vs4) i(vs5) i(vs6) i(vs7) i(vs8)
.endc
.end
