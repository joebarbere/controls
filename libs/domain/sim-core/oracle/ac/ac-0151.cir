controls oracle ac-0151
* Generated (plan F2.7, ADR 0012): do not edit; regenerate with `pnpm sim oracle regen`. ac seed 20261031 index 151 nodes 10 elements 15
.options sparse gmin=1e-12 noopac
RG1 1 0 1000000000000
RG2 2 0 1000000000000
RG3 3 0 1000000000000
RG4 4 0 1000000000000
RG5 5 0 1000000000000
RG6 6 0 1000000000000
RG7 7 0 1000000000000
RG8 8 0 1000000000000
RG9 9 0 1000000000000
VS0 8 s0 0
L0 s0 5 22e-4
VS1 9 s1 0
R1 s1 4 22e1
VS2 1 s2 0
R2 s2 8 10e2
VS3 0 s3 0
R3 s3 8 15e0
VS4 4 s4 0
R4 s4 6 39e3
VS5 7 s5 0
C5 s5 6 56e-5
VS6 2 s6 0
C6 s6 7 22e-7
VS7 0 s7 0
V7 e7 s7 DC 0 AC 22e0 120
RI7 e7 m7 39e-3
LI7 m7 4 39e-6
VS8 7 s8 0
L8 s8 4 47e-4
VS9 1 s9 0
C9 s9 6 27e-5
VS10 9 s10 0
V10 e10 s10 DC 0 AC 33e1 -120
RI10 e10 5 12e-3
VS11 3 s11 0
R11 s11 5 56e-2
VS12 2 s12 0
C12 s12 8 12e-4
VS13 3 s13 0
R13 s13 6 47e-2
VS14 4 s14 0
R14 s14 8 39e1
.control
set numdgt=17
ac lin 1 60 60
print v(1) v(2) v(3) v(4) v(5) v(6) v(7) v(8) v(9)
print i(vs0) i(vs1) i(vs2) i(vs3) i(vs4) i(vs5) i(vs6) i(vs7) i(vs8) i(vs9)
print i(vs10) i(vs11) i(vs12) i(vs13) i(vs14)
.endc
.end
