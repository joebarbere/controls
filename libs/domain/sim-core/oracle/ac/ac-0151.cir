controls oracle ac-0151
* Generated (plan F2.7, ADR 0012): do not edit; regenerate with `pnpm sim oracle regen`. ac seed 20261031 index 151 nodes 10 elements 14
.options sparse gmin=1e-12 noopac
RG1 1 0 1000000000000
RG2 2 0 1000000000000
RG3 3 0 1000000000000
RG4 4 0 1000000000000
RG5 5 0 1000000000000
RG6 6 0 1000000000000
RG7 7 0 1000000000000
RG8 8 0 1000000000000
RG9 9 0 1000000000000
VS0 4 s0 0
R0 s0 8 15e0
VS1 8 s1 0
L1 s1 0 22e-4
VS2 5 s2 0
R2 s2 6 39e3
VS3 0 s3 0
V3 e3 s3 DC 0 AC 33e1 0
RI3 e3 2 33e-1
VS4 7 s4 0
V4 e4 s4 DC 0 AC 39e0 0
RI4 e4 3 27e-1
VS5 1 s5 0
R5 s5 8 10e2
VS6 4 s6 0
V6 e6 s6 DC 0 AC 22e0 120
RI6 e6 5 39e-3
VS7 7 s7 0
L7 s7 5 47e-4
VS8 2 s8 0
C8 s8 7 22e-7
VS9 1 s9 0
C9 s9 9 12e-6
VS10 7 s10 0
C10 s10 6 56e-5
VS11 5 s11 0
R11 s11 8 39e1
VS12 9 s12 0
R12 s12 5 22e1
VS13 3 s13 0
R13 s13 6 47e-2
.control
set numdgt=17
ac lin 1 60 60
print v(1) v(2) v(3) v(4) v(5) v(6) v(7) v(8) v(9)
print i(vs0) i(vs1) i(vs2) i(vs3) i(vs4) i(vs5) i(vs6) i(vs7) i(vs8) i(vs9)
print i(vs10) i(vs11) i(vs12) i(vs13)
.endc
.end
