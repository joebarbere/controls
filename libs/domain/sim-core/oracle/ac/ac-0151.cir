controls oracle ac-0151
* Generated (plan F2.7, ADR 0012): do not edit; regenerate with `pnpm sim oracle regen`. ac seed 20261031 index 151 nodes 10 elements 11
.options sparse gmin=1e-12 noopac
RG1 1 0 1000000000000
RG2 2 0 1000000000000
RG3 3 0 1000000000000
RG4 4 0 1000000000000
RG5 5 0 1000000000000
RG6 6 0 1000000000000
RG7 7 0 1000000000000
RG8 8 0 1000000000000
RG9 9 0 1000000000000
VS0 4 s0 0
R0 s0 8 39e1
VS1 0 s1 0
V1 e1 s1 DC 0 AC 22e0 120
RI1 e1 4 39e-3
VS2 4 s2 0
R2 s2 6 39e3
VS3 1 s3 0
R3 s3 8 10e2
VS4 8 s4 0
L4 s4 5 22e-4
VS5 7 s5 0
L5 s5 4 47e-4
VS6 7 s6 0
C6 s6 6 56e-5
VS7 0 s7 0
R7 s7 8 15e0
VS8 3 s8 0
R8 s8 6 47e-2
VS9 2 s9 0
C9 s9 7 22e-7
VS10 9 s10 0
R10 s10 4 22e1
.control
set numdgt=17
ac lin 1 60 60
print v(1) v(2) v(3) v(4) v(5) v(6) v(7) v(8) v(9)
print i(vs0) i(vs1) i(vs2) i(vs3) i(vs4) i(vs5) i(vs6) i(vs7) i(vs8) i(vs9)
print i(vs10)
.endc
.end
