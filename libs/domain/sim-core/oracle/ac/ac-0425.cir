controls oracle ac-0425
* Generated (plan F2.7, ADR 0012): do not edit; regenerate with `pnpm sim oracle regen`. ac seed 20261031 index 425 nodes 19 elements 35
.options sparse gmin=1e-12 noopac
RG1 1 0 1000000000000
RG2 2 0 1000000000000
RG3 3 0 1000000000000
RG4 4 0 1000000000000
RG5 5 0 1000000000000
RG6 6 0 1000000000000
RG7 7 0 1000000000000
RG8 8 0 1000000000000
RG9 9 0 1000000000000
RG10 10 0 1000000000000
RG11 11 0 1000000000000
RG12 12 0 1000000000000
RG13 13 0 1000000000000
RG14 14 0 1000000000000
RG15 15 0 1000000000000
RG16 16 0 1000000000000
RG17 17 0 1000000000000
RG18 18 0 1000000000000
VS0 0 s0 0
V0 e0 s0 DC 0 AC 47e0 0
RI0 e0 6 22e-3
VS1 11 s1 0
C1 s1 0 12e-5
VS2 2 s2 0
V2 e2 s2 DC 0 AC 12e1 120
RI2 e2 1 39e-2
VS3 7 s3 0
L3 s3 10 39e-5
VS4 1 s4 0
C4 s4 8 10e-4
VS5 14 s5 0
L5 s5 13 82e-5
VS6 4 s6 0
R6 s6 2 15e1
VS7 2 s7 0
C7 s7 3 47e-4
VS8 8 s8 0
L8 s8 10 12e-3
VS9 0 s9 0
V9 e9 s9 DC 0 AC 12e0 120
RI9 e9 7 33e-3
VS10 18 s10 0
C10 s10 5 22e-7
VS11 15 s11 0
L11 s11 13 15e-2
VS12 16 s12 0
R12 s12 11 33e2
VS13 13 s13 0
V13 e13 s13 DC 0 AC 12e-1 120
RI13 e13 4 18e-1
VS14 12 s14 0
V14 e14 s14 DC 0 AC 56e1 0
RI14 e14 7 47e-2
VS15 15 s15 0
R15 s15 17 10e2
VS16 17 s16 0
L16 s16 3 68e-3
VS17 18 s17 0
C17 s17 4 33e-7
VS18 3 s18 0
V18 e18 s18 DC 0 AC 22e0 180
RI18 e18 6 22e-2
VS19 8 s19 0
V19 e19 s19 DC 0 AC 10e0 180
RI19 e19 9 27e-1
VS20 5 s20 0
V20 e20 s20 DC 0 AC 82e1 180
RI20 e20 8 56e-1
VS21 5 s21 0
V21 e21 s21 DC 0 AC 12e-1 180
RI21 e21 10 18e-3
VS22 14 s22 0
R22 s22 1 10e3
VS23 6 s23 0
V23 e23 s23 DC 0 AC 18e-1 -120
RI23 e23 10 33e-2
VS24 7 s24 0
C24 s24 11 33e-6
VS25 7 s25 0
V25 e25 s25 DC 0 AC 56e0 120
RI25 e25 6 12e-1
VS26 9 s26 0
L26 s26 13 82e-3
VS27 4 s27 0
C27 s27 9 12e-4
VS28 12 s28 0
C28 s28 6 33e-5
VS29 1 s29 0
V29 e29 s29 DC 0 AC 47e-1 0
RI29 e29 5 12e-2
VS30 13 s30 0
C30 s30 4 33e-5
VS31 11 s31 0
R31 s31 5 39e-2
VS32 3 s32 0
C32 s32 0 10e-4
VS33 6 s33 0
R33 s33 15 18e1
VS34 7 s34 0
R34 s34 18 56e2
.control
set numdgt=17
ac lin 1 60 60
print v(1) v(2) v(3) v(4) v(5) v(6) v(7) v(8) v(9) v(10)
print v(11) v(12) v(13) v(14) v(15) v(16) v(17) v(18)
print i(vs0) i(vs1) i(vs2) i(vs3) i(vs4) i(vs5) i(vs6) i(vs7) i(vs8) i(vs9)
print i(vs10) i(vs11) i(vs12) i(vs13) i(vs14) i(vs15) i(vs16) i(vs17) i(vs18) i(vs19)
print i(vs20) i(vs21) i(vs22) i(vs23) i(vs24) i(vs25) i(vs26) i(vs27) i(vs28) i(vs29)
print i(vs30) i(vs31) i(vs32) i(vs33) i(vs34)
.endc
.end
