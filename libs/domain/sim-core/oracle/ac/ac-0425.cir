controls oracle ac-0425
* Generated (plan F2.7, ADR 0012): do not edit; regenerate with `pnpm sim oracle regen`. ac seed 20261031 index 425 nodes 19 elements 33
.options sparse gmin=1e-12 noopac
RG1 1 0 1000000000000
RG2 2 0 1000000000000
RG3 3 0 1000000000000
RG4 4 0 1000000000000
RG5 5 0 1000000000000
RG6 6 0 1000000000000
RG7 7 0 1000000000000
RG8 8 0 1000000000000
RG9 9 0 1000000000000
RG10 10 0 1000000000000
RG11 11 0 1000000000000
RG12 12 0 1000000000000
RG13 13 0 1000000000000
RG14 14 0 1000000000000
RG15 15 0 1000000000000
RG16 16 0 1000000000000
RG17 17 0 1000000000000
RG18 18 0 1000000000000
VS0 12 s0 0
R0 s0 11 33e2
VS1 5 s1 0
C1 s1 3 39e-5
VS2 0 s2 0
V2 e2 s2 DC 0 AC 47e0 0
RI2 e2 7 22e-1
VS3 13 s3 0
C3 s3 7 22e-5
VS4 9 s4 0
C4 s4 13 10e-5
VS5 18 s5 0
C5 s5 3 82e-6
VS6 7 s6 0
V6 e6 s6 DC 0 AC 12e0 180
RI6 e6 m6 47e-1
LI6 m6 11 33e-7
VS7 4 s7 0
R7 s7 2 15e1
VS8 10 s8 0
L8 s8 6 82e-5
VS9 16 s9 0
L9 s9 8 39e-5
VS10 2 s10 0
R10 s10 14 10e3
VS11 1 s11 0
V11 e11 s11 DC 0 AC 56e0 -120
RI11 e11 18 56e-1
VS12 2 s12 0
V12 e12 s12 DC 0 AC 12e1 120
RI12 e12 1 39e-2
VS13 7 s13 0
C13 s13 11 33e-6
VS14 5 s14 0
R14 s14 16 33e1
VS15 15 s15 0
L15 s15 16 18e-2
VS16 13 s16 0
C16 s16 16 22e-7
VS17 17 s17 0
R17 s17 6 56e2
VS18 3 s18 0
C18 s18 16 10e-4
VS19 12 s19 0
R19 s19 18 82e-2
VS20 8 s20 0
L20 s20 10 12e-3
VS21 0 s21 0
L21 s21 13 27e-3
VS22 11 s22 0
C22 s22 16 12e-5
VS23 13 s23 0
R23 s23 10 22e2
VS24 17 s24 0
V24 e24 s24 DC 0 AC 68e0 180
RI24 e24 7 10e-2
VS25 17 s25 0
C25 s25 9 10e-4
VS26 16 s26 0
V26 e26 s26 DC 0 AC 47e0 0
RI26 e26 6 22e-3
VS27 11 s27 0
L27 s27 14 33e-4
VS28 15 s28 0
V28 e28 s28 DC 0 AC 56e1 120
RI28 e28 m28 56e-3
LI28 m28 3 15e-6
VS29 3 s29 0
R29 s29 6 33e-2
VS30 4 s30 0
L30 s30 11 22e-5
VS31 2 s31 0
V31 e31 s31 DC 0 AC 39e1 -120
RI31 e31 m31 10e-2
LI31 m31 4 27e-5
VS32 1 s32 0
C32 s32 8 10e-4
.control
set numdgt=17
ac lin 1 60 60
print v(1) v(2) v(3) v(4) v(5) v(6) v(7) v(8) v(9) v(10)
print v(11) v(12) v(13) v(14) v(15) v(16) v(17) v(18)
print i(vs0) i(vs1) i(vs2) i(vs3) i(vs4) i(vs5) i(vs6) i(vs7) i(vs8) i(vs9)
print i(vs10) i(vs11) i(vs12) i(vs13) i(vs14) i(vs15) i(vs16) i(vs17) i(vs18) i(vs19)
print i(vs20) i(vs21) i(vs22) i(vs23) i(vs24) i(vs25) i(vs26) i(vs27) i(vs28) i(vs29)
print i(vs30) i(vs31) i(vs32)
.endc
.end
