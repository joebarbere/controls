controls oracle ac-0157
* Generated (plan F2.7, ADR 0012): do not edit; regenerate with `pnpm sim oracle regen`. ac seed 20261031 index 157 nodes 9 elements 15
.options sparse gmin=1e-12 noopac
RG1 1 0 1000000000000
RG2 2 0 1000000000000
RG3 3 0 1000000000000
RG4 4 0 1000000000000
RG5 5 0 1000000000000
RG6 6 0 1000000000000
RG7 7 0 1000000000000
RG8 8 0 1000000000000
VS0 0 s0 0
V0 e0 s0 DC 0 AC 15e1 180
RI0 e0 n0 27e-3
H0 n0 h0 VS3 -47e-4
ED0 h0 3 d0 0 -15e-7
F0 0 d0 VS3 1
LD0 d0 0 1
VS1 4 s1 0
C1 s1 7 18e-4
VS2 2 s2 0
C2 s2 5 68e-6
VS3 0 s3 0
V3 e3 s3 DC 0 AC 22e0 0
RI3 e3 m3 27e-3
LI3 m3 n3 22e-7
H3 n3 h3 VS0 -47e-4
ED3 h3 6 d3 0 -15e-7
F3 0 d3 VS0 1
LD3 d3 0 1
VS4 8 s4 0
R4 s4 0 22e-1
VS5 8 s5 0
R5 s5 1 27e1
VS6 0 s6 0
R6 s6 4 39e-2
VS7 5 s7 0
R7 s7 4 12e-2
VS8 2 s8 0
C8 s8 1 27e-6
VS9 1 s9 0
R9 s9 8 22e0
VS10 8 s10 0
L10 s10 3 15e-2
VS11 5 s11 0
L11 s11 8 10e-2
VS12 6 s12 0
C12 s12 5 27e-7
VS13 2 s13 0
C13 s13 0 82e-5
VS14 0 s14 0
L14 s14 7 68e-2
.control
set numdgt=17
ac lin 1 60 60
print v(1) v(2) v(3) v(4) v(5) v(6) v(7) v(8)
print i(vs0) i(vs1) i(vs2) i(vs3) i(vs4) i(vs5) i(vs6) i(vs7) i(vs8) i(vs9)
print i(vs10) i(vs11) i(vs12) i(vs13) i(vs14)
.endc
.end
