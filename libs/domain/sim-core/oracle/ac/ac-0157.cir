controls oracle ac-0157
* Generated (plan F2.7, ADR 0012): do not edit; regenerate with `pnpm sim oracle regen`. ac seed 20261031 index 157 nodes 9 elements 13
.options sparse gmin=1e-12 noopac
RG1 1 0 1000000000000
RG2 2 0 1000000000000
RG3 3 0 1000000000000
RG4 4 0 1000000000000
RG5 5 0 1000000000000
RG6 6 0 1000000000000
RG7 7 0 1000000000000
RG8 8 0 1000000000000
VS0 8 s0 0
R0 s0 1 27e1
VS1 0 s1 0
V1 e1 s1 DC 0 AC 15e1 180
RI1 e1 3 27e-3
VS2 2 s2 0
C2 s2 0 82e-5
VS3 8 s3 0
L3 s3 3 15e-2
VS4 1 s4 0
R4 s4 8 22e0
VS5 8 s5 0
R5 s5 0 22e-1
VS6 5 s6 0
R6 s6 4 12e-2
VS7 4 s7 0
C7 s7 7 18e-4
VS8 6 s8 0
C8 s8 5 27e-7
VS9 0 s9 0
R9 s9 4 39e-2
VS10 0 s10 0
V10 e10 s10 DC 0 AC 22e0 0
RI10 e10 6 27e-3
VS11 2 s11 0
C11 s11 5 68e-6
VS12 5 s12 0
L12 s12 8 10e-2
.control
set numdgt=17
ac lin 1 60 60
print v(1) v(2) v(3) v(4) v(5) v(6) v(7) v(8)
print i(vs0) i(vs1) i(vs2) i(vs3) i(vs4) i(vs5) i(vs6) i(vs7) i(vs8) i(vs9)
print i(vs10) i(vs11) i(vs12)
.endc
.end
