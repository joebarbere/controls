controls oracle ac-0062
* Generated (plan F2.7, ADR 0012): do not edit; regenerate with `pnpm sim oracle regen`. ac seed 20261031 index 62 nodes 22 elements 36
.options sparse gmin=1e-12 noopac
RG1 1 0 1000000000000
RG2 2 0 1000000000000
RG3 3 0 1000000000000
RG4 4 0 1000000000000
RG5 5 0 1000000000000
RG6 6 0 1000000000000
RG7 7 0 1000000000000
RG8 8 0 1000000000000
RG9 9 0 1000000000000
RG10 10 0 1000000000000
RG11 11 0 1000000000000
RG12 12 0 1000000000000
RG13 13 0 1000000000000
RG14 14 0 1000000000000
RG15 15 0 1000000000000
RG16 16 0 1000000000000
RG17 17 0 1000000000000
RG18 18 0 1000000000000
RG19 19 0 1000000000000
RG20 20 0 1000000000000
RG21 21 0 1000000000000
VS0 10 s0 0
R0 s0 5 39e3
VS1 20 s1 0
L1 s1 8 82e-3
VS2 17 s2 0
L2 s2 18 15e-3
VS3 0 s3 0
V3 e3 s3 DC 0 AC 12e1 120
RI3 e3 16 18e-3
VS4 11 s4 0
C4 s4 0 82e-7
VS5 15 s5 0
R5 s5 8 18e-2
VS6 16 s6 0
C6 s6 7 15e-6
VS7 20 s7 0
R7 s7 12 10e1
VS8 9 s8 0
C8 s8 11 22e-4
VS9 12 s9 0
L9 s9 5 68e-4
VS10 9 s10 0
L10 s10 11 27e-2
VS11 10 s11 0
R11 s11 16 68e0
VS12 15 s12 0
L12 s12 12 27e-2
VS13 7 s13 0
L13 s13 15 27e-4
VS14 6 s14 0
R14 s14 15 15e2
VS15 18 s15 0
C15 s15 10 10e-6
VS16 12 s16 0
C16 s16 11 39e-5
VS17 3 s17 0
C17 s17 21 47e-7
VS18 1 s18 0
R18 s18 13 22e3
VS19 15 s19 0
L19 s19 16 82e-3
VS20 11 s20 0
C20 s20 2 12e-6
VS21 5 s21 0
C21 s21 4 33e-6
VS22 21 s22 0
R22 s22 2 15e1
VS23 4 s23 0
V23 e23 s23 DC 0 AC 39e-1 120
RI23 e23 21 39e-2
VS24 3 s24 0
R24 s24 15 12e1
VS25 8 s25 0
V25 e25 s25 DC 0 AC 68e0 -120
RI25 e25 20 33e-1
VS26 17 s26 0
R26 s26 11 18e2
VS27 4 s27 0
R27 s27 13 33e1
VS28 15 s28 0
R28 s28 0 56e0
VS29 14 s29 0
R29 s29 10 10e-2
VS30 18 s30 0
C30 s30 6 15e-7
VS31 9 s31 0
C31 s31 10 39e-7
VS32 19 s32 0
V32 e32 s32 DC 0 AC 22e1 120
RI32 e32 1 10e-3
VS33 20 s33 0
V33 e33 s33 DC 0 AC 15e0 0
RI33 e33 14 33e-2
VS34 3 s34 0
L34 s34 19 10e-3
VS35 4 s35 0
C35 s35 20 56e-5
.control
set numdgt=17
ac lin 1 60 60
print v(1) v(2) v(3) v(4) v(5) v(6) v(7) v(8) v(9) v(10)
print v(11) v(12) v(13) v(14) v(15) v(16) v(17) v(18) v(19) v(20)
print v(21)
print i(vs0) i(vs1) i(vs2) i(vs3) i(vs4) i(vs5) i(vs6) i(vs7) i(vs8) i(vs9)
print i(vs10) i(vs11) i(vs12) i(vs13) i(vs14) i(vs15) i(vs16) i(vs17) i(vs18) i(vs19)
print i(vs20) i(vs21) i(vs22) i(vs23) i(vs24) i(vs25) i(vs26) i(vs27) i(vs28) i(vs29)
print i(vs30) i(vs31) i(vs32) i(vs33) i(vs34) i(vs35)
.endc
.end
