controls oracle ac-0062
* Generated (plan F2.7, ADR 0012): do not edit; regenerate with `pnpm sim oracle regen`. ac seed 20261031 index 62 nodes 22 elements 28
.options sparse gmin=1e-12 noopac
RG1 1 0 1000000000000
RG2 2 0 1000000000000
RG3 3 0 1000000000000
RG4 4 0 1000000000000
RG5 5 0 1000000000000
RG6 6 0 1000000000000
RG7 7 0 1000000000000
RG8 8 0 1000000000000
RG9 9 0 1000000000000
RG10 10 0 1000000000000
RG11 11 0 1000000000000
RG12 12 0 1000000000000
RG13 13 0 1000000000000
RG14 14 0 1000000000000
RG15 15 0 1000000000000
RG16 16 0 1000000000000
RG17 17 0 1000000000000
RG18 18 0 1000000000000
RG19 19 0 1000000000000
RG20 20 0 1000000000000
RG21 21 0 1000000000000
VS0 0 s0 0
V0 e0 s0 DC 0 AC 12e1 120
RI0 e0 16 18e-3
VS1 3 s1 0
R1 s1 15 12e1
VS2 9 s2 0
L2 s2 11 27e-2
VS3 4 s3 0
R3 s3 13 33e1
VS4 3 s4 0
L4 s4 19 10e-3
VS5 17 s5 0
R5 s5 11 18e2
VS6 6 s6 0
R6 s6 15 15e2
VS7 9 s7 0
C7 s7 11 22e-4
VS8 3 s8 0
C8 s8 21 47e-7
VS9 16 s9 0
C9 s9 7 15e-6
VS10 20 s10 0
L10 s10 8 82e-3
VS11 5 s11 0
C11 s11 4 33e-6
VS12 20 s12 0
R12 s12 12 10e1
VS13 12 s13 0
C13 s13 11 39e-5
VS14 11 s14 0
C14 s14 2 12e-6
VS15 18 s15 0
C15 s15 6 15e-7
VS16 7 s16 0
L16 s16 15 27e-4
VS17 11 s17 0
C17 s17 0 82e-7
VS18 19 s18 0
V18 e18 s18 DC 0 AC 22e1 120
RI18 e18 1 10e-3
VS19 10 s19 0
R19 s19 5 39e3
VS20 12 s20 0
L20 s20 5 68e-4
VS21 20 s21 0
V21 e21 s21 DC 0 AC 15e0 0
RI21 e21 14 33e-2
VS22 15 s22 0
L22 s22 16 82e-3
VS23 15 s23 0
L23 s23 12 27e-2
VS24 4 s24 0
C24 s24 20 56e-5
VS25 8 s25 0
V25 e25 s25 DC 0 AC 68e0 -120
RI25 e25 20 33e-1
VS26 10 s26 0
R26 s26 16 68e0
VS27 15 s27 0
R27 s27 0 56e0
.control
set numdgt=17
ac lin 1 60 60
print v(1) v(2) v(3) v(4) v(5) v(6) v(7) v(8) v(9) v(10)
print v(11) v(12) v(13) v(14) v(15) v(16) v(17) v(18) v(19) v(20)
print v(21)
print i(vs0) i(vs1) i(vs2) i(vs3) i(vs4) i(vs5) i(vs6) i(vs7) i(vs8) i(vs9)
print i(vs10) i(vs11) i(vs12) i(vs13) i(vs14) i(vs15) i(vs16) i(vs17) i(vs18) i(vs19)
print i(vs20) i(vs21) i(vs22) i(vs23) i(vs24) i(vs25) i(vs26) i(vs27)
.endc
.end
