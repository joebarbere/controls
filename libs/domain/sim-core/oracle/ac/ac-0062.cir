controls oracle ac-0062
* Generated (plan F2.7, ADR 0012): do not edit; regenerate with `pnpm sim oracle regen`. ac seed 20261031 index 62 nodes 22 elements 39
.options sparse gmin=1e-12 noopac
RG1 1 0 1000000000000
RG2 2 0 1000000000000
RG3 3 0 1000000000000
RG4 4 0 1000000000000
RG5 5 0 1000000000000
RG6 6 0 1000000000000
RG7 7 0 1000000000000
RG8 8 0 1000000000000
RG9 9 0 1000000000000
RG10 10 0 1000000000000
RG11 11 0 1000000000000
RG12 12 0 1000000000000
RG13 13 0 1000000000000
RG14 14 0 1000000000000
RG15 15 0 1000000000000
RG16 16 0 1000000000000
RG17 17 0 1000000000000
RG18 18 0 1000000000000
RG19 19 0 1000000000000
RG20 20 0 1000000000000
RG21 21 0 1000000000000
VS0 4 s0 0
R0 s0 13 33e1
VS1 7 s1 0
L1 s1 15 27e-4
VS2 0 s2 0
R2 s2 20 10e1
VS3 17 s3 0
R3 s3 11 18e2
VS4 3 s4 0
L4 s4 19 10e-3
VS5 0 s5 0
V5 e5 s5 DC 0 AC 47e0 -120
RI5 e5 19 39e-1
VS6 2 s6 0
R6 s6 8 27e-2
VS7 15 s7 0
L7 s7 16 82e-3
VS8 6 s8 0
R8 s8 15 15e2
VS9 6 s9 0
L9 s9 13 18e-4
VS10 15 s10 0
R10 s10 6 47e-1
VS11 7 s11 0
C11 s11 2 47e-5
VS12 3 s12 0
R12 s12 6 82e3
VS13 2 s13 0
V13 e13 s13 DC 0 AC 56e0 -120
RI13 e13 12 33e-2
VS14 9 s14 0
C14 s14 11 22e-4
VS15 0 s15 0
V15 e15 s15 DC 0 AC 15e0 180
RI15 e15 20 82e-1
VS16 4 s16 0
C16 s16 0 56e-5
VS17 8 s17 0
C17 s17 21 12e-7
VS18 12 s18 0
C18 s18 16 15e-5
VS19 0 s19 0
V19 e19 s19 DC 0 AC 15e0 0
RI19 e19 14 33e-2
VS20 10 s20 0
R20 s20 9 27e-1
VS21 18 s21 0
L21 s21 1 27e-3
VS22 15 s22 0
L22 s22 20 27e-2
VS23 12 s23 0
R23 s23 21 22e3
VS24 3 s24 0
C24 s24 21 82e-5
VS25 0 s25 0
L25 s25 8 82e-3
VS26 20 s26 0
L26 s26 5 68e-4
VS27 9 s27 0
R27 s27 18 10e3
VS28 14 s28 0
V28 e28 s28 DC 0 AC 18e-1 0
RI28 e28 m28 27e-1
LI28 m28 17 33e-6
VS29 12 s29 0
R29 s29 4 56e3
VS30 20 s30 0
C30 s30 11 39e-5
VS31 5 s31 0
R31 s31 10 39e-2
VS32 12 s32 0
C32 s32 14 82e-4
VS33 4 s33 0
R33 s33 14 12e1
VS34 15 s34 0
R34 s34 12 56e0
VS35 1 s35 0
R35 s35 8 82e2
VS36 18 s36 0
R36 s36 10 18e0
VS37 6 s37 0
L37 s37 15 82e-2
VS38 3 s38 0
R38 s38 15 12e1
.control
set numdgt=17
ac lin 1 60 60
print v(1) v(2) v(3) v(4) v(5) v(6) v(7) v(8) v(9) v(10)
print v(11) v(12) v(13) v(14) v(15) v(16) v(17) v(18) v(19) v(20)
print v(21)
print i(vs0) i(vs1) i(vs2) i(vs3) i(vs4) i(vs5) i(vs6) i(vs7) i(vs8) i(vs9)
print i(vs10) i(vs11) i(vs12) i(vs13) i(vs14) i(vs15) i(vs16) i(vs17) i(vs18) i(vs19)
print i(vs20) i(vs21) i(vs22) i(vs23) i(vs24) i(vs25) i(vs26) i(vs27) i(vs28) i(vs29)
print i(vs30) i(vs31) i(vs32) i(vs33) i(vs34) i(vs35) i(vs36) i(vs37) i(vs38)
.endc
.end
