controls oracle ac-0166
* Generated (plan F2.7, ADR 0012): do not edit; regenerate with `pnpm sim oracle regen`. ac seed 20261031 index 166 nodes 16 elements 23
.options sparse gmin=1e-12 noopac
RG1 1 0 1000000000000
RG2 2 0 1000000000000
RG3 3 0 1000000000000
RG4 4 0 1000000000000
RG5 5 0 1000000000000
RG6 6 0 1000000000000
RG7 7 0 1000000000000
RG8 8 0 1000000000000
RG9 9 0 1000000000000
RG10 10 0 1000000000000
RG11 11 0 1000000000000
RG12 12 0 1000000000000
RG13 13 0 1000000000000
RG14 14 0 1000000000000
RG15 15 0 1000000000000
VS0 13 s0 0
R0 s0 11 68e3
VS1 12 s1 0
L1 s1 3 33e-3
VS2 3 s2 0
L2 s2 4 68e-5
VS3 13 s3 0
R3 s3 2 82e1
VS4 9 s4 0
C4 s4 1 12e-7
VS5 13 s5 0
L5 s5 8 27e-2
VS6 1 s6 0
L6 s6 12 33e-3
VS7 8 s7 0
C7 s7 9 68e-7
VS8 0 s8 0
V8 e8 s8 DC 0 AC 10e1 120
RI8 e8 m8 12e-3
LI8 m8 3 56e-6
VS9 4 s9 0
L9 s9 13 10e-5
VS10 11 s10 0
L10 s10 13 56e-3
VS11 10 s11 0
R11 s11 7 12e1
VS12 5 s12 0
R12 s12 6 22e1
VS13 15 s13 0
L13 s13 3 27e-4
VS14 8 s14 0
R14 s14 7 56e2
VS15 14 s15 0
C15 s15 11 47e-4
VS16 6 s16 0
L16 s16 4 68e-4
VS17 14 s17 0
R17 s17 5 15e0
VS18 0 s18 0
C18 s18 12 10e-6
VS19 10 s19 0
C19 s19 3 82e-6
VS20 15 s20 0
C20 s20 6 15e-6
VS21 6 s21 0
L21 s21 8 47e-5
VS22 12 s22 0
R22 s22 2 82e1
.control
set numdgt=17
ac lin 1 60 60
print v(1) v(2) v(3) v(4) v(5) v(6) v(7) v(8) v(9) v(10)
print v(11) v(12) v(13) v(14) v(15)
print i(vs0) i(vs1) i(vs2) i(vs3) i(vs4) i(vs5) i(vs6) i(vs7) i(vs8) i(vs9)
print i(vs10) i(vs11) i(vs12) i(vs13) i(vs14) i(vs15) i(vs16) i(vs17) i(vs18) i(vs19)
print i(vs20) i(vs21) i(vs22)
.endc
.end
