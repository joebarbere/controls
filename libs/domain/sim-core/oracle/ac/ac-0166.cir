controls oracle ac-0166
* Generated (plan F2.7, ADR 0012): do not edit; regenerate with `pnpm sim oracle regen`. ac seed 20261031 index 166 nodes 16 elements 20
.options sparse gmin=1e-12 noopac
RG1 1 0 1000000000000
RG2 2 0 1000000000000
RG3 3 0 1000000000000
RG4 4 0 1000000000000
RG5 5 0 1000000000000
RG6 6 0 1000000000000
RG7 7 0 1000000000000
RG8 8 0 1000000000000
RG9 9 0 1000000000000
RG10 10 0 1000000000000
RG11 11 0 1000000000000
RG12 12 0 1000000000000
RG13 13 0 1000000000000
RG14 14 0 1000000000000
RG15 15 0 1000000000000
VS0 10 s0 0
C0 s0 3 82e-6
VS1 1 s1 0
L1 s1 12 33e-3
VS2 14 s2 0
R2 s2 5 15e0
VS3 13 s3 0
L3 s3 8 27e-2
VS4 8 s4 0
C4 s4 9 68e-7
VS5 3 s5 0
L5 s5 4 68e-5
VS6 15 s6 0
C6 s6 6 15e-6
VS7 12 s7 0
L7 s7 3 33e-3
VS8 5 s8 0
R8 s8 6 22e1
VS9 13 s9 0
R9 s9 2 82e1
VS10 4 s10 0
L10 s10 13 10e-5
VS11 10 s11 0
R11 s11 7 12e1
VS12 6 s12 0
L12 s12 4 68e-4
VS13 11 s13 0
L13 s13 13 56e-3
VS14 6 s14 0
L14 s14 8 47e-5
VS15 0 s15 0
C15 s15 12 10e-6
VS16 0 s16 0
V16 e16 s16 DC 0 AC 10e1 120
RI16 e16 3 12e-3
VS17 12 s17 0
R17 s17 2 82e1
VS18 8 s18 0
R18 s18 7 56e2
VS19 13 s19 0
R19 s19 11 68e3
.control
set numdgt=17
ac lin 1 60 60
print v(1) v(2) v(3) v(4) v(5) v(6) v(7) v(8) v(9) v(10)
print v(11) v(12) v(13) v(14) v(15)
print i(vs0) i(vs1) i(vs2) i(vs3) i(vs4) i(vs5) i(vs6) i(vs7) i(vs8) i(vs9)
print i(vs10) i(vs11) i(vs12) i(vs13) i(vs14) i(vs15) i(vs16) i(vs17) i(vs18) i(vs19)
.endc
.end
