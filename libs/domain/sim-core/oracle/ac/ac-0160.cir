controls oracle ac-0160
* Generated (plan F2.7, ADR 0012): do not edit; regenerate with `pnpm sim oracle regen`. ac seed 20261031 index 160 nodes 25 elements 50
.options sparse gmin=1e-12 noopac
RG1 1 0 1000000000000
RG2 2 0 1000000000000
RG3 3 0 1000000000000
RG4 4 0 1000000000000
RG5 5 0 1000000000000
RG6 6 0 1000000000000
RG7 7 0 1000000000000
RG8 8 0 1000000000000
RG9 9 0 1000000000000
RG10 10 0 1000000000000
RG11 11 0 1000000000000
RG12 12 0 1000000000000
RG13 13 0 1000000000000
RG14 14 0 1000000000000
RG15 15 0 1000000000000
RG16 16 0 1000000000000
RG17 17 0 1000000000000
RG18 18 0 1000000000000
RG19 19 0 1000000000000
RG20 20 0 1000000000000
RG21 21 0 1000000000000
RG22 22 0 1000000000000
RG23 23 0 1000000000000
RG24 24 0 1000000000000
VS0 20 s0 0
L0 s0 7 39e-2
VS1 17 s1 0
R1 s1 7 10e1
VS2 8 s2 0
L2 s2 15 68e-2
VS3 15 s3 0
R3 s3 23 39e1
VS4 5 s4 0
C4 s4 2 10e-7
VS5 21 s5 0
C5 s5 24 47e-4
VS6 8 s6 0
R6 s6 22 39e3
VS7 9 s7 0
C7 s7 19 39e-4
VS8 20 s8 0
C8 s8 13 27e-4
VS9 0 s9 0
V9 e9 s9 DC 0 AC 12e0 180
RI9 e9 n9 33e-2
H9 n9 h9 VS14 -82e-3
ED9 h9 6 d9 0 -82e-5
F9 0 d9 VS14 1
LD9 d9 0 1
VS10 11 s10 0
L10 s10 5 47e-4
VS11 16 s11 0
L11 s11 24 22e-3
VS12 20 s12 0
R12 s12 17 10e2
VS13 8 s13 0
R13 s13 21 56e-2
VS14 1 s14 0
V14 e14 s14 DC 0 AC 18e1 120
RI14 e14 n14 15e-1
H14 n14 h14 VS9 -82e-3
ED14 h14 14 d14 0 -82e-5
F14 0 d14 VS9 1
LD14 d14 0 1
VS15 24 s15 0
R15 s15 10 18e3
VS16 6 s16 0
V16 e16 s16 DC 0 AC 18e0 0
RI16 e16 0 47e-1
VS17 2 s17 0
L17 s17 12 82e-2
VS18 5 s18 0
R18 s18 23 18e-2
VS19 8 s19 0
R19 s19 2 18e1
VS20 22 s20 0
V20 e20 s20 DC 0 AC 33e0 -120
RI20 e20 11 10e-2
VS21 12 s21 0
L21 s21 13 56e-5
VS22 24 s22 0
C22 s22 20 15e-5
VS23 1 s23 0
V23 e23 s23 DC 0 AC 56e1 -120
RI23 e23 13 27e-2
VS24 19 s24 0
C24 s24 0 47e-6
VS25 12 s25 0
L25 s25 2 12e-5
VS26 8 s26 0
V26 e26 s26 DC 0 AC 27e1 -120
RI26 e26 m26 27e-3
LI26 m26 2 47e-5
VS27 24 s27 0
V27 e27 s27 DC 0 AC 33e-1 -120
RI27 e27 m27 10e-3
LI27 m27 13 10e-7
VS28 0 s28 0
C28 s28 10 68e-4
VS29 21 s29 0
C29 s29 16 68e-6
VS30 15 s30 0
R30 s30 3 47e-1
VS31 1 s31 0
C31 s31 5 15e-6
VS32 9 s32 0
C32 s32 6 82e-6
VS33 23 s33 0
R33 s33 6 27e0
VS34 9 s34 0
L34 s34 3 22e-4
VS35 15 s35 0
R35 s35 8 12e3
VS36 4 s36 0
R36 s36 11 56e0
VS37 6 s37 0
L37 s37 13 22e-5
VS38 20 s38 0
C38 s38 18 68e-7
VS39 1 s39 0
L39 s39 7 33e-3
VS40 14 s40 0
C40 s40 2 27e-6
VS41 24 s41 0
C41 s41 15 27e-5
VS42 4 s42 0
R42 s42 13 56e-2
VS43 23 s43 0
L43 s43 18 15e-4
VS44 24 s44 0
R44 s44 11 39e-2
VS45 15 s45 0
R45 s45 24 12e0
VS46 11 s46 0
V46 e46 s46 DC 0 AC 33e1 0
RI46 e46 5 12e-3
VS47 24 s47 0
V47 e47 s47 DC 0 AC 10e-1 -120
RI47 e47 m47 10e-2
LI47 m47 1 47e-5
VS48 5 s48 0
R48 s48 13 27e-1
VS49 24 s49 0
C49 s49 9 12e-6
.control
set numdgt=17
ac lin 1 60 60
print v(1) v(2) v(3) v(4) v(5) v(6) v(7) v(8) v(9) v(10)
print v(11) v(12) v(13) v(14) v(15) v(16) v(17) v(18) v(19) v(20)
print v(21) v(22) v(23) v(24)
print i(vs0) i(vs1) i(vs2) i(vs3) i(vs4) i(vs5) i(vs6) i(vs7) i(vs8) i(vs9)
print i(vs10) i(vs11) i(vs12) i(vs13) i(vs14) i(vs15) i(vs16) i(vs17) i(vs18) i(vs19)
print i(vs20) i(vs21) i(vs22) i(vs23) i(vs24) i(vs25) i(vs26) i(vs27) i(vs28) i(vs29)
print i(vs30) i(vs31) i(vs32) i(vs33) i(vs34) i(vs35) i(vs36) i(vs37) i(vs38) i(vs39)
print i(vs40) i(vs41) i(vs42) i(vs43) i(vs44) i(vs45) i(vs46) i(vs47) i(vs48) i(vs49)
.endc
.end
