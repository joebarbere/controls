controls oracle ac-0160
* Generated (plan F2.7, ADR 0012): do not edit; regenerate with `pnpm sim oracle regen`. ac seed 20261031 index 160 nodes 25 elements 53
.options sparse gmin=1e-12 noopac
RG1 1 0 1000000000000
RG2 2 0 1000000000000
RG3 3 0 1000000000000
RG4 4 0 1000000000000
RG5 5 0 1000000000000
RG6 6 0 1000000000000
RG7 7 0 1000000000000
RG8 8 0 1000000000000
RG9 9 0 1000000000000
RG10 10 0 1000000000000
RG11 11 0 1000000000000
RG12 12 0 1000000000000
RG13 13 0 1000000000000
RG14 14 0 1000000000000
RG15 15 0 1000000000000
RG16 16 0 1000000000000
RG17 17 0 1000000000000
RG18 18 0 1000000000000
RG19 19 0 1000000000000
RG20 20 0 1000000000000
RG21 21 0 1000000000000
RG22 22 0 1000000000000
RG23 23 0 1000000000000
RG24 24 0 1000000000000
VS0 2 s0 0
R0 s0 7 39e-1
VS1 0 s1 0
V1 e1 s1 DC 0 AC 10e-1 -120
RI1 e1 m1 10e-2
LI1 m1 24 27e-6
VS2 16 s2 0
R2 s2 14 15e3
VS3 11 s3 0
L3 s3 5 47e-4
VS4 15 s4 0
R4 s4 3 47e-1
VS5 20 s5 0
C5 s5 18 68e-7
VS6 5 s6 0
C6 s6 2 10e-7
VS7 20 s7 0
L7 s7 7 39e-2
VS8 20 s8 0
C8 s8 13 27e-4
VS9 0 s9 0
C9 s9 15 27e-5
VS10 12 s10 0
C10 s10 1 27e-6
VS11 1 s11 0
C11 s11 10 68e-4
VS12 23 s12 0
R12 s12 6 27e0
VS13 20 s13 0
R13 s13 17 10e2
VS14 8 s14 0
R14 s14 22 39e3
VS15 8 s15 0
L15 s15 17 22e-2
VS16 9 s16 0
C16 s16 6 82e-6
VS17 16 s17 0
L17 s17 11 18e-3
VS18 6 s18 0
L18 s18 7 39e-5
VS19 6 s19 0
V19 e19 s19 DC 0 AC 18e0 0
RI19 e19 m19 47e-1
LI19 m19 1 10e-6
VS20 24 s20 0
C20 s20 5 15e-6
VS21 11 s21 0
V21 e21 s21 DC 0 AC 33e1 0
RI21 e21 5 12e-3
VS22 16 s22 0
R22 s22 24 39e-2
VS23 15 s23 0
R23 s23 23 39e1
VS24 6 s24 0
L24 s24 13 22e-5
VS25 24 s25 0
R25 s25 21 12e-1
VS26 4 s26 0
R26 s26 13 56e-2
VS27 3 s27 0
V27 e27 s27 DC 0 AC 82e0 180
RI27 e27 24 82e-1
VS28 12 s28 0
L28 s28 13 56e-5
VS29 9 s29 0
L29 s29 3 22e-4
VS30 21 s30 0
C30 s30 16 68e-6
VS31 11 s31 0
R31 s31 20 33e2
VS32 9 s32 0
C32 s32 19 39e-4
VS33 23 s33 0
L33 s33 18 15e-4
VS34 2 s34 0
L34 s34 12 82e-2
VS35 18 s35 0
C35 s35 14 15e-7
VS36 14 s36 0
C36 s36 15 82e-4
VS37 21 s37 0
R37 s37 18 10e3
VS38 0 s38 0
C38 s38 9 12e-6
VS39 8 s39 0
R39 s39 2 18e1
VS40 21 s40 0
V40 e40 s40 DC 0 AC 18e1 180
RI40 e40 20 18e-3
VS41 14 s41 0
C41 s41 19 27e-4
VS42 10 s42 0
C42 s42 16 56e-5
VS43 6 s43 0
R43 s43 18 82e-2
VS44 7 s44 0
L44 s44 3 68e-4
VS45 14 s45 0
C45 s45 2 27e-6
VS46 24 s46 0
L46 s46 4 68e-2
VS47 5 s47 0
R47 s47 13 27e-1
VS48 12 s48 0
L48 s48 2 12e-5
VS49 5 s49 0
R49 s49 23 18e-2
VS50 2 s50 0
L50 s50 15 27e-3
VS51 8 s51 0
R51 s51 21 56e-2
VS52 22 s52 0
R52 s52 2 12e-2
.control
set numdgt=17
ac lin 1 60 60
print v(1) v(2) v(3) v(4) v(5) v(6) v(7) v(8) v(9) v(10)
print v(11) v(12) v(13) v(14) v(15) v(16) v(17) v(18) v(19) v(20)
print v(21) v(22) v(23) v(24)
print i(vs0) i(vs1) i(vs2) i(vs3) i(vs4) i(vs5) i(vs6) i(vs7) i(vs8) i(vs9)
print i(vs10) i(vs11) i(vs12) i(vs13) i(vs14) i(vs15) i(vs16) i(vs17) i(vs18) i(vs19)
print i(vs20) i(vs21) i(vs22) i(vs23) i(vs24) i(vs25) i(vs26) i(vs27) i(vs28) i(vs29)
print i(vs30) i(vs31) i(vs32) i(vs33) i(vs34) i(vs35) i(vs36) i(vs37) i(vs38) i(vs39)
print i(vs40) i(vs41) i(vs42) i(vs43) i(vs44) i(vs45) i(vs46) i(vs47) i(vs48) i(vs49)
print i(vs50) i(vs51) i(vs52)
.endc
.end
