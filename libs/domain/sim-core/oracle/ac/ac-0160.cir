controls oracle ac-0160
* Generated (plan F2.7, ADR 0012): do not edit; regenerate with `pnpm sim oracle regen`. ac seed 20261031 index 160 nodes 25 elements 49
.options sparse gmin=1e-12 noopac
RG1 1 0 1000000000000
RG2 2 0 1000000000000
RG3 3 0 1000000000000
RG4 4 0 1000000000000
RG5 5 0 1000000000000
RG6 6 0 1000000000000
RG7 7 0 1000000000000
RG8 8 0 1000000000000
RG9 9 0 1000000000000
RG10 10 0 1000000000000
RG11 11 0 1000000000000
RG12 12 0 1000000000000
RG13 13 0 1000000000000
RG14 14 0 1000000000000
RG15 15 0 1000000000000
RG16 16 0 1000000000000
RG17 17 0 1000000000000
RG18 18 0 1000000000000
RG19 19 0 1000000000000
RG20 20 0 1000000000000
RG21 21 0 1000000000000
RG22 22 0 1000000000000
RG23 23 0 1000000000000
RG24 24 0 1000000000000
VS0 17 s0 0
R0 s0 7 10e1
VS1 9 s1 0
C1 s1 6 82e-6
VS2 21 s2 0
C2 s2 16 68e-6
VS3 22 s3 0
C3 s3 5 15e-6
VS4 6 s4 0
L4 s4 13 22e-5
VS5 0 s5 0
V5 e5 s5 DC 0 AC 33e0 -120
RI5 e5 11 10e-2
VS6 5 s6 0
R6 s6 13 27e-1
VS7 12 s7 0
L7 s7 2 12e-5
VS8 16 s8 0
L8 s8 24 22e-3
VS9 8 s9 0
V9 e9 s9 DC 0 AC 27e1 -120
RI9 e9 2 27e-3
VS10 22 s10 0
L10 s10 7 33e-3
VS11 11 s11 0
V11 e11 s11 DC 0 AC 33e1 0
RI11 e11 5 12e-3
VS12 8 s12 0
R12 s12 0 39e3
VS13 8 s13 0
R13 s13 2 18e1
VS14 15 s14 0
R14 s14 23 39e1
VS15 9 s15 0
C15 s15 19 39e-4
VS16 20 s16 0
R16 s16 17 10e2
VS17 23 s17 0
R17 s17 6 27e0
VS18 24 s18 0
R18 s18 10 18e3
VS19 24 s19 0
V19 e19 s19 DC 0 AC 33e-1 -120
RI19 e19 13 10e-3
VS20 1 s20 0
V20 e20 s20 DC 0 AC 12e0 180
RI20 e20 6 33e-2
VS21 15 s21 0
R21 s21 3 47e-1
VS22 5 s22 0
C22 s22 2 10e-7
VS23 4 s23 0
R23 s23 13 56e-2
VS24 21 s24 0
C24 s24 24 47e-4
VS25 9 s25 0
L25 s25 3 22e-4
VS26 22 s26 0
V26 e26 s26 DC 0 AC 56e1 -120
RI26 e26 13 27e-2
VS27 14 s27 0
C27 s27 2 27e-6
VS28 24 s28 0
C28 s28 15 27e-5
VS29 15 s29 0
R29 s29 8 12e3
VS30 24 s30 0
C30 s30 20 15e-5
VS31 8 s31 0
L31 s31 15 68e-2
VS32 20 s32 0
C32 s32 13 27e-4
VS33 1 s33 0
C33 s33 10 68e-4
VS34 12 s34 0
L34 s34 13 56e-5
VS35 8 s35 0
R35 s35 21 56e-2
VS36 6 s36 0
V36 e36 s36 DC 0 AC 18e0 0
RI36 e36 1 47e-1
VS37 24 s37 0
V37 e37 s37 DC 0 AC 10e-1 -120
RI37 e37 22 10e-2
VS38 2 s38 0
L38 s38 12 82e-2
VS39 24 s39 0
C39 s39 9 12e-6
VS40 24 s40 0
R40 s40 11 39e-2
VS41 20 s41 0
C41 s41 18 68e-7
VS42 5 s42 0
R42 s42 23 18e-2
VS43 15 s43 0
R43 s43 24 12e0
VS44 11 s44 0
L44 s44 5 47e-4
VS45 19 s45 0
C45 s45 1 47e-6
VS46 22 s46 0
V46 e46 s46 DC 0 AC 18e1 120
RI46 e46 14 15e-1
VS47 20 s47 0
L47 s47 7 39e-2
VS48 23 s48 0
L48 s48 18 15e-4
.control
set numdgt=17
ac lin 1 60 60
print v(1) v(2) v(3) v(4) v(5) v(6) v(7) v(8) v(9) v(10)
print v(11) v(12) v(13) v(14) v(15) v(16) v(17) v(18) v(19) v(20)
print v(21) v(22) v(23) v(24)
print i(vs0) i(vs1) i(vs2) i(vs3) i(vs4) i(vs5) i(vs6) i(vs7) i(vs8) i(vs9)
print i(vs10) i(vs11) i(vs12) i(vs13) i(vs14) i(vs15) i(vs16) i(vs17) i(vs18) i(vs19)
print i(vs20) i(vs21) i(vs22) i(vs23) i(vs24) i(vs25) i(vs26) i(vs27) i(vs28) i(vs29)
print i(vs30) i(vs31) i(vs32) i(vs33) i(vs34) i(vs35) i(vs36) i(vs37) i(vs38) i(vs39)
print i(vs40) i(vs41) i(vs42) i(vs43) i(vs44) i(vs45) i(vs46) i(vs47) i(vs48)
.endc
.end
