controls oracle ac-0261
* Generated (plan F2.7, ADR 0012): do not edit; regenerate with `pnpm sim oracle regen`. ac seed 20261031 index 261 nodes 8 elements 16
.options sparse gmin=1e-12 noopac
RG1 1 0 1000000000000
RG2 2 0 1000000000000
RG3 3 0 1000000000000
RG4 4 0 1000000000000
RG5 5 0 1000000000000
RG6 6 0 1000000000000
RG7 7 0 1000000000000
VS0 0 s0 0
V0 e0 s0 DC 0 AC 39e0 0
RI0 e0 1 27e-2
VS1 6 s1 0
R1 s1 7 39e2
VS2 5 s2 0
C2 s2 2 68e-6
VS3 1 s3 0
C3 s3 0 22e-4
VS4 2 s4 0
R4 s4 0 47e1
VS5 6 s5 0
R5 s5 1 68e-1
VS6 0 s6 0
V6 e6 s6 DC 0 AC 18e0 120
RI6 e6 4 27e-2
VS7 0 s7 0
V7 e7 s7 DC 0 AC 56e-1 180
RI7 e7 m7 82e-3
LI7 m7 5 27e-5
VS8 0 s8 0
C8 s8 3 33e-5
VS9 6 s9 0
R9 s9 2 22e0
VS10 0 s10 0
C10 s10 4 39e-5
VS11 5 s11 0
R11 s11 4 68e1
VS12 1 s12 0
R12 s12 3 22e1
VS13 2 s13 0
R13 s13 7 27e-1
VS14 4 s14 0
C14 s14 6 56e-7
VS15 1 s15 0
L15 s15 3 18e-3
.control
set numdgt=17
ac lin 1 60 60
print v(1) v(2) v(3) v(4) v(5) v(6) v(7)
print i(vs0) i(vs1) i(vs2) i(vs3) i(vs4) i(vs5) i(vs6) i(vs7) i(vs8) i(vs9)
print i(vs10) i(vs11) i(vs12) i(vs13) i(vs14) i(vs15)
.endc
.end
