controls oracle ac-0261
* Generated (plan F2.7, ADR 0012): do not edit; regenerate with `pnpm sim oracle regen`. ac seed 20261031 index 261 nodes 8 elements 12
.options sparse gmin=1e-12 noopac
RG1 1 0 1000000000000
RG2 2 0 1000000000000
RG3 3 0 1000000000000
RG4 4 0 1000000000000
RG5 5 0 1000000000000
RG6 6 0 1000000000000
RG7 7 0 1000000000000
VS0 0 s0 0
V0 e0 s0 DC 0 AC 56e-1 180
RI0 e0 n0 82e-3
H0 n0 h0 VS3 22e-4
ED0 h0 5 d0 0 -15e-5
F0 0 d0 VS3 1
LD0 d0 0 1
VS1 6 s1 0
R1 s1 1 68e-1
VS2 2 s2 0
R2 s2 4 15e3
VS3 5 s3 0
V3 e3 s3 DC 0 AC 15e-1 0
RI3 e3 m3 10e-1
LI3 m3 n3 27e-5
H3 n3 h3 VS0 22e-4
ED3 h3 3 d3 0 -15e-5
F3 0 d3 VS0 1
LD3 d3 0 1
VS4 1 s4 0
R4 s4 2 47e-2
VS5 1 s5 0
R5 s5 4 22e1
VS6 6 s6 0
V6 e6 s6 DC 0 AC 18e1 -120
RI6 e6 0 10e-3
VS7 6 s7 0
R7 s7 7 33e0
VS8 4 s8 0
L8 s8 3 22e-5
VS9 7 s9 0
R9 s9 5 15e3
VS10 1 s10 0
C10 s10 0 22e-4
VS11 4 s11 0
V11 e11 s11 DC 0 AC 56e0 -120
RI11 e11 1 56e-2
.control
set numdgt=17
ac lin 1 60 60
print v(1) v(2) v(3) v(4) v(5) v(6) v(7)
print i(vs0) i(vs1) i(vs2) i(vs3) i(vs4) i(vs5) i(vs6) i(vs7) i(vs8) i(vs9)
print i(vs10) i(vs11)
.endc
.end
