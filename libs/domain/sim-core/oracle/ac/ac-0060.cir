controls oracle ac-0060
* Generated (plan F2.7, ADR 0012): do not edit; regenerate with `pnpm sim oracle regen`. ac seed 20261031 index 60 nodes 11 elements 16
.options sparse gmin=1e-12 noopac
RG1 1 0 1000000000000
RG2 2 0 1000000000000
RG3 3 0 1000000000000
RG4 4 0 1000000000000
RG5 5 0 1000000000000
RG6 6 0 1000000000000
RG7 7 0 1000000000000
RG8 8 0 1000000000000
RG9 9 0 1000000000000
RG10 10 0 1000000000000
VS0 2 s0 0
L0 s0 0 68e-5
VS1 6 s1 0
L1 s1 8 10e-3
VS2 0 s2 0
L2 s2 1 47e-4
VS3 0 s3 0
L3 s3 3 82e-5
VS4 0 s4 0
V4 e4 s4 DC 0 AC 10e1 120
RI4 e4 2 12e-2
VS5 5 s5 0
C5 s5 6 68e-7
VS6 4 s6 0
R6 s6 10 10e2
VS7 5 s7 0
R7 s7 4 27e0
VS8 5 s8 0
R8 s8 1 82e-1
VS9 8 s9 0
L9 s9 9 47e-5
VS10 7 s10 0
L10 s10 0 10e-4
VS11 6 s11 0
C11 s11 1 39e-5
VS12 9 s12 0
V12 e12 s12 DC 0 AC 18e-1 -120
RI12 e12 7 15e-3
VS13 7 s13 0
C13 s13 6 33e-5
VS14 0 s14 0
R14 s14 6 12e2
VS15 5 s15 0
R15 s15 8 12e-1
.control
set numdgt=17
ac lin 1 60 60
print v(1) v(2) v(3) v(4) v(5) v(6) v(7) v(8) v(9) v(10)
print i(vs0) i(vs1) i(vs2) i(vs3) i(vs4) i(vs5) i(vs6) i(vs7) i(vs8) i(vs9)
print i(vs10) i(vs11) i(vs12) i(vs13) i(vs14) i(vs15)
.endc
.end
