controls oracle ac-0468
* Generated (plan F2.7, ADR 0012): do not edit; regenerate with `pnpm sim oracle regen`. ac seed 20261031 index 468 nodes 24 elements 44
.options sparse gmin=1e-12 noopac
RG1 1 0 1000000000000
RG2 2 0 1000000000000
RG3 3 0 1000000000000
RG4 4 0 1000000000000
RG5 5 0 1000000000000
RG6 6 0 1000000000000
RG7 7 0 1000000000000
RG8 8 0 1000000000000
RG9 9 0 1000000000000
RG10 10 0 1000000000000
RG11 11 0 1000000000000
RG12 12 0 1000000000000
RG13 13 0 1000000000000
RG14 14 0 1000000000000
RG15 15 0 1000000000000
RG16 16 0 1000000000000
RG17 17 0 1000000000000
RG18 18 0 1000000000000
RG19 19 0 1000000000000
RG20 20 0 1000000000000
RG21 21 0 1000000000000
RG22 22 0 1000000000000
RG23 23 0 1000000000000
VS0 4 s0 0
R0 s0 9 12e1
VS1 0 s1 0
R1 s1 8 47e-2
VS2 0 s2 0
V2 e2 s2 DC 0 AC 68e1 120
RI2 e2 n2 47e-1
H2 n2 h2 VS5 12e-3
ED2 h2 14 d2 0 -10e-7
F2 0 d2 VS5 1
LD2 d2 0 1
VS3 5 s3 0
L3 s3 21 82e-2
VS4 5 s4 0
R4 s4 19 47e-2
VS5 6 s5 0
V5 e5 s5 DC 0 AC 68e1 120
RI5 e5 m5 10e-2
LI5 m5 n5 10e-5
H5 n5 h5 VS2 12e-3
ED5 h5 22 d5 0 -10e-7
F5 0 d5 VS2 1
LD5 d5 0 1
VS6 5 s6 0
L6 s6 13 18e-5
VS7 15 s7 0
R7 s7 18 12e1
VS8 22 s8 0
R8 s8 16 82e2
VS9 12 s9 0
R9 s9 14 82e-2
VS10 9 s10 0
C10 s10 7 12e-4
VS11 2 s11 0
R11 s11 15 18e2
VS12 9 s12 0
C12 s12 13 68e-7
VS13 3 s13 0
C13 s13 12 68e-5
VS14 2 s14 0
C14 s14 15 15e-6
VS15 23 s15 0
L15 s15 5 33e-4
VS16 10 s16 0
R16 s16 17 47e-1
VS17 17 s17 0
R17 s17 16 68e2
VS18 22 s18 0
C18 s18 17 10e-5
VS19 2 s19 0
R19 s19 12 82e2
VS20 2 s20 0
V20 e20 s20 DC 0 AC 27e-1 120
RI20 e20 4 39e-3
VS21 11 s21 0
V21 e21 s21 DC 0 AC 47e-1 0
RI21 e21 m21 47e-2
LI21 m21 17 27e-5
VS22 14 s22 0
C22 s22 0 10e-5
VS23 20 s23 0
L23 s23 21 33e-4
VS24 6 s24 0
R24 s24 20 33e-2
VS25 9 s25 0
R25 s25 11 22e-2
VS26 11 s26 0
R26 s26 21 33e3
VS27 7 s27 0
V27 e27 s27 DC 0 AC 56e0 0
RI27 e27 18 22e-2
VS28 1 s28 0
L28 s28 10 18e-2
VS29 19 s29 0
C29 s29 10 56e-5
VS30 9 s30 0
C30 s30 14 15e-5
VS31 3 s31 0
L31 s31 9 68e-3
VS32 8 s32 0
R32 s32 23 47e3
VS33 10 s33 0
C33 s33 19 10e-4
VS34 7 s34 0
V34 e34 s34 DC 0 AC 22e-1 120
RI34 e34 m34 33e-2
LI34 m34 0 82e-7
VS35 17 s35 0
C35 s35 14 18e-6
VS36 17 s36 0
R36 s36 7 47e0
VS37 20 s37 0
R37 s37 15 10e3
VS38 19 s38 0
V38 e38 s38 DC 0 AC 10e1 120
RI38 e38 m38 22e-3
LI38 m38 21 39e-7
VS39 6 s39 0
R39 s39 19 33e1
VS40 17 s40 0
C40 s40 6 15e-4
VS41 1 s41 0
R41 s41 14 10e1
VS42 21 s42 0
R42 s42 8 18e2
VS43 10 s43 0
R43 s43 5 39e-1
.control
set numdgt=17
ac lin 1 60 60
print v(1) v(2) v(3) v(4) v(5) v(6) v(7) v(8) v(9) v(10)
print v(11) v(12) v(13) v(14) v(15) v(16) v(17) v(18) v(19) v(20)
print v(21) v(22) v(23)
print i(vs0) i(vs1) i(vs2) i(vs3) i(vs4) i(vs5) i(vs6) i(vs7) i(vs8) i(vs9)
print i(vs10) i(vs11) i(vs12) i(vs13) i(vs14) i(vs15) i(vs16) i(vs17) i(vs18) i(vs19)
print i(vs20) i(vs21) i(vs22) i(vs23) i(vs24) i(vs25) i(vs26) i(vs27) i(vs28) i(vs29)
print i(vs30) i(vs31) i(vs32) i(vs33) i(vs34) i(vs35) i(vs36) i(vs37) i(vs38) i(vs39)
print i(vs40) i(vs41) i(vs42) i(vs43)
.endc
.end
