controls oracle ac-0035
* Generated (plan F2.7, ADR 0012): do not edit; regenerate with `pnpm sim oracle regen`. ac seed 20261031 index 35 nodes 11 elements 19
.options sparse gmin=1e-12 noopac
RG1 1 0 1000000000000
RG2 2 0 1000000000000
RG3 3 0 1000000000000
RG4 4 0 1000000000000
RG5 5 0 1000000000000
RG6 6 0 1000000000000
RG7 7 0 1000000000000
RG8 8 0 1000000000000
RG9 9 0 1000000000000
RG10 10 0 1000000000000
VS0 0 s0 0
V0 e0 s0 DC 0 AC 10e-1 0
RI0 e0 m0 56e-3
LI0 m0 n0 56e-5
H0 n0 h0 VS2 -12e-4
ED0 h0 8 d0 0 -68e-7
F0 0 d0 VS2 1
LD0 d0 0 1
VS1 7 s1 0
R1 s1 10 27e1
VS2 4 s2 0
V2 e2 s2 DC 0 AC 56e0 180
RI2 e2 n2 56e-1
H2 n2 h2 VS0 -12e-4
ED2 h2 2 d2 0 -68e-7
F2 0 d2 VS0 1
LD2 d2 0 1
VS3 0 s3 0
L3 s3 1 15e-5
VS4 9 s4 0
R4 s4 3 82e0
VS5 5 s5 0
V5 e5 s5 DC 0 AC 15e0 180
RI5 e5 4 47e-3
VS6 4 s6 0
R6 s6 6 68e2
VS7 6 s7 0
L7 s7 4 56e-3
VS8 1 s8 0
C8 s8 3 82e-6
VS9 10 s9 0
L9 s9 3 18e-4
VS10 1 s10 0
C10 s10 10 15e-4
VS11 1 s11 0
C11 s11 3 33e-5
VS12 8 s12 0
V12 e12 s12 DC 0 AC 10e-1 120
RI12 e12 m12 12e-3
LI12 m12 10 56e-5
VS13 7 s13 0
R13 s13 0 39e0
VS14 6 s14 0
L14 s14 9 39e-2
VS15 5 s15 0
V15 e15 s15 DC 0 AC 12e-1 180
RI15 e15 m15 39e-1
LI15 m15 10 68e-6
VS16 8 s16 0
V16 e16 s16 DC 0 AC 47e1 180
RI16 e16 5 82e-1
VS17 3 s17 0
C17 s17 2 68e-7
VS18 0 s18 0
R18 s18 5 27e1
.control
set numdgt=17
ac lin 1 60 60
print v(1) v(2) v(3) v(4) v(5) v(6) v(7) v(8) v(9) v(10)
print i(vs0) i(vs1) i(vs2) i(vs3) i(vs4) i(vs5) i(vs6) i(vs7) i(vs8) i(vs9)
print i(vs10) i(vs11) i(vs12) i(vs13) i(vs14) i(vs15) i(vs16) i(vs17) i(vs18)
.endc
.end
