controls oracle ac-0035
* Generated (plan F2.7, ADR 0012): do not edit; regenerate with `pnpm sim oracle regen`. ac seed 20261031 index 35 nodes 11 elements 21
.options sparse gmin=1e-12 noopac
RG1 1 0 1000000000000
RG2 2 0 1000000000000
RG3 3 0 1000000000000
RG4 4 0 1000000000000
RG5 5 0 1000000000000
RG6 6 0 1000000000000
RG7 7 0 1000000000000
RG8 8 0 1000000000000
RG9 9 0 1000000000000
RG10 10 0 1000000000000
VS0 0 s0 0
R0 s0 3 68e2
VS1 4 s1 0
C1 s1 7 10e-6
VS2 9 s2 0
R2 s2 0 27e1
VS3 8 s3 0
R3 s3 2 82e0
VS4 5 s4 0
L4 s4 1 18e-4
VS5 6 s5 0
C5 s5 5 15e-5
VS6 0 s6 0
V6 e6 s6 DC 0 AC 47e1 0
RI6 e6 4 12e-1
VS7 4 s7 0
L7 s7 1 56e-3
VS8 10 s8 0
C8 s8 2 33e-7
VS9 7 s9 0
C9 s9 3 15e-4
VS10 9 s10 0
L10 s10 7 68e-3
VS11 3 s11 0
V11 e11 s11 DC 0 AC 22e0 180
RI11 e11 4 39e-2
VS12 0 s12 0
V12 e12 s12 DC 0 AC 15e0 180
RI12 e12 5 47e-3
VS13 6 s13 0
R13 s13 10 27e1
VS14 5 s14 0
C14 s14 10 82e-6
VS15 4 s15 0
R15 s15 8 10e-2
VS16 4 s16 0
R16 s16 10 15e2
VS17 4 s17 0
R17 s17 2 56e3
VS18 10 s18 0
L18 s18 1 33e-3
VS19 10 s19 0
R19 s19 5 56e-1
VS20 8 s20 0
C20 s20 7 10e-4
.control
set numdgt=17
ac lin 1 60 60
print v(1) v(2) v(3) v(4) v(5) v(6) v(7) v(8) v(9) v(10)
print i(vs0) i(vs1) i(vs2) i(vs3) i(vs4) i(vs5) i(vs6) i(vs7) i(vs8) i(vs9)
print i(vs10) i(vs11) i(vs12) i(vs13) i(vs14) i(vs15) i(vs16) i(vs17) i(vs18) i(vs19)
print i(vs20)
.endc
.end
