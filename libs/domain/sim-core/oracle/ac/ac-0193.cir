controls oracle ac-0193
* Generated (plan F2.7, ADR 0012): do not edit; regenerate with `pnpm sim oracle regen`. ac seed 20261031 index 193 nodes 28 elements 46
.options sparse gmin=1e-12 noopac
RG1 1 0 1000000000000
RG2 2 0 1000000000000
RG3 3 0 1000000000000
RG4 4 0 1000000000000
RG5 5 0 1000000000000
RG6 6 0 1000000000000
RG7 7 0 1000000000000
RG8 8 0 1000000000000
RG9 9 0 1000000000000
RG10 10 0 1000000000000
RG11 11 0 1000000000000
RG12 12 0 1000000000000
RG13 13 0 1000000000000
RG14 14 0 1000000000000
RG15 15 0 1000000000000
RG16 16 0 1000000000000
RG17 17 0 1000000000000
RG18 18 0 1000000000000
RG19 19 0 1000000000000
RG20 20 0 1000000000000
RG21 21 0 1000000000000
RG22 22 0 1000000000000
RG23 23 0 1000000000000
RG24 24 0 1000000000000
RG25 25 0 1000000000000
RG26 26 0 1000000000000
RG27 27 0 1000000000000
VS0 0 s0 0
V0 e0 s0 DC 0 AC 12e0 180
RI0 e0 m0 27e-1
LI0 m0 2 68e-6
VS1 5 s1 0
R1 s1 14 18e3
VS2 24 s2 0
C2 s2 1 68e-5
VS3 0 s3 0
V3 e3 s3 DC 0 AC 27e1 0
RI3 e3 5 12e-2
VS4 16 s4 0
L4 s4 26 82e-5
VS5 19 s5 0
L5 s5 16 18e-2
VS6 27 s6 0
L6 s6 9 12e-3
VS7 8 s7 0
L7 s7 7 12e-2
VS8 14 s8 0
R8 s8 3 12e-2
VS9 6 s9 0
R9 s9 18 10e-1
VS10 16 s10 0
C10 s10 26 27e-7
VS11 27 s11 0
L11 s11 17 12e-4
VS12 13 s12 0
C12 s12 22 18e-4
VS13 8 s13 0
R13 s13 2 10e-1
VS14 8 s14 0
R14 s14 20 68e-2
VS15 4 s15 0
R15 s15 17 27e1
VS16 17 s16 0
L16 s16 15 33e-5
VS17 10 s17 0
R17 s17 26 82e-2
VS18 25 s18 0
L18 s18 7 18e-5
VS19 24 s19 0
V19 e19 s19 DC 0 AC 68e1 120
RI19 e19 m19 15e-1
LI19 m19 11 68e-7
VS20 9 s20 0
R20 s20 19 39e2
VS21 11 s21 0
L21 s21 4 12e-3
VS22 1 s22 0
R22 s22 12 47e-2
VS23 18 s23 0
R23 s23 26 68e0
VS24 0 s24 0
L24 s24 4 15e-4
VS25 21 s25 0
L25 s25 9 68e-5
VS26 8 s26 0
R26 s26 17 82e-2
VS27 15 s27 0
V27 e27 s27 DC 0 AC 47e1 -120
RI27 e27 m27 82e-2
LI27 m27 1 22e-6
VS28 17 s28 0
R28 s28 22 15e1
VS29 22 s29 0
C29 s29 10 15e-6
VS30 23 s30 0
R30 s30 24 68e-2
VS31 24 s31 0
L31 s31 3 82e-3
VS32 0 s32 0
L32 s32 21 10e-2
VS33 20 s33 0
V33 e33 s33 DC 0 AC 39e0 0
RI33 e33 18 18e-2
VS34 18 s34 0
R34 s34 3 15e1
VS35 20 s35 0
L35 s35 25 82e-3
VS36 0 s36 0
C36 s36 4 12e-4
VS37 8 s37 0
R37 s37 16 33e3
VS38 14 s38 0
L38 s38 7 68e-5
VS39 14 s39 0
R39 s39 1 68e-2
VS40 6 s40 0
R40 s40 5 27e-1
VS41 12 s41 0
L41 s41 2 22e-2
VS42 13 s42 0
R42 s42 24 39e2
VS43 20 s43 0
C43 s43 8 27e-6
VS44 22 s44 0
L44 s44 23 18e-5
VS45 14 s45 0
C45 s45 3 27e-7
.control
set numdgt=17
ac lin 1 60 60
print v(1) v(2) v(3) v(4) v(5) v(6) v(7) v(8) v(9) v(10)
print v(11) v(12) v(13) v(14) v(15) v(16) v(17) v(18) v(19) v(20)
print v(21) v(22) v(23) v(24) v(25) v(26) v(27)
print i(vs0) i(vs1) i(vs2) i(vs3) i(vs4) i(vs5) i(vs6) i(vs7) i(vs8) i(vs9)
print i(vs10) i(vs11) i(vs12) i(vs13) i(vs14) i(vs15) i(vs16) i(vs17) i(vs18) i(vs19)
print i(vs20) i(vs21) i(vs22) i(vs23) i(vs24) i(vs25) i(vs26) i(vs27) i(vs28) i(vs29)
print i(vs30) i(vs31) i(vs32) i(vs33) i(vs34) i(vs35) i(vs36) i(vs37) i(vs38) i(vs39)
print i(vs40) i(vs41) i(vs42) i(vs43) i(vs44) i(vs45)
.endc
.end
