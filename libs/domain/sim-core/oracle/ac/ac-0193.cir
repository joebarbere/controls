controls oracle ac-0193
* Generated (plan F2.7, ADR 0012): do not edit; regenerate with `pnpm sim oracle regen`. ac seed 20261031 index 193 nodes 28 elements 54
.options sparse gmin=1e-12 noopac
RG1 1 0 1000000000000
RG2 2 0 1000000000000
RG3 3 0 1000000000000
RG4 4 0 1000000000000
RG5 5 0 1000000000000
RG6 6 0 1000000000000
RG7 7 0 1000000000000
RG8 8 0 1000000000000
RG9 9 0 1000000000000
RG10 10 0 1000000000000
RG11 11 0 1000000000000
RG12 12 0 1000000000000
RG13 13 0 1000000000000
RG14 14 0 1000000000000
RG15 15 0 1000000000000
RG16 16 0 1000000000000
RG17 17 0 1000000000000
RG18 18 0 1000000000000
RG19 19 0 1000000000000
RG20 20 0 1000000000000
RG21 21 0 1000000000000
RG22 22 0 1000000000000
RG23 23 0 1000000000000
RG24 24 0 1000000000000
RG25 25 0 1000000000000
RG26 26 0 1000000000000
RG27 27 0 1000000000000
VS0 22 s0 0
R0 s0 10 15e1
VS1 2 s1 0
C1 s1 20 39e-4
VS2 0 s2 0
R2 s2 21 47e3
VS3 27 s3 0
C3 s3 17 56e-6
VS4 18 s4 0
R4 s4 17 12e-1
VS5 20 s5 0
C5 s5 16 15e-6
VS6 10 s6 0
R6 s6 19 47e0
VS7 7 s7 0
L7 s7 9 82e-3
VS8 0 s8 0
V8 e8 s8 DC 0 AC 47e-1 180
RI8 e8 17 27e-2
VS9 26 s9 0
V9 e9 s9 DC 0 AC 47e1 -120
RI9 e9 11 82e-2
VS10 2 s10 0
R10 s10 17 10e-2
VS11 14 s11 0
V11 e11 s11 DC 0 AC 12e0 180
RI11 e11 2 27e-1
VS12 24 s12 0
R12 s12 3 47e-1
VS13 19 s13 0
R13 s13 18 10e-1
VS14 5 s14 0
C14 s14 14 12e-5
VS15 16 s15 0
R15 s15 15 39e2
VS16 14 s16 0
V16 e16 s16 DC 0 AC 56e0 180
RI16 e16 6 82e-3
VS17 2 s17 0
L17 s17 24 12e-3
VS18 22 s18 0
V18 e18 s18 DC 0 AC 47e0 0
RI18 e18 5 33e-3
VS19 24 s19 0
R19 s19 13 22e0
VS20 26 s20 0
R20 s20 19 18e-1
VS21 7 s21 0
V21 e21 s21 DC 0 AC 39e-1 -120
RI21 e21 4 18e-1
VS22 0 s22 0
R22 s22 1 10e2
VS23 24 s23 0
C23 s23 19 47e-7
VS24 0 s24 0
R24 s24 24 56e2
VS25 0 s25 0
L25 s25 13 33e-2
VS26 20 s26 0
L26 s26 12 18e-5
VS27 23 s27 0
L27 s27 7 56e-3
VS28 0 s28 0
L28 s28 4 56e-4
VS29 0 s29 0
L29 s29 22 39e-2
VS30 6 s30 0
C30 s30 12 22e-4
VS31 23 s31 0
V31 e31 s31 DC 0 AC 68e1 120
RI31 e31 25 15e-1
VS32 18 s32 0
R32 s32 11 15e-2
VS33 9 s33 0
L33 s33 12 22e-2
VS34 3 s34 0
V34 e34 s34 DC 0 AC 12e-1 -120
RI34 e34 14 68e-3
VS35 27 s35 0
R35 s35 20 33e2
VS36 5 s36 0
L36 s36 6 12e-3
VS37 19 s37 0
R37 s37 17 18e-1
VS38 12 s38 0
R38 s38 2 18e2
VS39 8 s39 0
C39 s39 15 12e-6
VS40 17 s40 0
R40 s40 22 15e1
VS41 19 s41 0
R41 s41 13 15e-1
VS42 22 s42 0
R42 s42 14 15e3
VS43 17 s43 0
C43 s43 10 56e-7
VS44 8 s44 0
V44 e44 s44 DC 0 AC 47e0 -120
RI44 e44 5 10e-1
VS45 7 s45 0
R45 s45 2 18e-2
VS46 26 s46 0
R46 s46 17 39e1
VS47 20 s47 0
L47 s47 23 39e-3
VS48 10 s48 0
V48 e48 s48 DC 0 AC 18e0 0
RI48 e48 23 33e-2
VS49 18 s49 0
R49 s49 23 33e3
VS50 11 s50 0
L50 s50 3 10e-3
VS51 14 s51 0
R51 s51 8 56e-2
VS52 17 s52 0
R52 s52 13 82e3
VS53 22 s53 0
L53 s53 11 12e-2
.control
set numdgt=17
ac lin 1 60 60
print v(1) v(2) v(3) v(4) v(5) v(6) v(7) v(8) v(9) v(10)
print v(11) v(12) v(13) v(14) v(15) v(16) v(17) v(18) v(19) v(20)
print v(21) v(22) v(23) v(24) v(25) v(26) v(27)
print i(vs0) i(vs1) i(vs2) i(vs3) i(vs4) i(vs5) i(vs6) i(vs7) i(vs8) i(vs9)
print i(vs10) i(vs11) i(vs12) i(vs13) i(vs14) i(vs15) i(vs16) i(vs17) i(vs18) i(vs19)
print i(vs20) i(vs21) i(vs22) i(vs23) i(vs24) i(vs25) i(vs26) i(vs27) i(vs28) i(vs29)
print i(vs30) i(vs31) i(vs32) i(vs33) i(vs34) i(vs35) i(vs36) i(vs37) i(vs38) i(vs39)
print i(vs40) i(vs41) i(vs42) i(vs43) i(vs44) i(vs45) i(vs46) i(vs47) i(vs48) i(vs49)
print i(vs50) i(vs51) i(vs52) i(vs53)
.endc
.end
