controls oracle ac-0193
* Generated (plan F2.7, ADR 0012): do not edit; regenerate with `pnpm sim oracle regen`. ac seed 20261031 index 193 nodes 28 elements 57
.options sparse gmin=1e-12 noopac
RG1 1 0 1000000000000
RG2 2 0 1000000000000
RG3 3 0 1000000000000
RG4 4 0 1000000000000
RG5 5 0 1000000000000
RG6 6 0 1000000000000
RG7 7 0 1000000000000
RG8 8 0 1000000000000
RG9 9 0 1000000000000
RG10 10 0 1000000000000
RG11 11 0 1000000000000
RG12 12 0 1000000000000
RG13 13 0 1000000000000
RG14 14 0 1000000000000
RG15 15 0 1000000000000
RG16 16 0 1000000000000
RG17 17 0 1000000000000
RG18 18 0 1000000000000
RG19 19 0 1000000000000
RG20 20 0 1000000000000
RG21 21 0 1000000000000
RG22 22 0 1000000000000
RG23 23 0 1000000000000
RG24 24 0 1000000000000
RG25 25 0 1000000000000
RG26 26 0 1000000000000
RG27 27 0 1000000000000
VS0 26 s0 0
R0 s0 17 39e1
VS1 0 s1 0
V1 e1 s1 DC 0 AC 12e0 180
RI1 e1 2 27e-1
VS2 22 s2 0
R2 s2 0 15e3
VS3 24 s3 0
R3 s3 13 22e0
VS4 6 s4 0
C4 s4 12 22e-4
VS5 20 s5 0
L5 s5 12 18e-5
VS6 14 s6 0
L6 s6 22 39e-2
VS7 20 s7 0
C7 s7 16 15e-6
VS8 3 s8 0
V8 e8 s8 DC 0 AC 12e-1 -120
RI8 e8 m8 68e-3
LI8 m8 0 12e-5
VS9 7 s9 0
V9 e9 s9 DC 0 AC 39e-1 -120
RI9 e9 4 18e-1
VS10 14 s10 0
L10 s10 4 56e-4
VS11 20 s11 0
L11 s11 23 39e-3
VS12 17 s12 0
R12 s12 13 82e3
VS13 11 s13 0
L13 s13 3 10e-3
VS14 14 s14 0
R14 s14 24 56e2
VS15 24 s15 0
R15 s15 3 47e-1
VS16 19 s16 0
R16 s16 18 10e-1
VS17 27 s17 0
R17 s17 20 33e2
VS18 26 s18 0
V18 e18 s18 DC 0 AC 47e1 -120
RI18 e18 11 82e-2
VS19 10 s19 0
V19 e19 s19 DC 0 AC 18e0 0
RI19 e19 23 33e-2
VS20 7 s20 0
R20 s20 2 18e-2
VS21 18 s21 0
R21 s21 11 15e-2
VS22 8 s22 0
V22 e22 s22 DC 0 AC 47e0 -120
RI22 e22 5 10e-1
VS23 18 s23 0
R23 s23 17 12e-1
VS24 5 s24 0
C24 s24 0 12e-5
VS25 21 s25 0
C25 s25 10 56e-6
VS26 5 s26 0
L26 s26 6 12e-3
VS27 22 s27 0
L27 s27 11 12e-2
VS28 23 s28 0
L28 s28 7 56e-3
VS29 0 s29 0
V29 e29 s29 DC 0 AC 56e0 180
RI29 e29 m29 82e-3
LI29 m29 6 82e-6
VS30 23 s30 0
V30 e30 s30 DC 0 AC 68e1 120
RI30 e30 25 15e-1
VS31 12 s31 0
R31 s31 2 18e2
VS32 22 s32 0
R32 s32 10 15e1
VS33 17 s33 0
C33 s33 10 56e-7
VS34 9 s34 0
L34 s34 12 22e-2
VS35 2 s35 0
R35 s35 25 18e-2
VS36 2 s36 0
L36 s36 24 12e-3
VS37 7 s37 0
L37 s37 9 82e-3
VS38 27 s38 0
C38 s38 17 56e-6
VS39 26 s39 0
R39 s39 19 18e-1
VS40 8 s40 0
C40 s40 15 12e-6
VS41 14 s41 0
R41 s41 21 47e3
VS42 2 s42 0
C42 s42 20 39e-4
VS43 14 s43 0
R43 s43 1 10e2
VS44 18 s44 0
R44 s44 23 33e3
VS45 1 s45 0
V45 e45 s45 DC 0 AC 47e-1 -120
RI45 e45 13 39e-1
VS46 19 s46 0
R46 s46 13 15e-1
VS47 10 s47 0
R47 s47 19 47e0
VS48 0 s48 0
R48 s48 8 56e-2
VS49 22 s49 0
V49 e49 s49 DC 0 AC 47e0 0
RI49 e49 m49 33e-3
LI49 m49 5 56e-6
VS50 24 s50 0
C50 s50 19 47e-7
VS51 14 s51 0
L51 s51 13 33e-2
VS52 17 s52 0
R52 s52 22 15e1
VS53 19 s53 0
R53 s53 17 18e-1
VS54 16 s54 0
R54 s54 15 39e2
VS55 14 s55 0
V55 e55 s55 DC 0 AC 47e-1 180
RI55 e55 m55 27e-2
LI55 m55 17 39e-5
VS56 2 s56 0
R56 s56 17 10e-2
.control
set numdgt=17
ac lin 1 60 60
print v(1) v(2) v(3) v(4) v(5) v(6) v(7) v(8) v(9) v(10)
print v(11) v(12) v(13) v(14) v(15) v(16) v(17) v(18) v(19) v(20)
print v(21) v(22) v(23) v(24) v(25) v(26) v(27)
print i(vs0) i(vs1) i(vs2) i(vs3) i(vs4) i(vs5) i(vs6) i(vs7) i(vs8) i(vs9)
print i(vs10) i(vs11) i(vs12) i(vs13) i(vs14) i(vs15) i(vs16) i(vs17) i(vs18) i(vs19)
print i(vs20) i(vs21) i(vs22) i(vs23) i(vs24) i(vs25) i(vs26) i(vs27) i(vs28) i(vs29)
print i(vs30) i(vs31) i(vs32) i(vs33) i(vs34) i(vs35) i(vs36) i(vs37) i(vs38) i(vs39)
print i(vs40) i(vs41) i(vs42) i(vs43) i(vs44) i(vs45) i(vs46) i(vs47) i(vs48) i(vs49)
print i(vs50) i(vs51) i(vs52) i(vs53) i(vs54) i(vs55) i(vs56)
.endc
.end
