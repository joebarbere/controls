controls oracle ac-0248
* Generated (plan F2.7, ADR 0012): do not edit; regenerate with `pnpm sim oracle regen`. ac seed 20261031 index 248 nodes 7 elements 11
.options sparse gmin=1e-12 noopac
RG1 1 0 1000000000000
RG2 2 0 1000000000000
RG3 3 0 1000000000000
RG4 4 0 1000000000000
RG5 5 0 1000000000000
RG6 6 0 1000000000000
VS0 1 s0 0
C0 s0 6 18e-5
VS1 0 s1 0
V1 e1 s1 DC 0 AC 68e0 0
RI1 e1 m1 33e-1
LI1 m1 n1 27e-5
H1 n1 h1 VS3 -10e-2
ED1 h1 1 d1 0 -18e-5
F1 0 d1 VS3 1
LD1 d1 0 1
VS2 4 s2 0
C2 s2 3 33e-6
VS3 1 s3 0
V3 e3 s3 DC 0 AC 82e0 -120
RI3 e3 n3 47e-1
H3 n3 h3 VS1 -10e-2
ED3 h3 6 d3 0 -18e-5
F3 0 d3 VS1 1
LD3 d3 0 1
VS4 4 s4 0
L4 s4 0 22e-2
VS5 3 s5 0
R5 s5 2 68e2
VS6 4 s6 0
C6 s6 6 33e-4
VS7 4 s7 0
L7 s7 2 82e-2
VS8 5 s8 0
R8 s8 4 47e2
VS9 0 s9 0
V9 e9 s9 DC 0 AC 12e0 180
RI9 e9 m9 33e-1
LI9 m9 3 39e-7
VS10 0 s10 0
R10 s10 5 10e3
.control
set numdgt=17
ac lin 1 60 60
print v(1) v(2) v(3) v(4) v(5) v(6)
print i(vs0) i(vs1) i(vs2) i(vs3) i(vs4) i(vs5) i(vs6) i(vs7) i(vs8) i(vs9)
print i(vs10)
.endc
.end
