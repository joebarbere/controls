controls oracle ac-0279
* Generated (plan F2.7, ADR 0012): do not edit; regenerate with `pnpm sim oracle regen`. ac seed 20261031 index 279 nodes 19 elements 30
.options sparse gmin=1e-12 noopac
RG1 1 0 1000000000000
RG2 2 0 1000000000000
RG3 3 0 1000000000000
RG4 4 0 1000000000000
RG5 5 0 1000000000000
RG6 6 0 1000000000000
RG7 7 0 1000000000000
RG8 8 0 1000000000000
RG9 9 0 1000000000000
RG10 10 0 1000000000000
RG11 11 0 1000000000000
RG12 12 0 1000000000000
RG13 13 0 1000000000000
RG14 14 0 1000000000000
RG15 15 0 1000000000000
RG16 16 0 1000000000000
RG17 17 0 1000000000000
RG18 18 0 1000000000000
VS0 0 s0 0
V0 e0 s0 DC 0 AC 56e1 -120
RI0 e0 n0 22e-1
H0 n0 h0 VS3 -10e-2
ED0 h0 7 d0 0 82e-5
F0 0 d0 VS3 1
LD0 d0 0 1
VS1 12 s1 0
L1 s1 13 33e-4
VS2 1 s2 0
L2 s2 14 56e-5
VS3 5 s3 0
V3 e3 s3 DC 0 AC 82e1 0
RI3 e3 m3 27e-1
LI3 m3 n3 82e-5
H3 n3 h3 VS0 -10e-2
ED3 h3 13 d3 0 82e-5
F3 0 d3 VS0 1
LD3 d3 0 1
VS4 14 s4 0
R4 s4 18 68e3
VS5 0 s5 0
R5 s5 8 82e3
VS6 5 s6 0
C6 s6 0 15e-6
VS7 3 s7 0
C7 s7 13 68e-6
VS8 8 s8 0
R8 s8 6 22e-1
VS9 15 s9 0
R9 s9 10 12e-2
VS10 16 s10 0
C10 s10 13 68e-4
VS11 16 s11 0
R11 s11 4 56e3
VS12 14 s12 0
C12 s12 3 22e-6
VS13 8 s13 0
R13 s13 13 27e3
VS14 3 s14 0
R14 s14 15 56e0
VS15 17 s15 0
L15 s15 13 18e-5
VS16 2 s16 0
L16 s16 8 10e-5
VS17 17 s17 0
R17 s17 12 47e-1
VS18 4 s18 0
R18 s18 3 33e1
VS19 11 s19 0
R19 s19 12 68e-2
VS20 0 s20 0
V20 e20 s20 DC 0 AC 33e1 180
RI20 e20 8 68e-2
VS21 5 s21 0
L21 s21 9 15e-3
VS22 2 s22 0
R22 s22 15 18e2
VS23 18 s23 0
V23 e23 s23 DC 0 AC 68e1 0
RI23 e23 9 15e-3
VS24 7 s24 0
C24 s24 11 39e-4
VS25 10 s25 0
V25 e25 s25 DC 0 AC 10e-1 0
RI25 e25 m25 18e-3
LI25 m25 5 47e-7
VS26 8 s26 0
R26 s26 10 18e-2
VS27 1 s27 0
V27 e27 s27 DC 0 AC 18e1 -120
RI27 e27 10 12e-1
VS28 9 s28 0
R28 s28 4 33e0
VS29 16 s29 0
V29 e29 s29 DC 0 AC 68e0 180
RI29 e29 m29 82e-2
LI29 m29 6 18e-7
.control
set numdgt=17
ac lin 1 60 60
print v(1) v(2) v(3) v(4) v(5) v(6) v(7) v(8) v(9) v(10)
print v(11) v(12) v(13) v(14) v(15) v(16) v(17) v(18)
print i(vs0) i(vs1) i(vs2) i(vs3) i(vs4) i(vs5) i(vs6) i(vs7) i(vs8) i(vs9)
print i(vs10) i(vs11) i(vs12) i(vs13) i(vs14) i(vs15) i(vs16) i(vs17) i(vs18) i(vs19)
print i(vs20) i(vs21) i(vs22) i(vs23) i(vs24) i(vs25) i(vs26) i(vs27) i(vs28) i(vs29)
.endc
.end
