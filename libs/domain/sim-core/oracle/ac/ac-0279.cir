controls oracle ac-0279
* Generated (plan F2.7, ADR 0012): do not edit; regenerate with `pnpm sim oracle regen`. ac seed 20261031 index 279 nodes 19 elements 28
.options sparse gmin=1e-12 noopac
RG1 1 0 1000000000000
RG2 2 0 1000000000000
RG3 3 0 1000000000000
RG4 4 0 1000000000000
RG5 5 0 1000000000000
RG6 6 0 1000000000000
RG7 7 0 1000000000000
RG8 8 0 1000000000000
RG9 9 0 1000000000000
RG10 10 0 1000000000000
RG11 11 0 1000000000000
RG12 12 0 1000000000000
RG13 13 0 1000000000000
RG14 14 0 1000000000000
RG15 15 0 1000000000000
RG16 16 0 1000000000000
RG17 17 0 1000000000000
RG18 18 0 1000000000000
VS0 5 s0 0
L0 s0 9 15e-3
VS1 5 s1 0
C1 s1 13 15e-6
VS2 1 s2 0
L2 s2 14 56e-5
VS3 16 s3 0
C3 s3 10 68e-4
VS4 3 s4 0
C4 s4 10 68e-6
VS5 0 s5 0
V5 e5 s5 DC 0 AC 10e-1 0
RI5 e5 5 18e-3
VS6 13 s6 0
V6 e6 s6 DC 0 AC 33e1 180
RI6 e6 8 68e-2
VS7 2 s7 0
L7 s7 8 10e-5
VS8 9 s8 0
R8 s8 4 33e0
VS9 14 s9 0
C9 s9 3 22e-6
VS10 8 s10 0
R10 s10 10 27e3
VS11 14 s11 0
R11 s11 18 68e3
VS12 12 s12 0
L12 s12 10 33e-4
VS13 5 s13 0
V13 e13 s13 DC 0 AC 82e1 0
RI13 e13 10 27e-1
VS14 15 s14 0
R14 s14 0 12e-2
VS15 16 s15 0
V15 e15 s15 DC 0 AC 68e0 180
RI15 e15 6 82e-2
VS16 16 s16 0
R16 s16 4 56e3
VS17 18 s17 0
V17 e17 s17 DC 0 AC 68e1 0
RI17 e17 9 15e-3
VS18 4 s18 0
R18 s18 3 33e1
VS19 7 s19 0
C19 s19 11 39e-4
VS20 2 s20 0
R20 s20 15 18e2
VS21 13 s21 0
R21 s21 8 82e3
VS22 3 s22 0
R22 s22 15 56e0
VS23 17 s23 0
R23 s23 12 47e-1
VS24 13 s24 0
V24 e24 s24 DC 0 AC 56e1 -120
RI24 e24 7 22e-1
VS25 17 s25 0
L25 s25 10 18e-5
VS26 8 s26 0
R26 s26 0 18e-2
VS27 1 s27 0
V27 e27 s27 DC 0 AC 18e1 -120
RI27 e27 0 12e-1
.control
set numdgt=17
ac lin 1 60 60
print v(1) v(2) v(3) v(4) v(5) v(6) v(7) v(8) v(9) v(10)
print v(11) v(12) v(13) v(14) v(15) v(16) v(17) v(18)
print i(vs0) i(vs1) i(vs2) i(vs3) i(vs4) i(vs5) i(vs6) i(vs7) i(vs8) i(vs9)
print i(vs10) i(vs11) i(vs12) i(vs13) i(vs14) i(vs15) i(vs16) i(vs17) i(vs18) i(vs19)
print i(vs20) i(vs21) i(vs22) i(vs23) i(vs24) i(vs25) i(vs26) i(vs27)
.endc
.end
