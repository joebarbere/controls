controls oracle ac-0019
* Generated (plan F2.7, ADR 0012): do not edit; regenerate with `pnpm sim oracle regen`. ac seed 20261031 index 19 nodes 14 elements 30
.options sparse gmin=1e-12 noopac
RG1 1 0 1000000000000
RG2 2 0 1000000000000
RG3 3 0 1000000000000
RG4 4 0 1000000000000
RG5 5 0 1000000000000
RG6 6 0 1000000000000
RG7 7 0 1000000000000
RG8 8 0 1000000000000
RG9 9 0 1000000000000
RG10 10 0 1000000000000
RG11 11 0 1000000000000
RG12 12 0 1000000000000
RG13 13 0 1000000000000
VS0 9 s0 0
L0 s0 6 39e-2
VS1 5 s1 0
C1 s1 12 33e-5
VS2 0 s2 0
R2 s2 1 12e-1
VS3 11 s3 0
C3 s3 9 56e-7
VS4 7 s4 0
R4 s4 10 68e-2
VS5 2 s5 0
L5 s5 13 68e-4
VS6 4 s6 0
R6 s6 0 10e1
VS7 0 s7 0
C7 s7 5 56e-7
VS8 8 s8 0
L8 s8 1 18e-4
VS9 8 s9 0
C9 s9 3 47e-5
VS10 7 s10 0
R10 s10 9 22e2
VS11 11 s11 0
C11 s11 8 27e-5
VS12 0 s12 0
V12 e12 s12 DC 0 AC 15e0 120
RI12 e12 m12 56e-2
LI12 m12 n12 82e-6
H12 n12 h12 VS15 22e-3
ED12 h12 4 d12 0 10e-5
F12 0 d12 VS15 1
LD12 d12 0 1
VS13 12 s13 0
L13 s13 3 15e-3
VS14 6 s14 0
R14 s14 4 12e-2
VS15 13 s15 0
V15 e15 s15 DC 0 AC 15e0 0
RI15 e15 n15 10e-2
H15 n15 h15 VS12 22e-3
ED15 h15 0 d15 0 10e-5
F15 0 d15 VS12 1
LD15 d15 0 1
VS16 5 s16 0
C16 s16 1 22e-5
VS17 6 s17 0
V17 e17 s17 DC 0 AC 22e0 0
RI17 e17 m17 68e-2
LI17 m17 1 27e-5
VS18 0 s18 0
L18 s18 4 12e-2
VS19 0 s19 0
V19 e19 s19 DC 0 AC 47e0 120
RI19 e19 2 56e-2
VS20 5 s20 0
L20 s20 8 18e-2
VS21 0 s21 0
L21 s21 11 27e-5
VS22 11 s22 0
V22 e22 s22 DC 0 AC 39e0 120
RI22 e22 m22 82e-2
LI22 m22 2 15e-6
VS23 7 s23 0
L23 s23 10 47e-5
VS24 13 s24 0
C24 s24 12 15e-5
VS25 11 s25 0
R25 s25 5 33e1
VS26 8 s26 0
V26 e26 s26 DC 0 AC 82e1 180
RI26 e26 10 18e-2
VS27 10 s27 0
C27 s27 11 56e-7
VS28 1 s28 0
L28 s28 12 22e-5
VS29 9 s29 0
R29 s29 11 15e0
.control
set numdgt=17
ac lin 1 60 60
print v(1) v(2) v(3) v(4) v(5) v(6) v(7) v(8) v(9) v(10)
print v(11) v(12) v(13)
print i(vs0) i(vs1) i(vs2) i(vs3) i(vs4) i(vs5) i(vs6) i(vs7) i(vs8) i(vs9)
print i(vs10) i(vs11) i(vs12) i(vs13) i(vs14) i(vs15) i(vs16) i(vs17) i(vs18) i(vs19)
print i(vs20) i(vs21) i(vs22) i(vs23) i(vs24) i(vs25) i(vs26) i(vs27) i(vs28) i(vs29)
.endc
.end
