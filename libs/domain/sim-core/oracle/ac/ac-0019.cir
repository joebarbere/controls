controls oracle ac-0019
* Generated (plan F2.7, ADR 0012): do not edit; regenerate with `pnpm sim oracle regen`. ac seed 20261031 index 19 nodes 14 elements 27
.options sparse gmin=1e-12 noopac
RG1 1 0 1000000000000
RG2 2 0 1000000000000
RG3 3 0 1000000000000
RG4 4 0 1000000000000
RG5 5 0 1000000000000
RG6 6 0 1000000000000
RG7 7 0 1000000000000
RG8 8 0 1000000000000
RG9 9 0 1000000000000
RG10 10 0 1000000000000
RG11 11 0 1000000000000
RG12 12 0 1000000000000
RG13 13 0 1000000000000
VS0 2 s0 0
R0 s0 1 12e-1
VS1 2 s1 0
C1 s1 5 56e-7
VS2 0 s2 0
V2 e2 s2 DC 0 AC 39e0 120
RI2 e2 11 82e-2
VS3 7 s3 0
R3 s3 9 22e2
VS4 2 s4 0
V4 e4 s4 DC 0 AC 47e0 120
RI4 e4 11 56e-2
VS5 2 s5 0
L5 s5 0 27e-5
VS6 0 s6 0
C6 s6 9 56e-7
VS7 7 s7 0
R7 s7 10 68e-2
VS8 5 s8 0
C8 s8 12 33e-5
VS9 13 s9 0
C9 s9 12 15e-5
VS10 2 s10 0
L10 s10 4 12e-2
VS11 8 s11 0
C11 s11 3 47e-5
VS12 0 s12 0
C12 s12 8 27e-5
VS13 9 s13 0
R13 s13 0 15e0
VS14 7 s14 0
L14 s14 10 47e-5
VS15 10 s15 0
C15 s15 0 56e-7
VS16 4 s16 0
R16 s16 2 10e1
VS17 0 s17 0
R17 s17 5 33e1
VS18 5 s18 0
C18 s18 1 22e-5
VS19 11 s19 0
L19 s19 13 68e-4
VS20 1 s20 0
L20 s20 12 22e-5
VS21 2 s21 0
V21 e21 s21 DC 0 AC 15e0 120
RI21 e21 4 56e-2
VS22 5 s22 0
L22 s22 8 18e-2
VS23 8 s23 0
V23 e23 s23 DC 0 AC 82e1 180
RI23 e23 10 18e-2
VS24 6 s24 0
V24 e24 s24 DC 0 AC 22e0 0
RI24 e24 1 68e-2
VS25 8 s25 0
L25 s25 1 18e-4
VS26 13 s26 0
V26 e26 s26 DC 0 AC 15e0 0
RI26 e26 2 10e-2
.control
set numdgt=17
ac lin 1 60 60
print v(1) v(2) v(3) v(4) v(5) v(6) v(7) v(8) v(9) v(10)
print v(11) v(12) v(13)
print i(vs0) i(vs1) i(vs2) i(vs3) i(vs4) i(vs5) i(vs6) i(vs7) i(vs8) i(vs9)
print i(vs10) i(vs11) i(vs12) i(vs13) i(vs14) i(vs15) i(vs16) i(vs17) i(vs18) i(vs19)
print i(vs20) i(vs21) i(vs22) i(vs23) i(vs24) i(vs25) i(vs26)
.endc
.end
