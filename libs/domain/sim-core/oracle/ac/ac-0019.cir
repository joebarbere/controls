controls oracle ac-0019
* Generated (plan F2.7, ADR 0012): do not edit; regenerate with `pnpm sim oracle regen`. ac seed 20261031 index 19 nodes 14 elements 23
.options sparse gmin=1e-12 noopac
RG1 1 0 1000000000000
RG2 2 0 1000000000000
RG3 3 0 1000000000000
RG4 4 0 1000000000000
RG5 5 0 1000000000000
RG6 6 0 1000000000000
RG7 7 0 1000000000000
RG8 8 0 1000000000000
RG9 9 0 1000000000000
RG10 10 0 1000000000000
RG11 11 0 1000000000000
RG12 12 0 1000000000000
RG13 13 0 1000000000000
VS0 3 s0 0
R0 s0 11 47e2
VS1 5 s1 0
L1 s1 13 39e-4
VS2 4 s2 0
C2 s2 9 39e-5
VS3 0 s3 0
V3 e3 s3 DC 0 AC 47e0 120
RI3 e3 2 10e-2
VS4 11 s4 0
R4 s4 2 18e0
VS5 5 s5 0
V5 e5 s5 DC 0 AC 18e0 180
RI5 e5 m5 47e-2
LI5 m5 9 82e-5
VS6 8 s6 0
C6 s6 10 10e-6
VS7 1 s7 0
L7 s7 5 33e-5
VS8 5 s8 0
C8 s8 0 47e-6
VS9 9 s9 0
R9 s9 7 22e0
VS10 11 s10 0
R10 s10 0 39e2
VS11 2 s11 0
V11 e11 s11 DC 0 AC 47e0 120
RI11 e11 0 56e-2
VS12 11 s12 0
L12 s12 12 18e-2
VS13 5 s13 0
C13 s13 12 18e-5
VS14 5 s14 0
L14 s14 6 12e-4
VS15 7 s15 0
L15 s15 3 33e-4
VS16 4 s16 0
C16 s16 8 33e-5
VS17 13 s17 0
L17 s17 6 39e-5
VS18 10 s18 0
C18 s18 7 10e-5
VS19 9 s19 0
L19 s19 1 18e-4
VS20 12 s20 0
L20 s20 5 15e-3
VS21 10 s21 0
R21 s21 13 10e0
VS22 8 s22 0
R22 s22 0 12e-2
.control
set numdgt=17
ac lin 1 60 60
print v(1) v(2) v(3) v(4) v(5) v(6) v(7) v(8) v(9) v(10)
print v(11) v(12) v(13)
print i(vs0) i(vs1) i(vs2) i(vs3) i(vs4) i(vs5) i(vs6) i(vs7) i(vs8) i(vs9)
print i(vs10) i(vs11) i(vs12) i(vs13) i(vs14) i(vs15) i(vs16) i(vs17) i(vs18) i(vs19)
print i(vs20) i(vs21) i(vs22)
.endc
.end
