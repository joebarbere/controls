controls oracle ac-0313
* Generated (plan F2.7, ADR 0012): do not edit; regenerate with `pnpm sim oracle regen`. ac seed 20261031 index 313 nodes 17 elements 24
.options sparse gmin=1e-12 noopac
RG1 1 0 1000000000000
RG2 2 0 1000000000000
RG3 3 0 1000000000000
RG4 4 0 1000000000000
RG5 5 0 1000000000000
RG6 6 0 1000000000000
RG7 7 0 1000000000000
RG8 8 0 1000000000000
RG9 9 0 1000000000000
RG10 10 0 1000000000000
RG11 11 0 1000000000000
RG12 12 0 1000000000000
RG13 13 0 1000000000000
RG14 14 0 1000000000000
RG15 15 0 1000000000000
RG16 16 0 1000000000000
VS0 1 s0 0
L0 s0 4 18e-2
VS1 13 s1 0
L1 s1 16 33e-5
VS2 7 s2 0
R2 s2 9 47e-1
VS3 2 s3 0
R3 s3 1 10e-2
VS4 2 s4 0
R4 s4 3 68e3
VS5 11 s5 0
R5 s5 1 33e-1
VS6 1 s6 0
R6 s6 14 12e3
VS7 2 s7 0
R7 s7 8 47e-1
VS8 9 s8 0
C8 s8 16 82e-5
VS9 14 s9 0
R9 s9 16 27e3
VS10 5 s10 0
L10 s10 7 33e-4
VS11 3 s11 0
L11 s11 15 39e-4
VS12 12 s12 0
R12 s12 13 12e-1
VS13 3 s13 0
C13 s13 4 22e-4
VS14 0 s14 0
R14 s14 4 12e-1
VS15 3 s15 0
L15 s15 12 56e-2
VS16 10 s16 0
L16 s16 8 47e-5
VS17 10 s17 0
L17 s17 11 10e-3
VS18 16 s18 0
R18 s18 6 82e-1
VS19 5 s19 0
R19 s19 12 10e3
VS20 0 s20 0
V20 e20 s20 DC 0 AC 27e0 180
RI20 e20 m20 33e-2
LI20 m20 n20 39e-7
H20 n20 h20 VS21 12e-3
ED20 h20 15 d20 0 -82e-6
F20 0 d20 VS21 1
LD20 d20 0 1
VS21 3 s21 0
V21 e21 s21 DC 0 AC 18e-1 120
RI21 e21 m21 18e-1
LI21 m21 n21 39e-5
H21 n21 h21 VS20 12e-3
ED21 h21 16 d21 0 -82e-6
F21 0 d21 VS20 1
LD21 d21 0 1
VS22 0 s22 0
L22 s22 2 47e-5
VS23 6 s23 0
V23 e23 s23 DC 0 AC 47e0 -120
RI23 e23 12 10e-3
.control
set numdgt=17
ac lin 1 60 60
print v(1) v(2) v(3) v(4) v(5) v(6) v(7) v(8) v(9) v(10)
print v(11) v(12) v(13) v(14) v(15) v(16)
print i(vs0) i(vs1) i(vs2) i(vs3) i(vs4) i(vs5) i(vs6) i(vs7) i(vs8) i(vs9)
print i(vs10) i(vs11) i(vs12) i(vs13) i(vs14) i(vs15) i(vs16) i(vs17) i(vs18) i(vs19)
print i(vs20) i(vs21) i(vs22) i(vs23)
.endc
.end
