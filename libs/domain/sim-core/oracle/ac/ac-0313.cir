controls oracle ac-0313
* Generated (plan F2.7, ADR 0012): do not edit; regenerate with `pnpm sim oracle regen`. ac seed 20261031 index 313 nodes 17 elements 26
.options sparse gmin=1e-12 noopac
RG1 1 0 1000000000000
RG2 2 0 1000000000000
RG3 3 0 1000000000000
RG4 4 0 1000000000000
RG5 5 0 1000000000000
RG6 6 0 1000000000000
RG7 7 0 1000000000000
RG8 8 0 1000000000000
RG9 9 0 1000000000000
RG10 10 0 1000000000000
RG11 11 0 1000000000000
RG12 12 0 1000000000000
RG13 13 0 1000000000000
RG14 14 0 1000000000000
RG15 15 0 1000000000000
RG16 16 0 1000000000000
VS0 0 s0 0
V0 e0 s0 DC 0 AC 39e1 0
RI0 e0 m0 22e-1
LI0 m0 13 68e-5
VS1 0 s1 0
C1 s1 7 22e-7
VS2 9 s2 0
R2 s2 1 22e-1
VS3 3 s3 0
R3 s3 11 12e3
VS4 15 s4 0
R4 s4 16 56e2
VS5 9 s5 0
L5 s5 7 12e-4
VS6 9 s6 0
C6 s6 10 82e-5
VS7 9 s7 0
R7 s7 15 27e0
VS8 10 s8 0
R8 s8 6 82e-1
VS9 15 s9 0
V9 e9 s9 DC 0 AC 27e1 120
RI9 e9 m9 15e-2
LI9 m9 3 39e-7
VS10 12 s10 0
C10 s10 9 27e-6
VS11 5 s11 0
C11 s11 13 47e-7
VS12 3 s12 0
V12 e12 s12 DC 0 AC 18e-1 120
RI12 e12 10 18e-1
VS13 8 s13 0
C13 s13 14 22e-7
VS14 2 s14 0
R14 s14 9 47e-1
VS15 4 s15 0
C15 s15 5 82e-5
VS16 6 s16 0
L16 s16 2 82e-5
VS17 5 s17 0
V17 e17 s17 DC 0 AC 10e-1 0
RI17 e17 m17 47e-2
LI17 m17 7 18e-6
VS18 6 s18 0
C18 s18 5 27e-7
VS19 11 s19 0
L19 s19 12 82e-2
VS20 8 s20 0
R20 s20 14 33e0
VS21 12 s21 0
V21 e21 s21 DC 0 AC 68e1 180
RI21 e21 m21 10e-2
LI21 m21 8 18e-6
VS22 6 s22 0
R22 s22 1 33e0
VS23 15 s23 0
V23 e23 s23 DC 0 AC 18e1 -120
RI23 e23 m23 82e-3
LI23 m23 11 27e-7
VS24 4 s24 0
L24 s24 16 18e-2
VS25 14 s25 0
R25 s25 15 10e3
.control
set numdgt=17
ac lin 1 60 60
print v(1) v(2) v(3) v(4) v(5) v(6) v(7) v(8) v(9) v(10)
print v(11) v(12) v(13) v(14) v(15) v(16)
print i(vs0) i(vs1) i(vs2) i(vs3) i(vs4) i(vs5) i(vs6) i(vs7) i(vs8) i(vs9)
print i(vs10) i(vs11) i(vs12) i(vs13) i(vs14) i(vs15) i(vs16) i(vs17) i(vs18) i(vs19)
print i(vs20) i(vs21) i(vs22) i(vs23) i(vs24) i(vs25)
.endc
.end
