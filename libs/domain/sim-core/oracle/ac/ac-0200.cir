controls oracle ac-0200
* Generated (plan F2.7, ADR 0012): do not edit; regenerate with `pnpm sim oracle regen`. ac seed 20261031 index 200 nodes 6 elements 9
.options sparse gmin=1e-12 noopac
RG1 1 0 1000000000000
RG2 2 0 1000000000000
RG3 3 0 1000000000000
RG4 4 0 1000000000000
RG5 5 0 1000000000000
VS0 3 s0 0
L0 s0 2 33e-4
VS1 5 s1 0
L1 s1 3 68e-2
VS2 1 s2 0
L2 s2 2 33e-4
VS3 0 s3 0
V3 e3 s3 DC 0 AC 15e-1 -120
RI3 e3 m3 39e-2
LI3 m3 1 22e-6
VS4 0 s4 0
R4 s4 4 10e2
VS5 1 s5 0
R5 s5 3 47e-1
VS6 2 s6 0
R6 s6 4 39e0
VS7 0 s7 0
L7 s7 1 39e-3
VS8 2 s8 0
L8 s8 5 47e-3
.control
set numdgt=17
ac lin 1 60 60
print v(1) v(2) v(3) v(4) v(5)
print i(vs0) i(vs1) i(vs2) i(vs3) i(vs4) i(vs5) i(vs6) i(vs7) i(vs8)
.endc
.end
