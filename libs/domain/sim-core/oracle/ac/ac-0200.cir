controls oracle ac-0200
* Generated (plan F2.7, ADR 0012): do not edit; regenerate with `pnpm sim oracle regen`. ac seed 20261031 index 200 nodes 6 elements 8
.options sparse gmin=1e-12 noopac
RG1 1 0 1000000000000
RG2 2 0 1000000000000
RG3 3 0 1000000000000
RG4 4 0 1000000000000
RG5 5 0 1000000000000
VS0 0 s0 0
L0 s0 1 39e-3
VS1 2 s1 0
L1 s1 5 47e-3
VS2 1 s2 0
R2 s2 3 47e-1
VS3 4 s3 0
R3 s3 5 15e3
VS4 1 s4 0
L4 s4 2 33e-4
VS5 0 s5 0
R5 s5 4 10e2
VS6 0 s6 0
V6 e6 s6 DC 0 AC 15e-1 -120
RI6 e6 1 39e-2
VS7 2 s7 0
R7 s7 3 27e-1
.control
set numdgt=17
ac lin 1 60 60
print v(1) v(2) v(3) v(4) v(5)
print i(vs0) i(vs1) i(vs2) i(vs3) i(vs4) i(vs5) i(vs6) i(vs7)
.endc
.end
