controls oracle ac-0018
* Generated (plan F2.7, ADR 0012): do not edit; regenerate with `pnpm sim oracle regen`. ac seed 20261031 index 18 nodes 20 elements 28
.options sparse gmin=1e-12 noopac
RG1 1 0 1000000000000
RG2 2 0 1000000000000
RG3 3 0 1000000000000
RG4 4 0 1000000000000
RG5 5 0 1000000000000
RG6 6 0 1000000000000
RG7 7 0 1000000000000
RG8 8 0 1000000000000
RG9 9 0 1000000000000
RG10 10 0 1000000000000
RG11 11 0 1000000000000
RG12 12 0 1000000000000
RG13 13 0 1000000000000
RG14 14 0 1000000000000
RG15 15 0 1000000000000
RG16 16 0 1000000000000
RG17 17 0 1000000000000
RG18 18 0 1000000000000
RG19 19 0 1000000000000
VS0 0 s0 0
V0 e0 s0 DC 0 AC 39e-1 180
RI0 e0 4 15e-3
VS1 1 s1 0
C1 s1 2 22e-5
VS2 13 s2 0
V2 e2 s2 DC 0 AC 18e-1 180
RI2 e2 1 12e-1
VS3 4 s3 0
C3 s3 3 15e-7
VS4 5 s4 0
R4 s4 4 27e0
VS5 8 s5 0
V5 e5 s5 DC 0 AC 82e-1 -120
RI5 e5 10 27e-1
VS6 16 s6 0
R6 s6 13 39e-1
VS7 7 s7 0
L7 s7 5 82e-3
VS8 17 s8 0
L8 s8 19 12e-4
VS9 14 s9 0
V9 e9 s9 DC 0 AC 18e0 180
RI9 e9 2 10e-3
VS10 4 s10 0
L10 s10 0 82e-5
VS11 7 s11 0
C11 s11 6 27e-6
VS12 13 s12 0
C12 s12 14 15e-5
VS13 3 s13 0
R13 s13 13 68e1
VS14 0 s14 0
C14 s14 10 56e-7
VS15 12 s15 0
V15 e15 s15 DC 0 AC 27e-1 0
RI15 e15 m15 47e-1
LI15 m15 18 27e-7
VS16 15 s16 0
V16 e16 s16 DC 0 AC 12e1 -120
RI16 e16 m16 12e-1
LI16 m16 3 82e-5
VS17 18 s17 0
R17 s17 9 15e-2
VS18 9 s18 0
R18 s18 1 68e0
VS19 12 s19 0
L19 s19 6 56e-5
VS20 3 s20 0
L20 s20 19 12e-5
VS21 18 s21 0
R21 s21 10 47e2
VS22 16 s22 0
C22 s22 8 10e-6
VS23 16 s23 0
R23 s23 11 82e3
VS24 2 s24 0
C24 s24 17 68e-4
VS25 19 s25 0
L25 s25 15 22e-5
VS26 11 s26 0
C26 s26 14 68e-7
VS27 19 s27 0
R27 s27 18 15e0
.control
set numdgt=17
ac lin 1 60 60
print v(1) v(2) v(3) v(4) v(5) v(6) v(7) v(8) v(9) v(10)
print v(11) v(12) v(13) v(14) v(15) v(16) v(17) v(18) v(19)
print i(vs0) i(vs1) i(vs2) i(vs3) i(vs4) i(vs5) i(vs6) i(vs7) i(vs8) i(vs9)
print i(vs10) i(vs11) i(vs12) i(vs13) i(vs14) i(vs15) i(vs16) i(vs17) i(vs18) i(vs19)
print i(vs20) i(vs21) i(vs22) i(vs23) i(vs24) i(vs25) i(vs26) i(vs27)
.endc
.end
