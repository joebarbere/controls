controls oracle ac-0018
* Generated (plan F2.7, ADR 0012): do not edit; regenerate with `pnpm sim oracle regen`. ac seed 20261031 index 18 nodes 20 elements 36
.options sparse gmin=1e-12 noopac
RG1 1 0 1000000000000
RG2 2 0 1000000000000
RG3 3 0 1000000000000
RG4 4 0 1000000000000
RG5 5 0 1000000000000
RG6 6 0 1000000000000
RG7 7 0 1000000000000
RG8 8 0 1000000000000
RG9 9 0 1000000000000
RG10 10 0 1000000000000
RG11 11 0 1000000000000
RG12 12 0 1000000000000
RG13 13 0 1000000000000
RG14 14 0 1000000000000
RG15 15 0 1000000000000
RG16 16 0 1000000000000
RG17 17 0 1000000000000
RG18 18 0 1000000000000
RG19 19 0 1000000000000
VS0 11 s0 0
L0 s0 3 82e-2
VS1 17 s1 0
L1 s1 19 12e-4
VS2 0 s2 0
V2 e2 s2 DC 0 AC 33e-1 0
RI2 e2 m2 47e-3
LI2 m2 9 27e-7
VS3 15 s3 0
L3 s3 13 27e-2
VS4 3 s4 0
R4 s4 14 68e2
VS5 0 s5 0
R5 s5 8 33e2
VS6 5 s6 0
R6 s6 13 68e1
VS7 13 s7 0
R7 s7 4 39e1
VS8 4 s8 0
L8 s8 3 82e-5
VS9 7 s9 0
C9 s9 4 56e-7
VS10 18 s10 0
R10 s10 7 33e0
VS11 17 s11 0
V11 e11 s11 DC 0 AC 18e0 120
RI11 e11 m11 27e-2
LI11 m11 8 68e-6
VS12 6 s12 0
V12 e12 s12 DC 0 AC 33e1 0
RI12 e12 14 10e-1
VS13 8 s13 0
C13 s13 1 56e-6
VS14 0 s14 0
C14 s14 12 82e-7
VS15 14 s15 0
R15 s15 9 33e-1
VS16 7 s16 0
R16 s16 2 15e0
VS17 9 s17 0
R17 s17 18 10e1
VS18 13 s18 0
V18 e18 s18 DC 0 AC 56e1 180
RI18 e18 19 27e-1
VS19 12 s19 0
V19 e19 s19 DC 0 AC 27e-1 0
RI19 e19 18 47e-1
VS20 1 s20 0
R20 s20 18 82e0
VS21 0 s21 0
R21 s21 10 15e0
VS22 6 s22 0
C22 s22 4 10e-7
VS23 6 s23 0
R23 s23 11 33e-2
VS24 13 s24 0
R24 s24 3 56e3
VS25 2 s25 0
L25 s25 14 47e-2
VS26 19 s26 0
R26 s26 18 15e0
VS27 16 s27 0
L27 s27 3 12e-2
VS28 5 s28 0
L28 s28 19 12e-5
VS29 6 s29 0
R29 s29 4 10e0
VS30 6 s30 0
R30 s30 18 56e0
VS31 19 s31 0
C31 s31 10 68e-5
VS32 4 s32 0
C32 s32 5 15e-7
VS33 14 s33 0
L33 s33 6 39e-4
VS34 16 s34 0
C34 s34 2 15e-5
VS35 17 s35 0
R35 s35 15 18e2
.control
set numdgt=17
ac lin 1 60 60
print v(1) v(2) v(3) v(4) v(5) v(6) v(7) v(8) v(9) v(10)
print v(11) v(12) v(13) v(14) v(15) v(16) v(17) v(18) v(19)
print i(vs0) i(vs1) i(vs2) i(vs3) i(vs4) i(vs5) i(vs6) i(vs7) i(vs8) i(vs9)
print i(vs10) i(vs11) i(vs12) i(vs13) i(vs14) i(vs15) i(vs16) i(vs17) i(vs18) i(vs19)
print i(vs20) i(vs21) i(vs22) i(vs23) i(vs24) i(vs25) i(vs26) i(vs27) i(vs28) i(vs29)
print i(vs30) i(vs31) i(vs32) i(vs33) i(vs34) i(vs35)
.endc
.end
