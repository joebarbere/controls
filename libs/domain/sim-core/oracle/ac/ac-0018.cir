controls oracle ac-0018
* Generated (plan F2.7, ADR 0012): do not edit; regenerate with `pnpm sim oracle regen`. ac seed 20261031 index 18 nodes 20 elements 21
.options sparse gmin=1e-12 noopac
RG1 1 0 1000000000000
RG2 2 0 1000000000000
RG3 3 0 1000000000000
RG4 4 0 1000000000000
RG5 5 0 1000000000000
RG6 6 0 1000000000000
RG7 7 0 1000000000000
RG8 8 0 1000000000000
RG9 9 0 1000000000000
RG10 10 0 1000000000000
RG11 11 0 1000000000000
RG12 12 0 1000000000000
RG13 13 0 1000000000000
RG14 14 0 1000000000000
RG15 15 0 1000000000000
RG16 16 0 1000000000000
RG17 17 0 1000000000000
RG18 18 0 1000000000000
RG19 19 0 1000000000000
VS0 0 s0 0
C0 s0 14 15e-5
VS1 19 s1 0
R1 s1 18 15e0
VS2 18 s2 0
R2 s2 9 15e-2
VS3 17 s3 0
L3 s3 19 12e-4
VS4 0 s4 0
V4 e4 s4 DC 0 AC 18e-1 180
RI4 e4 1 12e-1
VS5 5 s5 0
R5 s5 4 27e0
VS6 4 s6 0
L6 s6 3 82e-5
VS7 15 s7 0
V7 e7 s7 DC 0 AC 12e1 -120
RI7 e7 13 12e-1
VS8 12 s8 0
L8 s8 6 56e-5
VS9 7 s9 0
C9 s9 6 27e-6
VS10 14 s10 0
V10 e10 s10 DC 0 AC 18e0 180
RI10 e10 2 10e-3
VS11 16 s11 0
C11 s11 8 10e-6
VS12 3 s12 0
V12 e12 s12 DC 0 AC 39e-1 180
RI12 e12 4 15e-3
VS13 16 s13 0
R13 s13 11 82e3
VS14 4 s14 0
C14 s14 13 15e-7
VS15 13 s15 0
R15 s15 0 68e1
VS16 12 s16 0
V16 e16 s16 DC 0 AC 27e-1 0
RI16 e16 18 47e-1
VS17 13 s17 0
L17 s17 19 12e-5
VS18 16 s18 0
R18 s18 0 39e-1
VS19 7 s19 0
L19 s19 5 82e-3
VS20 18 s20 0
R20 s20 10 47e2
.control
set numdgt=17
ac lin 1 60 60
print v(1) v(2) v(3) v(4) v(5) v(6) v(7) v(8) v(9) v(10)
print v(11) v(12) v(13) v(14) v(15) v(16) v(17) v(18) v(19)
print i(vs0) i(vs1) i(vs2) i(vs3) i(vs4) i(vs5) i(vs6) i(vs7) i(vs8) i(vs9)
print i(vs10) i(vs11) i(vs12) i(vs13) i(vs14) i(vs15) i(vs16) i(vs17) i(vs18) i(vs19)
print i(vs20)
.endc
.end
