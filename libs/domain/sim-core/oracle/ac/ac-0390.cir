controls oracle ac-0390
* Generated (plan F2.7, ADR 0012): do not edit; regenerate with `pnpm sim oracle regen`. ac seed 20261031 index 390 nodes 26 elements 38
.options sparse gmin=1e-12 noopac
RG1 1 0 1000000000000
RG2 2 0 1000000000000
RG3 3 0 1000000000000
RG4 4 0 1000000000000
RG5 5 0 1000000000000
RG6 6 0 1000000000000
RG7 7 0 1000000000000
RG8 8 0 1000000000000
RG9 9 0 1000000000000
RG10 10 0 1000000000000
RG11 11 0 1000000000000
RG12 12 0 1000000000000
RG13 13 0 1000000000000
RG14 14 0 1000000000000
RG15 15 0 1000000000000
RG16 16 0 1000000000000
RG17 17 0 1000000000000
RG18 18 0 1000000000000
RG19 19 0 1000000000000
RG20 20 0 1000000000000
RG21 21 0 1000000000000
RG22 22 0 1000000000000
RG23 23 0 1000000000000
RG24 24 0 1000000000000
RG25 25 0 1000000000000
VS0 16 s0 0
R0 s0 15 15e-2
VS1 23 s1 0
L1 s1 0 68e-2
VS2 22 s2 0
L2 s2 10 82e-4
VS3 21 s3 0
R3 s3 2 22e-2
VS4 0 s4 0
V4 e4 s4 DC 0 AC 47e-1 180
RI4 e4 n4 82e-3
H4 n4 h4 VS18 -10e-4
ED4 h4 20 d4 0 -10e-5
F4 0 d4 VS18 1
LD4 d4 0 1
VS5 2 s5 0
C5 s5 0 56e-4
VS6 20 s6 0
L6 s6 8 56e-3
VS7 25 s7 0
C7 s7 18 82e-7
VS8 22 s8 0
R8 s8 24 18e1
VS9 15 s9 0
C9 s9 0 12e-7
VS10 16 s10 0
L10 s10 18 47e-4
VS11 11 s11 0
R11 s11 5 10e1
VS12 24 s12 0
L12 s12 4 82e-5
VS13 19 s13 0
L13 s13 4 68e-5
VS14 16 s14 0
L14 s14 1 39e-2
VS15 25 s15 0
L15 s15 24 68e-3
VS16 7 s16 0
R16 s16 5 27e1
VS17 2 s17 0
L17 s17 9 12e-5
VS18 15 s18 0
V18 e18 s18 DC 0 AC 82e1 0
RI18 e18 m18 27e-2
LI18 m18 n18 12e-5
H18 n18 h18 VS4 -10e-4
ED18 h18 3 d18 0 -10e-5
F18 0 d18 VS4 1
LD18 d18 0 1
VS19 7 s19 0
V19 e19 s19 DC 0 AC 56e-1 -120
RI19 e19 3 12e-3
VS20 21 s20 0
L20 s20 22 82e-5
VS21 13 s21 0
V21 e21 s21 DC 0 AC 68e1 0
RI21 e21 m21 33e-2
LI21 m21 17 68e-5
VS22 15 s22 0
R22 s22 24 56e2
VS23 21 s23 0
C23 s23 25 27e-7
VS24 1 s24 0
V24 e24 s24 DC 0 AC 33e-1 120
RI24 e24 m24 27e-2
LI24 m24 19 10e-6
VS25 10 s25 0
V25 e25 s25 DC 0 AC 68e0 180
RI25 e25 12 10e-2
VS26 11 s26 0
V26 e26 s26 DC 0 AC 39e-1 0
RI26 e26 6 12e-2
VS27 22 s27 0
V27 e27 s27 DC 0 AC 56e0 120
RI27 e27 5 10e-3
VS28 8 s28 0
R28 s28 21 56e1
VS29 3 s29 0
V29 e29 s29 DC 0 AC 22e0 -120
RI29 e29 m29 10e-1
LI29 m29 14 15e-7
VS30 13 s30 0
V30 e30 s30 DC 0 AC 82e0 -120
RI30 e30 m30 33e-2
LI30 m30 12 15e-5
VS31 6 s31 0
V31 e31 s31 DC 0 AC 68e1 -120
RI31 e31 m31 56e-2
LI31 m31 17 47e-6
VS32 25 s32 0
C32 s32 12 12e-4
VS33 23 s33 0
V33 e33 s33 DC 0 AC 47e0 120
RI33 e33 21 15e-3
VS34 24 s34 0
C34 s34 9 82e-6
VS35 13 s35 0
C35 s35 1 82e-4
VS36 25 s36 0
L36 s36 3 82e-5
VS37 14 s37 0
C37 s37 22 39e-4
.control
set numdgt=17
ac lin 1 60 60
print v(1) v(2) v(3) v(4) v(5) v(6) v(7) v(8) v(9) v(10)
print v(11) v(12) v(13) v(14) v(15) v(16) v(17) v(18) v(19) v(20)
print v(21) v(22) v(23) v(24) v(25)
print i(vs0) i(vs1) i(vs2) i(vs3) i(vs4) i(vs5) i(vs6) i(vs7) i(vs8) i(vs9)
print i(vs10) i(vs11) i(vs12) i(vs13) i(vs14) i(vs15) i(vs16) i(vs17) i(vs18) i(vs19)
print i(vs20) i(vs21) i(vs22) i(vs23) i(vs24) i(vs25) i(vs26) i(vs27) i(vs28) i(vs29)
print i(vs30) i(vs31) i(vs32) i(vs33) i(vs34) i(vs35) i(vs36) i(vs37)
.endc
.end
