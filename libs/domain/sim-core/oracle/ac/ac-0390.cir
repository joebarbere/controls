controls oracle ac-0390
* Generated (plan F2.7, ADR 0012): do not edit; regenerate with `pnpm sim oracle regen`. ac seed 20261031 index 390 nodes 26 elements 27
.options sparse gmin=1e-12 noopac
RG1 1 0 1000000000000
RG2 2 0 1000000000000
RG3 3 0 1000000000000
RG4 4 0 1000000000000
RG5 5 0 1000000000000
RG6 6 0 1000000000000
RG7 7 0 1000000000000
RG8 8 0 1000000000000
RG9 9 0 1000000000000
RG10 10 0 1000000000000
RG11 11 0 1000000000000
RG12 12 0 1000000000000
RG13 13 0 1000000000000
RG14 14 0 1000000000000
RG15 15 0 1000000000000
RG16 16 0 1000000000000
RG17 17 0 1000000000000
RG18 18 0 1000000000000
RG19 19 0 1000000000000
RG20 20 0 1000000000000
RG21 21 0 1000000000000
RG22 22 0 1000000000000
RG23 23 0 1000000000000
RG24 24 0 1000000000000
RG25 25 0 1000000000000
VS0 25 s0 0
C0 s0 18 82e-7
VS1 25 s1 0
C1 s1 12 12e-4
VS2 11 s2 0
R2 s2 5 10e1
VS3 10 s3 0
C3 s3 25 27e-7
VS4 0 s4 0
V4 e4 s4 DC 0 AC 68e0 180
RI4 e4 12 10e-2
VS5 2 s5 0
C5 s5 21 56e-4
VS6 16 s6 0
R6 s6 15 15e-2
VS7 20 s7 0
L7 s7 8 56e-3
VS8 13 s8 0
V8 e8 s8 DC 0 AC 68e1 0
RI8 e8 17 33e-2
VS9 15 s9 0
V9 e9 s9 DC 0 AC 82e1 0
RI9 e9 3 27e-2
VS10 15 s10 0
R10 s10 24 56e2
VS11 22 s11 0
V11 e11 s11 DC 0 AC 56e0 120
RI11 e11 5 10e-3
VS12 22 s12 0
R12 s12 24 18e1
VS13 14 s13 0
C13 s13 22 39e-4
VS14 10 s14 0
L14 s14 22 82e-5
VS15 24 s15 0
C15 s15 9 82e-6
VS16 8 s16 0
R16 s16 10 56e1
VS17 19 s17 0
L17 s17 4 68e-5
VS18 23 s18 0
V18 e18 s18 DC 0 AC 47e0 120
RI18 e18 10 15e-3
VS19 10 s19 0
R19 s19 2 22e-2
VS20 25 s20 0
L20 s20 24 68e-3
VS21 24 s21 0
L21 s21 4 82e-5
VS22 22 s22 0
L22 s22 0 82e-4
VS23 1 s23 0
V23 e23 s23 DC 0 AC 33e-1 120
RI23 e23 19 27e-2
VS24 11 s24 0
V24 e24 s24 DC 0 AC 39e-1 0
RI24 e24 6 12e-2
VS25 13 s25 0
V25 e25 s25 DC 0 AC 82e0 -120
RI25 e25 12 33e-2
VS26 7 s26 0
R26 s26 5 27e1
.control
set numdgt=17
ac lin 1 60 60
print v(1) v(2) v(3) v(4) v(5) v(6) v(7) v(8) v(9) v(10)
print v(11) v(12) v(13) v(14) v(15) v(16) v(17) v(18) v(19) v(20)
print v(21) v(22) v(23) v(24) v(25)
print i(vs0) i(vs1) i(vs2) i(vs3) i(vs4) i(vs5) i(vs6) i(vs7) i(vs8) i(vs9)
print i(vs10) i(vs11) i(vs12) i(vs13) i(vs14) i(vs15) i(vs16) i(vs17) i(vs18) i(vs19)
print i(vs20) i(vs21) i(vs22) i(vs23) i(vs24) i(vs25) i(vs26)
.endc
.end
