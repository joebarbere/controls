controls oracle ac-0390
* Generated (plan F2.7, ADR 0012): do not edit; regenerate with `pnpm sim oracle regen`. ac seed 20261031 index 390 nodes 26 elements 39
.options sparse gmin=1e-12 noopac
RG1 1 0 1000000000000
RG2 2 0 1000000000000
RG3 3 0 1000000000000
RG4 4 0 1000000000000
RG5 5 0 1000000000000
RG6 6 0 1000000000000
RG7 7 0 1000000000000
RG8 8 0 1000000000000
RG9 9 0 1000000000000
RG10 10 0 1000000000000
RG11 11 0 1000000000000
RG12 12 0 1000000000000
RG13 13 0 1000000000000
RG14 14 0 1000000000000
RG15 15 0 1000000000000
RG16 16 0 1000000000000
RG17 17 0 1000000000000
RG18 18 0 1000000000000
RG19 19 0 1000000000000
RG20 20 0 1000000000000
RG21 21 0 1000000000000
RG22 22 0 1000000000000
RG23 23 0 1000000000000
RG24 24 0 1000000000000
RG25 25 0 1000000000000
VS0 24 s0 0
R0 s0 22 18e2
VS1 10 s1 0
R1 s1 13 33e3
VS2 0 s2 0
V2 e2 s2 DC 0 AC 22e1 0
RI2 e2 5 12e-2
VS3 21 s3 0
R3 s3 6 10e2
VS4 23 s4 0
V4 e4 s4 DC 0 AC 47e0 0
RI4 e4 20 39e-1
VS5 4 s5 0
C5 s5 25 27e-7
VS6 22 s6 0
C6 s6 25 15e-6
VS7 6 s7 0
R7 s7 8 47e3
VS8 7 s8 0
L8 s8 2 68e-5
VS9 24 s9 0
C9 s9 9 82e-6
VS10 16 s10 0
R10 s10 15 15e-2
VS11 14 s11 0
L11 s11 20 56e-4
VS12 18 s12 0
C12 s12 17 82e-7
VS13 18 s13 0
C13 s13 25 68e-7
VS14 22 s14 0
R14 s14 19 56e0
VS15 22 s15 0
V15 e15 s15 DC 0 AC 56e0 120
RI15 e15 5 10e-3
VS16 12 s16 0
R16 s16 1 82e-1
VS17 3 s17 0
L17 s17 21 39e-4
VS18 22 s18 0
L18 s18 15 27e-5
VS19 22 s19 0
L19 s19 10 82e-4
VS20 19 s20 0
C20 s20 9 18e-7
VS21 19 s21 0
V21 e21 s21 DC 0 AC 56e0 180
RI21 e21 m21 18e-2
LI21 m21 23 82e-7
VS22 1 s22 0
R22 s22 24 18e2
VS23 10 s23 0
R23 s23 20 18e-2
VS24 11 s24 0
L24 s24 19 47e-4
VS25 4 s25 0
R25 s25 17 33e2
VS26 4 s26 0
L26 s26 22 82e-5
VS27 11 s27 0
V27 e27 s27 DC 0 AC 68e0 -120
RI27 e27 24 47e-2
VS28 5 s28 0
R28 s28 7 22e-1
VS29 8 s29 0
V29 e29 s29 DC 0 AC 15e1 120
RI29 e29 m29 10e-1
LI29 m29 22 82e-5
VS30 13 s30 0
R30 s30 12 15e1
VS31 10 s31 0
C31 s31 5 22e-4
VS32 21 s32 0
C32 s32 19 12e-6
VS33 3 s33 0
C33 s33 5 18e-4
VS34 14 s34 0
R34 s34 10 68e-2
VS35 16 s35 0
C35 s35 19 12e-5
VS36 25 s36 0
R36 s36 2 82e1
VS37 0 s37 0
V37 e37 s37 DC 0 AC 68e1 -120
RI37 e37 1 56e-2
VS38 12 s38 0
L38 s38 24 82e-2
.control
set numdgt=17
ac lin 1 60 60
print v(1) v(2) v(3) v(4) v(5) v(6) v(7) v(8) v(9) v(10)
print v(11) v(12) v(13) v(14) v(15) v(16) v(17) v(18) v(19) v(20)
print v(21) v(22) v(23) v(24) v(25)
print i(vs0) i(vs1) i(vs2) i(vs3) i(vs4) i(vs5) i(vs6) i(vs7) i(vs8) i(vs9)
print i(vs10) i(vs11) i(vs12) i(vs13) i(vs14) i(vs15) i(vs16) i(vs17) i(vs18) i(vs19)
print i(vs20) i(vs21) i(vs22) i(vs23) i(vs24) i(vs25) i(vs26) i(vs27) i(vs28) i(vs29)
print i(vs30) i(vs31) i(vs32) i(vs33) i(vs34) i(vs35) i(vs36) i(vs37) i(vs38)
.endc
.end
