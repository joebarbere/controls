controls oracle ac-0323
* Generated (plan F2.7, ADR 0012): do not edit; regenerate with `pnpm sim oracle regen`. ac seed 20261031 index 323 nodes 25 elements 42
.options sparse gmin=1e-12 noopac
RG1 1 0 1000000000000
RG2 2 0 1000000000000
RG3 3 0 1000000000000
RG4 4 0 1000000000000
RG5 5 0 1000000000000
RG6 6 0 1000000000000
RG7 7 0 1000000000000
RG8 8 0 1000000000000
RG9 9 0 1000000000000
RG10 10 0 1000000000000
RG11 11 0 1000000000000
RG12 12 0 1000000000000
RG13 13 0 1000000000000
RG14 14 0 1000000000000
RG15 15 0 1000000000000
RG16 16 0 1000000000000
RG17 17 0 1000000000000
RG18 18 0 1000000000000
RG19 19 0 1000000000000
RG20 20 0 1000000000000
RG21 21 0 1000000000000
RG22 22 0 1000000000000
RG23 23 0 1000000000000
RG24 24 0 1000000000000
VS0 0 s0 0
V0 e0 s0 DC 0 AC 68e1 0
RI0 e0 7 18e-3
VS1 2 s1 0
C1 s1 17 22e-7
VS2 11 s2 0
V2 e2 s2 DC 0 AC 15e0 180
RI2 e2 22 39e-1
VS3 2 s3 0
V3 e3 s3 DC 0 AC 39e-1 0
RI3 e3 1 33e-3
VS4 3 s4 0
R4 s4 22 56e2
VS5 8 s5 0
C5 s5 10 18e-4
VS6 16 s6 0
R6 s6 19 56e-2
VS7 3 s7 0
R7 s7 14 15e-2
VS8 12 s8 0
R8 s8 13 22e2
VS9 7 s9 0
V9 e9 s9 DC 0 AC 39e0 0
RI9 e9 3 68e-1
VS10 9 s10 0
R10 s10 19 47e0
VS11 3 s11 0
R11 s11 4 56e-1
VS12 9 s12 0
C12 s12 7 12e-6
VS13 20 s13 0
C13 s13 0 10e-7
VS14 7 s14 0
R14 s14 9 10e-2
VS15 0 s15 0
V15 e15 s15 DC 0 AC 22e1 180
RI15 e15 14 68e-2
VS16 10 s16 0
L16 s16 1 22e-2
VS17 10 s17 0
L17 s17 6 68e-2
VS18 5 s18 0
L18 s18 20 33e-5
VS19 13 s19 0
R19 s19 8 47e-2
VS20 14 s20 0
C20 s20 5 39e-5
VS21 5 s21 0
V21 e21 s21 DC 0 AC 33e1 0
RI21 e21 3 22e-1
VS22 14 s22 0
C22 s22 10 22e-6
VS23 6 s23 0
C23 s23 15 27e-6
VS24 4 s24 0
V24 e24 s24 DC 0 AC 18e0 180
RI24 e24 7 22e-1
VS25 24 s25 0
L25 s25 7 39e-4
VS26 19 s26 0
R26 s26 24 27e0
VS27 7 s27 0
V27 e27 s27 DC 0 AC 68e1 -120
RI27 e27 2 22e-3
VS28 22 s28 0
R28 s28 7 10e2
VS29 19 s29 0
L29 s29 7 22e-2
VS30 24 s30 0
C30 s30 15 56e-5
VS31 21 s31 0
R31 s31 17 68e0
VS32 9 s32 0
R32 s32 8 18e0
VS33 21 s33 0
V33 e33 s33 DC 0 AC 33e0 -120
RI33 e33 22 33e-3
VS34 20 s34 0
L34 s34 19 18e-5
VS35 3 s35 0
L35 s35 17 82e-5
VS36 10 s36 0
C36 s36 21 68e-4
VS37 23 s37 0
R37 s37 22 39e2
VS38 22 s38 0
L38 s38 10 15e-4
VS39 6 s39 0
V39 e39 s39 DC 0 AC 33e-1 0
RI39 e39 5 12e-1
VS40 6 s40 0
C40 s40 18 27e-6
VS41 20 s41 0
C41 s41 22 82e-7
.control
set numdgt=17
ac lin 1 60 60
print v(1) v(2) v(3) v(4) v(5) v(6) v(7) v(8) v(9) v(10)
print v(11) v(12) v(13) v(14) v(15) v(16) v(17) v(18) v(19) v(20)
print v(21) v(22) v(23) v(24)
print i(vs0) i(vs1) i(vs2) i(vs3) i(vs4) i(vs5) i(vs6) i(vs7) i(vs8) i(vs9)
print i(vs10) i(vs11) i(vs12) i(vs13) i(vs14) i(vs15) i(vs16) i(vs17) i(vs18) i(vs19)
print i(vs20) i(vs21) i(vs22) i(vs23) i(vs24) i(vs25) i(vs26) i(vs27) i(vs28) i(vs29)
print i(vs30) i(vs31) i(vs32) i(vs33) i(vs34) i(vs35) i(vs36) i(vs37) i(vs38) i(vs39)
print i(vs40) i(vs41)
.endc
.end
