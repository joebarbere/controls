controls oracle ac-0429
* Generated (plan F2.7, ADR 0012): do not edit; regenerate with `pnpm sim oracle regen`. ac seed 20261031 index 429 nodes 15 elements 22
.options sparse gmin=1e-12 noopac
RG1 1 0 1000000000000
RG2 2 0 1000000000000
RG3 3 0 1000000000000
RG4 4 0 1000000000000
RG5 5 0 1000000000000
RG6 6 0 1000000000000
RG7 7 0 1000000000000
RG8 8 0 1000000000000
RG9 9 0 1000000000000
RG10 10 0 1000000000000
RG11 11 0 1000000000000
RG12 12 0 1000000000000
RG13 13 0 1000000000000
RG14 14 0 1000000000000
VS0 0 s0 0
V0 e0 s0 DC 0 AC 10e0 0
RI0 e0 n0 68e-3
H0 n0 h0 VS1 -47e-4
ED0 h0 2 d0 0 -47e-5
F0 0 d0 VS1 1
LD0 d0 0 1
VS1 11 s1 0
V1 e1 s1 DC 0 AC 33e-1 0
RI1 e1 n1 22e-3
H1 n1 h1 VS0 -47e-4
ED1 h1 8 d1 0 -47e-5
F1 0 d1 VS0 1
LD1 d1 0 1
VS2 0 s2 0
R2 s2 7 47e-2
VS3 2 s3 0
L3 s3 1 12e-4
VS4 3 s4 0
C4 s4 10 22e-6
VS5 3 s5 0
R5 s5 9 10e-1
VS6 14 s6 0
R6 s6 11 12e1
VS7 11 s7 0
C7 s7 9 68e-7
VS8 1 s8 0
L8 s8 14 33e-4
VS9 5 s9 0
R9 s9 13 15e-2
VS10 1 s10 0
C10 s10 3 27e-7
VS11 14 s11 0
L11 s11 6 10e-4
VS12 12 s12 0
V12 e12 s12 DC 0 AC 68e-1 0
RI12 e12 m12 82e-1
LI12 m12 14 33e-6
VS13 10 s13 0
R13 s13 5 22e3
VS14 6 s14 0
V14 e14 s14 DC 0 AC 10e1 0
RI14 e14 0 47e-1
VS15 9 s15 0
C15 s15 13 12e-5
VS16 13 s16 0
L16 s16 3 18e-4
VS17 7 s17 0
R17 s17 4 68e1
VS18 3 s18 0
C18 s18 0 47e-4
VS19 12 s19 0
L19 s19 4 18e-3
VS20 12 s20 0
C20 s20 8 82e-4
VS21 7 s21 0
V21 e21 s21 DC 0 AC 56e0 -120
RI21 e21 m21 27e-3
LI21 m21 1 10e-7
.control
set numdgt=17
ac lin 1 60 60
print v(1) v(2) v(3) v(4) v(5) v(6) v(7) v(8) v(9) v(10)
print v(11) v(12) v(13) v(14)
print i(vs0) i(vs1) i(vs2) i(vs3) i(vs4) i(vs5) i(vs6) i(vs7) i(vs8) i(vs9)
print i(vs10) i(vs11) i(vs12) i(vs13) i(vs14) i(vs15) i(vs16) i(vs17) i(vs18) i(vs19)
print i(vs20) i(vs21)
.endc
.end
