controls oracle ac-0429
* Generated (plan F2.7, ADR 0012): do not edit; regenerate with `pnpm sim oracle regen`. ac seed 20261031 index 429 nodes 15 elements 20
.options sparse gmin=1e-12 noopac
RG1 1 0 1000000000000
RG2 2 0 1000000000000
RG3 3 0 1000000000000
RG4 4 0 1000000000000
RG5 5 0 1000000000000
RG6 6 0 1000000000000
RG7 7 0 1000000000000
RG8 8 0 1000000000000
RG9 9 0 1000000000000
RG10 10 0 1000000000000
RG11 11 0 1000000000000
RG12 12 0 1000000000000
RG13 13 0 1000000000000
RG14 14 0 1000000000000
VS0 9 s0 0
C0 s0 13 12e-5
VS1 5 s1 0
R1 s1 13 15e-2
VS2 0 s2 0
V2 e2 s2 DC 0 AC 68e-1 0
RI2 e2 14 82e-1
VS3 12 s3 0
C3 s3 3 47e-4
VS4 3 s4 0
R4 s4 7 47e-2
VS5 7 s5 0
R5 s5 4 68e1
VS6 11 s6 0
C6 s6 9 68e-7
VS7 6 s7 0
V7 e7 s7 DC 0 AC 10e1 0
RI7 e7 3 47e-1
VS8 14 s8 0
R8 s8 11 12e1
VS9 1 s9 0
L9 s9 14 33e-4
VS10 7 s10 0
V10 e10 s10 DC 0 AC 56e0 -120
RI10 e10 1 27e-3
VS11 1 s11 0
C11 s11 12 27e-7
VS12 10 s12 0
R12 s12 5 22e3
VS13 12 s13 0
C13 s13 10 22e-6
VS14 13 s14 0
L14 s14 12 18e-4
VS15 3 s15 0
V15 e15 s15 DC 0 AC 10e0 0
RI15 e15 2 68e-3
VS16 12 s16 0
R16 s16 9 10e-1
VS17 0 s17 0
L17 s17 4 18e-3
VS18 11 s18 0
V18 e18 s18 DC 0 AC 33e-1 0
RI18 e18 8 22e-3
VS19 14 s19 0
L19 s19 6 10e-4
.control
set numdgt=17
ac lin 1 60 60
print v(1) v(2) v(3) v(4) v(5) v(6) v(7) v(8) v(9) v(10)
print v(11) v(12) v(13) v(14)
print i(vs0) i(vs1) i(vs2) i(vs3) i(vs4) i(vs5) i(vs6) i(vs7) i(vs8) i(vs9)
print i(vs10) i(vs11) i(vs12) i(vs13) i(vs14) i(vs15) i(vs16) i(vs17) i(vs18) i(vs19)
.endc
.end
