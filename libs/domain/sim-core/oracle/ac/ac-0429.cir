controls oracle ac-0429
* Generated (plan F2.7, ADR 0012): do not edit; regenerate with `pnpm sim oracle regen`. ac seed 20261031 index 429 nodes 15 elements 22
.options sparse gmin=1e-12 noopac
RG1 1 0 1000000000000
RG2 2 0 1000000000000
RG3 3 0 1000000000000
RG4 4 0 1000000000000
RG5 5 0 1000000000000
RG6 6 0 1000000000000
RG7 7 0 1000000000000
RG8 8 0 1000000000000
RG9 9 0 1000000000000
RG10 10 0 1000000000000
RG11 11 0 1000000000000
RG12 12 0 1000000000000
RG13 13 0 1000000000000
RG14 14 0 1000000000000
VS0 5 s0 0
L0 s0 0 27e-5
VS1 14 s1 0
C1 s1 6 27e-7
VS2 11 s2 0
R2 s2 9 47e-1
VS3 1 s3 0
R3 s3 5 82e2
VS4 0 s4 0
V4 e4 s4 DC 0 AC 10e0 -120
RI4 e4 m4 18e-3
LI4 m4 8 18e-6
VS5 7 s5 0
R5 s5 4 39e3
VS6 12 s6 0
V6 e6 s6 DC 0 AC 68e-1 0
RI6 e6 5 47e-2
VS7 1 s7 0
L7 s7 14 33e-4
VS8 4 s8 0
C8 s8 14 10e-4
VS9 6 s9 0
R9 s9 11 22e2
VS10 0 s10 0
R10 s10 9 10e-1
VS11 2 s11 0
V11 e11 s11 DC 0 AC 68e-1 120
RI11 e11 m11 33e-2
LI11 m11 5 15e-5
VS12 2 s12 0
C12 s12 12 47e-6
VS13 1 s13 0
C13 s13 0 27e-7
VS14 4 s14 0
R14 s14 10 82e-1
VS15 4 s15 0
R15 s15 12 33e-1
VS16 1 s16 0
R16 s16 8 82e1
VS17 9 s17 0
V17 e17 s17 DC 0 AC 18e1 180
RI17 e17 m17 68e-3
LI17 m17 13 22e-5
VS18 7 s18 0
V18 e18 s18 DC 0 AC 56e0 -120
RI18 e18 m18 27e-3
LI18 m18 1 33e-5
VS19 10 s19 0
V19 e19 s19 DC 0 AC 12e0 180
RI19 e19 3 68e-1
VS20 1 s20 0
L20 s20 13 15e-3
VS21 0 s21 0
C21 s21 3 47e-4
.control
set numdgt=17
ac lin 1 60 60
print v(1) v(2) v(3) v(4) v(5) v(6) v(7) v(8) v(9) v(10)
print v(11) v(12) v(13) v(14)
print i(vs0) i(vs1) i(vs2) i(vs3) i(vs4) i(vs5) i(vs6) i(vs7) i(vs8) i(vs9)
print i(vs10) i(vs11) i(vs12) i(vs13) i(vs14) i(vs15) i(vs16) i(vs17) i(vs18) i(vs19)
print i(vs20) i(vs21)
.endc
.end
