controls oracle ac-0355
* Generated (plan F2.7, ADR 0012): do not edit; regenerate with `pnpm sim oracle regen`. ac seed 20261031 index 355 nodes 26 elements 36
.options sparse gmin=1e-12 noopac
RG1 1 0 1000000000000
RG2 2 0 1000000000000
RG3 3 0 1000000000000
RG4 4 0 1000000000000
RG5 5 0 1000000000000
RG6 6 0 1000000000000
RG7 7 0 1000000000000
RG8 8 0 1000000000000
RG9 9 0 1000000000000
RG10 10 0 1000000000000
RG11 11 0 1000000000000
RG12 12 0 1000000000000
RG13 13 0 1000000000000
RG14 14 0 1000000000000
RG15 15 0 1000000000000
RG16 16 0 1000000000000
RG17 17 0 1000000000000
RG18 18 0 1000000000000
RG19 19 0 1000000000000
RG20 20 0 1000000000000
RG21 21 0 1000000000000
RG22 22 0 1000000000000
RG23 23 0 1000000000000
RG24 24 0 1000000000000
RG25 25 0 1000000000000
VS0 9 s0 0
L0 s0 23 47e-2
VS1 0 s1 0
V1 e1 s1 DC 0 AC 82e0 180
RI1 e1 15 12e-3
VS2 17 s2 0
V2 e2 s2 DC 0 AC 18e1 -120
RI2 e2 3 33e-1
VS3 11 s3 0
C3 s3 3 15e-6
VS4 21 s4 0
R4 s4 12 47e2
VS5 24 s5 0
R5 s5 1 33e2
VS6 23 s6 0
V6 e6 s6 DC 0 AC 68e-1 0
RI6 e6 7 56e-3
VS7 8 s7 0
L7 s7 20 33e-3
VS8 11 s8 0
C8 s8 18 39e-5
VS9 13 s9 0
L9 s9 2 27e-2
VS10 24 s10 0
V10 e10 s10 DC 0 AC 68e1 -120
RI10 e10 16 47e-1
VS11 12 s11 0
R11 s11 19 82e0
VS12 21 s12 0
R12 s12 0 56e3
VS13 15 s13 0
R13 s13 17 33e-2
VS14 19 s14 0
V14 e14 s14 DC 0 AC 10e0 120
RI14 e14 15 33e-3
VS15 5 s15 0
L15 s15 4 15e-5
VS16 24 s16 0
L16 s16 9 33e-4
VS17 2 s17 0
C17 s17 6 18e-6
VS18 16 s18 0
L18 s18 20 27e-4
VS19 18 s19 0
L19 s19 23 15e-4
VS20 21 s20 0
V20 e20 s20 DC 0 AC 33e1 -120
RI20 e20 14 47e-2
VS21 1 s21 0
R21 s21 20 33e0
VS22 18 s22 0
R22 s22 22 56e3
VS23 20 s23 0
R23 s23 2 68e0
VS24 15 s24 0
L24 s24 1 39e-3
VS25 14 s25 0
V25 e25 s25 DC 0 AC 82e1 180
RI25 e25 5 33e-1
VS26 17 s26 0
C26 s26 9 39e-7
VS27 17 s27 0
R27 s27 8 39e-1
VS28 10 s28 0
L28 s28 25 15e-4
VS29 17 s29 0
L29 s29 20 10e-3
VS30 10 s30 0
R30 s30 17 10e3
VS31 3 s31 0
C31 s31 4 68e-6
VS32 24 s32 0
C32 s32 8 15e-5
VS33 5 s33 0
C33 s33 17 56e-7
VS34 0 s34 0
R34 s34 9 68e-1
VS35 15 s35 0
C35 s35 9 10e-5
.control
set numdgt=17
ac lin 1 60 60
print v(1) v(2) v(3) v(4) v(5) v(6) v(7) v(8) v(9) v(10)
print v(11) v(12) v(13) v(14) v(15) v(16) v(17) v(18) v(19) v(20)
print v(21) v(22) v(23) v(24) v(25)
print i(vs0) i(vs1) i(vs2) i(vs3) i(vs4) i(vs5) i(vs6) i(vs7) i(vs8) i(vs9)
print i(vs10) i(vs11) i(vs12) i(vs13) i(vs14) i(vs15) i(vs16) i(vs17) i(vs18) i(vs19)
print i(vs20) i(vs21) i(vs22) i(vs23) i(vs24) i(vs25) i(vs26) i(vs27) i(vs28) i(vs29)
print i(vs30) i(vs31) i(vs32) i(vs33) i(vs34) i(vs35)
.endc
.end
