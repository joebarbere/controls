controls oracle ac-0284
* Generated (plan F2.7, ADR 0012): do not edit; regenerate with `pnpm sim oracle regen`. ac seed 20261031 index 284 nodes 30 elements 41
.options sparse gmin=1e-12 noopac
RG1 1 0 1000000000000
RG2 2 0 1000000000000
RG3 3 0 1000000000000
RG4 4 0 1000000000000
RG5 5 0 1000000000000
RG6 6 0 1000000000000
RG7 7 0 1000000000000
RG8 8 0 1000000000000
RG9 9 0 1000000000000
RG10 10 0 1000000000000
RG11 11 0 1000000000000
RG12 12 0 1000000000000
RG13 13 0 1000000000000
RG14 14 0 1000000000000
RG15 15 0 1000000000000
RG16 16 0 1000000000000
RG17 17 0 1000000000000
RG18 18 0 1000000000000
RG19 19 0 1000000000000
RG20 20 0 1000000000000
RG21 21 0 1000000000000
RG22 22 0 1000000000000
RG23 23 0 1000000000000
RG24 24 0 1000000000000
RG25 25 0 1000000000000
RG26 26 0 1000000000000
RG27 27 0 1000000000000
RG28 28 0 1000000000000
RG29 29 0 1000000000000
VS0 20 s0 0
L0 s0 7 82e-4
VS1 0 s1 0
R1 s1 25 12e2
VS2 16 s2 0
L2 s2 28 22e-4
VS3 29 s3 0
L3 s3 16 12e-2
VS4 6 s4 0
R4 s4 25 82e3
VS5 6 s5 0
C5 s5 4 10e-7
VS6 22 s6 0
R6 s6 9 12e-1
VS7 0 s7 0
V7 e7 s7 DC 0 AC 12e1 120
RI7 e7 m7 18e-2
LI7 m7 27 27e-5
VS8 4 s8 0
R8 s8 5 27e1
VS9 12 s9 0
R9 s9 20 15e0
VS10 6 s10 0
C10 s10 15 33e-7
VS11 17 s11 0
C11 s11 16 10e-7
VS12 14 s12 0
R12 s12 9 39e2
VS13 17 s13 0
R13 s13 8 10e1
VS14 14 s14 0
R14 s14 22 68e-2
VS15 7 s15 0
L15 s15 14 47e-4
VS16 3 s16 0
R16 s16 1 12e0
VS17 20 s17 0
R17 s17 28 68e2
VS18 8 s18 0
R18 s18 26 12e2
VS19 24 s19 0
R19 s19 4 15e-1
VS20 18 s20 0
L20 s20 2 39e-5
VS21 15 s21 0
R21 s21 10 18e1
VS22 25 s22 0
L22 s22 14 33e-3
VS23 8 s23 0
R23 s23 14 82e2
VS24 13 s24 0
R24 s24 28 10e-2
VS25 6 s25 0
L25 s25 29 27e-2
VS26 27 s26 0
L26 s26 2 27e-4
VS27 12 s27 0
L27 s27 25 33e-2
VS28 26 s28 0
L28 s28 10 18e-5
VS29 11 s29 0
R29 s29 23 18e3
VS30 11 s30 0
C30 s30 3 12e-5
VS31 13 s31 0
R31 s31 26 39e2
VS32 4 s32 0
R32 s32 1 18e3
VS33 23 s33 0
L33 s33 27 56e-5
VS34 21 s34 0
V34 e34 s34 DC 0 AC 68e0 -120
RI34 e34 m34 10e-2
LI34 m34 26 47e-6
VS35 27 s35 0
V35 e35 s35 DC 0 AC 10e1 120
RI35 e35 m35 27e-3
LI35 m35 24 39e-6
VS36 18 s36 0
V36 e36 s36 DC 0 AC 68e0 180
RI36 e36 m36 56e-3
LI36 m36 15 12e-6
VS37 8 s37 0
R37 s37 19 22e3
VS38 29 s38 0
R38 s38 5 68e3
VS39 19 s39 0
R39 s39 22 82e-2
VS40 21 s40 0
L40 s40 16 39e-3
.control
set numdgt=17
ac lin 1 60 60
print v(1) v(2) v(3) v(4) v(5) v(6) v(7) v(8) v(9) v(10)
print v(11) v(12) v(13) v(14) v(15) v(16) v(17) v(18) v(19) v(20)
print v(21) v(22) v(23) v(24) v(25) v(26) v(27) v(28) v(29)
print i(vs0) i(vs1) i(vs2) i(vs3) i(vs4) i(vs5) i(vs6) i(vs7) i(vs8) i(vs9)
print i(vs10) i(vs11) i(vs12) i(vs13) i(vs14) i(vs15) i(vs16) i(vs17) i(vs18) i(vs19)
print i(vs20) i(vs21) i(vs22) i(vs23) i(vs24) i(vs25) i(vs26) i(vs27) i(vs28) i(vs29)
print i(vs30) i(vs31) i(vs32) i(vs33) i(vs34) i(vs35) i(vs36) i(vs37) i(vs38) i(vs39)
print i(vs40)
.endc
.end
