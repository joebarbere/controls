controls oracle ac-0284
* Generated (plan F2.7, ADR 0012): do not edit; regenerate with `pnpm sim oracle regen`. ac seed 20261031 index 284 nodes 30 elements 34
.options sparse gmin=1e-12 noopac
RG1 1 0 1000000000000
RG2 2 0 1000000000000
RG3 3 0 1000000000000
RG4 4 0 1000000000000
RG5 5 0 1000000000000
RG6 6 0 1000000000000
RG7 7 0 1000000000000
RG8 8 0 1000000000000
RG9 9 0 1000000000000
RG10 10 0 1000000000000
RG11 11 0 1000000000000
RG12 12 0 1000000000000
RG13 13 0 1000000000000
RG14 14 0 1000000000000
RG15 15 0 1000000000000
RG16 16 0 1000000000000
RG17 17 0 1000000000000
RG18 18 0 1000000000000
RG19 19 0 1000000000000
RG20 20 0 1000000000000
RG21 21 0 1000000000000
RG22 22 0 1000000000000
RG23 23 0 1000000000000
RG24 24 0 1000000000000
RG25 25 0 1000000000000
RG26 26 0 1000000000000
RG27 27 0 1000000000000
RG28 28 0 1000000000000
RG29 29 0 1000000000000
VS0 8 s0 0
R0 s0 14 82e2
VS1 0 s1 0
V1 e1 s1 DC 0 AC 68e0 -120
RI1 e1 26 10e-2
VS2 24 s2 0
R2 s2 21 15e-1
VS3 9 s3 0
R3 s3 12 12e-2
VS4 14 s4 0
R4 s4 22 68e-2
VS5 0 s5 0
L5 s5 16 39e-3
VS6 13 s6 0
R6 s6 28 10e-2
VS7 26 s7 0
R7 s7 20 18e3
VS8 4 s8 0
V8 e8 s8 DC 0 AC 12e1 180
RI8 e8 8 12e-1
VS9 17 s9 0
R9 s9 8 10e1
VS10 22 s10 0
R10 s10 9 12e-1
VS11 6 s11 0
C11 s11 21 10e-7
VS12 20 s12 0
R12 s12 28 68e2
VS13 6 s13 0
R13 s13 5 15e-2
VS14 8 s14 0
R14 s14 19 22e3
VS15 18 s15 0
V15 e15 s15 DC 0 AC 68e0 180
RI15 e15 15 56e-3
VS16 4 s16 0
R16 s16 25 12e2
VS17 29 s17 0
L17 s17 16 12e-2
VS18 12 s18 0
L18 s18 25 33e-2
VS19 21 s19 0
R19 s19 1 18e3
VS20 6 s20 0
R20 s20 25 82e3
VS21 8 s21 0
R21 s21 26 12e2
VS22 7 s22 0
V22 e22 s22 DC 0 AC 27e1 -120
RI22 e22 16 22e-1
VS23 3 s23 0
V23 e23 s23 DC 0 AC 15e1 180
RI23 e23 8 12e-1
VS24 11 s24 0
R24 s24 28 18e-1
VS25 10 s25 0
C25 s25 12 68e-7
VS26 7 s26 0
L26 s26 14 47e-4
VS27 6 s27 0
L27 s27 29 27e-2
VS28 25 s28 0
V28 e28 s28 DC 0 AC 12e1 -120
RI28 e28 23 56e-1
VS29 11 s29 0
C29 s29 3 12e-5
VS30 6 s30 0
C30 s30 15 33e-7
VS31 25 s31 0
L31 s31 14 33e-3
VS32 26 s32 0
V32 e32 s32 DC 0 AC 22e1 120
RI32 e32 2 33e-3
VS33 27 s33 0
V33 e33 s33 DC 0 AC 10e1 120
RI33 e33 24 27e-3
.control
set numdgt=17
ac lin 1 60 60
print v(1) v(2) v(3) v(4) v(5) v(6) v(7) v(8) v(9) v(10)
print v(11) v(12) v(13) v(14) v(15) v(16) v(17) v(18) v(19) v(20)
print v(21) v(22) v(23) v(24) v(25) v(26) v(27) v(28) v(29)
print i(vs0) i(vs1) i(vs2) i(vs3) i(vs4) i(vs5) i(vs6) i(vs7) i(vs8) i(vs9)
print i(vs10) i(vs11) i(vs12) i(vs13) i(vs14) i(vs15) i(vs16) i(vs17) i(vs18) i(vs19)
print i(vs20) i(vs21) i(vs22) i(vs23) i(vs24) i(vs25) i(vs26) i(vs27) i(vs28) i(vs29)
print i(vs30) i(vs31) i(vs32) i(vs33)
.endc
.end
