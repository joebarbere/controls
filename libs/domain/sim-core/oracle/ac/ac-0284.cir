controls oracle ac-0284
* Generated (plan F2.7, ADR 0012): do not edit; regenerate with `pnpm sim oracle regen`. ac seed 20261031 index 284 nodes 30 elements 42
.options sparse gmin=1e-12 noopac
RG1 1 0 1000000000000
RG2 2 0 1000000000000
RG3 3 0 1000000000000
RG4 4 0 1000000000000
RG5 5 0 1000000000000
RG6 6 0 1000000000000
RG7 7 0 1000000000000
RG8 8 0 1000000000000
RG9 9 0 1000000000000
RG10 10 0 1000000000000
RG11 11 0 1000000000000
RG12 12 0 1000000000000
RG13 13 0 1000000000000
RG14 14 0 1000000000000
RG15 15 0 1000000000000
RG16 16 0 1000000000000
RG17 17 0 1000000000000
RG18 18 0 1000000000000
RG19 19 0 1000000000000
RG20 20 0 1000000000000
RG21 21 0 1000000000000
RG22 22 0 1000000000000
RG23 23 0 1000000000000
RG24 24 0 1000000000000
RG25 25 0 1000000000000
RG26 26 0 1000000000000
RG27 27 0 1000000000000
RG28 28 0 1000000000000
RG29 29 0 1000000000000
VS0 8 s0 0
R0 s0 26 12e2
VS1 19 s1 0
R1 s1 22 82e-2
VS2 7 s2 0
L2 s2 14 47e-4
VS3 13 s3 0
R3 s3 28 10e-2
VS4 22 s4 0
R4 s4 9 12e-1
VS5 29 s5 0
L5 s5 16 12e-2
VS6 8 s6 0
R6 s6 19 22e3
VS7 0 s7 0
V7 e7 s7 DC 0 AC 12e1 -120
RI7 e7 m7 56e-1
LI7 m7 n7 15e-7
H7 n7 h7 VS15 -22e-2
ED7 h7 23 d7 0 82e-5
F7 0 d7 VS15 1
LD7 d7 0 1
VS8 8 s8 0
R8 s8 14 82e2
VS9 12 s9 0
L9 s9 0 33e-2
VS10 0 s10 0
L10 s10 14 33e-3
VS11 5 s11 0
R11 s11 27 39e2
VS12 25 s12 0
R12 s12 10 27e1
VS13 10 s13 0
C13 s13 12 68e-7
VS14 26 s14 0
R14 s14 20 18e3
VS15 3 s15 0
V15 e15 s15 DC 0 AC 15e1 180
RI15 e15 n15 12e-1
H15 n15 h15 VS7 -22e-2
ED15 h15 8 d15 0 82e-5
F15 0 d15 VS7 1
LD15 d15 0 1
VS16 6 s16 0
L16 s16 29 27e-2
VS17 7 s17 0
V17 e17 s17 DC 0 AC 27e1 -120
RI17 e17 m17 22e-1
LI17 m17 16 22e-5
VS18 20 s18 0
L18 s18 18 82e-4
VS19 21 s19 0
V19 e19 s19 DC 0 AC 68e0 -120
RI19 e19 m19 10e-2
LI19 m19 26 12e-6
VS20 14 s20 0
R20 s20 23 18e1
VS21 21 s21 0
L21 s21 16 39e-3
VS22 11 s22 0
R22 s22 28 18e-1
VS23 26 s23 0
V23 e23 s23 DC 0 AC 22e1 120
RI23 e23 m23 33e-3
LI23 m23 2 18e-5
VS24 11 s24 0
C24 s24 3 12e-5
VS25 9 s25 0
R25 s25 12 12e-2
VS26 17 s26 0
R26 s26 8 10e1
VS27 20 s27 0
R27 s27 28 68e2
VS28 4 s28 0
R28 s28 0 12e2
VS29 24 s29 0
R29 s29 25 15e-1
VS30 18 s30 0
V30 e30 s30 DC 0 AC 68e0 180
RI30 e30 15 56e-3
VS31 17 s31 0
C31 s31 16 10e-7
VS32 27 s32 0
V32 e32 s32 DC 0 AC 10e1 120
RI32 e32 m32 27e-3
LI32 m32 24 47e-5
VS33 6 s33 0
R33 s33 0 82e3
VS34 6 s34 0
R34 s34 5 15e-2
VS35 4 s35 0
V35 e35 s35 DC 0 AC 12e1 180
RI35 e35 m35 12e-1
LI35 m35 8 10e-7
VS36 13 s36 0
L36 s36 2 39e-5
VS37 14 s37 0
R37 s37 22 68e-2
VS38 1 s38 0
V38 e38 s38 DC 0 AC 39e0 180
RI38 e38 4 18e-1
VS39 6 s39 0
C39 s39 25 10e-7
VS40 6 s40 0
C40 s40 15 33e-7
VS41 25 s41 0
R41 s41 1 18e3
.control
set numdgt=17
ac lin 1 60 60
print v(1) v(2) v(3) v(4) v(5) v(6) v(7) v(8) v(9) v(10)
print v(11) v(12) v(13) v(14) v(15) v(16) v(17) v(18) v(19) v(20)
print v(21) v(22) v(23) v(24) v(25) v(26) v(27) v(28) v(29)
print i(vs0) i(vs1) i(vs2) i(vs3) i(vs4) i(vs5) i(vs6) i(vs7) i(vs8) i(vs9)
print i(vs10) i(vs11) i(vs12) i(vs13) i(vs14) i(vs15) i(vs16) i(vs17) i(vs18) i(vs19)
print i(vs20) i(vs21) i(vs22) i(vs23) i(vs24) i(vs25) i(vs26) i(vs27) i(vs28) i(vs29)
print i(vs30) i(vs31) i(vs32) i(vs33) i(vs34) i(vs35) i(vs36) i(vs37) i(vs38) i(vs39)
print i(vs40) i(vs41)
.endc
.end
