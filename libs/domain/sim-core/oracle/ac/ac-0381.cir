controls oracle ac-0381
* Generated (plan F2.7, ADR 0012): do not edit; regenerate with `pnpm sim oracle regen`. ac seed 20261031 index 381 nodes 5 elements 9
.options sparse gmin=1e-12 noopac
RG1 1 0 1000000000000
RG2 2 0 1000000000000
RG3 3 0 1000000000000
RG4 4 0 1000000000000
VS0 1 s0 0
R0 s0 3 33e0
VS1 0 s1 0
V1 e1 s1 DC 0 AC 33e1 120
RI1 e1 m1 12e-1
LI1 m1 1 10e-7
VS2 2 s2 0
R2 s2 3 18e3
VS3 3 s3 0
R3 s3 1 33e-2
VS4 1 s4 0
V4 e4 s4 DC 0 AC 56e1 -120
RI4 e4 3 27e-3
VS5 2 s5 0
V5 e5 s5 DC 0 AC 27e0 0
RI5 e5 m5 56e-2
LI5 m5 4 39e-5
VS6 4 s6 0
L6 s6 0 22e-4
VS7 3 s7 0
C7 s7 0 27e-7
VS8 4 s8 0
R8 s8 1 39e1
.control
set numdgt=17
ac lin 1 60 60
print v(1) v(2) v(3) v(4)
print i(vs0) i(vs1) i(vs2) i(vs3) i(vs4) i(vs5) i(vs6) i(vs7) i(vs8)
.endc
.end
