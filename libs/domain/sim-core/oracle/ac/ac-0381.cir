controls oracle ac-0381
* Generated (plan F2.7, ADR 0012): do not edit; regenerate with `pnpm sim oracle regen`. ac seed 20261031 index 381 nodes 5 elements 7
.options sparse gmin=1e-12 noopac
RG1 1 0 1000000000000
RG2 2 0 1000000000000
RG3 3 0 1000000000000
RG4 4 0 1000000000000
VS0 0 s0 0
R0 s0 3 27e1
VS1 2 s1 0
R1 s1 0 12e1
VS2 4 s2 0
L2 s2 2 22e-4
VS3 0 s3 0
V3 e3 s3 DC 0 AC 33e0 -120
RI3 e3 m3 18e-3
LI3 m3 n3 15e-7
H3 n3 h3 VS6 -10e-4
ED3 h3 1 d3 0 39e-7
F3 0 d3 VS6 1
LD3 d3 0 1
VS4 3 s4 0
C4 s4 2 27e-7
VS5 4 s5 0
R5 s5 0 56e-1
VS6 2 s6 0
V6 e6 s6 DC 0 AC 33e1 120
RI6 e6 n6 12e-1
H6 n6 h6 VS3 -10e-4
ED6 h6 1 d6 0 39e-7
F6 0 d6 VS3 1
LD6 d6 0 1
.control
set numdgt=17
ac lin 1 60 60
print v(1) v(2) v(3) v(4)
print i(vs0) i(vs1) i(vs2) i(vs3) i(vs4) i(vs5) i(vs6)
.endc
.end
