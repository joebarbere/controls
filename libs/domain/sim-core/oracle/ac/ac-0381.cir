controls oracle ac-0381
* Generated (plan F2.7, ADR 0012): do not edit; regenerate with `pnpm sim oracle regen`. ac seed 20261031 index 381 nodes 5 elements 6
.options sparse gmin=1e-12 noopac
RG1 1 0 1000000000000
RG2 2 0 1000000000000
RG3 3 0 1000000000000
RG4 4 0 1000000000000
VS0 0 s0 0
R0 s0 2 12e1
VS1 4 s1 0
R1 s1 2 56e-1
VS2 3 s2 0
C2 s2 0 27e-7
VS3 0 s3 0
V3 e3 s3 DC 0 AC 33e1 120
RI3 e3 1 12e-1
VS4 4 s4 0
L4 s4 0 22e-4
VS5 1 s5 0
R5 s5 0 47e-1
.control
set numdgt=17
ac lin 1 60 60
print v(1) v(2) v(3) v(4)
print i(vs0) i(vs1) i(vs2) i(vs3) i(vs4) i(vs5)
.endc
.end
