controls oracle ac-0491
* Generated (plan F2.7, ADR 0012): do not edit; regenerate with `pnpm sim oracle regen`. ac seed 20261031 index 491 nodes 26 elements 48
.options sparse gmin=1e-12 noopac
RG1 1 0 1000000000000
RG2 2 0 1000000000000
RG3 3 0 1000000000000
RG4 4 0 1000000000000
RG5 5 0 1000000000000
RG6 6 0 1000000000000
RG7 7 0 1000000000000
RG8 8 0 1000000000000
RG9 9 0 1000000000000
RG10 10 0 1000000000000
RG11 11 0 1000000000000
RG12 12 0 1000000000000
RG13 13 0 1000000000000
RG14 14 0 1000000000000
RG15 15 0 1000000000000
RG16 16 0 1000000000000
RG17 17 0 1000000000000
RG18 18 0 1000000000000
RG19 19 0 1000000000000
RG20 20 0 1000000000000
RG21 21 0 1000000000000
RG22 22 0 1000000000000
RG23 23 0 1000000000000
RG24 24 0 1000000000000
RG25 25 0 1000000000000
VS0 23 s0 0
C0 s0 8 18e-4
VS1 24 s1 0
R1 s1 19 15e2
VS2 14 s2 0
L2 s2 1 68e-5
VS3 23 s3 0
L3 s3 14 12e-3
VS4 3 s4 0
R4 s4 25 56e3
VS5 7 s5 0
C5 s5 3 18e-4
VS6 18 s6 0
C6 s6 19 47e-4
VS7 8 s7 0
L7 s7 22 56e-2
VS8 15 s8 0
R8 s8 1 47e2
VS9 0 s9 0
V9 e9 s9 DC 0 AC 15e-1 -120
RI9 e9 m9 27e-2
LI9 m9 n9 10e-5
H9 n9 h9 VS11 33e-3
ED9 h9 21 d9 0 47e-7
F9 0 d9 VS11 1
LD9 d9 0 1
VS10 23 s10 0
R10 s10 2 47e2
VS11 22 s11 0
V11 e11 s11 DC 0 AC 12e1 0
RI11 e11 n11 68e-2
H11 n11 h11 VS9 33e-3
ED11 h11 23 d11 0 47e-7
F11 0 d11 VS9 1
LD11 d11 0 1
VS12 1 s12 0
L12 s12 2 10e-5
VS13 8 s13 0
L13 s13 18 22e-2
VS14 11 s14 0
C14 s14 6 15e-6
VS15 9 s15 0
L15 s15 18 68e-2
VS16 10 s16 0
R16 s16 6 10e0
VS17 24 s17 0
C17 s17 11 15e-5
VS18 18 s18 0
L18 s18 20 27e-2
VS19 15 s19 0
V19 e19 s19 DC 0 AC 12e0 180
RI19 e19 5 82e-2
VS20 16 s20 0
V20 e20 s20 DC 0 AC 82e0 -120
RI20 e20 m20 12e-2
LI20 m20 17 68e-7
VS21 17 s21 0
R21 s21 0 10e0
VS22 19 s22 0
R22 s22 12 22e-1
VS23 8 s23 0
R23 s23 4 22e0
VS24 7 s24 0
L24 s24 18 22e-4
VS25 18 s25 0
C25 s25 2 33e-7
VS26 4 s26 0
L26 s26 9 56e-4
VS27 3 s27 0
R27 s27 16 18e-1
VS28 23 s28 0
R28 s28 4 12e-1
VS29 17 s29 0
V29 e29 s29 DC 0 AC 33e1 0
RI29 e29 0 56e-2
VS30 2 s30 0
C30 s30 10 56e-6
VS31 12 s31 0
L31 s31 16 47e-5
VS32 9 s32 0
R32 s32 14 33e0
VS33 9 s33 0
V33 e33 s33 DC 0 AC 22e1 120
RI33 e33 5 27e-2
VS34 25 s34 0
V34 e34 s34 DC 0 AC 68e0 180
RI34 e34 m34 82e-3
LI34 m34 5 39e-7
VS35 25 s35 0
V35 e35 s35 DC 0 AC 27e-1 180
RI35 e35 m35 82e-1
LI35 m35 22 33e-5
VS36 17 s36 0
V36 e36 s36 DC 0 AC 39e0 120
RI36 e36 14 18e-2
VS37 21 s37 0
C37 s37 23 15e-6
VS38 7 s38 0
L38 s38 21 39e-3
VS39 0 s39 0
V39 e39 s39 DC 0 AC 15e1 180
RI39 e39 6 10e-2
VS40 13 s40 0
R40 s40 20 33e0
VS41 13 s41 0
L41 s41 14 82e-4
VS42 16 s42 0
V42 e42 s42 DC 0 AC 68e0 -120
RI42 e42 m42 68e-2
LI42 m42 10 27e-5
VS43 14 s43 0
R43 s43 2 18e-2
VS44 5 s44 0
R44 s44 12 12e0
VS45 16 s45 0
R45 s45 4 22e-2
VS46 7 s46 0
R46 s46 14 18e-2
VS47 3 s47 0
R47 s47 9 39e3
.control
set numdgt=17
ac lin 1 60 60
print v(1) v(2) v(3) v(4) v(5) v(6) v(7) v(8) v(9) v(10)
print v(11) v(12) v(13) v(14) v(15) v(16) v(17) v(18) v(19) v(20)
print v(21) v(22) v(23) v(24) v(25)
print i(vs0) i(vs1) i(vs2) i(vs3) i(vs4) i(vs5) i(vs6) i(vs7) i(vs8) i(vs9)
print i(vs10) i(vs11) i(vs12) i(vs13) i(vs14) i(vs15) i(vs16) i(vs17) i(vs18) i(vs19)
print i(vs20) i(vs21) i(vs22) i(vs23) i(vs24) i(vs25) i(vs26) i(vs27) i(vs28) i(vs29)
print i(vs30) i(vs31) i(vs32) i(vs33) i(vs34) i(vs35) i(vs36) i(vs37) i(vs38) i(vs39)
print i(vs40) i(vs41) i(vs42) i(vs43) i(vs44) i(vs45) i(vs46) i(vs47)
.endc
.end
