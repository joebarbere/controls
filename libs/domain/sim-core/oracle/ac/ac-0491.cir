controls oracle ac-0491
* Generated (plan F2.7, ADR 0012): do not edit; regenerate with `pnpm sim oracle regen`. ac seed 20261031 index 491 nodes 26 elements 40
.options sparse gmin=1e-12 noopac
RG1 1 0 1000000000000
RG2 2 0 1000000000000
RG3 3 0 1000000000000
RG4 4 0 1000000000000
RG5 5 0 1000000000000
RG6 6 0 1000000000000
RG7 7 0 1000000000000
RG8 8 0 1000000000000
RG9 9 0 1000000000000
RG10 10 0 1000000000000
RG11 11 0 1000000000000
RG12 12 0 1000000000000
RG13 13 0 1000000000000
RG14 14 0 1000000000000
RG15 15 0 1000000000000
RG16 16 0 1000000000000
RG17 17 0 1000000000000
RG18 18 0 1000000000000
RG19 19 0 1000000000000
RG20 20 0 1000000000000
RG21 21 0 1000000000000
RG22 22 0 1000000000000
RG23 23 0 1000000000000
RG24 24 0 1000000000000
RG25 25 0 1000000000000
VS0 2 s0 0
R0 s0 16 39e3
VS1 24 s1 0
R1 s1 19 39e-1
VS2 0 s2 0
V2 e2 s2 DC 0 AC 82e0 -120
RI2 e2 17 12e-2
VS3 18 s3 0
C3 s3 3 56e-7
VS4 22 s4 0
V4 e4 s4 DC 0 AC 12e1 0
RI4 e4 23 68e-2
VS5 23 s5 0
L5 s5 11 10e-5
VS6 10 s6 0
V6 e6 s6 DC 0 AC 18e0 -120
RI6 e6 m6 15e-1
LI6 m6 12 27e-6
VS7 13 s7 0
R7 s7 25 27e3
VS8 8 s8 0
C8 s8 21 82e-5
VS9 15 s9 0
L9 s9 12 33e-4
VS10 14 s10 0
C10 s10 16 12e-5
VS11 4 s11 0
L11 s11 9 56e-3
VS12 23 s12 0
V12 e12 s12 DC 0 AC 68e1 180
RI12 e12 25 22e-2
VS13 0 s13 0
L13 s13 16 15e-4
VS14 1 s14 0
R14 s14 9 15e-2
VS15 22 s15 0
R15 s15 3 68e3
VS16 5 s16 0
V16 e16 s16 DC 0 AC 56e-1 180
RI16 e16 15 82e-1
VS17 18 s17 0
C17 s17 19 47e-4
VS18 8 s18 0
L18 s18 18 22e-2
VS19 23 s19 0
V19 e19 s19 DC 0 AC 39e1 0
RI19 e19 m19 33e-3
LI19 m19 6 22e-5
VS20 0 s20 0
R20 s20 11 27e3
VS21 14 s21 0
R21 s21 2 18e-2
VS22 13 s22 0
V22 e22 s22 DC 0 AC 10e0 -120
RI22 e22 m22 56e-1
LI22 m22 16 27e-6
VS23 19 s23 0
L23 s23 20 47e-5
VS24 24 s24 0
R24 s24 21 33e-1
VS25 6 s25 0
L25 s25 1 47e-3
VS26 17 s26 0
R26 s26 9 18e3
VS27 12 s27 0
R27 s27 14 33e-1
VS28 6 s28 0
L28 s28 16 56e-3
VS29 20 s29 0
R29 s29 2 39e2
VS30 3 s30 0
V30 e30 s30 DC 0 AC 12e1 180
RI30 e30 8 22e-1
VS31 7 s31 0
R31 s31 10 39e1
VS32 14 s32 0
L32 s32 4 10e-3
VS33 14 s33 0
R33 s33 24 12e3
VS34 5 s34 0
L34 s34 14 47e-5
VS35 14 s35 0
V35 e35 s35 DC 0 AC 68e0 120
RI35 e35 m35 39e-2
LI35 m35 7 56e-7
VS36 19 s36 0
L36 s36 3 47e-4
VS37 0 s37 0
L37 s37 3 22e-4
VS38 12 s38 0
C38 s38 16 27e-7
VS39 7 s39 0
L39 s39 14 33e-2
.control
set numdgt=17
ac lin 1 60 60
print v(1) v(2) v(3) v(4) v(5) v(6) v(7) v(8) v(9) v(10)
print v(11) v(12) v(13) v(14) v(15) v(16) v(17) v(18) v(19) v(20)
print v(21) v(22) v(23) v(24) v(25)
print i(vs0) i(vs1) i(vs2) i(vs3) i(vs4) i(vs5) i(vs6) i(vs7) i(vs8) i(vs9)
print i(vs10) i(vs11) i(vs12) i(vs13) i(vs14) i(vs15) i(vs16) i(vs17) i(vs18) i(vs19)
print i(vs20) i(vs21) i(vs22) i(vs23) i(vs24) i(vs25) i(vs26) i(vs27) i(vs28) i(vs29)
print i(vs30) i(vs31) i(vs32) i(vs33) i(vs34) i(vs35) i(vs36) i(vs37) i(vs38) i(vs39)
.endc
.end
