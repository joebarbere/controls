controls oracle ac-0491
* Generated (plan F2.7, ADR 0012): do not edit; regenerate with `pnpm sim oracle regen`. ac seed 20261031 index 491 nodes 26 elements 47
.options sparse gmin=1e-12 noopac
RG1 1 0 1000000000000
RG2 2 0 1000000000000
RG3 3 0 1000000000000
RG4 4 0 1000000000000
RG5 5 0 1000000000000
RG6 6 0 1000000000000
RG7 7 0 1000000000000
RG8 8 0 1000000000000
RG9 9 0 1000000000000
RG10 10 0 1000000000000
RG11 11 0 1000000000000
RG12 12 0 1000000000000
RG13 13 0 1000000000000
RG14 14 0 1000000000000
RG15 15 0 1000000000000
RG16 16 0 1000000000000
RG17 17 0 1000000000000
RG18 18 0 1000000000000
RG19 19 0 1000000000000
RG20 20 0 1000000000000
RG21 21 0 1000000000000
RG22 22 0 1000000000000
RG23 23 0 1000000000000
RG24 24 0 1000000000000
RG25 25 0 1000000000000
VS0 7 s0 0
L0 s0 21 39e-3
VS1 12 s1 0
L1 s1 22 47e-5
VS2 22 s2 0
R2 s2 4 22e-2
VS3 19 s3 0
R3 s3 12 22e-1
VS4 23 s4 0
C4 s4 8 18e-4
VS5 7 s5 0
R5 s5 14 18e-2
VS6 7 s6 0
C6 s6 3 18e-4
VS7 3 s7 0
R7 s7 9 39e3
VS8 21 s8 0
C8 s8 23 15e-6
VS9 2 s9 0
C9 s9 10 56e-6
VS10 23 s10 0
R10 s10 2 47e2
VS11 23 s11 0
L11 s11 14 12e-3
VS12 0 s12 0
V12 e12 s12 DC 0 AC 12e1 0
RI12 e12 23 68e-2
VS13 16 s13 0
V13 e13 s13 DC 0 AC 15e-1 -120
RI13 e13 21 27e-2
VS14 8 s14 0
R14 s14 4 22e0
VS15 16 s15 0
V15 e15 s15 DC 0 AC 15e1 180
RI15 e15 6 10e-2
VS16 17 s16 0
R16 s16 16 10e0
VS17 15 s17 0
V17 e17 s17 DC 0 AC 12e0 180
RI17 e17 5 82e-2
VS18 3 s18 0
R18 s18 22 18e-1
VS19 10 s19 0
R19 s19 6 10e0
VS20 25 s20 0
V20 e20 s20 DC 0 AC 27e-1 180
RI20 e20 0 82e-1
VS21 18 s21 0
C21 s21 2 33e-7
VS22 5 s22 0
R22 s22 12 12e0
VS23 18 s23 0
L23 s23 20 27e-2
VS24 14 s24 0
L24 s24 1 68e-5
VS25 24 s25 0
C25 s25 11 15e-5
VS26 22 s26 0
V26 e26 s26 DC 0 AC 82e0 -120
RI26 e26 17 12e-2
VS27 11 s27 0
C27 s27 6 15e-6
VS28 25 s28 0
V28 e28 s28 DC 0 AC 68e0 180
RI28 e28 5 82e-3
VS29 13 s29 0
L29 s29 14 82e-4
VS30 23 s30 0
R30 s30 4 12e-1
VS31 8 s31 0
L31 s31 0 56e-2
VS32 9 s32 0
V32 e32 s32 DC 0 AC 22e1 120
RI32 e32 5 27e-2
VS33 1 s33 0
L33 s33 2 10e-5
VS34 8 s34 0
L34 s34 18 22e-2
VS35 14 s35 0
R35 s35 2 18e-2
VS36 9 s36 0
L36 s36 18 68e-2
VS37 22 s37 0
V37 e37 s37 DC 0 AC 68e0 -120
RI37 e37 10 68e-2
VS38 13 s38 0
R38 s38 20 33e0
VS39 17 s39 0
V39 e39 s39 DC 0 AC 33e1 0
RI39 e39 16 56e-2
VS40 15 s40 0
R40 s40 1 47e2
VS41 3 s41 0
R41 s41 25 56e3
VS42 4 s42 0
L42 s42 9 56e-4
VS43 7 s43 0
L43 s43 18 22e-4
VS44 18 s44 0
C44 s44 19 47e-4
VS45 9 s45 0
R45 s45 14 33e0
VS46 17 s46 0
V46 e46 s46 DC 0 AC 39e0 120
RI46 e46 14 18e-2
.control
set numdgt=17
ac lin 1 60 60
print v(1) v(2) v(3) v(4) v(5) v(6) v(7) v(8) v(9) v(10)
print v(11) v(12) v(13) v(14) v(15) v(16) v(17) v(18) v(19) v(20)
print v(21) v(22) v(23) v(24) v(25)
print i(vs0) i(vs1) i(vs2) i(vs3) i(vs4) i(vs5) i(vs6) i(vs7) i(vs8) i(vs9)
print i(vs10) i(vs11) i(vs12) i(vs13) i(vs14) i(vs15) i(vs16) i(vs17) i(vs18) i(vs19)
print i(vs20) i(vs21) i(vs22) i(vs23) i(vs24) i(vs25) i(vs26) i(vs27) i(vs28) i(vs29)
print i(vs30) i(vs31) i(vs32) i(vs33) i(vs34) i(vs35) i(vs36) i(vs37) i(vs38) i(vs39)
print i(vs40) i(vs41) i(vs42) i(vs43) i(vs44) i(vs45) i(vs46)
.endc
.end
