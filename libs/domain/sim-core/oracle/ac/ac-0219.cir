controls oracle ac-0219
* Generated (plan F2.7, ADR 0012): do not edit; regenerate with `pnpm sim oracle regen`. ac seed 20261031 index 219 nodes 5 elements 8
.options sparse gmin=1e-12 noopac
RG1 1 0 1000000000000
RG2 2 0 1000000000000
RG3 3 0 1000000000000
RG4 4 0 1000000000000
VS0 3 s0 0
C0 s0 0 27e-5
VS1 0 s1 0
V1 e1 s1 DC 0 AC 33e0 -120
RI1 e1 3 15e-1
VS2 0 s2 0
C2 s2 4 56e-7
VS3 1 s3 0
R3 s3 2 39e-1
VS4 4 s4 0
L4 s4 1 39e-4
VS5 0 s5 0
C5 s5 4 12e-7
VS6 4 s6 0
L6 s6 0 22e-5
VS7 0 s7 0
R7 s7 4 33e0
.control
set numdgt=17
ac lin 1 60 60
print v(1) v(2) v(3) v(4)
print i(vs0) i(vs1) i(vs2) i(vs3) i(vs4) i(vs5) i(vs6) i(vs7)
.endc
.end
