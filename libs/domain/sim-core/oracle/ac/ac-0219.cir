controls oracle ac-0219
* Generated (plan F2.7, ADR 0012): do not edit; regenerate with `pnpm sim oracle regen`. ac seed 20261031 index 219 nodes 5 elements 9
.options sparse gmin=1e-12 noopac
RG1 1 0 1000000000000
RG2 2 0 1000000000000
RG3 3 0 1000000000000
RG4 4 0 1000000000000
VS0 2 s0 0
C0 s0 0 56e-7
VS1 0 s1 0
L1 s1 2 22e-5
VS2 0 s2 0
L2 s2 1 39e-4
VS3 1 s3 0
C3 s3 3 68e-7
VS4 0 s4 0
V4 e4 s4 DC 0 AC 22e0 120
RI4 e4 4 56e-3
VS5 2 s5 0
V5 e5 s5 DC 0 AC 33e0 -120
RI5 e5 m5 15e-1
LI5 m5 3 12e-5
VS6 2 s6 0
C6 s6 0 12e-7
VS7 1 s7 0
R7 s7 4 39e-1
VS8 2 s8 0
R8 s8 0 33e0
.control
set numdgt=17
ac lin 1 60 60
print v(1) v(2) v(3) v(4)
print i(vs0) i(vs1) i(vs2) i(vs3) i(vs4) i(vs5) i(vs6) i(vs7) i(vs8)
.endc
.end
