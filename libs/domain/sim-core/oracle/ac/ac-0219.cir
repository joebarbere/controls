controls oracle ac-0219
* Generated (plan F2.7, ADR 0012): do not edit; regenerate with `pnpm sim oracle regen`. ac seed 20261031 index 219 nodes 5 elements 5
.options sparse gmin=1e-12 noopac
RG1 1 0 1000000000000
RG2 2 0 1000000000000
RG3 3 0 1000000000000
RG4 4 0 1000000000000
VS0 0 s0 0
V0 e0 s0 DC 0 AC 33e0 -120
RI0 e0 m0 15e-1
LI0 m0 3 18e-6
VS1 1 s1 0
R1 s1 2 39e-1
VS2 0 s2 0
R2 s2 4 33e0
VS3 4 s3 0
L3 s3 1 39e-4
VS4 2 s4 0
R4 s4 3 12e0
.control
set numdgt=17
ac lin 1 60 60
print v(1) v(2) v(3) v(4)
print i(vs0) i(vs1) i(vs2) i(vs3) i(vs4)
.endc
.end
