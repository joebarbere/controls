controls oracle ac-0167
* Generated (plan F2.7, ADR 0012): do not edit; regenerate with `pnpm sim oracle regen`. ac seed 20261031 index 167 nodes 23 elements 35
.options sparse gmin=1e-12 noopac
RG1 1 0 1000000000000
RG2 2 0 1000000000000
RG3 3 0 1000000000000
RG4 4 0 1000000000000
RG5 5 0 1000000000000
RG6 6 0 1000000000000
RG7 7 0 1000000000000
RG8 8 0 1000000000000
RG9 9 0 1000000000000
RG10 10 0 1000000000000
RG11 11 0 1000000000000
RG12 12 0 1000000000000
RG13 13 0 1000000000000
RG14 14 0 1000000000000
RG15 15 0 1000000000000
RG16 16 0 1000000000000
RG17 17 0 1000000000000
RG18 18 0 1000000000000
RG19 19 0 1000000000000
RG20 20 0 1000000000000
RG21 21 0 1000000000000
RG22 22 0 1000000000000
VS0 15 s0 0
C0 s0 19 18e-6
VS1 10 s1 0
R1 s1 14 10e0
VS2 0 s2 0
V2 e2 s2 DC 0 AC 18e1 -120
RI2 e2 m2 33e-3
LI2 m2 2 12e-5
VS3 5 s3 0
R3 s3 13 27e2
VS4 2 s4 0
R4 s4 10 18e2
VS5 6 s5 0
R5 s5 11 15e2
VS6 9 s6 0
V6 e6 s6 DC 0 AC 27e1 180
RI6 e6 17 47e-2
VS7 19 s7 0
R7 s7 16 47e1
VS8 19 s8 0
L8 s8 22 47e-5
VS9 14 s9 0
C9 s9 9 18e-5
VS10 1 s10 0
R10 s10 10 10e-1
VS11 15 s11 0
C11 s11 14 82e-7
VS12 0 s12 0
L12 s12 21 56e-4
VS13 8 s13 0
V13 e13 s13 DC 0 AC 15e0 0
RI13 e13 m13 68e-3
LI13 m13 2 22e-7
VS14 3 s14 0
V14 e14 s14 DC 0 AC 18e0 0
RI14 e14 4 27e-3
VS15 12 s15 0
R15 s15 4 68e1
VS16 19 s16 0
V16 e16 s16 DC 0 AC 27e0 -120
RI16 e16 m16 68e-2
LI16 m16 5 68e-5
VS17 10 s17 0
C17 s17 13 33e-4
VS18 7 s18 0
R18 s18 11 39e-1
VS19 12 s19 0
C19 s19 3 39e-6
VS20 19 s20 0
L20 s20 18 12e-5
VS21 4 s21 0
L21 s21 20 56e-4
VS22 10 s22 0
R22 s22 16 56e2
VS23 17 s23 0
C23 s23 10 27e-6
VS24 4 s24 0
R24 s24 1 18e0
VS25 18 s25 0
R25 s25 11 39e-1
VS26 21 s26 0
R26 s26 13 39e0
VS27 10 s27 0
R27 s27 12 15e3
VS28 6 s28 0
C28 s28 3 68e-7
VS29 1 s29 0
C29 s29 22 12e-4
VS30 11 s30 0
C30 s30 16 27e-7
VS31 10 s31 0
C31 s31 20 47e-6
VS32 21 s32 0
L32 s32 8 27e-4
VS33 7 s33 0
V33 e33 s33 DC 0 AC 33e1 0
RI33 e33 m33 18e-3
LI33 m33 0 10e-7
VS34 11 s34 0
C34 s34 17 82e-6
.control
set numdgt=17
ac lin 1 60 60
print v(1) v(2) v(3) v(4) v(5) v(6) v(7) v(8) v(9) v(10)
print v(11) v(12) v(13) v(14) v(15) v(16) v(17) v(18) v(19) v(20)
print v(21) v(22)
print i(vs0) i(vs1) i(vs2) i(vs3) i(vs4) i(vs5) i(vs6) i(vs7) i(vs8) i(vs9)
print i(vs10) i(vs11) i(vs12) i(vs13) i(vs14) i(vs15) i(vs16) i(vs17) i(vs18) i(vs19)
print i(vs20) i(vs21) i(vs22) i(vs23) i(vs24) i(vs25) i(vs26) i(vs27) i(vs28) i(vs29)
print i(vs30) i(vs31) i(vs32) i(vs33) i(vs34)
.endc
.end
