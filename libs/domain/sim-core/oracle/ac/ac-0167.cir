controls oracle ac-0167
* Generated (plan F2.7, ADR 0012): do not edit; regenerate with `pnpm sim oracle regen`. ac seed 20261031 index 167 nodes 23 elements 36
.options sparse gmin=1e-12 noopac
RG1 1 0 1000000000000
RG2 2 0 1000000000000
RG3 3 0 1000000000000
RG4 4 0 1000000000000
RG5 5 0 1000000000000
RG6 6 0 1000000000000
RG7 7 0 1000000000000
RG8 8 0 1000000000000
RG9 9 0 1000000000000
RG10 10 0 1000000000000
RG11 11 0 1000000000000
RG12 12 0 1000000000000
RG13 13 0 1000000000000
RG14 14 0 1000000000000
RG15 15 0 1000000000000
RG16 16 0 1000000000000
RG17 17 0 1000000000000
RG18 18 0 1000000000000
RG19 19 0 1000000000000
RG20 20 0 1000000000000
RG21 21 0 1000000000000
RG22 22 0 1000000000000
VS0 0 s0 0
V0 e0 s0 DC 0 AC 27e-1 -120
RI0 e0 15 39e-1
VS1 22 s1 0
L1 s1 1 15e-4
VS2 22 s2 0
C2 s2 18 33e-4
VS3 15 s3 0
R3 s3 8 12e0
VS4 1 s4 0
R4 s4 9 10e-1
VS5 3 s5 0
V5 e5 s5 DC 0 AC 18e0 0
RI5 e5 4 27e-3
VS6 16 s6 0
R6 s6 0 27e-2
VS7 21 s7 0
R7 s7 13 39e0
VS8 6 s8 0
V8 e8 s8 DC 0 AC 22e1 120
RI8 e8 15 33e-1
VS9 17 s9 0
V9 e9 s9 DC 0 AC 56e-1 -120
RI9 e9 11 22e-2
VS10 2 s10 0
R10 s10 9 18e2
VS11 4 s11 0
R11 s11 1 18e0
VS12 11 s12 0
C12 s12 16 27e-7
VS13 20 s13 0
R13 s13 19 22e1
VS14 9 s14 0
C14 s14 13 33e-4
VS15 7 s15 0
C15 s15 16 68e-4
VS16 5 s16 0
C16 s16 2 56e-6
VS17 7 s17 0
C17 s17 8 22e-4
VS18 19 s18 0
R18 s18 16 47e1
VS19 12 s19 0
V19 e19 s19 DC 0 AC 27e1 -120
RI19 e19 11 12e-2
VS20 6 s20 0
R20 s20 11 15e2
VS21 12 s21 0
R21 s21 4 68e1
VS22 4 s22 0
V22 e22 s22 DC 0 AC 56e-1 120
RI22 e22 10 18e-3
VS23 21 s23 0
C23 s23 16 10e-7
VS24 14 s24 0
L24 s24 15 47e-3
VS25 14 s25 0
C25 s25 22 82e-7
VS26 0 s26 0
R26 s26 3 47e-2
VS27 9 s27 0
V27 e27 s27 DC 0 AC 15e1 -120
RI27 e27 18 56e-2
VS28 16 s28 0
R28 s28 17 82e3
VS29 5 s29 0
V29 e29 s29 DC 0 AC 15e0 0
RI29 e29 18 68e-3
VS30 21 s30 0
R30 s30 7 27e3
VS31 20 s31 0
L31 s31 13 39e-2
VS32 10 s32 0
L32 s32 15 39e-5
VS33 16 s33 0
R33 s33 7 15e-2
VS34 9 s34 0
R34 s34 16 56e2
VS35 0 s35 0
V35 e35 s35 DC 0 AC 22e0 180
RI35 e35 22 56e-1
.control
set numdgt=17
ac lin 1 60 60
print v(1) v(2) v(3) v(4) v(5) v(6) v(7) v(8) v(9) v(10)
print v(11) v(12) v(13) v(14) v(15) v(16) v(17) v(18) v(19) v(20)
print v(21) v(22)
print i(vs0) i(vs1) i(vs2) i(vs3) i(vs4) i(vs5) i(vs6) i(vs7) i(vs8) i(vs9)
print i(vs10) i(vs11) i(vs12) i(vs13) i(vs14) i(vs15) i(vs16) i(vs17) i(vs18) i(vs19)
print i(vs20) i(vs21) i(vs22) i(vs23) i(vs24) i(vs25) i(vs26) i(vs27) i(vs28) i(vs29)
print i(vs30) i(vs31) i(vs32) i(vs33) i(vs34) i(vs35)
.endc
.end
