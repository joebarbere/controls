controls oracle ac-0460
* Generated (plan F2.7, ADR 0012): do not edit; regenerate with `pnpm sim oracle regen`. ac seed 20261031 index 460 nodes 17 elements 31
.options sparse gmin=1e-12 noopac
RG1 1 0 1000000000000
RG2 2 0 1000000000000
RG3 3 0 1000000000000
RG4 4 0 1000000000000
RG5 5 0 1000000000000
RG6 6 0 1000000000000
RG7 7 0 1000000000000
RG8 8 0 1000000000000
RG9 9 0 1000000000000
RG10 10 0 1000000000000
RG11 11 0 1000000000000
RG12 12 0 1000000000000
RG13 13 0 1000000000000
RG14 14 0 1000000000000
RG15 15 0 1000000000000
RG16 16 0 1000000000000
VS0 10 s0 0
R0 s0 5 56e0
VS1 0 s1 0
C1 s1 6 12e-5
VS2 7 s2 0
R2 s2 8 15e3
VS3 3 s3 0
C3 s3 14 22e-7
VS4 5 s4 0
L4 s4 3 18e-4
VS5 2 s5 0
C5 s5 10 82e-5
VS6 10 s6 0
R6 s6 11 22e-1
VS7 10 s7 0
L7 s7 15 56e-4
VS8 14 s8 0
R8 s8 8 39e2
VS9 0 s9 0
C9 s9 3 82e-7
VS10 10 s10 0
C10 s10 15 82e-6
VS11 8 s11 0
R11 s11 0 68e-1
VS12 0 s12 0
V12 e12 s12 DC 0 AC 10e-1 -120
RI12 e12 16 33e-3
VS13 10 s13 0
L13 s13 3 68e-5
VS14 4 s14 0
C14 s14 1 39e-6
VS15 0 s15 0
R15 s15 2 15e-1
VS16 8 s16 0
C16 s16 13 82e-4
VS17 16 s17 0
R17 s17 1 27e0
VS18 2 s18 0
L18 s18 12 22e-3
VS19 2 s19 0
L19 s19 10 27e-3
VS20 16 s20 0
C20 s20 5 82e-5
VS21 9 s21 0
C21 s21 2 10e-6
VS22 9 s22 0
L22 s22 2 56e-4
VS23 3 s23 0
R23 s23 2 22e1
VS24 15 s24 0
R24 s24 13 15e-2
VS25 3 s25 0
L25 s25 1 27e-4
VS26 1 s26 0
L26 s26 6 22e-3
VS27 13 s27 0
L27 s27 2 82e-3
VS28 12 s28 0
L28 s28 13 18e-5
VS29 14 s29 0
L29 s29 13 39e-3
VS30 13 s30 0
R30 s30 16 10e-2
.control
set numdgt=17
ac lin 1 60 60
print v(1) v(2) v(3) v(4) v(5) v(6) v(7) v(8) v(9) v(10)
print v(11) v(12) v(13) v(14) v(15) v(16)
print i(vs0) i(vs1) i(vs2) i(vs3) i(vs4) i(vs5) i(vs6) i(vs7) i(vs8) i(vs9)
print i(vs10) i(vs11) i(vs12) i(vs13) i(vs14) i(vs15) i(vs16) i(vs17) i(vs18) i(vs19)
print i(vs20) i(vs21) i(vs22) i(vs23) i(vs24) i(vs25) i(vs26) i(vs27) i(vs28) i(vs29)
print i(vs30)
.endc
.end
