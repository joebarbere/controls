controls oracle ac-0460
* Generated (plan F2.7, ADR 0012): do not edit; regenerate with `pnpm sim oracle regen`. ac seed 20261031 index 460 nodes 17 elements 35
.options sparse gmin=1e-12 noopac
RG1 1 0 1000000000000
RG2 2 0 1000000000000
RG3 3 0 1000000000000
RG4 4 0 1000000000000
RG5 5 0 1000000000000
RG6 6 0 1000000000000
RG7 7 0 1000000000000
RG8 8 0 1000000000000
RG9 9 0 1000000000000
RG10 10 0 1000000000000
RG11 11 0 1000000000000
RG12 12 0 1000000000000
RG13 13 0 1000000000000
RG14 14 0 1000000000000
RG15 15 0 1000000000000
RG16 16 0 1000000000000
VS0 9 s0 0
C0 s0 3 22e-6
VS1 10 s1 0
L1 s1 15 56e-4
VS2 10 s2 0
L2 s2 3 68e-5
VS3 11 s3 0
C3 s3 2 68e-4
VS4 2 s4 0
C4 s4 10 82e-5
VS5 15 s5 0
R5 s5 13 15e-2
VS6 10 s6 0
R6 s6 5 56e0
VS7 12 s7 0
L7 s7 13 18e-5
VS8 10 s8 0
C8 s8 15 82e-6
VS9 16 s9 0
R9 s9 1 27e0
VS10 3 s10 0
L10 s10 1 27e-4
VS11 14 s11 0
R11 s11 8 39e2
VS12 7 s12 0
R12 s12 8 15e3
VS13 4 s13 0
C13 s13 1 39e-6
VS14 0 s14 0
R14 s14 2 15e-1
VS15 2 s15 0
L15 s15 12 22e-3
VS16 14 s16 0
R16 s16 7 27e0
VS17 13 s17 0
R17 s17 16 10e-2
VS18 3 s18 0
C18 s18 14 22e-7
VS19 14 s19 0
L19 s19 13 39e-3
VS20 9 s20 0
C20 s20 2 10e-6
VS21 16 s21 0
C21 s21 5 82e-5
VS22 1 s22 0
L22 s22 6 22e-3
VS23 0 s23 0
C23 s23 6 12e-5
VS24 13 s24 0
L24 s24 4 82e-5
VS25 10 s25 0
R25 s25 11 22e-1
VS26 2 s26 0
L26 s26 10 27e-3
VS27 9 s27 0
L27 s27 2 56e-4
VS28 0 s28 0
V28 e28 s28 DC 0 AC 10e-1 -120
RI28 e28 16 33e-3
VS29 8 s29 0
C29 s29 13 82e-4
VS30 5 s30 0
L30 s30 3 18e-4
VS31 3 s31 0
R31 s31 2 22e1
VS32 13 s32 0
L32 s32 2 82e-3
VS33 8 s33 0
R33 s33 0 68e-1
VS34 0 s34 0
C34 s34 3 82e-7
.control
set numdgt=17
ac lin 1 60 60
print v(1) v(2) v(3) v(4) v(5) v(6) v(7) v(8) v(9) v(10)
print v(11) v(12) v(13) v(14) v(15) v(16)
print i(vs0) i(vs1) i(vs2) i(vs3) i(vs4) i(vs5) i(vs6) i(vs7) i(vs8) i(vs9)
print i(vs10) i(vs11) i(vs12) i(vs13) i(vs14) i(vs15) i(vs16) i(vs17) i(vs18) i(vs19)
print i(vs20) i(vs21) i(vs22) i(vs23) i(vs24) i(vs25) i(vs26) i(vs27) i(vs28) i(vs29)
print i(vs30) i(vs31) i(vs32) i(vs33) i(vs34)
.endc
.end
