controls oracle ac-0460
* Generated (plan F2.7, ADR 0012): do not edit; regenerate with `pnpm sim oracle regen`. ac seed 20261031 index 460 nodes 17 elements 35
.options sparse gmin=1e-12 noopac
RG1 1 0 1000000000000
RG2 2 0 1000000000000
RG3 3 0 1000000000000
RG4 4 0 1000000000000
RG5 5 0 1000000000000
RG6 6 0 1000000000000
RG7 7 0 1000000000000
RG8 8 0 1000000000000
RG9 9 0 1000000000000
RG10 10 0 1000000000000
RG11 11 0 1000000000000
RG12 12 0 1000000000000
RG13 13 0 1000000000000
RG14 14 0 1000000000000
RG15 15 0 1000000000000
RG16 16 0 1000000000000
VS0 3 s0 0
R0 s0 2 22e1
VS1 0 s1 0
R1 s1 2 15e-1
VS2 14 s2 0
L2 s2 13 39e-3
VS3 0 s3 0
C3 s3 6 12e-5
VS4 7 s4 0
R4 s4 8 15e3
VS5 9 s5 0
L5 s5 2 56e-4
VS6 0 s6 0
V6 e6 s6 DC 0 AC 10e-1 -120
RI6 e6 16 33e-3
VS7 9 s7 0
C7 s7 2 10e-6
VS8 8 s8 0
R8 s8 0 68e-1
VS9 16 s9 0
R9 s9 1 27e0
VS10 13 s10 0
L10 s10 2 82e-3
VS11 5 s11 0
L11 s11 3 18e-4
VS12 7 s12 0
C12 s12 16 15e-4
VS13 3 s13 0
C13 s13 14 22e-7
VS14 10 s14 0
L14 s14 15 56e-4
VS15 4 s15 0
L15 s15 15 22e-3
VS16 8 s16 0
C16 s16 13 82e-4
VS17 4 s17 0
C17 s17 1 39e-6
VS18 15 s18 0
R18 s18 13 15e-2
VS19 2 s19 0
C19 s19 10 82e-5
VS20 2 s20 0
C20 s20 11 39e-4
VS21 14 s21 0
R21 s21 8 39e2
VS22 2 s22 0
L22 s22 10 27e-3
VS23 13 s23 0
R23 s23 16 10e-2
VS24 12 s24 0
L24 s24 13 18e-5
VS25 1 s25 0
L25 s25 6 22e-3
VS26 0 s26 0
C26 s26 3 82e-7
VS27 3 s27 0
L27 s27 1 27e-4
VS28 10 s28 0
C28 s28 15 82e-6
VS29 10 s29 0
R29 s29 11 22e-1
VS30 10 s30 0
L30 s30 3 68e-5
VS31 5 s31 0
L31 s31 9 12e-3
VS32 16 s32 0
C32 s32 5 82e-5
VS33 2 s33 0
L33 s33 12 22e-3
VS34 10 s34 0
R34 s34 5 56e0
.control
set numdgt=17
ac lin 1 60 60
print v(1) v(2) v(3) v(4) v(5) v(6) v(7) v(8) v(9) v(10)
print v(11) v(12) v(13) v(14) v(15) v(16)
print i(vs0) i(vs1) i(vs2) i(vs3) i(vs4) i(vs5) i(vs6) i(vs7) i(vs8) i(vs9)
print i(vs10) i(vs11) i(vs12) i(vs13) i(vs14) i(vs15) i(vs16) i(vs17) i(vs18) i(vs19)
print i(vs20) i(vs21) i(vs22) i(vs23) i(vs24) i(vs25) i(vs26) i(vs27) i(vs28) i(vs29)
print i(vs30) i(vs31) i(vs32) i(vs33) i(vs34)
.endc
.end
