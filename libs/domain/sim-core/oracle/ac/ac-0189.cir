controls oracle ac-0189
* Generated (plan F2.7, ADR 0012): do not edit; regenerate with `pnpm sim oracle regen`. ac seed 20261031 index 189 nodes 19 elements 36
.options sparse gmin=1e-12 noopac
RG1 1 0 1000000000000
RG2 2 0 1000000000000
RG3 3 0 1000000000000
RG4 4 0 1000000000000
RG5 5 0 1000000000000
RG6 6 0 1000000000000
RG7 7 0 1000000000000
RG8 8 0 1000000000000
RG9 9 0 1000000000000
RG10 10 0 1000000000000
RG11 11 0 1000000000000
RG12 12 0 1000000000000
RG13 13 0 1000000000000
RG14 14 0 1000000000000
RG15 15 0 1000000000000
RG16 16 0 1000000000000
RG17 17 0 1000000000000
RG18 18 0 1000000000000
VS0 5 s0 0
L0 s0 15 15e-5
VS1 5 s1 0
C1 s1 7 15e-4
VS2 8 s2 0
R2 s2 16 56e1
VS3 2 s3 0
R3 s3 0 22e2
VS4 1 s4 0
R4 s4 4 15e-2
VS5 7 s5 0
R5 s5 8 47e-2
VS6 8 s6 0
L6 s6 3 68e-5
VS7 6 s7 0
R7 s7 14 10e0
VS8 4 s8 0
R8 s8 10 47e0
VS9 0 s9 0
V9 e9 s9 DC 0 AC 47e1 180
RI9 e9 m9 68e-2
LI9 m9 n9 12e-6
H9 n9 h9 VS14 18e-3
ED9 h9 1 d9 0 22e-5
F9 0 d9 VS14 1
LD9 d9 0 1
VS10 5 s10 0
L10 s10 12 33e-5
VS11 17 s11 0
R11 s11 5 82e0
VS12 0 s12 0
C12 s12 13 12e-5
VS13 6 s13 0
L13 s13 7 12e-4
VS14 3 s14 0
V14 e14 s14 DC 0 AC 22e0 -120
RI14 e14 n14 47e-1
H14 n14 h14 VS9 18e-3
ED14 h14 1 d14 0 22e-5
F14 0 d14 VS9 1
LD14 d14 0 1
VS15 12 s15 0
R15 s15 18 56e1
VS16 11 s16 0
L16 s16 1 27e-2
VS17 1 s17 0
L17 s17 9 82e-5
VS18 12 s18 0
L18 s18 1 39e-3
VS19 2 s19 0
C19 s19 9 47e-5
VS20 18 s20 0
R20 s20 3 18e1
VS21 5 s21 0
V21 e21 s21 DC 0 AC 39e0 0
RI21 e21 14 12e-3
VS22 7 s22 0
C22 s22 10 39e-4
VS23 18 s23 0
L23 s23 15 39e-4
VS24 9 s24 0
R24 s24 13 22e-2
VS25 2 s25 0
C25 s25 7 33e-7
VS26 7 s26 0
L26 s26 3 39e-5
VS27 18 s27 0
L27 s27 9 33e-2
VS28 11 s28 0
R28 s28 3 68e0
VS29 1 s29 0
C29 s29 0 18e-7
VS30 16 s30 0
L30 s30 2 47e-2
VS31 4 s31 0
L31 s31 2 10e-5
VS32 17 s32 0
R32 s32 9 22e0
VS33 5 s33 0
C33 s33 8 27e-4
VS34 14 s34 0
V34 e34 s34 DC 0 AC 27e0 -120
RI34 e34 13 39e-2
VS35 5 s35 0
L35 s35 13 27e-4
.control
set numdgt=17
ac lin 1 60 60
print v(1) v(2) v(3) v(4) v(5) v(6) v(7) v(8) v(9) v(10)
print v(11) v(12) v(13) v(14) v(15) v(16) v(17) v(18)
print i(vs0) i(vs1) i(vs2) i(vs3) i(vs4) i(vs5) i(vs6) i(vs7) i(vs8) i(vs9)
print i(vs10) i(vs11) i(vs12) i(vs13) i(vs14) i(vs15) i(vs16) i(vs17) i(vs18) i(vs19)
print i(vs20) i(vs21) i(vs22) i(vs23) i(vs24) i(vs25) i(vs26) i(vs27) i(vs28) i(vs29)
print i(vs30) i(vs31) i(vs32) i(vs33) i(vs34) i(vs35)
.endc
.end
