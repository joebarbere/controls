controls oracle ac-0189
* Generated (plan F2.7, ADR 0012): do not edit; regenerate with `pnpm sim oracle regen`. ac seed 20261031 index 189 nodes 19 elements 33
.options sparse gmin=1e-12 noopac
RG1 1 0 1000000000000
RG2 2 0 1000000000000
RG3 3 0 1000000000000
RG4 4 0 1000000000000
RG5 5 0 1000000000000
RG6 6 0 1000000000000
RG7 7 0 1000000000000
RG8 8 0 1000000000000
RG9 9 0 1000000000000
RG10 10 0 1000000000000
RG11 11 0 1000000000000
RG12 12 0 1000000000000
RG13 13 0 1000000000000
RG14 14 0 1000000000000
RG15 15 0 1000000000000
RG16 16 0 1000000000000
RG17 17 0 1000000000000
RG18 18 0 1000000000000
VS0 14 s0 0
L0 s0 3 68e-5
VS1 18 s1 0
L1 s1 15 39e-4
VS2 14 s2 0
R2 s2 16 56e1
VS3 5 s3 0
L3 s3 12 33e-5
VS4 7 s4 0
C4 s4 10 39e-4
VS5 12 s5 0
L5 s5 1 39e-3
VS6 0 s6 0
V6 e6 s6 DC 0 AC 27e0 -120
RI6 e6 13 39e-2
VS7 8 s7 0
C7 s7 13 12e-5
VS8 5 s8 0
V8 e8 s8 DC 0 AC 39e0 0
RI8 e8 0 12e-3
VS9 3 s9 0
V9 e9 s9 DC 0 AC 22e0 -120
RI9 e9 1 47e-1
VS10 16 s10 0
L10 s10 2 47e-2
VS11 17 s11 0
R11 s11 9 22e0
VS12 2 s12 0
C12 s12 9 47e-5
VS13 2 s13 0
R13 s13 8 22e2
VS14 18 s14 0
R14 s14 3 18e1
VS15 17 s15 0
R15 s15 5 82e0
VS16 5 s16 0
L16 s16 15 15e-5
VS17 11 s17 0
R17 s17 3 68e0
VS18 12 s18 0
R18 s18 18 56e1
VS19 9 s19 0
R19 s19 13 22e-2
VS20 1 s20 0
L20 s20 9 82e-5
VS21 7 s21 0
R21 s21 14 47e-2
VS22 2 s22 0
C22 s22 7 33e-7
VS23 7 s23 0
L23 s23 3 39e-5
VS24 5 s24 0
C24 s24 14 27e-4
VS25 4 s25 0
L25 s25 2 10e-5
VS26 8 s26 0
V26 e26 s26 DC 0 AC 47e1 180
RI26 e26 1 68e-2
VS27 5 s27 0
C27 s27 7 15e-4
VS28 11 s28 0
L28 s28 1 27e-2
VS29 6 s29 0
L29 s29 7 12e-4
VS30 1 s30 0
C30 s30 8 18e-7
VS31 5 s31 0
L31 s31 13 27e-4
VS32 18 s32 0
L32 s32 9 33e-2
.control
set numdgt=17
ac lin 1 60 60
print v(1) v(2) v(3) v(4) v(5) v(6) v(7) v(8) v(9) v(10)
print v(11) v(12) v(13) v(14) v(15) v(16) v(17) v(18)
print i(vs0) i(vs1) i(vs2) i(vs3) i(vs4) i(vs5) i(vs6) i(vs7) i(vs8) i(vs9)
print i(vs10) i(vs11) i(vs12) i(vs13) i(vs14) i(vs15) i(vs16) i(vs17) i(vs18) i(vs19)
print i(vs20) i(vs21) i(vs22) i(vs23) i(vs24) i(vs25) i(vs26) i(vs27) i(vs28) i(vs29)
print i(vs30) i(vs31) i(vs32)
.endc
.end
