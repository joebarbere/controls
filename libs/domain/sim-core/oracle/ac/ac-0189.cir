controls oracle ac-0189
* Generated (plan F2.7, ADR 0012): do not edit; regenerate with `pnpm sim oracle regen`. ac seed 20261031 index 189 nodes 19 elements 36
.options sparse gmin=1e-12 noopac
RG1 1 0 1000000000000
RG2 2 0 1000000000000
RG3 3 0 1000000000000
RG4 4 0 1000000000000
RG5 5 0 1000000000000
RG6 6 0 1000000000000
RG7 7 0 1000000000000
RG8 8 0 1000000000000
RG9 9 0 1000000000000
RG10 10 0 1000000000000
RG11 11 0 1000000000000
RG12 12 0 1000000000000
RG13 13 0 1000000000000
RG14 14 0 1000000000000
RG15 15 0 1000000000000
RG16 16 0 1000000000000
RG17 17 0 1000000000000
RG18 18 0 1000000000000
VS0 18 s0 0
L0 s0 3 68e-5
VS1 5 s1 0
L1 s1 15 15e-5
VS2 17 s2 0
R2 s2 11 12e0
VS3 14 s3 0
R3 s3 12 47e-2
VS4 0 s4 0
V4 e4 s4 DC 0 AC 39e-1 0
RI4 e4 14 15e-3
VS5 18 s5 0
R5 s5 3 18e1
VS6 14 s6 0
R6 s6 3 39e0
VS7 7 s7 0
R7 s7 11 47e-2
VS8 10 s8 0
R8 s8 6 39e-1
VS9 5 s9 0
L9 s9 13 27e-4
VS10 4 s10 0
L10 s10 2 10e-5
VS11 16 s11 0
C11 s11 5 27e-6
VS12 8 s12 0
L12 s12 7 68e-4
VS13 18 s13 0
L13 s13 15 39e-4
VS14 6 s14 0
L14 s14 7 12e-4
VS15 16 s15 0
L15 s15 2 47e-2
VS16 2 s16 0
C16 s16 7 33e-7
VS17 0 s17 0
R17 s17 3 68e0
VS18 5 s18 0
L18 s18 12 33e-5
VS19 8 s19 0
V19 e19 s19 DC 0 AC 47e1 180
RI19 e19 m19 68e-2
LI19 m19 1 47e-7
VS20 18 s20 0
R20 s20 2 27e3
VS21 17 s21 0
R21 s21 9 22e0
VS22 3 s22 0
V22 e22 s22 DC 0 AC 22e0 -120
RI22 e22 1 47e-1
VS23 4 s23 0
L23 s23 11 39e-4
VS24 5 s24 0
C24 s24 7 15e-4
VS25 12 s25 0
L25 s25 1 39e-3
VS26 2 s26 0
C26 s26 9 47e-5
VS27 13 s27 0
V27 e27 s27 DC 0 AC 56e1 180
RI27 e27 m27 18e-1
LI27 m27 12 22e-6
VS28 1 s28 0
C28 s28 8 18e-7
VS29 2 s29 0
R29 s29 10 82e3
VS30 7 s30 0
L30 s30 3 39e-5
VS31 6 s31 0
L31 s31 17 33e-2
VS32 5 s32 0
C32 s32 11 27e-4
VS33 0 s33 0
R33 s33 3 18e3
VS34 9 s34 0
C34 s34 5 33e-4
VS35 2 s35 0
R35 s35 8 22e2
.control
set numdgt=17
ac lin 1 60 60
print v(1) v(2) v(3) v(4) v(5) v(6) v(7) v(8) v(9) v(10)
print v(11) v(12) v(13) v(14) v(15) v(16) v(17) v(18)
print i(vs0) i(vs1) i(vs2) i(vs3) i(vs4) i(vs5) i(vs6) i(vs7) i(vs8) i(vs9)
print i(vs10) i(vs11) i(vs12) i(vs13) i(vs14) i(vs15) i(vs16) i(vs17) i(vs18) i(vs19)
print i(vs20) i(vs21) i(vs22) i(vs23) i(vs24) i(vs25) i(vs26) i(vs27) i(vs28) i(vs29)
print i(vs30) i(vs31) i(vs32) i(vs33) i(vs34) i(vs35)
.endc
.end
