controls oracle ac-0022
* Generated (plan F2.7, ADR 0012): do not edit; regenerate with `pnpm sim oracle regen`. ac seed 20261031 index 22 nodes 13 elements 14
.options sparse gmin=1e-12 noopac
RG1 1 0 1000000000000
RG2 2 0 1000000000000
RG3 3 0 1000000000000
RG4 4 0 1000000000000
RG5 5 0 1000000000000
RG6 6 0 1000000000000
RG7 7 0 1000000000000
RG8 8 0 1000000000000
RG9 9 0 1000000000000
RG10 10 0 1000000000000
RG11 11 0 1000000000000
RG12 12 0 1000000000000
VS0 0 s0 0
L0 s0 11 27e-3
VS1 4 s1 0
C1 s1 8 82e-6
VS2 5 s2 0
C2 s2 12 68e-6
VS3 6 s3 0
C3 s3 12 82e-5
VS4 8 s4 0
R4 s4 1 56e0
VS5 9 s5 0
R5 s5 1 33e3
VS6 10 s6 0
R6 s6 12 18e0
VS7 0 s7 0
V7 e7 s7 DC 0 AC 12e0 180
RI7 e7 9 56e-1
VS8 12 s8 0
V8 e8 s8 DC 0 AC 33e1 0
RI8 e8 2 22e-2
VS9 3 s9 0
V9 e9 s9 DC 0 AC 47e1 -120
RI9 e9 0 18e-2
VS10 4 s10 0
V10 e10 s10 DC 0 AC 10e1 180
RI10 e10 12 15e-3
VS11 11 s11 0
R11 s11 5 18e0
VS12 2 s12 0
L12 s12 7 33e-5
VS13 0 s13 0
R13 s13 6 68e0
.control
set numdgt=17
ac lin 1 60 60
print v(1) v(2) v(3) v(4) v(5) v(6) v(7) v(8) v(9) v(10)
print v(11) v(12)
print i(vs0) i(vs1) i(vs2) i(vs3) i(vs4) i(vs5) i(vs6) i(vs7) i(vs8) i(vs9)
print i(vs10) i(vs11) i(vs12) i(vs13)
.endc
.end
