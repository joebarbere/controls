controls oracle ac-0022
* Generated (plan F2.7, ADR 0012): do not edit; regenerate with `pnpm sim oracle regen`. ac seed 20261031 index 22 nodes 13 elements 17
.options sparse gmin=1e-12 noopac
RG1 1 0 1000000000000
RG2 2 0 1000000000000
RG3 3 0 1000000000000
RG4 4 0 1000000000000
RG5 5 0 1000000000000
RG6 6 0 1000000000000
RG7 7 0 1000000000000
RG8 8 0 1000000000000
RG9 9 0 1000000000000
RG10 10 0 1000000000000
RG11 11 0 1000000000000
RG12 12 0 1000000000000
VS0 6 s0 0
L0 s0 11 27e-3
VS1 9 s1 0
R1 s1 1 33e3
VS2 11 s2 0
R2 s2 5 18e0
VS3 0 s3 0
V3 e3 s3 DC 0 AC 39e-1 -120
RI3 e3 3 12e-1
VS4 5 s4 0
C4 s4 12 68e-6
VS5 11 s5 0
L5 s5 10 10e-2
VS6 12 s6 0
V6 e6 s6 DC 0 AC 33e1 0
RI6 e6 2 22e-2
VS7 6 s7 0
V7 e7 s7 DC 0 AC 12e0 180
RI7 e7 9 56e-1
VS8 8 s8 0
R8 s8 1 56e0
VS9 2 s9 0
L9 s9 0 33e-5
VS10 3 s10 0
V10 e10 s10 DC 0 AC 47e1 -120
RI10 e10 6 18e-2
VS11 4 s11 0
C11 s11 8 82e-6
VS12 10 s12 0
R12 s12 12 18e0
VS13 6 s13 0
R13 s13 7 68e0
VS14 4 s14 0
V14 e14 s14 DC 0 AC 10e1 180
RI14 e14 12 15e-3
VS15 3 s15 0
R15 s15 8 10e1
VS16 7 s16 0
C16 s16 12 82e-5
.control
set numdgt=17
ac lin 1 60 60
print v(1) v(2) v(3) v(4) v(5) v(6) v(7) v(8) v(9) v(10)
print v(11) v(12)
print i(vs0) i(vs1) i(vs2) i(vs3) i(vs4) i(vs5) i(vs6) i(vs7) i(vs8) i(vs9)
print i(vs10) i(vs11) i(vs12) i(vs13) i(vs14) i(vs15) i(vs16)
.endc
.end
