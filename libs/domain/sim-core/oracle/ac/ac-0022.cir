controls oracle ac-0022
* Generated (plan F2.7, ADR 0012): do not edit; regenerate with `pnpm sim oracle regen`. ac seed 20261031 index 22 nodes 13 elements 19
.options sparse gmin=1e-12 noopac
RG1 1 0 1000000000000
RG2 2 0 1000000000000
RG3 3 0 1000000000000
RG4 4 0 1000000000000
RG5 5 0 1000000000000
RG6 6 0 1000000000000
RG7 7 0 1000000000000
RG8 8 0 1000000000000
RG9 9 0 1000000000000
RG10 10 0 1000000000000
RG11 11 0 1000000000000
RG12 12 0 1000000000000
VS0 0 s0 0
V0 e0 s0 DC 0 AC 33e1 0
RI0 e0 2 22e-2
VS1 12 s1 0
C1 s1 7 56e-7
VS2 9 s2 0
R2 s2 5 56e0
VS3 6 s3 0
R3 s3 12 68e0
VS4 3 s4 0
C4 s4 6 22e-4
VS5 4 s5 0
C5 s5 8 82e-6
VS6 12 s6 0
C6 s6 0 82e-5
VS7 11 s7 0
R7 s7 5 18e0
VS8 10 s8 0
R8 s8 0 18e0
VS9 5 s9 0
L9 s9 9 18e-2
VS10 11 s10 0
R10 s10 7 10e-2
VS11 12 s11 0
V11 e11 s11 DC 0 AC 10e-1 0
RI11 e11 2 82e-2
VS12 1 s12 0
R12 s12 2 82e0
VS13 10 s13 0
R13 s13 11 68e2
VS14 0 s14 0
V14 e14 s14 DC 0 AC 33e-1 180
RI14 e14 1 15e-2
VS15 8 s15 0
R15 s15 3 82e3
VS16 4 s16 0
V16 e16 s16 DC 0 AC 10e1 180
RI16 e16 m16 15e-3
LI16 m16 0 47e-6
VS17 9 s17 0
R17 s17 1 33e3
VS18 5 s18 0
C18 s18 0 68e-6
.control
set numdgt=17
ac lin 1 60 60
print v(1) v(2) v(3) v(4) v(5) v(6) v(7) v(8) v(9) v(10)
print v(11) v(12)
print i(vs0) i(vs1) i(vs2) i(vs3) i(vs4) i(vs5) i(vs6) i(vs7) i(vs8) i(vs9)
print i(vs10) i(vs11) i(vs12) i(vs13) i(vs14) i(vs15) i(vs16) i(vs17) i(vs18)
.endc
.end
