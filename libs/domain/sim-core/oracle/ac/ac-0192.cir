controls oracle ac-0192
* Generated (plan F2.7, ADR 0012): do not edit; regenerate with `pnpm sim oracle regen`. ac seed 20261031 index 192 nodes 9 elements 11
.options sparse gmin=1e-12 noopac
RG1 1 0 1000000000000
RG2 2 0 1000000000000
RG3 3 0 1000000000000
RG4 4 0 1000000000000
RG5 5 0 1000000000000
RG6 6 0 1000000000000
RG7 7 0 1000000000000
RG8 8 0 1000000000000
VS0 5 s0 0
C0 s0 7 68e-5
VS1 0 s1 0
R1 s1 2 82e-1
VS2 5 s2 0
C2 s2 1 12e-5
VS3 4 s3 0
R3 s3 1 22e2
VS4 8 s4 0
C4 s4 0 56e-6
VS5 0 s5 0
V5 e5 s5 DC 0 AC 39e1 -120
RI5 e5 4 15e-1
VS6 7 s6 0
R6 s6 6 22e3
VS7 8 s7 0
R7 s7 0 47e-2
VS8 6 s8 0
R8 s8 2 12e-1
VS9 7 s9 0
V9 e9 s9 DC 0 AC 47e-1 120
RI9 e9 1 22e-2
VS10 3 s10 0
L10 s10 6 12e-3
.control
set numdgt=17
ac lin 1 60 60
print v(1) v(2) v(3) v(4) v(5) v(6) v(7) v(8)
print i(vs0) i(vs1) i(vs2) i(vs3) i(vs4) i(vs5) i(vs6) i(vs7) i(vs8) i(vs9)
print i(vs10)
.endc
.end
