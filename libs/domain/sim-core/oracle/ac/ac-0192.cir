controls oracle ac-0192
* Generated (plan F2.7, ADR 0012): do not edit; regenerate with `pnpm sim oracle regen`. ac seed 20261031 index 192 nodes 9 elements 13
.options sparse gmin=1e-12 noopac
RG1 1 0 1000000000000
RG2 2 0 1000000000000
RG3 3 0 1000000000000
RG4 4 0 1000000000000
RG5 5 0 1000000000000
RG6 6 0 1000000000000
RG7 7 0 1000000000000
RG8 8 0 1000000000000
VS0 8 s0 0
L0 s0 4 39e-5
VS1 6 s1 0
R1 s1 2 12e-1
VS2 0 s2 0
R2 s2 2 82e-1
VS3 8 s3 0
R3 s3 0 47e-2
VS4 0 s4 0
V4 e4 s4 DC 0 AC 39e1 -120
RI4 e4 4 15e-1
VS5 8 s5 0
C5 s5 0 56e-6
VS6 7 s6 0
C6 s6 3 22e-6
VS7 5 s7 0
C7 s7 1 12e-5
VS8 3 s8 0
L8 s8 6 12e-3
VS9 7 s9 0
R9 s9 6 22e3
VS10 7 s10 0
V10 e10 s10 DC 0 AC 47e-1 120
RI10 e10 m10 22e-2
LI10 m10 1 12e-5
VS11 4 s11 0
R11 s11 1 22e2
VS12 5 s12 0
C12 s12 7 68e-5
.control
set numdgt=17
ac lin 1 60 60
print v(1) v(2) v(3) v(4) v(5) v(6) v(7) v(8)
print i(vs0) i(vs1) i(vs2) i(vs3) i(vs4) i(vs5) i(vs6) i(vs7) i(vs8) i(vs9)
print i(vs10) i(vs11) i(vs12)
.endc
.end
