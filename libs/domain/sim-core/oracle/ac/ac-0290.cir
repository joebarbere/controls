controls oracle ac-0290
* Generated (plan F2.7, ADR 0012): do not edit; regenerate with `pnpm sim oracle regen`. ac seed 20261031 index 290 nodes 17 elements 24
.options sparse gmin=1e-12 noopac
RG1 1 0 1000000000000
RG2 2 0 1000000000000
RG3 3 0 1000000000000
RG4 4 0 1000000000000
RG5 5 0 1000000000000
RG6 6 0 1000000000000
RG7 7 0 1000000000000
RG8 8 0 1000000000000
RG9 9 0 1000000000000
RG10 10 0 1000000000000
RG11 11 0 1000000000000
RG12 12 0 1000000000000
RG13 13 0 1000000000000
RG14 14 0 1000000000000
RG15 15 0 1000000000000
RG16 16 0 1000000000000
VS0 14 s0 0
R0 s0 6 68e-1
VS1 7 s1 0
L1 s1 11 56e-3
VS2 11 s2 0
R2 s2 6 82e-1
VS3 14 s3 0
L3 s3 0 15e-4
VS4 0 s4 0
V4 e4 s4 DC 0 AC 22e1 -120
RI4 e4 m4 12e-3
LI4 m4 5 47e-5
VS5 3 s5 0
C5 s5 8 47e-4
VS6 13 s6 0
L6 s6 6 18e-4
VS7 14 s7 0
R7 s7 1 15e-2
VS8 6 s8 0
C8 s8 5 22e-7
VS9 13 s9 0
L9 s9 2 56e-4
VS10 7 s10 0
L10 s10 0 27e-4
VS11 5 s11 0
R11 s11 16 22e0
VS12 8 s12 0
L12 s12 15 47e-4
VS13 16 s13 0
R13 s13 6 12e0
VS14 4 s14 0
R14 s14 10 22e0
VS15 12 s15 0
R15 s15 14 22e2
VS16 13 s16 0
L16 s16 12 56e-5
VS17 6 s17 0
V17 e17 s17 DC 0 AC 47e0 120
RI17 e17 m17 27e-3
LI17 m17 9 82e-6
VS18 14 s18 0
R18 s18 10 47e-2
VS19 4 s19 0
V19 e19 s19 DC 0 AC 68e-1 120
RI19 e19 15 33e-2
VS20 13 s20 0
V20 e20 s20 DC 0 AC 18e-1 120
RI20 e20 9 10e-1
VS21 3 s21 0
L21 s21 2 56e-3
VS22 1 s22 0
R22 s22 6 56e3
VS23 0 s23 0
L23 s23 2 68e-2
.control
set numdgt=17
ac lin 1 60 60
print v(1) v(2) v(3) v(4) v(5) v(6) v(7) v(8) v(9) v(10)
print v(11) v(12) v(13) v(14) v(15) v(16)
print i(vs0) i(vs1) i(vs2) i(vs3) i(vs4) i(vs5) i(vs6) i(vs7) i(vs8) i(vs9)
print i(vs10) i(vs11) i(vs12) i(vs13) i(vs14) i(vs15) i(vs16) i(vs17) i(vs18) i(vs19)
print i(vs20) i(vs21) i(vs22) i(vs23)
.endc
.end
