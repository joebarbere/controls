controls oracle ac-0290
* Generated (plan F2.7, ADR 0012): do not edit; regenerate with `pnpm sim oracle regen`. ac seed 20261031 index 290 nodes 17 elements 25
.options sparse gmin=1e-12 noopac
RG1 1 0 1000000000000
RG2 2 0 1000000000000
RG3 3 0 1000000000000
RG4 4 0 1000000000000
RG5 5 0 1000000000000
RG6 6 0 1000000000000
RG7 7 0 1000000000000
RG8 8 0 1000000000000
RG9 9 0 1000000000000
RG10 10 0 1000000000000
RG11 11 0 1000000000000
RG12 12 0 1000000000000
RG13 13 0 1000000000000
RG14 14 0 1000000000000
RG15 15 0 1000000000000
RG16 16 0 1000000000000
VS0 0 s0 0
V0 e0 s0 DC 0 AC 68e-1 120
RI0 e0 15 33e-2
VS1 9 s1 0
R1 s1 3 22e3
VS2 14 s2 0
R2 s2 6 68e-1
VS3 14 s3 0
R3 s3 1 15e-2
VS4 16 s4 0
R4 s4 12 10e-1
VS5 14 s5 0
R5 s5 10 47e-2
VS6 9 s6 0
L6 s6 16 10e-2
VS7 2 s7 0
R7 s7 5 10e0
VS8 15 s8 0
V8 e8 s8 DC 0 AC 15e0 180
RI8 e8 8 33e-2
VS9 8 s9 0
L9 s9 10 39e-2
VS10 10 s10 0
R10 s10 2 27e-1
VS11 12 s11 0
R11 s11 4 22e0
VS12 3 s12 0
C12 s12 6 10e-6
VS13 5 s13 0
C13 s13 0 82e-6
VS14 0 s14 0
R14 s14 13 22e-1
VS15 7 s15 0
R15 s15 10 68e2
VS16 14 s16 0
L16 s16 12 15e-4
VS17 11 s17 0
C17 s17 7 12e-6
VS18 1 s18 0
R18 s18 7 47e-2
VS19 0 s19 0
R19 s19 10 22e0
VS20 14 s20 0
R20 s20 11 27e3
VS21 5 s21 0
L21 s21 6 47e-5
VS22 11 s22 0
V22 e22 s22 DC 0 AC 18e-1 120
RI22 e22 16 10e-1
VS23 8 s23 0
C23 s23 14 39e-7
VS24 4 s24 0
R24 s24 14 22e2
.control
set numdgt=17
ac lin 1 60 60
print v(1) v(2) v(3) v(4) v(5) v(6) v(7) v(8) v(9) v(10)
print v(11) v(12) v(13) v(14) v(15) v(16)
print i(vs0) i(vs1) i(vs2) i(vs3) i(vs4) i(vs5) i(vs6) i(vs7) i(vs8) i(vs9)
print i(vs10) i(vs11) i(vs12) i(vs13) i(vs14) i(vs15) i(vs16) i(vs17) i(vs18) i(vs19)
print i(vs20) i(vs21) i(vs22) i(vs23) i(vs24)
.endc
.end
