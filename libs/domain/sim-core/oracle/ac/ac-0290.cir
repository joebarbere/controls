controls oracle ac-0290
* Generated (plan F2.7, ADR 0012): do not edit; regenerate with `pnpm sim oracle regen`. ac seed 20261031 index 290 nodes 17 elements 26
.options sparse gmin=1e-12 noopac
RG1 1 0 1000000000000
RG2 2 0 1000000000000
RG3 3 0 1000000000000
RG4 4 0 1000000000000
RG5 5 0 1000000000000
RG6 6 0 1000000000000
RG7 7 0 1000000000000
RG8 8 0 1000000000000
RG9 9 0 1000000000000
RG10 10 0 1000000000000
RG11 11 0 1000000000000
RG12 12 0 1000000000000
RG13 13 0 1000000000000
RG14 14 0 1000000000000
RG15 15 0 1000000000000
RG16 16 0 1000000000000
VS0 14 s0 0
R0 s0 0 27e3
VS1 8 s1 0
C1 s1 14 39e-7
VS2 14 s2 0
R2 s2 1 15e-2
VS3 0 s3 0
V3 e3 s3 DC 0 AC 18e-1 120
RI3 e3 16 10e-1
VS4 3 s4 0
C4 s4 6 10e-6
VS5 15 s5 0
V5 e5 s5 DC 0 AC 15e0 180
RI5 e5 8 33e-2
VS6 7 s6 0
R6 s6 10 68e2
VS7 1 s7 0
R7 s7 7 47e-2
VS8 2 s8 0
R8 s8 5 10e0
VS9 12 s9 0
R9 s9 11 22e0
VS10 16 s10 0
R10 s10 12 10e-1
VS11 13 s11 0
L11 s11 0 82e-5
VS12 5 s12 0
C12 s12 4 82e-6
VS13 8 s13 0
L13 s13 10 39e-2
VS14 14 s14 0
L14 s14 12 15e-4
VS15 4 s15 0
V15 e15 s15 DC 0 AC 68e-1 120
RI15 e15 15 33e-2
VS16 9 s16 0
L16 s16 16 10e-2
VS17 14 s17 0
R17 s17 10 47e-2
VS18 4 s18 0
R18 s18 10 22e0
VS19 4 s19 0
R19 s19 13 22e-1
VS20 5 s20 0
L20 s20 6 47e-5
VS21 11 s21 0
R21 s21 14 22e2
VS22 14 s22 0
R22 s22 6 68e-1
VS23 9 s23 0
R23 s23 3 22e3
VS24 0 s24 0
C24 s24 7 12e-6
VS25 10 s25 0
R25 s25 2 27e-1
.control
set numdgt=17
ac lin 1 60 60
print v(1) v(2) v(3) v(4) v(5) v(6) v(7) v(8) v(9) v(10)
print v(11) v(12) v(13) v(14) v(15) v(16)
print i(vs0) i(vs1) i(vs2) i(vs3) i(vs4) i(vs5) i(vs6) i(vs7) i(vs8) i(vs9)
print i(vs10) i(vs11) i(vs12) i(vs13) i(vs14) i(vs15) i(vs16) i(vs17) i(vs18) i(vs19)
print i(vs20) i(vs21) i(vs22) i(vs23) i(vs24) i(vs25)
.endc
.end
