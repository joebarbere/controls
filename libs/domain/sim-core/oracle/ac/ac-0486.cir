controls oracle ac-0486
* Generated (plan F2.7, ADR 0012): do not edit; regenerate with `pnpm sim oracle regen`. ac seed 20261031 index 486 nodes 23 elements 31
.options sparse gmin=1e-12 noopac
RG1 1 0 1000000000000
RG2 2 0 1000000000000
RG3 3 0 1000000000000
RG4 4 0 1000000000000
RG5 5 0 1000000000000
RG6 6 0 1000000000000
RG7 7 0 1000000000000
RG8 8 0 1000000000000
RG9 9 0 1000000000000
RG10 10 0 1000000000000
RG11 11 0 1000000000000
RG12 12 0 1000000000000
RG13 13 0 1000000000000
RG14 14 0 1000000000000
RG15 15 0 1000000000000
RG16 16 0 1000000000000
RG17 17 0 1000000000000
RG18 18 0 1000000000000
RG19 19 0 1000000000000
RG20 20 0 1000000000000
RG21 21 0 1000000000000
RG22 22 0 1000000000000
VS0 3 s0 0
L0 s0 0 10e-2
VS1 11 s1 0
R1 s1 18 15e0
VS2 0 s2 0
V2 e2 s2 DC 0 AC 47e-1 -120
RI2 e2 16 56e-3
VS3 3 s3 0
L3 s3 19 47e-2
VS4 1 s4 0
L4 s4 0 18e-2
VS5 20 s5 0
V5 e5 s5 DC 0 AC 18e-1 120
RI5 e5 15 39e-1
VS6 12 s6 0
R6 s6 7 82e-2
VS7 21 s7 0
L7 s7 10 39e-5
VS8 10 s8 0
V8 e8 s8 DC 0 AC 82e1 120
RI8 e8 8 22e-2
VS9 21 s9 0
R9 s9 20 33e2
VS10 16 s10 0
R10 s10 2 27e1
VS11 21 s11 0
V11 e11 s11 DC 0 AC 33e1 180
RI11 e11 5 68e-2
VS12 4 s12 0
C12 s12 21 39e-7
VS13 3 s13 0
V13 e13 s13 DC 0 AC 56e1 120
RI13 e13 14 39e-3
VS14 21 s14 0
V14 e14 s14 DC 0 AC 56e0 -120
RI14 e14 15 68e-2
VS15 6 s15 0
R15 s15 3 68e0
VS16 7 s16 0
V16 e16 s16 DC 0 AC 22e-1 180
RI16 e16 4 12e-2
VS17 2 s17 0
R17 s17 18 39e3
VS18 21 s18 0
C18 s18 11 22e-7
VS19 21 s19 0
R19 s19 0 47e1
VS20 17 s20 0
V20 e20 s20 DC 0 AC 18e0 180
RI20 e20 12 82e-3
VS21 7 s21 0
R21 s21 1 10e2
VS22 15 s22 0
C22 s22 21 22e-6
VS23 13 s23 0
L23 s23 7 39e-4
VS24 16 s24 0
R24 s24 19 15e3
VS25 22 s25 0
L25 s25 19 39e-2
VS26 18 s26 0
V26 e26 s26 DC 0 AC 68e-1 0
RI26 e26 3 39e-1
VS27 2 s27 0
V27 e27 s27 DC 0 AC 15e0 120
RI27 e27 22 82e-2
VS28 10 s28 0
C28 s28 22 39e-5
VS29 15 s29 0
L29 s29 9 22e-4
VS30 6 s30 0
V30 e30 s30 DC 0 AC 22e1 120
RI30 e30 22 12e-1
.control
set numdgt=17
ac lin 1 60 60
print v(1) v(2) v(3) v(4) v(5) v(6) v(7) v(8) v(9) v(10)
print v(11) v(12) v(13) v(14) v(15) v(16) v(17) v(18) v(19) v(20)
print v(21) v(22)
print i(vs0) i(vs1) i(vs2) i(vs3) i(vs4) i(vs5) i(vs6) i(vs7) i(vs8) i(vs9)
print i(vs10) i(vs11) i(vs12) i(vs13) i(vs14) i(vs15) i(vs16) i(vs17) i(vs18) i(vs19)
print i(vs20) i(vs21) i(vs22) i(vs23) i(vs24) i(vs25) i(vs26) i(vs27) i(vs28) i(vs29)
print i(vs30)
.endc
.end
