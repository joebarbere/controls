controls oracle ac-0486
* Generated (plan F2.7, ADR 0012): do not edit; regenerate with `pnpm sim oracle regen`. ac seed 20261031 index 486 nodes 23 elements 41
.options sparse gmin=1e-12 noopac
RG1 1 0 1000000000000
RG2 2 0 1000000000000
RG3 3 0 1000000000000
RG4 4 0 1000000000000
RG5 5 0 1000000000000
RG6 6 0 1000000000000
RG7 7 0 1000000000000
RG8 8 0 1000000000000
RG9 9 0 1000000000000
RG10 10 0 1000000000000
RG11 11 0 1000000000000
RG12 12 0 1000000000000
RG13 13 0 1000000000000
RG14 14 0 1000000000000
RG15 15 0 1000000000000
RG16 16 0 1000000000000
RG17 17 0 1000000000000
RG18 18 0 1000000000000
RG19 19 0 1000000000000
RG20 20 0 1000000000000
RG21 21 0 1000000000000
RG22 22 0 1000000000000
VS0 14 s0 0
R0 s0 2 56e2
VS1 0 s1 0
V1 e1 s1 DC 0 AC 56e1 120
RI1 e1 8 39e-3
VS2 7 s2 0
V2 e2 s2 DC 0 AC 22e-1 180
RI2 e2 m2 12e-2
LI2 m2 4 10e-7
VS3 9 s3 0
L3 s3 13 18e-5
VS4 8 s4 0
R4 s4 2 68e3
VS5 4 s5 0
R5 s5 0 68e0
VS6 18 s6 0
C6 s6 0 33e-5
VS7 11 s7 0
V7 e7 s7 DC 0 AC 15e0 0
RI7 e7 m7 18e-2
LI7 m7 2 33e-5
VS8 13 s8 0
L8 s8 18 12e-4
VS9 18 s9 0
L9 s9 7 39e-4
VS10 20 s10 0
C10 s10 6 39e-5
VS11 4 s11 0
C11 s11 12 39e-7
VS12 12 s12 0
C12 s12 11 12e-6
VS13 15 s13 0
L13 s13 18 39e-4
VS14 7 s14 0
R14 s14 21 82e3
VS15 3 s15 0
L15 s15 7 15e-2
VS16 9 s16 0
C16 s16 15 39e-6
VS17 20 s17 0
V17 e17 s17 DC 0 AC 33e1 -120
RI17 e17 3 68e-2
VS18 12 s18 0
L18 s18 15 10e-3
VS19 6 s19 0
R19 s19 18 22e3
VS20 17 s20 0
V20 e20 s20 DC 0 AC 82e-1 0
RI20 e20 10 82e-1
VS21 17 s21 0
L21 s21 14 47e-4
VS22 16 s22 0
L22 s22 5 15e-3
VS23 10 s23 0
V23 e23 s23 DC 0 AC 22e0 0
RI23 e23 m23 18e-3
LI23 m23 4 39e-6
VS24 19 s24 0
L24 s24 21 12e-4
VS25 3 s25 0
R25 s25 12 82e-2
VS26 9 s26 0
R26 s26 7 27e0
VS27 15 s27 0
V27 e27 s27 DC 0 AC 68e0 180
RI27 e27 m27 82e-2
LI27 m27 10 82e-7
VS28 5 s28 0
V28 e28 s28 DC 0 AC 27e0 120
RI28 e28 18 22e-1
VS29 0 s29 0
L29 s29 1 22e-2
VS30 9 s30 0
R30 s30 12 12e2
VS31 6 s31 0
L31 s31 20 82e-2
VS32 20 s32 0
L32 s32 15 33e-3
VS33 11 s33 0
C33 s33 22 18e-7
VS34 21 s34 0
V34 e34 s34 DC 0 AC 56e-1 120
RI34 e34 19 47e-1
VS35 16 s35 0
C35 s35 5 10e-5
VS36 19 s36 0
R36 s36 22 39e-1
VS37 0 s37 0
L37 s37 16 10e-3
VS38 15 s38 0
L38 s38 17 47e-3
VS39 1 s39 0
C39 s39 12 22e-7
VS40 15 s40 0
C40 s40 21 18e-6
.control
set numdgt=17
ac lin 1 60 60
print v(1) v(2) v(3) v(4) v(5) v(6) v(7) v(8) v(9) v(10)
print v(11) v(12) v(13) v(14) v(15) v(16) v(17) v(18) v(19) v(20)
print v(21) v(22)
print i(vs0) i(vs1) i(vs2) i(vs3) i(vs4) i(vs5) i(vs6) i(vs7) i(vs8) i(vs9)
print i(vs10) i(vs11) i(vs12) i(vs13) i(vs14) i(vs15) i(vs16) i(vs17) i(vs18) i(vs19)
print i(vs20) i(vs21) i(vs22) i(vs23) i(vs24) i(vs25) i(vs26) i(vs27) i(vs28) i(vs29)
print i(vs30) i(vs31) i(vs32) i(vs33) i(vs34) i(vs35) i(vs36) i(vs37) i(vs38) i(vs39)
print i(vs40)
.endc
.end
