controls oracle ac-0486
* Generated (plan F2.7, ADR 0012): do not edit; regenerate with `pnpm sim oracle regen`. ac seed 20261031 index 486 nodes 23 elements 36
.options sparse gmin=1e-12 noopac
RG1 1 0 1000000000000
RG2 2 0 1000000000000
RG3 3 0 1000000000000
RG4 4 0 1000000000000
RG5 5 0 1000000000000
RG6 6 0 1000000000000
RG7 7 0 1000000000000
RG8 8 0 1000000000000
RG9 9 0 1000000000000
RG10 10 0 1000000000000
RG11 11 0 1000000000000
RG12 12 0 1000000000000
RG13 13 0 1000000000000
RG14 14 0 1000000000000
RG15 15 0 1000000000000
RG16 16 0 1000000000000
RG17 17 0 1000000000000
RG18 18 0 1000000000000
RG19 19 0 1000000000000
RG20 20 0 1000000000000
RG21 21 0 1000000000000
RG22 22 0 1000000000000
VS0 13 s0 0
L0 s0 7 39e-4
VS1 4 s1 0
C1 s1 3 39e-7
VS2 15 s2 0
L2 s2 9 22e-4
VS3 0 s3 0
V3 e3 s3 DC 0 AC 56e1 120
RI3 e3 14 39e-3
VS4 0 s4 0
L4 s4 21 10e-2
VS5 3 s5 0
R5 s5 21 47e1
VS6 16 s6 0
R6 s6 5 12e3
VS7 0 s7 0
L7 s7 19 47e-2
VS8 3 s8 0
R8 s8 20 33e2
VS9 22 s9 0
L9 s9 19 39e-2
VS10 11 s10 0
R10 s10 18 15e0
VS11 6 s11 0
R11 s11 0 68e0
VS12 16 s12 0
R12 s12 19 15e3
VS13 7 s13 0
V13 e13 s13 DC 0 AC 22e-1 180
RI13 e13 m13 12e-2
LI13 m13 4 56e-7
VS14 13 s14 0
V14 e14 s14 DC 0 AC 12e-1 180
RI14 e14 9 22e-1
VS15 17 s15 0
R15 s15 20 56e3
VS16 16 s16 0
R16 s16 2 27e1
VS17 10 s17 0
C17 s17 22 39e-5
VS18 10 s18 0
V18 e18 s18 DC 0 AC 82e1 120
RI18 e18 8 22e-2
VS19 20 s19 0
V19 e19 s19 DC 0 AC 18e-1 120
RI19 e19 15 39e-1
VS20 21 s20 0
V20 e20 s20 DC 0 AC 47e-1 -120
RI20 e20 16 56e-3
VS21 7 s21 0
R21 s21 1 10e2
VS22 3 s22 0
V22 e22 s22 DC 0 AC 56e0 -120
RI22 e22 m22 68e-2
LI22 m22 15 39e-6
VS23 17 s23 0
V23 e23 s23 DC 0 AC 18e0 180
RI23 e23 m23 82e-3
LI23 m23 12 68e-6
VS24 12 s24 0
R24 s24 7 82e-2
VS25 15 s25 0
C25 s25 3 22e-6
VS26 8 s26 0
V26 e26 s26 DC 0 AC 82e-1 -120
RI26 e26 m26 82e-2
LI26 m26 17 82e-6
VS27 3 s27 0
C27 s27 11 22e-7
VS28 3 s28 0
L28 s28 10 39e-5
VS29 18 s29 0
V29 e29 s29 DC 0 AC 68e-1 0
RI29 e29 m29 39e-1
LI29 m29 0 56e-7
VS30 6 s30 0
V30 e30 s30 DC 0 AC 22e1 120
RI30 e30 m30 12e-1
LI30 m30 22 39e-6
VS31 2 s31 0
V31 e31 s31 DC 0 AC 15e0 120
RI31 e31 22 82e-2
VS32 2 s32 0
R32 s32 18 39e3
VS33 10 s33 0
L33 s33 14 47e-2
VS34 1 s34 0
L34 s34 21 18e-2
VS35 3 s35 0
V35 e35 s35 DC 0 AC 33e1 180
RI35 e35 m35 68e-2
LI35 m35 5 27e-5
.control
set numdgt=17
ac lin 1 60 60
print v(1) v(2) v(3) v(4) v(5) v(6) v(7) v(8) v(9) v(10)
print v(11) v(12) v(13) v(14) v(15) v(16) v(17) v(18) v(19) v(20)
print v(21) v(22)
print i(vs0) i(vs1) i(vs2) i(vs3) i(vs4) i(vs5) i(vs6) i(vs7) i(vs8) i(vs9)
print i(vs10) i(vs11) i(vs12) i(vs13) i(vs14) i(vs15) i(vs16) i(vs17) i(vs18) i(vs19)
print i(vs20) i(vs21) i(vs22) i(vs23) i(vs24) i(vs25) i(vs26) i(vs27) i(vs28) i(vs29)
print i(vs30) i(vs31) i(vs32) i(vs33) i(vs34) i(vs35)
.endc
.end
