controls oracle ac-0120
* Generated (plan F2.7, ADR 0012): do not edit; regenerate with `pnpm sim oracle regen`. ac seed 20261031 index 120 nodes 16 elements 16
.options sparse gmin=1e-12 noopac
RG1 1 0 1000000000000
RG2 2 0 1000000000000
RG3 3 0 1000000000000
RG4 4 0 1000000000000
RG5 5 0 1000000000000
RG6 6 0 1000000000000
RG7 7 0 1000000000000
RG8 8 0 1000000000000
RG9 9 0 1000000000000
RG10 10 0 1000000000000
RG11 11 0 1000000000000
RG12 12 0 1000000000000
RG13 13 0 1000000000000
RG14 14 0 1000000000000
RG15 15 0 1000000000000
VS0 12 s0 0
L0 s0 13 68e-2
VS1 3 s1 0
L1 s1 15 27e-2
VS2 4 s2 0
C2 s2 12 12e-4
VS3 12 s3 0
R3 s3 7 12e2
VS4 15 s4 0
L4 s4 1 12e-3
VS5 0 s5 0
C5 s5 6 68e-6
VS6 9 s6 0
L6 s6 0 27e-5
VS7 0 s7 0
V7 e7 s7 DC 0 AC 22e1 -120
RI7 e7 6 15e-1
VS8 5 s8 0
C8 s8 0 12e-7
VS9 1 s9 0
V9 e9 s9 DC 0 AC 47e-1 0
RI9 e9 6 47e-3
VS10 8 s10 0
R10 s10 11 68e2
VS11 2 s11 0
V11 e11 s11 DC 0 AC 15e0 180
RI11 e11 10 27e-1
VS12 2 s12 0
R12 s12 15 15e3
VS13 11 s13 0
R13 s13 6 15e0
VS14 14 s14 0
R14 s14 0 15e3
VS15 12 s15 0
V15 e15 s15 DC 0 AC 39e1 -120
RI15 e15 6 39e-1
.control
set numdgt=17
ac lin 1 60 60
print v(1) v(2) v(3) v(4) v(5) v(6) v(7) v(8) v(9) v(10)
print v(11) v(12) v(13) v(14) v(15)
print i(vs0) i(vs1) i(vs2) i(vs3) i(vs4) i(vs5) i(vs6) i(vs7) i(vs8) i(vs9)
print i(vs10) i(vs11) i(vs12) i(vs13) i(vs14) i(vs15)
.endc
.end
