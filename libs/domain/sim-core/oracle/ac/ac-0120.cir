controls oracle ac-0120
* Generated (plan F2.7, ADR 0012): do not edit; regenerate with `pnpm sim oracle regen`. ac seed 20261031 index 120 nodes 16 elements 24
.options sparse gmin=1e-12 noopac
RG1 1 0 1000000000000
RG2 2 0 1000000000000
RG3 3 0 1000000000000
RG4 4 0 1000000000000
RG5 5 0 1000000000000
RG6 6 0 1000000000000
RG7 7 0 1000000000000
RG8 8 0 1000000000000
RG9 9 0 1000000000000
RG10 10 0 1000000000000
RG11 11 0 1000000000000
RG12 12 0 1000000000000
RG13 13 0 1000000000000
RG14 14 0 1000000000000
RG15 15 0 1000000000000
VS0 12 s0 0
C0 s0 5 12e-7
VS1 2 s1 0
C1 s1 4 27e-6
VS2 7 s2 0
R2 s2 5 12e1
VS3 3 s3 0
C3 s3 14 47e-6
VS4 8 s4 0
R4 s4 0 15e2
VS5 6 s5 0
C5 s5 4 12e-4
VS6 2 s6 0
R6 s6 0 15e3
VS7 9 s7 0
L7 s7 10 33e-4
VS8 0 s8 0
V8 e8 s8 DC 0 AC 15e-1 180
RI8 e8 m8 56e-3
LI8 m8 15 22e-7
VS9 2 s9 0
L9 s9 6 10e-4
VS10 11 s10 0
R10 s10 1 18e2
VS11 8 s11 0
C11 s11 13 12e-6
VS12 9 s12 0
V12 e12 s12 DC 0 AC 22e1 120
RI12 e12 m12 82e-2
LI12 m12 3 33e-5
VS13 6 s13 0
C13 s13 11 33e-4
VS14 14 s14 0
V14 e14 s14 DC 0 AC 39e0 120
RI14 e14 m14 82e-2
LI14 m14 10 39e-7
VS15 10 s15 0
V15 e15 s15 DC 0 AC 15e1 0
RI15 e15 m15 68e-2
LI15 m15 13 47e-5
VS16 11 s16 0
L16 s16 9 82e-4
VS17 12 s17 0
V17 e17 s17 DC 0 AC 47e-1 -120
RI17 e17 m17 33e-1
LI17 m17 1 47e-6
VS18 6 s18 0
L18 s18 0 82e-5
VS19 3 s19 0
L19 s19 7 39e-4
VS20 5 s20 0
V20 e20 s20 DC 0 AC 22e1 -120
RI20 e20 m20 15e-1
LI20 m20 6 47e-5
VS21 14 s21 0
R21 s21 5 33e2
VS22 14 s22 0
L22 s22 8 22e-5
VS23 15 s23 0
R23 s23 6 82e3
.control
set numdgt=17
ac lin 1 60 60
print v(1) v(2) v(3) v(4) v(5) v(6) v(7) v(8) v(9) v(10)
print v(11) v(12) v(13) v(14) v(15)
print i(vs0) i(vs1) i(vs2) i(vs3) i(vs4) i(vs5) i(vs6) i(vs7) i(vs8) i(vs9)
print i(vs10) i(vs11) i(vs12) i(vs13) i(vs14) i(vs15) i(vs16) i(vs17) i(vs18) i(vs19)
print i(vs20) i(vs21) i(vs22) i(vs23)
.endc
.end
