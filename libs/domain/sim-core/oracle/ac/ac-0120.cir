controls oracle ac-0120
* Generated (plan F2.7, ADR 0012): do not edit; regenerate with `pnpm sim oracle regen`. ac seed 20261031 index 120 nodes 16 elements 22
.options sparse gmin=1e-12 noopac
RG1 1 0 1000000000000
RG2 2 0 1000000000000
RG3 3 0 1000000000000
RG4 4 0 1000000000000
RG5 5 0 1000000000000
RG6 6 0 1000000000000
RG7 7 0 1000000000000
RG8 8 0 1000000000000
RG9 9 0 1000000000000
RG10 10 0 1000000000000
RG11 11 0 1000000000000
RG12 12 0 1000000000000
RG13 13 0 1000000000000
RG14 14 0 1000000000000
RG15 15 0 1000000000000
VS0 3 s0 0
L0 s0 15 27e-2
VS1 0 s1 0
V1 e1 s1 DC 0 AC 22e1 -120
RI1 e1 6 15e-1
VS2 11 s2 0
R2 s2 6 15e0
VS3 15 s3 0
L3 s3 1 12e-3
VS4 10 s4 0
C4 s4 13 15e-5
VS5 8 s5 0
R5 s5 4 18e0
VS6 9 s6 0
L6 s6 0 27e-5
VS7 1 s7 0
V7 e7 s7 DC 0 AC 47e-1 0
RI7 e7 m7 47e-3
LI7 m7 6 33e-6
VS8 8 s8 0
R8 s8 11 68e2
VS9 4 s9 0
L9 s9 9 12e-5
VS10 12 s10 0
V10 e10 s10 DC 0 AC 39e1 -120
RI10 e10 m10 39e-1
LI10 m10 6 27e-5
VS11 11 s11 0
V11 e11 s11 DC 0 AC 27e-1 180
RI11 e11 7 47e-2
VS12 12 s12 0
L12 s12 13 68e-2
VS13 14 s13 0
R13 s13 0 15e3
VS14 13 s14 0
R14 s14 3 10e3
VS15 5 s15 0
R15 s15 12 47e-2
VS16 2 s16 0
R16 s16 15 15e3
VS17 5 s17 0
C17 s17 0 12e-7
VS18 2 s18 0
V18 e18 s18 DC 0 AC 15e0 180
RI18 e18 m18 27e-1
LI18 m18 10 82e-6
VS19 12 s19 0
R19 s19 7 12e2
VS20 14 s20 0
L20 s20 15 82e-4
VS21 4 s21 0
C21 s21 12 12e-4
.control
set numdgt=17
ac lin 1 60 60
print v(1) v(2) v(3) v(4) v(5) v(6) v(7) v(8) v(9) v(10)
print v(11) v(12) v(13) v(14) v(15)
print i(vs0) i(vs1) i(vs2) i(vs3) i(vs4) i(vs5) i(vs6) i(vs7) i(vs8) i(vs9)
print i(vs10) i(vs11) i(vs12) i(vs13) i(vs14) i(vs15) i(vs16) i(vs17) i(vs18) i(vs19)
print i(vs20) i(vs21)
.endc
.end
