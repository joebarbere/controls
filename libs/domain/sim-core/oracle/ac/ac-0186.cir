controls oracle ac-0186
* Generated (plan F2.7, ADR 0012): do not edit; regenerate with `pnpm sim oracle regen`. ac seed 20261031 index 186 nodes 30 elements 47
.options sparse gmin=1e-12 noopac
RG1 1 0 1000000000000
RG2 2 0 1000000000000
RG3 3 0 1000000000000
RG4 4 0 1000000000000
RG5 5 0 1000000000000
RG6 6 0 1000000000000
RG7 7 0 1000000000000
RG8 8 0 1000000000000
RG9 9 0 1000000000000
RG10 10 0 1000000000000
RG11 11 0 1000000000000
RG12 12 0 1000000000000
RG13 13 0 1000000000000
RG14 14 0 1000000000000
RG15 15 0 1000000000000
RG16 16 0 1000000000000
RG17 17 0 1000000000000
RG18 18 0 1000000000000
RG19 19 0 1000000000000
RG20 20 0 1000000000000
RG21 21 0 1000000000000
RG22 22 0 1000000000000
RG23 23 0 1000000000000
RG24 24 0 1000000000000
RG25 25 0 1000000000000
RG26 26 0 1000000000000
RG27 27 0 1000000000000
RG28 28 0 1000000000000
RG29 29 0 1000000000000
VS0 10 s0 0
L0 s0 23 27e-3
VS1 1 s1 0
R1 s1 0 27e-1
VS2 0 s2 0
V2 e2 s2 DC 0 AC 18e-1 120
RI2 e2 m2 18e-3
LI2 m2 11 22e-7
VS3 15 s3 0
V3 e3 s3 DC 0 AC 39e-1 120
RI3 e3 m3 47e-2
LI3 m3 10 18e-7
VS4 9 s4 0
C4 s4 6 33e-5
VS5 27 s5 0
C5 s5 6 39e-7
VS6 9 s6 0
R6 s6 6 56e2
VS7 1 s7 0
C7 s7 7 82e-5
VS8 23 s8 0
L8 s8 17 10e-4
VS9 20 s9 0
V9 e9 s9 DC 0 AC 10e1 180
RI9 e9 10 39e-3
VS10 24 s10 0
C10 s10 20 33e-7
VS11 28 s11 0
L11 s11 12 33e-5
VS12 2 s12 0
R12 s12 24 82e-2
VS13 12 s13 0
R13 s13 3 15e-2
VS14 22 s14 0
L14 s14 19 18e-5
VS15 26 s15 0
R15 s15 2 15e2
VS16 3 s16 0
V16 e16 s16 DC 0 AC 56e1 120
RI16 e16 17 82e-1
VS17 29 s17 0
L17 s17 17 18e-4
VS18 5 s18 0
R18 s18 2 12e2
VS19 16 s19 0
C19 s19 13 56e-5
VS20 7 s20 0
R20 s20 9 82e0
VS21 26 s21 0
V21 e21 s21 DC 0 AC 27e1 180
RI21 e21 m21 18e-2
LI21 m21 10 27e-7
VS22 3 s22 0
V22 e22 s22 DC 0 AC 22e1 0
RI22 e22 m22 10e-1
LI22 m22 14 15e-7
VS23 13 s23 0
C23 s23 25 47e-5
VS24 0 s24 0
R24 s24 19 39e0
VS25 10 s25 0
V25 e25 s25 DC 0 AC 15e-1 120
RI25 e25 19 10e-1
VS26 16 s26 0
L26 s26 5 15e-2
VS27 15 s27 0
V27 e27 s27 DC 0 AC 68e1 120
RI27 e27 m27 27e-3
LI27 m27 23 12e-5
VS28 8 s28 0
C28 s28 14 12e-6
VS29 11 s29 0
L29 s29 13 18e-4
VS30 11 s30 0
C30 s30 12 22e-5
VS31 18 s31 0
R31 s31 12 18e1
VS32 21 s32 0
C32 s32 2 15e-4
VS33 18 s33 0
V33 e33 s33 DC 0 AC 22e-1 -120
RI33 e33 m33 56e-1
LI33 m33 26 47e-7
VS34 3 s34 0
R34 s34 26 18e2
VS35 28 s35 0
V35 e35 s35 DC 0 AC 22e1 180
RI35 e35 17 47e-1
VS36 22 s36 0
L36 s36 11 56e-2
VS37 27 s37 0
R37 s37 24 27e-2
VS38 18 s38 0
L38 s38 21 18e-5
VS39 23 s39 0
R39 s39 4 12e-1
VS40 28 s40 0
C40 s40 6 15e-7
VS41 25 s41 0
R41 s41 29 56e-1
VS42 16 s42 0
C42 s42 2 10e-6
VS43 26 s43 0
R43 s43 0 39e-2
VS44 13 s44 0
R44 s44 8 68e0
VS45 2 s45 0
R45 s45 11 82e2
VS46 0 s46 0
V46 e46 s46 DC 0 AC 12e1 0
RI46 e46 m46 68e-2
LI46 m46 4 33e-5
.control
set numdgt=17
ac lin 1 60 60
print v(1) v(2) v(3) v(4) v(5) v(6) v(7) v(8) v(9) v(10)
print v(11) v(12) v(13) v(14) v(15) v(16) v(17) v(18) v(19) v(20)
print v(21) v(22) v(23) v(24) v(25) v(26) v(27) v(28) v(29)
print i(vs0) i(vs1) i(vs2) i(vs3) i(vs4) i(vs5) i(vs6) i(vs7) i(vs8) i(vs9)
print i(vs10) i(vs11) i(vs12) i(vs13) i(vs14) i(vs15) i(vs16) i(vs17) i(vs18) i(vs19)
print i(vs20) i(vs21) i(vs22) i(vs23) i(vs24) i(vs25) i(vs26) i(vs27) i(vs28) i(vs29)
print i(vs30) i(vs31) i(vs32) i(vs33) i(vs34) i(vs35) i(vs36) i(vs37) i(vs38) i(vs39)
print i(vs40) i(vs41) i(vs42) i(vs43) i(vs44) i(vs45) i(vs46)
.endc
.end
