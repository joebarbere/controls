controls oracle ac-0186
* Generated (plan F2.7, ADR 0012): do not edit; regenerate with `pnpm sim oracle regen`. ac seed 20261031 index 186 nodes 30 elements 55
.options sparse gmin=1e-12 noopac
RG1 1 0 1000000000000
RG2 2 0 1000000000000
RG3 3 0 1000000000000
RG4 4 0 1000000000000
RG5 5 0 1000000000000
RG6 6 0 1000000000000
RG7 7 0 1000000000000
RG8 8 0 1000000000000
RG9 9 0 1000000000000
RG10 10 0 1000000000000
RG11 11 0 1000000000000
RG12 12 0 1000000000000
RG13 13 0 1000000000000
RG14 14 0 1000000000000
RG15 15 0 1000000000000
RG16 16 0 1000000000000
RG17 17 0 1000000000000
RG18 18 0 1000000000000
RG19 19 0 1000000000000
RG20 20 0 1000000000000
RG21 21 0 1000000000000
RG22 22 0 1000000000000
RG23 23 0 1000000000000
RG24 24 0 1000000000000
RG25 25 0 1000000000000
RG26 26 0 1000000000000
RG27 27 0 1000000000000
RG28 28 0 1000000000000
RG29 29 0 1000000000000
VS0 19 s0 0
C0 s0 12 27e-7
VS1 0 s1 0
V1 e1 s1 DC 0 AC 39e1 180
RI1 e1 n1 27e-2
H1 n1 h1 VS19 -56e-3
ED1 h1 6 d1 0 -10e-7
F1 0 d1 VS19 1
LD1 d1 0 1
VS2 11 s2 0
C2 s2 8 39e-7
VS3 23 s3 0
R3 s3 1 22e1
VS4 18 s4 0
R4 s4 1 15e0
VS5 7 s5 0
C5 s5 14 22e-4
VS6 6 s6 0
L6 s6 15 33e-5
VS7 11 s7 0
L7 s7 25 68e-3
VS8 24 s8 0
C8 s8 20 33e-7
VS9 11 s9 0
L9 s9 10 68e-2
VS10 8 s10 0
L10 s10 18 33e-5
VS11 2 s11 0
R11 s11 15 82e2
VS12 15 s12 0
R12 s12 13 27e-2
VS13 27 s13 0
L13 s13 1 22e-5
VS14 17 s14 0
C14 s14 0 39e-4
VS15 8 s15 0
R15 s15 3 22e1
VS16 11 s16 0
C16 s16 26 82e-7
VS17 20 s17 0
R17 s17 3 82e0
VS18 6 s18 0
C18 s18 23 82e-6
VS19 10 s19 0
V19 e19 s19 DC 0 AC 82e-1 -120
RI19 e19 m19 15e-2
LI19 m19 n19 10e-7
H19 n19 h19 VS1 -56e-3
ED19 h19 20 d19 0 -10e-7
F19 0 d19 VS1 1
LD19 d19 0 1
VS20 14 s20 0
C20 s20 3 22e-4
VS21 29 s21 0
L21 s21 9 68e-3
VS22 20 s22 0
L22 s22 28 68e-4
VS23 14 s23 0
R23 s23 23 12e0
VS24 25 s24 0
R24 s24 22 56e3
VS25 11 s25 0
V25 e25 s25 DC 0 AC 82e0 0
RI25 e25 m25 22e-1
LI25 m25 8 47e-7
VS26 22 s26 0
C26 s26 13 18e-5
VS27 3 s27 0
V27 e27 s27 DC 0 AC 22e0 120
RI27 e27 m27 82e-3
LI27 m27 17 12e-6
VS28 8 s28 0
V28 e28 s28 DC 0 AC 47e0 -120
RI28 e28 24 18e-3
VS29 18 s29 0
L29 s29 25 56e-3
VS30 11 s30 0
V30 e30 s30 DC 0 AC 18e-1 120
RI30 e30 m30 18e-3
LI30 m30 15 18e-5
VS31 5 s31 0
R31 s31 8 56e3
VS32 25 s32 0
V32 e32 s32 DC 0 AC 12e1 0
RI32 e32 28 68e-2
VS33 4 s33 0
R33 s33 3 82e1
VS34 2 s34 0
V34 e34 s34 DC 0 AC 33e-1 0
RI34 e34 m34 33e-3
LI34 m34 11 27e-6
VS35 5 s35 0
C35 s35 9 15e-4
VS36 10 s36 0
V36 e36 s36 DC 0 AC 15e1 -120
RI36 e36 9 15e-3
VS37 3 s37 0
V37 e37 s37 DC 0 AC 15e0 0
RI37 e37 0 47e-1
VS38 26 s38 0
V38 e38 s38 DC 0 AC 27e1 180
RI38 e38 m38 18e-2
LI38 m38 10 27e-7
VS39 19 s39 0
R39 s39 15 56e2
VS40 26 s40 0
C40 s40 6 82e-5
VS41 4 s41 0
R41 s41 26 56e3
VS42 18 s42 0
V42 e42 s42 DC 0 AC 12e0 0
RI42 e42 m42 56e-3
LI42 m42 16 56e-7
VS43 12 s43 0
L43 s43 2 27e-4
VS44 16 s44 0
R44 s44 20 27e-1
VS45 19 s45 0
L45 s45 12 33e-5
VS46 10 s46 0
R46 s46 5 27e1
VS47 21 s47 0
R47 s47 13 10e2
VS48 0 s48 0
L48 s48 29 12e-2
VS49 25 s49 0
V49 e49 s49 DC 0 AC 47e-1 0
RI49 e49 m49 47e-3
LI49 m49 10 12e-5
VS50 16 s50 0
C50 s50 2 10e-6
VS51 3 s51 0
V51 e51 s51 DC 0 AC 56e1 120
RI51 e51 27 82e-1
VS52 10 s52 0
L52 s52 23 27e-3
VS53 21 s53 0
C53 s53 12 82e-5
VS54 27 s54 0
R54 s54 7 33e-1
.control
set numdgt=17
ac lin 1 60 60
print v(1) v(2) v(3) v(4) v(5) v(6) v(7) v(8) v(9) v(10)
print v(11) v(12) v(13) v(14) v(15) v(16) v(17) v(18) v(19) v(20)
print v(21) v(22) v(23) v(24) v(25) v(26) v(27) v(28) v(29)
print i(vs0) i(vs1) i(vs2) i(vs3) i(vs4) i(vs5) i(vs6) i(vs7) i(vs8) i(vs9)
print i(vs10) i(vs11) i(vs12) i(vs13) i(vs14) i(vs15) i(vs16) i(vs17) i(vs18) i(vs19)
print i(vs20) i(vs21) i(vs22) i(vs23) i(vs24) i(vs25) i(vs26) i(vs27) i(vs28) i(vs29)
print i(vs30) i(vs31) i(vs32) i(vs33) i(vs34) i(vs35) i(vs36) i(vs37) i(vs38) i(vs39)
print i(vs40) i(vs41) i(vs42) i(vs43) i(vs44) i(vs45) i(vs46) i(vs47) i(vs48) i(vs49)
print i(vs50) i(vs51) i(vs52) i(vs53) i(vs54)
.endc
.end
