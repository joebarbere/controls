controls oracle ac-0186
* Generated (plan F2.7, ADR 0012): do not edit; regenerate with `pnpm sim oracle regen`. ac seed 20261031 index 186 nodes 30 elements 52
.options sparse gmin=1e-12 noopac
RG1 1 0 1000000000000
RG2 2 0 1000000000000
RG3 3 0 1000000000000
RG4 4 0 1000000000000
RG5 5 0 1000000000000
RG6 6 0 1000000000000
RG7 7 0 1000000000000
RG8 8 0 1000000000000
RG9 9 0 1000000000000
RG10 10 0 1000000000000
RG11 11 0 1000000000000
RG12 12 0 1000000000000
RG13 13 0 1000000000000
RG14 14 0 1000000000000
RG15 15 0 1000000000000
RG16 16 0 1000000000000
RG17 17 0 1000000000000
RG18 18 0 1000000000000
RG19 19 0 1000000000000
RG20 20 0 1000000000000
RG21 21 0 1000000000000
RG22 22 0 1000000000000
RG23 23 0 1000000000000
RG24 24 0 1000000000000
RG25 25 0 1000000000000
RG26 26 0 1000000000000
RG27 27 0 1000000000000
RG28 28 0 1000000000000
RG29 29 0 1000000000000
VS0 11 s0 0
C0 s0 0 39e-7
VS1 11 s1 0
L1 s1 10 68e-2
VS2 0 s2 0
V2 e2 s2 DC 0 AC 47e0 -120
RI2 e2 24 18e-3
VS3 25 s3 0
V3 e3 s3 DC 0 AC 12e1 0
RI3 e3 28 68e-2
VS4 12 s4 0
L4 s4 2 27e-4
VS5 19 s5 0
R5 s5 8 56e2
VS6 10 s6 0
V6 e6 s6 DC 0 AC 15e1 -120
RI6 e6 9 15e-3
VS7 7 s7 0
C7 s7 14 22e-4
VS8 3 s8 0
V8 e8 s8 DC 0 AC 56e1 120
RI8 e8 27 82e-1
VS9 15 s9 0
V9 e9 s9 DC 0 AC 39e1 180
RI9 e9 6 27e-2
VS10 0 s10 0
L10 s10 18 33e-5
VS11 26 s11 0
C11 s11 6 82e-5
VS12 4 s12 0
R12 s12 3 82e1
VS13 2 s13 0
V13 e13 s13 DC 0 AC 33e-1 0
RI13 e13 11 33e-3
VS14 22 s14 0
C14 s14 13 18e-5
VS15 11 s15 0
V15 e15 s15 DC 0 AC 18e-1 120
RI15 e15 8 18e-3
VS16 19 s16 0
C16 s16 12 27e-7
VS17 18 s17 0
V17 e17 s17 DC 0 AC 12e0 0
RI17 e17 16 56e-3
VS18 5 s18 0
C18 s18 9 15e-4
VS19 6 s19 0
C19 s19 23 82e-6
VS20 14 s20 0
R20 s20 23 12e0
VS21 11 s21 0
C21 s21 26 82e-7
VS22 19 s22 0
L22 s22 12 33e-5
VS23 6 s23 0
L23 s23 8 33e-5
VS24 20 s24 0
R24 s24 3 82e0
VS25 27 s25 0
R25 s25 7 33e-1
VS26 16 s26 0
R26 s26 20 27e-1
VS27 10 s27 0
L27 s27 23 27e-3
VS28 23 s28 0
R28 s28 1 22e1
VS29 2 s29 0
R29 s29 8 82e2
VS30 29 s30 0
L30 s30 9 68e-3
VS31 18 s31 0
L31 s31 25 56e-3
VS32 25 s32 0
R32 s32 22 56e3
VS33 18 s33 0
R33 s33 1 15e0
VS34 15 s34 0
L34 s34 29 12e-2
VS35 10 s35 0
V35 e35 s35 DC 0 AC 82e-1 -120
RI35 e35 20 15e-2
VS36 27 s36 0
L36 s36 1 22e-5
VS37 24 s37 0
C37 s37 20 33e-7
VS38 3 s38 0
V38 e38 s38 DC 0 AC 22e0 120
RI38 e38 17 82e-3
VS39 10 s39 0
R39 s39 5 27e1
VS40 11 s40 0
L40 s40 25 68e-3
VS41 8 s41 0
R41 s41 13 27e-2
VS42 0 s42 0
R42 s42 3 22e1
VS43 3 s43 0
V43 e43 s43 DC 0 AC 15e0 0
RI43 e43 15 47e-1
VS44 14 s44 0
C44 s44 3 22e-4
VS45 5 s45 0
R45 s45 0 56e3
VS46 26 s46 0
V46 e46 s46 DC 0 AC 27e1 180
RI46 e46 10 18e-2
VS47 16 s47 0
C47 s47 2 10e-6
VS48 25 s48 0
V48 e48 s48 DC 0 AC 47e-1 0
RI48 e48 10 47e-3
VS49 11 s49 0
V49 e49 s49 DC 0 AC 82e0 0
RI49 e49 0 22e-1
VS50 21 s50 0
R50 s50 13 10e2
VS51 20 s51 0
L51 s51 28 68e-4
.control
set numdgt=17
ac lin 1 60 60
print v(1) v(2) v(3) v(4) v(5) v(6) v(7) v(8) v(9) v(10)
print v(11) v(12) v(13) v(14) v(15) v(16) v(17) v(18) v(19) v(20)
print v(21) v(22) v(23) v(24) v(25) v(26) v(27) v(28) v(29)
print i(vs0) i(vs1) i(vs2) i(vs3) i(vs4) i(vs5) i(vs6) i(vs7) i(vs8) i(vs9)
print i(vs10) i(vs11) i(vs12) i(vs13) i(vs14) i(vs15) i(vs16) i(vs17) i(vs18) i(vs19)
print i(vs20) i(vs21) i(vs22) i(vs23) i(vs24) i(vs25) i(vs26) i(vs27) i(vs28) i(vs29)
print i(vs30) i(vs31) i(vs32) i(vs33) i(vs34) i(vs35) i(vs36) i(vs37) i(vs38) i(vs39)
print i(vs40) i(vs41) i(vs42) i(vs43) i(vs44) i(vs45) i(vs46) i(vs47) i(vs48) i(vs49)
print i(vs50) i(vs51)
.endc
.end
