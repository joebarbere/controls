controls oracle ac-0047
* Generated (plan F2.7, ADR 0012): do not edit; regenerate with `pnpm sim oracle regen`. ac seed 20261031 index 47 nodes 12 elements 24
.options sparse gmin=1e-12 noopac
RG1 1 0 1000000000000
RG2 2 0 1000000000000
RG3 3 0 1000000000000
RG4 4 0 1000000000000
RG5 5 0 1000000000000
RG6 6 0 1000000000000
RG7 7 0 1000000000000
RG8 8 0 1000000000000
RG9 9 0 1000000000000
RG10 10 0 1000000000000
RG11 11 0 1000000000000
VS0 6 s0 0
L0 s0 8 15e-2
VS1 2 s1 0
L1 s1 4 82e-5
VS2 0 s2 0
V2 e2 s2 DC 0 AC 82e-1 -120
RI2 e2 11 18e-2
VS3 7 s3 0
R3 s3 6 18e-1
VS4 0 s4 0
V4 e4 s4 DC 0 AC 68e1 180
RI4 e4 7 39e-3
VS5 1 s5 0
R5 s5 5 47e0
VS6 0 s6 0
R6 s6 6 22e1
VS7 1 s7 0
R7 s7 6 18e-2
VS8 10 s8 0
L8 s8 7 27e-2
VS9 5 s9 0
R9 s9 11 39e3
VS10 9 s10 0
R10 s10 0 68e2
VS11 0 s11 0
C11 s11 10 22e-4
VS12 3 s12 0
R12 s12 10 47e0
VS13 2 s13 0
R13 s13 6 68e2
VS14 2 s14 0
C14 s14 5 68e-4
VS15 5 s15 0
C15 s15 4 12e-7
VS16 5 s16 0
C16 s16 2 12e-6
VS17 10 s17 0
L17 s17 11 10e-4
VS18 4 s18 0
R18 s18 8 15e-2
VS19 3 s19 0
L19 s19 8 18e-5
VS20 3 s20 0
V20 e20 s20 DC 0 AC 47e-1 0
RI20 e20 m20 22e-3
LI20 m20 2 68e-7
VS21 9 s21 0
C21 s21 4 12e-5
VS22 3 s22 0
L22 s22 5 68e-5
VS23 11 s23 0
R23 s23 3 18e-1
.control
set numdgt=17
ac lin 1 60 60
print v(1) v(2) v(3) v(4) v(5) v(6) v(7) v(8) v(9) v(10)
print v(11)
print i(vs0) i(vs1) i(vs2) i(vs3) i(vs4) i(vs5) i(vs6) i(vs7) i(vs8) i(vs9)
print i(vs10) i(vs11) i(vs12) i(vs13) i(vs14) i(vs15) i(vs16) i(vs17) i(vs18) i(vs19)
print i(vs20) i(vs21) i(vs22) i(vs23)
.endc
.end
