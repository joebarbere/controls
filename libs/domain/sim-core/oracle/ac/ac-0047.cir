controls oracle ac-0047
* Generated (plan F2.7, ADR 0012): do not edit; regenerate with `pnpm sim oracle regen`. ac seed 20261031 index 47 nodes 12 elements 20
.options sparse gmin=1e-12 noopac
RG1 1 0 1000000000000
RG2 2 0 1000000000000
RG3 3 0 1000000000000
RG4 4 0 1000000000000
RG5 5 0 1000000000000
RG6 6 0 1000000000000
RG7 7 0 1000000000000
RG8 8 0 1000000000000
RG9 9 0 1000000000000
RG10 10 0 1000000000000
RG11 11 0 1000000000000
VS0 11 s0 0
R0 s0 3 18e-1
VS1 0 s1 0
V1 e1 s1 DC 0 AC 12e1 -120
RI1 e1 n1 39e-2
H1 n1 h1 VS8 -15e-3
ED1 h1 1 d1 0 18e-6
F1 0 d1 VS8 1
LD1 d1 0 1
VS2 3 s2 0
R2 s2 10 39e-1
VS3 3 s3 0
L3 s3 8 18e-5
VS4 3 s4 0
R4 s4 8 10e-2
VS5 10 s5 0
L5 s5 4 82e-5
VS6 2 s6 0
C6 s6 9 12e-4
VS7 9 s7 0
L7 s7 6 18e-2
VS8 2 s8 0
V8 e8 s8 DC 0 AC 82e-1 -120
RI8 e8 m8 18e-2
LI8 m8 n8 33e-7
H8 n8 h8 VS1 -15e-3
ED8 h8 11 d8 0 18e-6
F8 0 d8 VS1 1
LD8 d8 0 1
VS9 0 s9 0
C9 s9 11 10e-5
VS10 5 s10 0
C10 s10 7 33e-5
VS11 1 s11 0
R11 s11 6 18e-2
VS12 5 s12 0
C12 s12 10 12e-6
VS13 10 s13 0
C13 s13 5 27e-7
VS14 0 s14 0
V14 e14 s14 DC 0 AC 56e1 -120
RI14 e14 m14 39e-3
LI14 m14 3 47e-7
VS15 9 s15 0
R15 s15 5 12e-1
VS16 10 s16 0
R16 s16 6 68e2
VS17 7 s17 0
R17 s17 3 82e0
VS18 4 s18 0
R18 s18 8 15e-2
VS19 3 s19 0
L19 s19 6 56e-5
.control
set numdgt=17
ac lin 1 60 60
print v(1) v(2) v(3) v(4) v(5) v(6) v(7) v(8) v(9) v(10)
print v(11)
print i(vs0) i(vs1) i(vs2) i(vs3) i(vs4) i(vs5) i(vs6) i(vs7) i(vs8) i(vs9)
print i(vs10) i(vs11) i(vs12) i(vs13) i(vs14) i(vs15) i(vs16) i(vs17) i(vs18) i(vs19)
.endc
.end
