controls oracle ac-0278
* Generated (plan F2.7, ADR 0012): do not edit; regenerate with `pnpm sim oracle regen`. ac seed 20261031 index 278 nodes 19 elements 37
.options sparse gmin=1e-12 noopac
RG1 1 0 1000000000000
RG2 2 0 1000000000000
RG3 3 0 1000000000000
RG4 4 0 1000000000000
RG5 5 0 1000000000000
RG6 6 0 1000000000000
RG7 7 0 1000000000000
RG8 8 0 1000000000000
RG9 9 0 1000000000000
RG10 10 0 1000000000000
RG11 11 0 1000000000000
RG12 12 0 1000000000000
RG13 13 0 1000000000000
RG14 14 0 1000000000000
RG15 15 0 1000000000000
RG16 16 0 1000000000000
RG17 17 0 1000000000000
RG18 18 0 1000000000000
VS0 13 s0 0
R0 s0 15 56e3
VS1 15 s1 0
L1 s1 5 33e-3
VS2 0 s2 0
R2 s2 17 12e2
VS3 0 s3 0
V3 e3 s3 DC 0 AC 12e1 180
RI3 e3 1 10e-1
VS4 16 s4 0
V4 e4 s4 DC 0 AC 47e1 -120
RI4 e4 m4 12e-3
LI4 m4 12 68e-6
VS5 16 s5 0
R5 s5 6 10e-2
VS6 17 s6 0
V6 e6 s6 DC 0 AC 39e1 -120
RI6 e6 m6 12e-2
LI6 m6 14 47e-5
VS7 6 s7 0
V7 e7 s7 DC 0 AC 33e-1 120
RI7 e7 m7 82e-3
LI7 m7 11 18e-7
VS8 12 s8 0
V8 e8 s8 DC 0 AC 15e0 120
RI8 e8 m8 47e-3
LI8 m8 17 56e-7
VS9 15 s9 0
R9 s9 11 47e1
VS10 12 s10 0
C10 s10 17 22e-6
VS11 18 s11 0
R11 s11 15 15e-2
VS12 5 s12 0
V12 e12 s12 DC 0 AC 39e0 -120
RI12 e12 18 15e-3
VS13 1 s13 0
C13 s13 3 68e-4
VS14 9 s14 0
R14 s14 3 22e-2
VS15 15 s15 0
L15 s15 5 68e-5
VS16 3 s16 0
R16 s16 15 12e-2
VS17 1 s17 0
R17 s17 8 27e1
VS18 15 s18 0
R18 s18 18 56e1
VS19 7 s19 0
R19 s19 11 33e-2
VS20 14 s20 0
L20 s20 4 27e-3
VS21 17 s21 0
C21 s21 0 18e-6
VS22 6 s22 0
C22 s22 4 15e-5
VS23 8 s23 0
C23 s23 0 39e-7
VS24 17 s24 0
R24 s24 15 22e3
VS25 6 s25 0
V25 e25 s25 DC 0 AC 27e0 0
RI25 e25 m25 68e-2
LI25 m25 13 47e-6
VS26 8 s26 0
V26 e26 s26 DC 0 AC 33e0 120
RI26 e26 2 10e-3
VS27 16 s27 0
C27 s27 18 10e-4
VS28 14 s28 0
C28 s28 11 18e-7
VS29 6 s29 0
R29 s29 15 56e-1
VS30 2 s30 0
R30 s30 15 56e0
VS31 14 s31 0
R31 s31 1 18e3
VS32 7 s32 0
L32 s32 9 22e-2
VS33 3 s33 0
C33 s33 14 12e-6
VS34 16 s34 0
L34 s34 10 33e-3
VS35 14 s35 0
R35 s35 10 56e3
VS36 0 s36 0
R36 s36 16 39e3
.control
set numdgt=17
ac lin 1 60 60
print v(1) v(2) v(3) v(4) v(5) v(6) v(7) v(8) v(9) v(10)
print v(11) v(12) v(13) v(14) v(15) v(16) v(17) v(18)
print i(vs0) i(vs1) i(vs2) i(vs3) i(vs4) i(vs5) i(vs6) i(vs7) i(vs8) i(vs9)
print i(vs10) i(vs11) i(vs12) i(vs13) i(vs14) i(vs15) i(vs16) i(vs17) i(vs18) i(vs19)
print i(vs20) i(vs21) i(vs22) i(vs23) i(vs24) i(vs25) i(vs26) i(vs27) i(vs28) i(vs29)
print i(vs30) i(vs31) i(vs32) i(vs33) i(vs34) i(vs35) i(vs36)
.endc
.end
