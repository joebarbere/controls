controls oracle ac-0278
* Generated (plan F2.7, ADR 0012): do not edit; regenerate with `pnpm sim oracle regen`. ac seed 20261031 index 278 nodes 19 elements 35
.options sparse gmin=1e-12 noopac
RG1 1 0 1000000000000
RG2 2 0 1000000000000
RG3 3 0 1000000000000
RG4 4 0 1000000000000
RG5 5 0 1000000000000
RG6 6 0 1000000000000
RG7 7 0 1000000000000
RG8 8 0 1000000000000
RG9 9 0 1000000000000
RG10 10 0 1000000000000
RG11 11 0 1000000000000
RG12 12 0 1000000000000
RG13 13 0 1000000000000
RG14 14 0 1000000000000
RG15 15 0 1000000000000
RG16 16 0 1000000000000
RG17 17 0 1000000000000
RG18 18 0 1000000000000
VS0 14 s0 0
R0 s0 10 56e3
VS1 18 s1 0
C1 s1 13 56e-4
VS2 10 s2 0
R2 s2 11 10e1
VS3 1 s3 0
R3 s3 8 27e1
VS4 13 s4 0
R4 s4 15 56e3
VS5 7 s5 0
L5 s5 9 22e-2
VS6 7 s6 0
L6 s6 1 27e-2
VS7 15 s7 0
R7 s7 6 47e1
VS8 14 s8 0
C8 s8 6 18e-7
VS9 17 s9 0
L9 s9 8 10e-3
VS10 0 s10 0
V10 e10 s10 DC 0 AC 33e-1 120
RI10 e10 6 82e-3
VS11 16 s11 0
L11 s11 15 39e-2
VS12 18 s12 0
L12 s12 7 22e-3
VS13 3 s13 0
V13 e13 s13 DC 0 AC 15e-1 0
RI13 e13 11 12e-3
VS14 17 s14 0
C14 s14 10 10e-4
VS15 4 s15 0
L15 s15 0 18e-2
VS16 2 s16 0
R16 s16 11 12e3
VS17 9 s17 0
R17 s17 3 22e-2
VS18 14 s18 0
L18 s18 4 27e-3
VS19 18 s19 0
R19 s19 15 15e-2
VS20 8 s20 0
C20 s20 11 39e-7
VS21 2 s21 0
V21 e21 s21 DC 0 AC 82e1 -120
RI21 e21 0 33e-1
VS22 12 s22 0
C22 s22 1 10e-4
VS23 15 s23 0
L23 s23 5 33e-3
VS24 7 s24 0
R24 s24 6 33e-2
VS25 2 s25 0
R25 s25 15 56e0
VS26 3 s26 0
L26 s26 2 15e-2
VS27 12 s27 0
C27 s27 17 22e-6
VS28 8 s28 0
L28 s28 11 15e-3
VS29 13 s29 0
R29 s29 16 15e-1
VS30 17 s30 0
R30 s30 15 22e3
VS31 14 s31 0
R31 s31 1 18e3
VS32 13 s32 0
C32 s32 6 68e-6
VS33 9 s33 0
V33 e33 s33 DC 0 AC 56e-1 180
RI33 e33 2 22e-3
VS34 12 s34 0
V34 e34 s34 DC 0 AC 15e0 120
RI34 e34 17 47e-3
.control
set numdgt=17
ac lin 1 60 60
print v(1) v(2) v(3) v(4) v(5) v(6) v(7) v(8) v(9) v(10)
print v(11) v(12) v(13) v(14) v(15) v(16) v(17) v(18)
print i(vs0) i(vs1) i(vs2) i(vs3) i(vs4) i(vs5) i(vs6) i(vs7) i(vs8) i(vs9)
print i(vs10) i(vs11) i(vs12) i(vs13) i(vs14) i(vs15) i(vs16) i(vs17) i(vs18) i(vs19)
print i(vs20) i(vs21) i(vs22) i(vs23) i(vs24) i(vs25) i(vs26) i(vs27) i(vs28) i(vs29)
print i(vs30) i(vs31) i(vs32) i(vs33) i(vs34)
.endc
.end
