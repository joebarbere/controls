controls oracle ac-0278
* Generated (plan F2.7, ADR 0012): do not edit; regenerate with `pnpm sim oracle regen`. ac seed 20261031 index 278 nodes 19 elements 36
.options sparse gmin=1e-12 noopac
RG1 1 0 1000000000000
RG2 2 0 1000000000000
RG3 3 0 1000000000000
RG4 4 0 1000000000000
RG5 5 0 1000000000000
RG6 6 0 1000000000000
RG7 7 0 1000000000000
RG8 8 0 1000000000000
RG9 9 0 1000000000000
RG10 10 0 1000000000000
RG11 11 0 1000000000000
RG12 12 0 1000000000000
RG13 13 0 1000000000000
RG14 14 0 1000000000000
RG15 15 0 1000000000000
RG16 16 0 1000000000000
RG17 17 0 1000000000000
RG18 18 0 1000000000000
VS0 0 s0 0
V0 e0 s0 DC 0 AC 33e-1 120
RI0 e0 6 82e-3
VS1 14 s1 0
L1 s1 4 27e-3
VS2 17 s2 0
C2 s2 10 10e-4
VS3 7 s3 0
R3 s3 6 33e-2
VS4 18 s4 0
C4 s4 13 56e-4
VS5 12 s5 0
V5 e5 s5 DC 0 AC 15e0 120
RI5 e5 17 47e-3
VS6 14 s6 0
R6 s6 10 56e3
VS7 15 s7 0
L7 s7 5 33e-3
VS8 10 s8 0
R8 s8 11 10e1
VS9 8 s9 0
L9 s9 11 15e-3
VS10 17 s10 0
R10 s10 15 22e3
VS11 7 s11 0
L11 s11 1 27e-2
VS12 2 s12 0
R12 s12 15 56e0
VS13 8 s13 0
C13 s13 11 39e-7
VS14 1 s14 0
R14 s14 8 27e1
VS15 3 s15 0
L15 s15 2 15e-2
VS16 14 s16 0
C16 s16 6 18e-7
VS17 18 s17 0
L17 s17 7 22e-3
VS18 18 s18 0
R18 s18 15 15e-2
VS19 7 s19 0
L19 s19 9 22e-2
VS20 3 s20 0
V20 e20 s20 DC 0 AC 15e-1 0
RI20 e20 m20 12e-3
LI20 m20 11 12e-6
VS21 9 s21 0
R21 s21 3 22e-2
VS22 4 s22 0
L22 s22 0 18e-2
VS23 16 s23 0
L23 s23 15 39e-2
VS24 2 s24 0
V24 e24 s24 DC 0 AC 82e1 -120
RI24 e24 0 33e-1
VS25 13 s25 0
C25 s25 6 68e-6
VS26 5 s26 0
L26 s26 4 39e-2
VS27 2 s27 0
R27 s27 11 12e3
VS28 9 s28 0
V28 e28 s28 DC 0 AC 56e-1 180
RI28 e28 2 22e-3
VS29 13 s29 0
R29 s29 15 56e3
VS30 12 s30 0
C30 s30 1 10e-4
VS31 14 s31 0
R31 s31 1 18e3
VS32 13 s32 0
R32 s32 16 15e-1
VS33 17 s33 0
L33 s33 8 10e-3
VS34 12 s34 0
C34 s34 17 22e-6
VS35 15 s35 0
R35 s35 6 47e1
.control
set numdgt=17
ac lin 1 60 60
print v(1) v(2) v(3) v(4) v(5) v(6) v(7) v(8) v(9) v(10)
print v(11) v(12) v(13) v(14) v(15) v(16) v(17) v(18)
print i(vs0) i(vs1) i(vs2) i(vs3) i(vs4) i(vs5) i(vs6) i(vs7) i(vs8) i(vs9)
print i(vs10) i(vs11) i(vs12) i(vs13) i(vs14) i(vs15) i(vs16) i(vs17) i(vs18) i(vs19)
print i(vs20) i(vs21) i(vs22) i(vs23) i(vs24) i(vs25) i(vs26) i(vs27) i(vs28) i(vs29)
print i(vs30) i(vs31) i(vs32) i(vs33) i(vs34) i(vs35)
.endc
.end
