controls oracle ac-0324
* Generated (plan F2.7, ADR 0012): do not edit; regenerate with `pnpm sim oracle regen`. ac seed 20261031 index 324 nodes 4 elements 5
.options sparse gmin=1e-12 noopac
RG1 1 0 1000000000000
RG2 2 0 1000000000000
RG3 3 0 1000000000000
VS0 3 s0 0
R0 s0 0 68e-1
VS1 3 s1 0
R1 s1 1 47e0
VS2 0 s2 0
V2 e2 s2 DC 0 AC 33e-1 180
RI2 e2 2 15e-3
VS3 3 s3 0
L3 s3 2 47e-4
VS4 1 s4 0
C4 s4 0 15e-6
.control
set numdgt=17
ac lin 1 60 60
print v(1) v(2) v(3)
print i(vs0) i(vs1) i(vs2) i(vs3) i(vs4)
.endc
.end
