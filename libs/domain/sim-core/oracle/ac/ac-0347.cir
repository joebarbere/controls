controls oracle ac-0347
* Generated (plan F2.7, ADR 0012): do not edit; regenerate with `pnpm sim oracle regen`. ac seed 20261031 index 347 nodes 27 elements 37
.options sparse gmin=1e-12 noopac
RG1 1 0 1000000000000
RG2 2 0 1000000000000
RG3 3 0 1000000000000
RG4 4 0 1000000000000
RG5 5 0 1000000000000
RG6 6 0 1000000000000
RG7 7 0 1000000000000
RG8 8 0 1000000000000
RG9 9 0 1000000000000
RG10 10 0 1000000000000
RG11 11 0 1000000000000
RG12 12 0 1000000000000
RG13 13 0 1000000000000
RG14 14 0 1000000000000
RG15 15 0 1000000000000
RG16 16 0 1000000000000
RG17 17 0 1000000000000
RG18 18 0 1000000000000
RG19 19 0 1000000000000
RG20 20 0 1000000000000
RG21 21 0 1000000000000
RG22 22 0 1000000000000
RG23 23 0 1000000000000
RG24 24 0 1000000000000
RG25 25 0 1000000000000
RG26 26 0 1000000000000
VS0 14 s0 0
C0 s0 21 56e-7
VS1 6 s1 0
R1 s1 17 33e2
VS2 22 s2 0
R2 s2 20 39e1
VS3 9 s3 0
R3 s3 15 56e0
VS4 21 s4 0
L4 s4 15 15e-3
VS5 8 s5 0
L5 s5 13 27e-5
VS6 16 s6 0
R6 s6 14 27e-2
VS7 24 s7 0
R7 s7 7 12e-1
VS8 11 s8 0
C8 s8 10 18e-5
VS9 23 s9 0
L9 s9 1 56e-2
VS10 12 s10 0
C10 s10 17 33e-7
VS11 15 s11 0
R11 s11 10 27e1
VS12 18 s12 0
L12 s12 19 33e-2
VS13 11 s13 0
L13 s13 25 33e-2
VS14 0 s14 0
V14 e14 s14 DC 0 AC 56e0 120
RI14 e14 3 22e-2
VS15 11 s15 0
V15 e15 s15 DC 0 AC 82e0 0
RI15 e15 m15 68e-2
LI15 m15 14 39e-7
VS16 22 s16 0
C16 s16 25 56e-7
VS17 0 s17 0
C17 s17 1 15e-5
VS18 5 s18 0
V18 e18 s18 DC 0 AC 12e-1 -120
RI18 e18 7 56e-3
VS19 26 s19 0
R19 s19 5 22e1
VS20 7 s20 0
R20 s20 20 33e3
VS21 4 s21 0
R21 s21 19 82e0
VS22 2 s22 0
C22 s22 13 10e-4
VS23 24 s23 0
C23 s23 4 56e-7
VS24 8 s24 0
C24 s24 7 47e-4
VS25 1 s25 0
V25 e25 s25 DC 0 AC 47e0 0
RI25 e25 8 15e-3
VS26 13 s26 0
V26 e26 s26 DC 0 AC 12e0 0
RI26 e26 4 15e-1
VS27 10 s27 0
R27 s27 18 27e0
VS28 9 s28 0
R28 s28 19 18e2
VS29 8 s29 0
C29 s29 15 18e-7
VS30 17 s30 0
R30 s30 10 82e-2
VS31 16 s31 0
V31 e31 s31 DC 0 AC 56e0 180
RI31 e31 26 12e-2
VS32 3 s32 0
L32 s32 8 33e-3
VS33 6 s33 0
R33 s33 2 39e0
VS34 23 s34 0
R34 s34 12 27e1
VS35 26 s35 0
C35 s35 15 39e-6
VS36 15 s36 0
L36 s36 17 68e-4
.control
set numdgt=17
ac lin 1 60 60
print v(1) v(2) v(3) v(4) v(5) v(6) v(7) v(8) v(9) v(10)
print v(11) v(12) v(13) v(14) v(15) v(16) v(17) v(18) v(19) v(20)
print v(21) v(22) v(23) v(24) v(25) v(26)
print i(vs0) i(vs1) i(vs2) i(vs3) i(vs4) i(vs5) i(vs6) i(vs7) i(vs8) i(vs9)
print i(vs10) i(vs11) i(vs12) i(vs13) i(vs14) i(vs15) i(vs16) i(vs17) i(vs18) i(vs19)
print i(vs20) i(vs21) i(vs22) i(vs23) i(vs24) i(vs25) i(vs26) i(vs27) i(vs28) i(vs29)
print i(vs30) i(vs31) i(vs32) i(vs33) i(vs34) i(vs35) i(vs36)
.endc
.end
