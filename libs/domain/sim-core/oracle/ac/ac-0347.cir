controls oracle ac-0347
* Generated (plan F2.7, ADR 0012): do not edit; regenerate with `pnpm sim oracle regen`. ac seed 20261031 index 347 nodes 27 elements 31
.options sparse gmin=1e-12 noopac
RG1 1 0 1000000000000
RG2 2 0 1000000000000
RG3 3 0 1000000000000
RG4 4 0 1000000000000
RG5 5 0 1000000000000
RG6 6 0 1000000000000
RG7 7 0 1000000000000
RG8 8 0 1000000000000
RG9 9 0 1000000000000
RG10 10 0 1000000000000
RG11 11 0 1000000000000
RG12 12 0 1000000000000
RG13 13 0 1000000000000
RG14 14 0 1000000000000
RG15 15 0 1000000000000
RG16 16 0 1000000000000
RG17 17 0 1000000000000
RG18 18 0 1000000000000
RG19 19 0 1000000000000
RG20 20 0 1000000000000
RG21 21 0 1000000000000
RG22 22 0 1000000000000
RG23 23 0 1000000000000
RG24 24 0 1000000000000
RG25 25 0 1000000000000
RG26 26 0 1000000000000
VS0 19 s0 0
L0 s0 26 15e-3
VS1 3 s1 0
L1 s1 26 15e-5
VS2 8 s2 0
R2 s2 12 22e0
VS3 17 s3 0
L3 s3 16 82e-5
VS4 0 s4 0
V4 e4 s4 DC 0 AC 82e0 0
RI4 e4 10 39e-3
VS5 24 s5 0
V5 e5 s5 DC 0 AC 15e1 120
RI5 e5 5 10e-2
VS6 18 s6 0
L6 s6 8 15e-4
VS7 22 s7 0
R7 s7 10 27e1
VS8 1 s8 0
V8 e8 s8 DC 0 AC 47e0 0
RI8 e8 8 15e-3
VS9 2 s9 0
V9 e9 s9 DC 0 AC 47e0 180
RI9 e9 12 18e-2
VS10 11 s10 0
C10 s10 24 39e-4
VS11 18 s11 0
R11 s11 4 15e1
VS12 5 s12 0
R12 s12 22 68e3
VS13 24 s13 0
R13 s13 7 12e-1
VS14 7 s14 0
R14 s14 11 15e2
VS15 26 s15 0
R15 s15 8 12e-1
VS16 8 s16 0
C16 s16 7 47e-4
VS17 17 s17 0
R17 s17 21 68e0
VS18 23 s18 0
C18 s18 26 56e-5
VS19 13 s19 0
C19 s19 7 82e-4
VS20 8 s20 0
L20 s20 25 15e-3
VS21 9 s21 0
R21 s21 17 33e1
VS22 6 s22 0
L22 s22 9 10e-5
VS23 18 s23 0
L23 s23 19 33e-3
VS24 8 s24 0
C24 s24 22 18e-7
VS25 10 s25 0
V25 e25 s25 DC 0 AC 56e1 120
RI25 e25 15 15e-1
VS26 15 s26 0
L26 s26 20 47e-3
VS27 22 s27 0
V27 e27 s27 DC 0 AC 10e1 -120
RI27 e27 14 22e-2
VS28 13 s28 0
V28 e28 s28 DC 0 AC 56e-1 0
RI28 e28 19 22e-1
VS29 9 s29 0
R29 s29 22 56e0
VS30 11 s30 0
C30 s30 14 68e-6
.control
set numdgt=17
ac lin 1 60 60
print v(1) v(2) v(3) v(4) v(5) v(6) v(7) v(8) v(9) v(10)
print v(11) v(12) v(13) v(14) v(15) v(16) v(17) v(18) v(19) v(20)
print v(21) v(22) v(23) v(24) v(25) v(26)
print i(vs0) i(vs1) i(vs2) i(vs3) i(vs4) i(vs5) i(vs6) i(vs7) i(vs8) i(vs9)
print i(vs10) i(vs11) i(vs12) i(vs13) i(vs14) i(vs15) i(vs16) i(vs17) i(vs18) i(vs19)
print i(vs20) i(vs21) i(vs22) i(vs23) i(vs24) i(vs25) i(vs26) i(vs27) i(vs28) i(vs29)
print i(vs30)
.endc
.end
