controls oracle ac-0428
* Generated (plan F2.7, ADR 0012): do not edit; regenerate with `pnpm sim oracle regen`. ac seed 20261031 index 428 nodes 22 elements 40
.options sparse gmin=1e-12 noopac
RG1 1 0 1000000000000
RG2 2 0 1000000000000
RG3 3 0 1000000000000
RG4 4 0 1000000000000
RG5 5 0 1000000000000
RG6 6 0 1000000000000
RG7 7 0 1000000000000
RG8 8 0 1000000000000
RG9 9 0 1000000000000
RG10 10 0 1000000000000
RG11 11 0 1000000000000
RG12 12 0 1000000000000
RG13 13 0 1000000000000
RG14 14 0 1000000000000
RG15 15 0 1000000000000
RG16 16 0 1000000000000
RG17 17 0 1000000000000
RG18 18 0 1000000000000
RG19 19 0 1000000000000
RG20 20 0 1000000000000
RG21 21 0 1000000000000
VS0 0 s0 0
V0 e0 s0 DC 0 AC 56e-1 0
RI0 e0 m0 56e-1
LI0 m0 9 15e-6
VS1 12 s1 0
V1 e1 s1 DC 0 AC 12e1 180
RI1 e1 m1 18e-1
LI1 m1 2 22e-7
VS2 18 s2 0
C2 s2 17 10e-7
VS3 12 s3 0
V3 e3 s3 DC 0 AC 68e-1 0
RI3 e3 m3 56e-3
LI3 m3 7 12e-5
VS4 10 s4 0
C4 s4 16 15e-7
VS5 0 s5 0
L5 s5 6 15e-2
VS6 2 s6 0
V6 e6 s6 DC 0 AC 18e-1 0
RI6 e6 14 68e-3
VS7 8 s7 0
C7 s7 16 18e-5
VS8 7 s8 0
C8 s8 9 18e-7
VS9 20 s9 0
R9 s9 9 18e0
VS10 2 s10 0
C10 s10 13 82e-7
VS11 4 s11 0
L11 s11 0 12e-2
VS12 16 s12 0
V12 e12 s12 DC 0 AC 22e-1 120
RI12 e12 8 39e-2
VS13 3 s13 0
R13 s13 14 18e-2
VS14 7 s14 0
R14 s14 6 12e-2
VS15 15 s15 0
C15 s15 17 68e-4
VS16 8 s16 0
C16 s16 19 27e-6
VS17 21 s17 0
L17 s17 12 27e-5
VS18 8 s18 0
C18 s18 3 10e-6
VS19 21 s19 0
L19 s19 7 12e-2
VS20 10 s20 0
C20 s20 19 56e-7
VS21 12 s21 0
R21 s21 4 47e1
VS22 20 s22 0
R22 s22 16 56e2
VS23 0 s23 0
C23 s23 15 12e-6
VS24 4 s24 0
R24 s24 1 33e-2
VS25 21 s25 0
R25 s25 1 10e0
VS26 9 s26 0
R26 s26 12 15e1
VS27 21 s27 0
R27 s27 0 18e3
VS28 14 s28 0
R28 s28 4 15e3
VS29 0 s29 0
L29 s29 11 10e-3
VS30 19 s30 0
R30 s30 9 27e0
VS31 9 s31 0
C31 s31 8 12e-6
VS32 14 s32 0
R32 s32 16 27e3
VS33 8 s33 0
R33 s33 7 10e0
VS34 20 s34 0
C34 s34 18 12e-6
VS35 0 s35 0
R35 s35 14 22e2
VS36 5 s36 0
C36 s36 0 10e-6
VS37 7 s37 0
C37 s37 11 39e-6
VS38 6 s38 0
R38 s38 13 12e0
VS39 12 s39 0
R39 s39 5 18e1
.control
set numdgt=17
ac lin 1 60 60
print v(1) v(2) v(3) v(4) v(5) v(6) v(7) v(8) v(9) v(10)
print v(11) v(12) v(13) v(14) v(15) v(16) v(17) v(18) v(19) v(20)
print v(21)
print i(vs0) i(vs1) i(vs2) i(vs3) i(vs4) i(vs5) i(vs6) i(vs7) i(vs8) i(vs9)
print i(vs10) i(vs11) i(vs12) i(vs13) i(vs14) i(vs15) i(vs16) i(vs17) i(vs18) i(vs19)
print i(vs20) i(vs21) i(vs22) i(vs23) i(vs24) i(vs25) i(vs26) i(vs27) i(vs28) i(vs29)
print i(vs30) i(vs31) i(vs32) i(vs33) i(vs34) i(vs35) i(vs36) i(vs37) i(vs38) i(vs39)
.endc
.end
