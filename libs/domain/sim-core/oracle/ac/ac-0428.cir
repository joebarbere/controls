controls oracle ac-0428
* Generated (plan F2.7, ADR 0012): do not edit; regenerate with `pnpm sim oracle regen`. ac seed 20261031 index 428 nodes 22 elements 37
.options sparse gmin=1e-12 noopac
RG1 1 0 1000000000000
RG2 2 0 1000000000000
RG3 3 0 1000000000000
RG4 4 0 1000000000000
RG5 5 0 1000000000000
RG6 6 0 1000000000000
RG7 7 0 1000000000000
RG8 8 0 1000000000000
RG9 9 0 1000000000000
RG10 10 0 1000000000000
RG11 11 0 1000000000000
RG12 12 0 1000000000000
RG13 13 0 1000000000000
RG14 14 0 1000000000000
RG15 15 0 1000000000000
RG16 16 0 1000000000000
RG17 17 0 1000000000000
RG18 18 0 1000000000000
RG19 19 0 1000000000000
RG20 20 0 1000000000000
RG21 21 0 1000000000000
VS0 10 s0 0
R0 s0 16 22e1
VS1 20 s1 0
R1 s1 7 56e1
VS2 0 s2 0
V2 e2 s2 DC 0 AC 18e-1 0
RI2 e2 14 68e-3
VS3 17 s3 0
C3 s3 18 56e-7
VS4 16 s4 0
L4 s4 9 47e-2
VS5 2 s5 0
R5 s5 11 68e-2
VS6 6 s6 0
V6 e6 s6 DC 0 AC 27e1 180
RI6 e6 16 47e-2
VS7 9 s7 0
V7 e7 s7 DC 0 AC 68e-1 0
RI7 e7 17 15e-3
VS8 16 s8 0
C8 s8 3 15e-7
VS9 8 s9 0
V9 e9 s9 DC 0 AC 12e1 -120
RI9 e9 15 10e-1
VS10 14 s10 0
R10 s10 7 12e2
VS11 17 s11 0
C11 s11 19 47e-6
VS12 13 s12 0
C12 s12 10 56e-5
VS13 11 s13 0
R13 s13 8 18e1
VS14 0 s14 0
V14 e14 s14 DC 0 AC 15e1 -120
RI14 e14 16 33e-2
VS15 14 s15 0
R15 s15 9 68e0
VS16 6 s16 0
V16 e16 s16 DC 0 AC 47e1 -120
RI16 e16 2 18e-2
VS17 11 s17 0
V17 e17 s17 DC 0 AC 39e-1 120
RI17 e17 13 10e-1
VS18 2 s18 0
L18 s18 9 47e-4
VS19 6 s19 0
L19 s19 0 47e-4
VS20 0 s20 0
L20 s20 4 68e-2
VS21 9 s21 0
R21 s21 16 15e1
VS22 4 s22 0
L22 s22 2 39e-4
VS23 9 s23 0
R23 s23 15 10e-2
VS24 17 s24 0
R24 s24 7 10e1
VS25 12 s25 0
R25 s25 0 22e-1
VS26 1 s26 0
R26 s26 20 56e3
VS27 17 s27 0
R27 s27 5 56e-2
VS28 2 s28 0
R28 s28 14 22e2
VS29 21 s29 0
L29 s29 0 56e-5
VS30 18 s30 0
V30 e30 s30 DC 0 AC 18e-1 120
RI30 e30 14 68e-1
VS31 5 s31 0
R31 s31 9 10e3
VS32 13 s32 0
R32 s32 20 12e2
VS33 7 s33 0
L33 s33 4 15e-2
VS34 3 s34 0
L34 s34 1 22e-4
VS35 20 s35 0
L35 s35 4 47e-2
VS36 14 s36 0
R36 s36 8 27e3
.control
set numdgt=17
ac lin 1 60 60
print v(1) v(2) v(3) v(4) v(5) v(6) v(7) v(8) v(9) v(10)
print v(11) v(12) v(13) v(14) v(15) v(16) v(17) v(18) v(19) v(20)
print v(21)
print i(vs0) i(vs1) i(vs2) i(vs3) i(vs4) i(vs5) i(vs6) i(vs7) i(vs8) i(vs9)
print i(vs10) i(vs11) i(vs12) i(vs13) i(vs14) i(vs15) i(vs16) i(vs17) i(vs18) i(vs19)
print i(vs20) i(vs21) i(vs22) i(vs23) i(vs24) i(vs25) i(vs26) i(vs27) i(vs28) i(vs29)
print i(vs30) i(vs31) i(vs32) i(vs33) i(vs34) i(vs35) i(vs36)
.endc
.end
