controls oracle ac-0428
* Generated (plan F2.7, ADR 0012): do not edit; regenerate with `pnpm sim oracle regen`. ac seed 20261031 index 428 nodes 22 elements 40
.options sparse gmin=1e-12 noopac
RG1 1 0 1000000000000
RG2 2 0 1000000000000
RG3 3 0 1000000000000
RG4 4 0 1000000000000
RG5 5 0 1000000000000
RG6 6 0 1000000000000
RG7 7 0 1000000000000
RG8 8 0 1000000000000
RG9 9 0 1000000000000
RG10 10 0 1000000000000
RG11 11 0 1000000000000
RG12 12 0 1000000000000
RG13 13 0 1000000000000
RG14 14 0 1000000000000
RG15 15 0 1000000000000
RG16 16 0 1000000000000
RG17 17 0 1000000000000
RG18 18 0 1000000000000
RG19 19 0 1000000000000
RG20 20 0 1000000000000
RG21 21 0 1000000000000
VS0 20 s0 0
L0 s0 4 47e-2
VS1 10 s1 0
R1 s1 16 22e1
VS2 13 s2 0
C2 s2 10 56e-5
VS3 18 s3 0
R3 s3 14 22e2
VS4 0 s4 0
V4 e4 s4 DC 0 AC 18e-1 120
RI4 e4 n4 68e-1
H4 n4 h4 VS5 -47e-3
ED4 h4 14 d4 0 -27e-5
F4 0 d4 VS5 1
LD4 d4 0 1
VS5 2 s5 0
V5 e5 s5 DC 0 AC 15e1 -120
RI5 e5 n5 33e-2
H5 n5 h5 VS4 -47e-3
ED5 h5 16 d5 0 -27e-5
F5 0 d5 VS4 1
LD5 d5 0 1
VS6 18 s6 0
R6 s6 11 68e-2
VS7 3 s7 0
L7 s7 1 22e-4
VS8 13 s8 0
R8 s8 20 12e2
VS9 16 s9 0
L9 s9 9 47e-2
VS10 6 s10 0
V10 e10 s10 DC 0 AC 27e1 180
RI10 e10 16 47e-2
VS11 6 s11 0
L11 s11 2 47e-4
VS12 14 s12 0
R12 s12 8 27e3
VS13 9 s13 0
R13 s13 15 10e-2
VS14 6 s14 0
V14 e14 s14 DC 0 AC 47e1 -120
RI14 e14 18 18e-2
VS15 2 s15 0
L15 s15 4 68e-2
VS16 18 s16 0
L16 s16 9 47e-4
VS17 17 s17 0
R17 s17 5 56e-2
VS18 9 s18 0
V18 e18 s18 DC 0 AC 68e-1 0
RI18 e18 17 15e-3
VS19 11 s19 0
R19 s19 8 18e1
VS20 14 s20 0
R20 s20 9 68e0
VS21 16 s21 0
C21 s21 3 15e-7
VS22 1 s22 0
R22 s22 20 56e3
VS23 5 s23 0
R23 s23 9 10e3
VS24 20 s24 0
R24 s24 7 56e1
VS25 2 s25 0
V25 e25 s25 DC 0 AC 18e-1 0
RI25 e25 14 68e-3
VS26 19 s26 0
R26 s26 1 12e-1
VS27 9 s27 0
R27 s27 12 39e0
VS28 9 s28 0
R28 s28 16 15e1
VS29 11 s29 0
V29 e29 s29 DC 0 AC 39e-1 120
RI29 e29 m29 10e-1
LI29 m29 13 12e-7
VS30 4 s30 0
L30 s30 18 39e-4
VS31 21 s31 0
L31 s31 2 56e-5
VS32 5 s32 0
R32 s32 21 10e0
VS33 17 s33 0
C33 s33 0 56e-7
VS34 7 s34 0
L34 s34 4 15e-2
VS35 17 s35 0
R35 s35 7 10e1
VS36 17 s36 0
C36 s36 19 47e-6
VS37 12 s37 0
R37 s37 2 22e-1
VS38 8 s38 0
V38 e38 s38 DC 0 AC 12e1 -120
RI38 e38 m38 10e-1
LI38 m38 15 47e-6
VS39 14 s39 0
R39 s39 7 12e2
.control
set numdgt=17
ac lin 1 60 60
print v(1) v(2) v(3) v(4) v(5) v(6) v(7) v(8) v(9) v(10)
print v(11) v(12) v(13) v(14) v(15) v(16) v(17) v(18) v(19) v(20)
print v(21)
print i(vs0) i(vs1) i(vs2) i(vs3) i(vs4) i(vs5) i(vs6) i(vs7) i(vs8) i(vs9)
print i(vs10) i(vs11) i(vs12) i(vs13) i(vs14) i(vs15) i(vs16) i(vs17) i(vs18) i(vs19)
print i(vs20) i(vs21) i(vs22) i(vs23) i(vs24) i(vs25) i(vs26) i(vs27) i(vs28) i(vs29)
print i(vs30) i(vs31) i(vs32) i(vs33) i(vs34) i(vs35) i(vs36) i(vs37) i(vs38) i(vs39)
.endc
.end
