controls oracle ac-0343
* Generated (plan F2.7, ADR 0012): do not edit; regenerate with `pnpm sim oracle regen`. ac seed 20261031 index 343 nodes 29 elements 56
.options sparse gmin=1e-12 noopac
RG1 1 0 1000000000000
RG2 2 0 1000000000000
RG3 3 0 1000000000000
RG4 4 0 1000000000000
RG5 5 0 1000000000000
RG6 6 0 1000000000000
RG7 7 0 1000000000000
RG8 8 0 1000000000000
RG9 9 0 1000000000000
RG10 10 0 1000000000000
RG11 11 0 1000000000000
RG12 12 0 1000000000000
RG13 13 0 1000000000000
RG14 14 0 1000000000000
RG15 15 0 1000000000000
RG16 16 0 1000000000000
RG17 17 0 1000000000000
RG18 18 0 1000000000000
RG19 19 0 1000000000000
RG20 20 0 1000000000000
RG21 21 0 1000000000000
RG22 22 0 1000000000000
RG23 23 0 1000000000000
RG24 24 0 1000000000000
RG25 25 0 1000000000000
RG26 26 0 1000000000000
RG27 27 0 1000000000000
RG28 28 0 1000000000000
VS0 4 s0 0
R0 s0 7 15e0
VS1 0 s1 0
V1 e1 s1 DC 0 AC 68e1 120
RI1 e1 20 33e-1
VS2 9 s2 0
V2 e2 s2 DC 0 AC 18e1 0
RI2 e2 20 82e-1
VS3 2 s3 0
R3 s3 14 18e2
VS4 7 s4 0
R4 s4 10 68e-2
VS5 26 s5 0
R5 s5 18 39e1
VS6 10 s6 0
R6 s6 13 39e0
VS7 2 s7 0
V7 e7 s7 DC 0 AC 22e-1 120
RI7 e7 14 18e-1
VS8 20 s8 0
V8 e8 s8 DC 0 AC 82e-1 120
RI8 e8 1 12e-1
VS9 17 s9 0
V9 e9 s9 DC 0 AC 56e1 180
RI9 e9 0 27e-2
VS10 20 s10 0
R10 s10 14 47e0
VS11 11 s11 0
R11 s11 27 47e0
VS12 28 s12 0
V12 e12 s12 DC 0 AC 33e-1 120
RI12 e12 17 39e-1
VS13 11 s13 0
R13 s13 13 27e2
VS14 7 s14 0
L14 s14 24 56e-3
VS15 23 s15 0
C15 s15 26 39e-7
VS16 4 s16 0
L16 s16 15 27e-5
VS17 9 s17 0
R17 s17 0 33e-2
VS18 16 s18 0
C18 s18 7 39e-7
VS19 20 s19 0
V19 e19 s19 DC 0 AC 10e1 120
RI19 e19 24 68e-1
VS20 12 s20 0
R20 s20 19 39e1
VS21 5 s21 0
R21 s21 20 10e2
VS22 0 s22 0
L22 s22 27 18e-4
VS23 17 s23 0
L23 s23 26 33e-3
VS24 3 s24 0
C24 s24 28 47e-4
VS25 16 s25 0
V25 e25 s25 DC 0 AC 82e0 0
RI25 e25 9 22e-3
VS26 17 s26 0
C26 s26 26 68e-5
VS27 5 s27 0
R27 s27 26 56e1
VS28 0 s28 0
L28 s28 3 27e-5
VS29 16 s29 0
V29 e29 s29 DC 0 AC 18e0 180
RI29 e29 15 27e-3
VS30 7 s30 0
L30 s30 13 47e-4
VS31 4 s31 0
R31 s31 27 15e2
VS32 21 s32 0
C32 s32 1 18e-7
VS33 22 s33 0
R33 s33 28 15e0
VS34 21 s34 0
L34 s34 23 47e-5
VS35 11 s35 0
L35 s35 19 18e-5
VS36 4 s36 0
L36 s36 26 39e-4
VS37 7 s37 0
V37 e37 s37 DC 0 AC 12e-1 -120
RI37 e37 28 12e-2
VS38 20 s38 0
L38 s38 25 82e-3
VS39 2 s39 0
L39 s39 15 68e-2
VS40 23 s40 0
L40 s40 19 33e-5
VS41 6 s41 0
L41 s41 1 56e-2
VS42 15 s42 0
R42 s42 3 68e3
VS43 26 s43 0
L43 s43 7 15e-2
VS44 9 s44 0
C44 s44 25 27e-5
VS45 14 s45 0
R45 s45 15 15e0
VS46 18 s46 0
R46 s46 28 56e-2
VS47 0 s47 0
V47 e47 s47 DC 0 AC 33e-1 -120
RI47 e47 12 68e-3
VS48 22 s48 0
R48 s48 3 56e-1
VS49 8 s49 0
C49 s49 12 27e-5
VS50 19 s50 0
R50 s50 12 12e-1
VS51 12 s51 0
C51 s51 28 10e-6
VS52 19 s52 0
C52 s52 3 22e-5
VS53 12 s53 0
V53 e53 s53 DC 0 AC 10e-1 0
RI53 e53 26 27e-2
VS54 3 s54 0
R54 s54 21 68e-1
VS55 22 s55 0
C55 s55 0 15e-4
.control
set numdgt=17
ac lin 1 60 60
print v(1) v(2) v(3) v(4) v(5) v(6) v(7) v(8) v(9) v(10)
print v(11) v(12) v(13) v(14) v(15) v(16) v(17) v(18) v(19) v(20)
print v(21) v(22) v(23) v(24) v(25) v(26) v(27) v(28)
print i(vs0) i(vs1) i(vs2) i(vs3) i(vs4) i(vs5) i(vs6) i(vs7) i(vs8) i(vs9)
print i(vs10) i(vs11) i(vs12) i(vs13) i(vs14) i(vs15) i(vs16) i(vs17) i(vs18) i(vs19)
print i(vs20) i(vs21) i(vs22) i(vs23) i(vs24) i(vs25) i(vs26) i(vs27) i(vs28) i(vs29)
print i(vs30) i(vs31) i(vs32) i(vs33) i(vs34) i(vs35) i(vs36) i(vs37) i(vs38) i(vs39)
print i(vs40) i(vs41) i(vs42) i(vs43) i(vs44) i(vs45) i(vs46) i(vs47) i(vs48) i(vs49)
print i(vs50) i(vs51) i(vs52) i(vs53) i(vs54) i(vs55)
.endc
.end
