controls oracle ac-0343
* Generated (plan F2.7, ADR 0012): do not edit; regenerate with `pnpm sim oracle regen`. ac seed 20261031 index 343 nodes 29 elements 50
.options sparse gmin=1e-12 noopac
RG1 1 0 1000000000000
RG2 2 0 1000000000000
RG3 3 0 1000000000000
RG4 4 0 1000000000000
RG5 5 0 1000000000000
RG6 6 0 1000000000000
RG7 7 0 1000000000000
RG8 8 0 1000000000000
RG9 9 0 1000000000000
RG10 10 0 1000000000000
RG11 11 0 1000000000000
RG12 12 0 1000000000000
RG13 13 0 1000000000000
RG14 14 0 1000000000000
RG15 15 0 1000000000000
RG16 16 0 1000000000000
RG17 17 0 1000000000000
RG18 18 0 1000000000000
RG19 19 0 1000000000000
RG20 20 0 1000000000000
RG21 21 0 1000000000000
RG22 22 0 1000000000000
RG23 23 0 1000000000000
RG24 24 0 1000000000000
RG25 25 0 1000000000000
RG26 26 0 1000000000000
RG27 27 0 1000000000000
RG28 28 0 1000000000000
VS0 14 s0 0
R0 s0 28 56e-1
VS1 19 s1 0
C1 s1 15 39e-6
VS2 9 s2 0
L2 s2 27 33e-4
VS3 28 s3 0
C3 s3 10 18e-7
VS4 20 s4 0
L4 s4 11 47e-4
VS5 2 s5 0
C5 s5 1 47e-5
VS6 26 s6 0
C6 s6 19 68e-6
VS7 0 s7 0
V7 e7 s7 DC 0 AC 82e-1 120
RI7 e7 1 12e-1
VS8 10 s8 0
L8 s8 1 56e-3
VS9 11 s9 0
L9 s9 17 47e-5
VS10 24 s10 0
V10 e10 s10 DC 0 AC 56e0 -120
RI10 e10 m10 15e-3
LI10 m10 17 27e-6
VS11 4 s11 0
V11 e11 s11 DC 0 AC 12e1 180
RI11 e11 m11 47e-1
LI11 m11 12 68e-6
VS12 21 s12 0
L12 s12 11 22e-2
VS13 6 s13 0
R13 s13 16 18e2
VS14 16 s14 0
L14 s14 3 33e-2
VS15 16 s15 0
R15 s15 8 82e-1
VS16 17 s16 0
C16 s16 21 10e-5
VS17 19 s17 0
L17 s17 0 10e-2
VS18 23 s18 0
R18 s18 22 68e-2
VS19 26 s19 0
L19 s19 3 68e-2
VS20 8 s20 0
R20 s20 11 15e2
VS21 3 s21 0
L21 s21 9 47e-5
VS22 25 s22 0
R22 s22 3 47e-2
VS23 6 s23 0
C23 s23 22 47e-7
VS24 2 s24 0
C24 s24 21 27e-5
VS25 12 s25 0
V25 e25 s25 DC 0 AC 68e1 -120
RI25 e25 m25 33e-3
LI25 m25 0 47e-6
VS26 21 s26 0
C26 s26 3 18e-6
VS27 25 s27 0
R27 s27 13 15e1
VS28 24 s28 0
L28 s28 3 56e-2
VS29 12 s29 0
V29 e29 s29 DC 0 AC 33e-1 -120
RI29 e29 m29 68e-3
LI29 m29 20 12e-7
VS30 7 s30 0
R30 s30 3 47e-2
VS31 6 s31 0
V31 e31 s31 DC 0 AC 18e0 120
RI31 e31 19 33e-2
VS32 13 s32 0
V32 e32 s32 DC 0 AC 68e-1 120
RI32 e32 m32 12e-3
LI32 m32 18 12e-6
VS33 5 s33 0
L33 s33 9 33e-3
VS34 14 s34 0
R34 s34 24 47e3
VS35 28 s35 0
V35 e35 s35 DC 0 AC 33e-1 120
RI35 e35 17 39e-1
VS36 3 s36 0
L36 s36 18 10e-5
VS37 12 s37 0
R37 s37 13 68e-2
VS38 20 s38 0
V38 e38 s38 DC 0 AC 68e0 180
RI38 e38 9 47e-3
VS39 15 s39 0
V39 e39 s39 DC 0 AC 56e-1 180
RI39 e39 11 18e-3
VS40 5 s40 0
V40 e40 s40 DC 0 AC 56e0 120
RI40 e40 13 68e-1
VS41 2 s41 0
V41 e41 s41 DC 0 AC 68e1 -120
RI41 e41 m41 10e-1
LI41 m41 7 22e-5
VS42 4 s42 0
L42 s42 20 56e-4
VS43 6 s43 0
R43 s43 28 39e0
VS44 28 s44 0
C44 s44 12 82e-6
VS45 13 s45 0
R45 s45 27 47e2
VS46 13 s46 0
V46 e46 s46 DC 0 AC 10e-1 120
RI46 e46 m46 27e-1
LI46 m46 22 12e-7
VS47 9 s47 0
V47 e47 s47 DC 0 AC 15e-1 180
RI47 e47 16 15e-1
VS48 13 s48 0
R48 s48 23 47e0
VS49 24 s49 0
R49 s49 2 10e0
.control
set numdgt=17
ac lin 1 60 60
print v(1) v(2) v(3) v(4) v(5) v(6) v(7) v(8) v(9) v(10)
print v(11) v(12) v(13) v(14) v(15) v(16) v(17) v(18) v(19) v(20)
print v(21) v(22) v(23) v(24) v(25) v(26) v(27) v(28)
print i(vs0) i(vs1) i(vs2) i(vs3) i(vs4) i(vs5) i(vs6) i(vs7) i(vs8) i(vs9)
print i(vs10) i(vs11) i(vs12) i(vs13) i(vs14) i(vs15) i(vs16) i(vs17) i(vs18) i(vs19)
print i(vs20) i(vs21) i(vs22) i(vs23) i(vs24) i(vs25) i(vs26) i(vs27) i(vs28) i(vs29)
print i(vs30) i(vs31) i(vs32) i(vs33) i(vs34) i(vs35) i(vs36) i(vs37) i(vs38) i(vs39)
print i(vs40) i(vs41) i(vs42) i(vs43) i(vs44) i(vs45) i(vs46) i(vs47) i(vs48) i(vs49)
.endc
.end
