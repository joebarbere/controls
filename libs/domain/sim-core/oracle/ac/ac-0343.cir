controls oracle ac-0343
* Generated (plan F2.7, ADR 0012): do not edit; regenerate with `pnpm sim oracle regen`. ac seed 20261031 index 343 nodes 29 elements 58
.options sparse gmin=1e-12 noopac
RG1 1 0 1000000000000
RG2 2 0 1000000000000
RG3 3 0 1000000000000
RG4 4 0 1000000000000
RG5 5 0 1000000000000
RG6 6 0 1000000000000
RG7 7 0 1000000000000
RG8 8 0 1000000000000
RG9 9 0 1000000000000
RG10 10 0 1000000000000
RG11 11 0 1000000000000
RG12 12 0 1000000000000
RG13 13 0 1000000000000
RG14 14 0 1000000000000
RG15 15 0 1000000000000
RG16 16 0 1000000000000
RG17 17 0 1000000000000
RG18 18 0 1000000000000
RG19 19 0 1000000000000
RG20 20 0 1000000000000
RG21 21 0 1000000000000
RG22 22 0 1000000000000
RG23 23 0 1000000000000
RG24 24 0 1000000000000
RG25 25 0 1000000000000
RG26 26 0 1000000000000
RG27 27 0 1000000000000
RG28 28 0 1000000000000
VS0 10 s0 0
R0 s0 13 39e0
VS1 7 s1 0
L1 s1 13 47e-4
VS2 2 s2 0
R2 s2 14 18e2
VS3 9 s3 0
C3 s3 25 27e-5
VS4 0 s4 0
V4 e4 s4 DC 0 AC 68e1 -120
RI4 e4 n4 47e-3
H4 n4 h4 VS18 33e-4
ED4 h4 8 d4 0 -15e-7
F4 0 d4 VS18 1
LD4 d4 0 1
VS5 18 s5 0
R5 s5 28 56e-2
VS6 12 s6 0
L6 s6 3 27e-5
VS7 6 s7 0
L7 s7 1 56e-2
VS8 22 s8 0
R8 s8 3 56e-1
VS9 23 s9 0
C9 s9 26 39e-7
VS10 8 s10 0
C10 s10 21 27e-5
VS11 11 s11 0
R11 s11 27 47e0
VS12 26 s12 0
R12 s12 18 39e1
VS13 23 s13 0
L13 s13 19 33e-5
VS14 17 s14 0
L14 s14 26 33e-3
VS15 5 s15 0
R15 s15 20 10e2
VS16 21 s16 0
C16 s16 28 10e-6
VS17 20 s17 0
L17 s17 25 82e-3
VS18 20 s18 0
V18 e18 s18 DC 0 AC 10e1 120
RI18 e18 n18 68e-1
H18 n18 h18 VS4 33e-4
ED18 h18 24 d18 0 -15e-7
F18 0 d18 VS4 1
LD18 d18 0 1
VS19 7 s19 0
V19 e19 s19 DC 0 AC 12e-1 -120
RI19 e19 m19 12e-2
LI19 m19 28 27e-7
VS20 2 s20 0
V20 e20 s20 DC 0 AC 22e-1 120
RI20 e20 14 18e-1
VS21 16 s21 0
V21 e21 s21 DC 0 AC 18e0 180
RI21 e21 15 27e-3
VS22 17 s22 0
C22 s22 26 68e-5
VS23 4 s23 0
L23 s23 15 27e-5
VS24 9 s24 0
R24 s24 12 33e-2
VS25 12 s25 0
V25 e25 s25 DC 0 AC 68e1 120
RI25 e25 m25 33e-1
LI25 m25 20 22e-6
VS26 12 s26 0
L26 s26 27 18e-4
VS27 0 s27 0
C27 s27 1 18e-7
VS28 7 s28 0
R28 s28 10 68e-2
VS29 26 s29 0
L29 s29 7 15e-2
VS30 7 s30 0
L30 s30 24 56e-3
VS31 3 s31 0
R31 s31 0 68e-1
VS32 14 s32 0
R32 s32 15 15e0
VS33 20 s33 0
R33 s33 14 47e0
VS34 11 s34 0
R34 s34 13 27e2
VS35 4 s35 0
R35 s35 27 15e2
VS36 17 s36 0
V36 e36 s36 DC 0 AC 56e1 180
RI36 e36 m36 27e-2
LI36 m36 12 56e-5
VS37 9 s37 0
V37 e37 s37 DC 0 AC 18e1 0
RI37 e37 20 82e-1
VS38 2 s38 0
L38 s38 15 68e-2
VS39 0 s39 0
L39 s39 23 47e-5
VS40 21 s40 0
R40 s40 19 39e1
VS41 21 s41 0
V41 e41 s41 DC 0 AC 10e-1 0
RI41 e41 26 27e-2
VS42 22 s42 0
R42 s42 28 15e0
VS43 12 s43 0
V43 e43 s43 DC 0 AC 33e-1 -120
RI43 e43 21 68e-3
VS44 16 s44 0
V44 e44 s44 DC 0 AC 82e0 0
RI44 e44 9 22e-3
VS45 19 s45 0
R45 s45 21 12e-1
VS46 4 s46 0
R46 s46 7 15e0
VS47 20 s47 0
V47 e47 s47 DC 0 AC 82e-1 120
RI47 e47 m47 12e-1
LI47 m47 1 22e-7
VS48 16 s48 0
C48 s48 7 39e-7
VS49 4 s49 0
L49 s49 26 39e-4
VS50 5 s50 0
R50 s50 26 56e1
VS51 19 s51 0
C51 s51 3 22e-5
VS52 15 s52 0
R52 s52 3 68e3
VS53 3 s53 0
C53 s53 28 47e-4
VS54 28 s54 0
V54 e54 s54 DC 0 AC 33e-1 120
RI54 e54 17 39e-1
VS55 6 s55 0
L55 s55 23 15e-4
VS56 22 s56 0
C56 s56 12 15e-4
VS57 11 s57 0
L57 s57 19 18e-5
.control
set numdgt=17
ac lin 1 60 60
print v(1) v(2) v(3) v(4) v(5) v(6) v(7) v(8) v(9) v(10)
print v(11) v(12) v(13) v(14) v(15) v(16) v(17) v(18) v(19) v(20)
print v(21) v(22) v(23) v(24) v(25) v(26) v(27) v(28)
print i(vs0) i(vs1) i(vs2) i(vs3) i(vs4) i(vs5) i(vs6) i(vs7) i(vs8) i(vs9)
print i(vs10) i(vs11) i(vs12) i(vs13) i(vs14) i(vs15) i(vs16) i(vs17) i(vs18) i(vs19)
print i(vs20) i(vs21) i(vs22) i(vs23) i(vs24) i(vs25) i(vs26) i(vs27) i(vs28) i(vs29)
print i(vs30) i(vs31) i(vs32) i(vs33) i(vs34) i(vs35) i(vs36) i(vs37) i(vs38) i(vs39)
print i(vs40) i(vs41) i(vs42) i(vs43) i(vs44) i(vs45) i(vs46) i(vs47) i(vs48) i(vs49)
print i(vs50) i(vs51) i(vs52) i(vs53) i(vs54) i(vs55) i(vs56) i(vs57)
.endc
.end
