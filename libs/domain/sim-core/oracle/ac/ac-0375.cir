controls oracle ac-0375
* Generated (plan F2.7, ADR 0012): do not edit; regenerate with `pnpm sim oracle regen`. ac seed 20261031 index 375 nodes 17 elements 26
.options sparse gmin=1e-12 noopac
RG1 1 0 1000000000000
RG2 2 0 1000000000000
RG3 3 0 1000000000000
RG4 4 0 1000000000000
RG5 5 0 1000000000000
RG6 6 0 1000000000000
RG7 7 0 1000000000000
RG8 8 0 1000000000000
RG9 9 0 1000000000000
RG10 10 0 1000000000000
RG11 11 0 1000000000000
RG12 12 0 1000000000000
RG13 13 0 1000000000000
RG14 14 0 1000000000000
RG15 15 0 1000000000000
RG16 16 0 1000000000000
VS0 0 s0 0
V0 e0 s0 DC 0 AC 18e1 0
RI0 e0 m0 12e-3
LI0 m0 n0 10e-5
H0 n0 h0 VS4 82e-4
ED0 h0 14 d0 0 15e-7
F0 0 d0 VS4 1
LD0 d0 0 1
VS1 4 s1 0
R1 s1 13 47e3
VS2 8 s2 0
C2 s2 16 10e-6
VS3 9 s3 0
R3 s3 11 27e1
VS4 6 s4 0
V4 e4 s4 DC 0 AC 15e1 180
RI4 e4 n4 10e-3
H4 n4 h4 VS0 82e-4
ED4 h4 2 d4 0 15e-7
F4 0 d4 VS0 1
LD4 d4 0 1
VS5 10 s5 0
C5 s5 4 56e-5
VS6 1 s6 0
V6 e6 s6 DC 0 AC 27e-1 180
RI6 e6 5 10e-2
VS7 11 s7 0
C7 s7 4 10e-6
VS8 13 s8 0
L8 s8 7 12e-2
VS9 1 s9 0
C9 s9 4 82e-7
VS10 13 s10 0
R10 s10 9 10e3
VS11 10 s11 0
R11 s11 0 33e2
VS12 12 s12 0
C12 s12 16 82e-6
VS13 9 s13 0
L13 s13 0 68e-4
VS14 8 s14 0
R14 s14 5 33e3
VS15 4 s15 0
V15 e15 s15 DC 0 AC 22e0 -120
RI15 e15 7 47e-1
VS16 8 s16 0
R16 s16 13 27e2
VS17 6 s17 0
R17 s17 12 56e1
VS18 12 s18 0
L18 s18 9 10e-2
VS19 2 s19 0
V19 e19 s19 DC 0 AC 56e-1 0
RI19 e19 4 47e-1
VS20 6 s20 0
L20 s20 3 33e-3
VS21 15 s21 0
R21 s21 3 82e-1
VS22 15 s22 0
R22 s22 13 10e-2
VS23 8 s23 0
R23 s23 4 10e-1
VS24 6 s24 0
C24 s24 1 39e-4
VS25 14 s25 0
L25 s25 4 33e-4
.control
set numdgt=17
ac lin 1 60 60
print v(1) v(2) v(3) v(4) v(5) v(6) v(7) v(8) v(9) v(10)
print v(11) v(12) v(13) v(14) v(15) v(16)
print i(vs0) i(vs1) i(vs2) i(vs3) i(vs4) i(vs5) i(vs6) i(vs7) i(vs8) i(vs9)
print i(vs10) i(vs11) i(vs12) i(vs13) i(vs14) i(vs15) i(vs16) i(vs17) i(vs18) i(vs19)
print i(vs20) i(vs21) i(vs22) i(vs23) i(vs24) i(vs25)
.endc
.end
