controls oracle ac-0375
* Generated (plan F2.7, ADR 0012): do not edit; regenerate with `pnpm sim oracle regen`. ac seed 20261031 index 375 nodes 17 elements 29
.options sparse gmin=1e-12 noopac
RG1 1 0 1000000000000
RG2 2 0 1000000000000
RG3 3 0 1000000000000
RG4 4 0 1000000000000
RG5 5 0 1000000000000
RG6 6 0 1000000000000
RG7 7 0 1000000000000
RG8 8 0 1000000000000
RG9 9 0 1000000000000
RG10 10 0 1000000000000
RG11 11 0 1000000000000
RG12 12 0 1000000000000
RG13 13 0 1000000000000
RG14 14 0 1000000000000
RG15 15 0 1000000000000
RG16 16 0 1000000000000
VS0 10 s0 0
C0 s0 0 56e-5
VS1 5 s1 0
R1 s1 15 18e0
VS2 11 s2 0
R2 s2 9 18e2
VS3 0 s3 0
V3 e3 s3 DC 0 AC 47e1 -120
RI3 e3 m3 12e-1
LI3 m3 7 22e-6
VS4 11 s4 0
V4 e4 s4 DC 0 AC 10e-1 -120
RI4 e4 8 18e-3
VS5 14 s5 0
R5 s5 6 27e3
VS6 10 s6 0
R6 s6 13 27e1
VS7 1 s7 0
C7 s7 0 82e-7
VS8 9 s8 0
R8 s8 2 33e0
VS9 15 s9 0
C9 s9 6 18e-4
VS10 13 s10 0
V10 e10 s10 DC 0 AC 27e0 0
RI10 e10 12 56e-1
VS11 4 s11 0
V11 e11 s11 DC 0 AC 12e-1 120
RI11 e11 7 10e-2
VS12 8 s12 0
R12 s12 5 33e3
VS13 12 s13 0
C13 s13 3 27e-6
VS14 2 s14 0
L14 s14 10 47e-2
VS15 1 s15 0
C15 s15 0 47e-6
VS16 11 s16 0
C16 s16 0 10e-6
VS17 2 s17 0
V17 e17 s17 DC 0 AC 27e1 120
RI17 e17 m17 56e-3
LI17 m17 9 56e-7
VS18 2 s18 0
V18 e18 s18 DC 0 AC 56e-1 0
RI18 e18 0 47e-1
VS19 6 s19 0
L19 s19 3 18e-5
VS20 14 s20 0
R20 s20 1 39e0
VS21 16 s21 0
R21 s21 9 27e2
VS22 8 s22 0
R22 s22 0 10e-1
VS23 0 s23 0
V23 e23 s23 DC 0 AC 10e1 0
RI23 e23 m23 10e-1
LI23 m23 9 27e-7
VS24 10 s24 0
R24 s24 4 33e2
VS25 13 s25 0
C25 s25 15 39e-5
VS26 16 s26 0
L26 s26 0 15e-5
VS27 6 s27 0
C27 s27 1 39e-4
VS28 11 s28 0
C28 s28 8 82e-4
.control
set numdgt=17
ac lin 1 60 60
print v(1) v(2) v(3) v(4) v(5) v(6) v(7) v(8) v(9) v(10)
print v(11) v(12) v(13) v(14) v(15) v(16)
print i(vs0) i(vs1) i(vs2) i(vs3) i(vs4) i(vs5) i(vs6) i(vs7) i(vs8) i(vs9)
print i(vs10) i(vs11) i(vs12) i(vs13) i(vs14) i(vs15) i(vs16) i(vs17) i(vs18) i(vs19)
print i(vs20) i(vs21) i(vs22) i(vs23) i(vs24) i(vs25) i(vs26) i(vs27) i(vs28)
.endc
.end
