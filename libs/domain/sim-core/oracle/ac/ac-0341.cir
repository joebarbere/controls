controls oracle ac-0341
* Generated (plan F2.7, ADR 0012): do not edit; regenerate with `pnpm sim oracle regen`. ac seed 20261031 index 341 nodes 6 elements 10
.options sparse gmin=1e-12 noopac
RG1 1 0 1000000000000
RG2 2 0 1000000000000
RG3 3 0 1000000000000
RG4 4 0 1000000000000
RG5 5 0 1000000000000
VS0 3 s0 0
R0 s0 1 27e3
VS1 0 s1 0
V1 e1 s1 DC 0 AC 39e1 180
RI1 e1 m1 27e-2
LI1 m1 3 82e-7
VS2 2 s2 0
L2 s2 3 27e-3
VS3 1 s3 0
C3 s3 5 82e-5
VS4 1 s4 0
R4 s4 4 82e-2
VS5 3 s5 0
C5 s5 5 18e-4
VS6 2 s6 0
V6 e6 s6 DC 0 AC 15e1 180
RI6 e6 1 18e-1
VS7 5 s7 0
R7 s7 1 68e-2
VS8 3 s8 0
L8 s8 4 15e-4
VS9 5 s9 0
R9 s9 0 15e-2
.control
set numdgt=17
ac lin 1 60 60
print v(1) v(2) v(3) v(4) v(5)
print i(vs0) i(vs1) i(vs2) i(vs3) i(vs4) i(vs5) i(vs6) i(vs7) i(vs8) i(vs9)
.endc
.end
