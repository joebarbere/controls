controls oracle ac-0341
* Generated (plan F2.7, ADR 0012): do not edit; regenerate with `pnpm sim oracle regen`. ac seed 20261031 index 341 nodes 6 elements 10
.options sparse gmin=1e-12 noopac
RG1 1 0 1000000000000
RG2 2 0 1000000000000
RG3 3 0 1000000000000
RG4 4 0 1000000000000
RG5 5 0 1000000000000
VS0 3 s0 0
C0 s0 5 18e-4
VS1 2 s1 0
R1 s1 5 18e-2
VS2 0 s2 0
V2 e2 s2 DC 0 AC 39e1 180
RI2 e2 m2 27e-2
LI2 m2 3 82e-6
VS3 2 s3 0
L3 s3 4 68e-4
VS4 2 s4 0
R4 s4 3 12e3
VS5 1 s5 0
R5 s5 0 22e-1
VS6 2 s6 0
L6 s6 3 27e-3
VS7 3 s7 0
C7 s7 2 18e-5
VS8 2 s8 0
C8 s8 1 22e-5
VS9 4 s9 0
R9 s9 5 22e1
.control
set numdgt=17
ac lin 1 60 60
print v(1) v(2) v(3) v(4) v(5)
print i(vs0) i(vs1) i(vs2) i(vs3) i(vs4) i(vs5) i(vs6) i(vs7) i(vs8) i(vs9)
.endc
.end
