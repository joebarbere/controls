controls oracle ac-0291
* Generated (plan F2.7, ADR 0012): do not edit; regenerate with `pnpm sim oracle regen`. ac seed 20261031 index 291 nodes 24 elements 47
.options sparse gmin=1e-12 noopac
RG1 1 0 1000000000000
RG2 2 0 1000000000000
RG3 3 0 1000000000000
RG4 4 0 1000000000000
RG5 5 0 1000000000000
RG6 6 0 1000000000000
RG7 7 0 1000000000000
RG8 8 0 1000000000000
RG9 9 0 1000000000000
RG10 10 0 1000000000000
RG11 11 0 1000000000000
RG12 12 0 1000000000000
RG13 13 0 1000000000000
RG14 14 0 1000000000000
RG15 15 0 1000000000000
RG16 16 0 1000000000000
RG17 17 0 1000000000000
RG18 18 0 1000000000000
RG19 19 0 1000000000000
RG20 20 0 1000000000000
RG21 21 0 1000000000000
RG22 22 0 1000000000000
RG23 23 0 1000000000000
VS0 0 s0 0
V0 e0 s0 DC 0 AC 15e-1 180
RI0 e0 19 82e-1
VS1 14 s1 0
V1 e1 s1 DC 0 AC 68e-1 0
RI1 e1 12 39e-1
VS2 8 s2 0
C2 s2 18 68e-5
VS3 16 s3 0
R3 s3 15 33e-1
VS4 12 s4 0
C4 s4 1 68e-4
VS5 16 s5 0
R5 s5 7 12e3
VS6 23 s6 0
R6 s6 15 47e-1
VS7 9 s7 0
V7 e7 s7 DC 0 AC 10e1 180
RI7 e7 15 27e-3
VS8 15 s8 0
V8 e8 s8 DC 0 AC 10e0 180
RI8 e8 18 33e-1
VS9 10 s9 0
V9 e9 s9 DC 0 AC 22e-1 180
RI9 e9 3 22e-1
VS10 18 s10 0
C10 s10 19 82e-5
VS11 4 s11 0
C11 s11 14 56e-7
VS12 3 s12 0
R12 s12 19 18e3
VS13 15 s13 0
C13 s13 21 39e-6
VS14 13 s14 0
V14 e14 s14 DC 0 AC 82e-1 120
RI14 e14 6 18e-2
VS15 3 s15 0
L15 s15 0 12e-3
VS16 2 s16 0
L16 s16 10 18e-2
VS17 16 s17 0
R17 s17 20 18e2
VS18 15 s18 0
R18 s18 18 15e-2
VS19 20 s19 0
R19 s19 18 68e-2
VS20 14 s20 0
V20 e20 s20 DC 0 AC 39e-1 180
RI20 e20 15 47e-2
VS21 21 s21 0
R21 s21 13 56e1
VS22 15 s22 0
V22 e22 s22 DC 0 AC 39e0 -120
RI22 e22 10 33e-2
VS23 2 s23 0
C23 s23 9 82e-4
VS24 1 s24 0
R24 s24 11 39e-1
VS25 14 s25 0
L25 s25 19 33e-2
VS26 17 s26 0
V26 e26 s26 DC 0 AC 15e-1 120
RI26 e26 19 10e-1
VS27 20 s27 0
V27 e27 s27 DC 0 AC 15e0 180
RI27 e27 11 15e-2
VS28 5 s28 0
V28 e28 s28 DC 0 AC 27e1 0
RI28 e28 8 18e-1
VS29 12 s29 0
C29 s29 8 27e-4
VS30 7 s30 0
R30 s30 20 12e3
VS31 11 s31 0
V31 e31 s31 DC 0 AC 68e-1 0
RI31 e31 1 56e-2
VS32 16 s32 0
L32 s32 4 39e-3
VS33 19 s33 0
C33 s33 5 15e-7
VS34 15 s34 0
R34 s34 7 82e0
VS35 10 s35 0
R35 s35 12 47e2
VS36 15 s36 0
C36 s36 2 22e-7
VS37 17 s37 0
V37 e37 s37 DC 0 AC 10e-1 180
RI37 e37 13 82e-1
VS38 4 s38 0
R38 s38 13 33e-1
VS39 14 s39 0
V39 e39 s39 DC 0 AC 56e-1 -120
RI39 e39 13 12e-1
VS40 18 s40 0
R40 s40 15 56e-1
VS41 2 s41 0
C41 s41 6 12e-4
VS42 15 s42 0
C42 s42 3 18e-6
VS43 18 s43 0
R43 s43 22 82e3
VS44 4 s44 0
R44 s44 14 39e-1
VS45 1 s45 0
L45 s45 0 56e-3
VS46 15 s46 0
L46 s46 8 18e-5
.control
set numdgt=17
ac lin 1 60 60
print v(1) v(2) v(3) v(4) v(5) v(6) v(7) v(8) v(9) v(10)
print v(11) v(12) v(13) v(14) v(15) v(16) v(17) v(18) v(19) v(20)
print v(21) v(22) v(23)
print i(vs0) i(vs1) i(vs2) i(vs3) i(vs4) i(vs5) i(vs6) i(vs7) i(vs8) i(vs9)
print i(vs10) i(vs11) i(vs12) i(vs13) i(vs14) i(vs15) i(vs16) i(vs17) i(vs18) i(vs19)
print i(vs20) i(vs21) i(vs22) i(vs23) i(vs24) i(vs25) i(vs26) i(vs27) i(vs28) i(vs29)
print i(vs30) i(vs31) i(vs32) i(vs33) i(vs34) i(vs35) i(vs36) i(vs37) i(vs38) i(vs39)
print i(vs40) i(vs41) i(vs42) i(vs43) i(vs44) i(vs45) i(vs46)
.endc
.end
