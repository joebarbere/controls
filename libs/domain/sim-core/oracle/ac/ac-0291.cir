controls oracle ac-0291
* Generated (plan F2.7, ADR 0012): do not edit; regenerate with `pnpm sim oracle regen`. ac seed 20261031 index 291 nodes 24 elements 46
.options sparse gmin=1e-12 noopac
RG1 1 0 1000000000000
RG2 2 0 1000000000000
RG3 3 0 1000000000000
RG4 4 0 1000000000000
RG5 5 0 1000000000000
RG6 6 0 1000000000000
RG7 7 0 1000000000000
RG8 8 0 1000000000000
RG9 9 0 1000000000000
RG10 10 0 1000000000000
RG11 11 0 1000000000000
RG12 12 0 1000000000000
RG13 13 0 1000000000000
RG14 14 0 1000000000000
RG15 15 0 1000000000000
RG16 16 0 1000000000000
RG17 17 0 1000000000000
RG18 18 0 1000000000000
RG19 19 0 1000000000000
RG20 20 0 1000000000000
RG21 21 0 1000000000000
RG22 22 0 1000000000000
RG23 23 0 1000000000000
VS0 0 s0 0
V0 e0 s0 DC 0 AC 56e-1 120
RI0 e0 22 39e-2
VS1 17 s1 0
L1 s1 5 68e-4
VS2 20 s2 0
R2 s2 1 33e-1
VS3 19 s3 0
V3 e3 s3 DC 0 AC 82e1 0
RI3 e3 3 39e-1
VS4 18 s4 0
L4 s4 5 10e-4
VS5 6 s5 0
L5 s5 21 12e-5
VS6 22 s6 0
R6 s6 2 82e0
VS7 6 s7 0
V7 e7 s7 DC 0 AC 15e1 -120
RI7 e7 m7 56e-3
LI7 m7 2 33e-7
VS8 23 s8 0
L8 s8 1 22e-3
VS9 4 s9 0
R9 s9 14 39e-1
VS10 13 s10 0
R10 s10 4 10e-1
VS11 8 s11 0
R11 s11 7 39e0
VS12 15 s12 0
V12 e12 s12 DC 0 AC 10e0 180
RI12 e12 18 33e-1
VS13 10 s13 0
V13 e13 s13 DC 0 AC 15e-1 180
RI13 e13 7 56e-1
VS14 18 s14 0
L14 s14 16 22e-5
VS15 8 s15 0
C15 s15 18 68e-5
VS16 14 s16 0
L16 s16 21 12e-5
VS17 2 s17 0
V17 e17 s17 DC 0 AC 15e0 0
RI17 e17 m17 68e-1
LI17 m17 17 18e-5
VS18 16 s18 0
R18 s18 5 82e3
VS19 12 s19 0
C19 s19 8 27e-4
VS20 21 s20 0
C20 s20 19 47e-4
VS21 16 s21 0
L21 s21 15 15e-4
VS22 1 s22 0
C22 s22 5 56e-6
VS23 23 s23 0
R23 s23 16 27e3
VS24 15 s24 0
L24 s24 8 18e-5
VS25 9 s25 0
R25 s25 23 12e3
VS26 19 s26 0
L26 s26 10 12e-5
VS27 18 s27 0
R27 s27 15 56e-1
VS28 18 s28 0
C28 s28 3 82e-5
VS29 20 s29 0
R29 s29 18 68e-2
VS30 16 s30 0
V30 e30 s30 DC 0 AC 15e0 0
RI30 e30 8 15e-1
VS31 8 s31 0
R31 s31 11 82e3
VS32 11 s32 0
C32 s32 20 56e-5
VS33 7 s33 0
V33 e33 s33 DC 0 AC 10e-1 -120
RI33 e33 m33 12e-3
LI33 m33 8 56e-7
VS34 4 s34 0
V34 e34 s34 DC 0 AC 12e-1 180
RI34 e34 m34 68e-2
LI34 m34 14 56e-6
VS35 3 s35 0
L35 s35 9 18e-2
VS36 14 s36 0
V36 e36 s36 DC 0 AC 68e1 120
RI36 e36 m36 68e-1
LI36 m36 9 68e-5
VS37 0 s37 0
R37 s37 19 47e-1
VS38 14 s38 0
L38 s38 3 33e-2
VS39 21 s39 0
C39 s39 13 18e-4
VS40 8 s40 0
L40 s40 21 12e-5
VS41 15 s41 0
L41 s41 13 12e-3
VS42 13 s42 0
R42 s42 3 12e-1
VS43 17 s43 0
V43 e43 s43 DC 0 AC 15e-1 120
RI43 e43 m43 10e-1
LI43 m43 3 10e-7
VS44 12 s44 0
V44 e44 s44 DC 0 AC 82e0 -120
RI44 e44 m44 15e-3
LI44 m44 20 12e-5
VS45 3 s45 0
C45 s45 5 15e-7
.control
set numdgt=17
ac lin 1 60 60
print v(1) v(2) v(3) v(4) v(5) v(6) v(7) v(8) v(9) v(10)
print v(11) v(12) v(13) v(14) v(15) v(16) v(17) v(18) v(19) v(20)
print v(21) v(22) v(23)
print i(vs0) i(vs1) i(vs2) i(vs3) i(vs4) i(vs5) i(vs6) i(vs7) i(vs8) i(vs9)
print i(vs10) i(vs11) i(vs12) i(vs13) i(vs14) i(vs15) i(vs16) i(vs17) i(vs18) i(vs19)
print i(vs20) i(vs21) i(vs22) i(vs23) i(vs24) i(vs25) i(vs26) i(vs27) i(vs28) i(vs29)
print i(vs30) i(vs31) i(vs32) i(vs33) i(vs34) i(vs35) i(vs36) i(vs37) i(vs38) i(vs39)
print i(vs40) i(vs41) i(vs42) i(vs43) i(vs44) i(vs45)
.endc
.end
