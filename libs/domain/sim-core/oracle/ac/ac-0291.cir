controls oracle ac-0291
* Generated (plan F2.7, ADR 0012): do not edit; regenerate with `pnpm sim oracle regen`. ac seed 20261031 index 291 nodes 24 elements 49
.options sparse gmin=1e-12 noopac
RG1 1 0 1000000000000
RG2 2 0 1000000000000
RG3 3 0 1000000000000
RG4 4 0 1000000000000
RG5 5 0 1000000000000
RG6 6 0 1000000000000
RG7 7 0 1000000000000
RG8 8 0 1000000000000
RG9 9 0 1000000000000
RG10 10 0 1000000000000
RG11 11 0 1000000000000
RG12 12 0 1000000000000
RG13 13 0 1000000000000
RG14 14 0 1000000000000
RG15 15 0 1000000000000
RG16 16 0 1000000000000
RG17 17 0 1000000000000
RG18 18 0 1000000000000
RG19 19 0 1000000000000
RG20 20 0 1000000000000
RG21 21 0 1000000000000
RG22 22 0 1000000000000
RG23 23 0 1000000000000
VS0 15 s0 0
C0 s0 3 18e-6
VS1 2 s1 0
C1 s1 6 12e-4
VS2 23 s2 0
R2 s2 15 47e-1
VS3 4 s3 0
R3 s3 14 39e-1
VS4 0 s4 0
V4 e4 s4 DC 0 AC 27e1 0
RI4 e4 n4 18e-1
H4 n4 h4 VS11 33e-3
ED4 h4 8 d4 0 -15e-7
F4 0 d4 VS11 1
LD4 d4 0 1
VS5 12 s5 0
C5 s5 8 27e-4
VS6 1 s6 0
R6 s6 11 39e-1
VS7 5 s7 0
C7 s7 0 15e-7
VS8 15 s8 0
L8 s8 8 18e-5
VS9 8 s9 0
C9 s9 18 68e-5
VS10 22 s10 0
R10 s10 20 56e1
VS11 11 s11 0
V11 e11 s11 DC 0 AC 68e-1 0
RI11 e11 n11 56e-2
H11 n11 h11 VS4 33e-3
ED11 h11 1 d11 0 -15e-7
F11 0 d11 VS4 1
LD11 d11 0 1
VS12 16 s12 0
L12 s12 4 39e-3
VS13 14 s13 0
V13 e13 s13 DC 0 AC 68e-1 0
RI13 e13 m13 39e-1
LI13 m13 12 33e-6
VS14 17 s14 0
V14 e14 s14 DC 0 AC 15e-1 120
RI14 e14 5 10e-1
VS15 7 s15 0
R15 s15 20 12e3
VS16 20 s16 0
R16 s16 18 68e-2
VS17 15 s17 0
C17 s17 21 39e-6
VS18 10 s18 0
V18 e18 s18 DC 0 AC 22e-1 180
RI18 e18 3 22e-1
VS19 2 s19 0
L19 s19 10 18e-2
VS20 15 s20 0
R20 s20 18 15e-2
VS21 15 s21 0
V21 e21 s21 DC 0 AC 39e0 -120
RI21 e21 10 33e-2
VS22 14 s22 0
V22 e22 s22 DC 0 AC 56e-1 -120
RI22 e22 m22 12e-1
LI22 m22 13 15e-6
VS23 4 s23 0
R23 s23 13 33e-1
VS24 13 s24 0
V24 e24 s24 DC 0 AC 82e-1 120
RI24 e24 m24 18e-2
LI24 m24 6 12e-5
VS25 0 s25 0
C25 s25 23 47e-6
VS26 3 s26 0
R26 s26 5 18e3
VS27 4 s27 0
C27 s27 14 56e-7
VS28 18 s28 0
R28 s28 15 56e-1
VS29 15 s29 0
C29 s29 2 22e-7
VS30 15 s30 0
R30 s30 7 82e0
VS31 21 s31 0
R31 s31 13 56e1
VS32 17 s32 0
V32 e32 s32 DC 0 AC 10e-1 180
RI32 e32 13 82e-1
VS33 12 s33 0
C33 s33 1 68e-4
VS34 14 s34 0
V34 e34 s34 DC 0 AC 39e-1 180
RI34 e34 15 47e-2
VS35 16 s35 0
R35 s35 15 33e-1
VS36 14 s36 0
L36 s36 5 33e-2
VS37 10 s37 0
R37 s37 12 47e2
VS38 16 s38 0
R38 s38 7 12e3
VS39 1 s39 0
L39 s39 19 56e-3
VS40 9 s40 0
V40 e40 s40 DC 0 AC 10e1 180
RI40 e40 15 27e-3
VS41 16 s41 0
R41 s41 20 18e2
VS42 2 s42 0
C42 s42 9 82e-4
VS43 15 s43 0
V43 e43 s43 DC 0 AC 10e0 180
RI43 e43 m43 33e-1
LI43 m43 18 68e-7
VS44 20 s44 0
V44 e44 s44 DC 0 AC 15e0 180
RI44 e44 m44 15e-2
LI44 m44 11 39e-6
VS45 19 s45 0
V45 e45 s45 DC 0 AC 15e-1 180
RI45 e45 m45 82e-1
LI45 m45 5 39e-7
VS46 3 s46 0
L46 s46 19 12e-3
VS47 18 s47 0
C47 s47 5 82e-5
VS48 18 s48 0
R48 s48 22 82e3
.control
set numdgt=17
ac lin 1 60 60
print v(1) v(2) v(3) v(4) v(5) v(6) v(7) v(8) v(9) v(10)
print v(11) v(12) v(13) v(14) v(15) v(16) v(17) v(18) v(19) v(20)
print v(21) v(22) v(23)
print i(vs0) i(vs1) i(vs2) i(vs3) i(vs4) i(vs5) i(vs6) i(vs7) i(vs8) i(vs9)
print i(vs10) i(vs11) i(vs12) i(vs13) i(vs14) i(vs15) i(vs16) i(vs17) i(vs18) i(vs19)
print i(vs20) i(vs21) i(vs22) i(vs23) i(vs24) i(vs25) i(vs26) i(vs27) i(vs28) i(vs29)
print i(vs30) i(vs31) i(vs32) i(vs33) i(vs34) i(vs35) i(vs36) i(vs37) i(vs38) i(vs39)
print i(vs40) i(vs41) i(vs42) i(vs43) i(vs44) i(vs45) i(vs46) i(vs47) i(vs48)
.endc
.end
