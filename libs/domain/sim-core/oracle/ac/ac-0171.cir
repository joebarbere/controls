controls oracle ac-0171
* Generated (plan F2.7, ADR 0012): do not edit; regenerate with `pnpm sim oracle regen`. ac seed 20261031 index 171 nodes 14 elements 16
.options sparse gmin=1e-12 noopac
RG1 1 0 1000000000000
RG2 2 0 1000000000000
RG3 3 0 1000000000000
RG4 4 0 1000000000000
RG5 5 0 1000000000000
RG6 6 0 1000000000000
RG7 7 0 1000000000000
RG8 8 0 1000000000000
RG9 9 0 1000000000000
RG10 10 0 1000000000000
RG11 11 0 1000000000000
RG12 12 0 1000000000000
RG13 13 0 1000000000000
VS0 4 s0 0
C0 s0 1 33e-6
VS1 12 s1 0
C1 s1 1 18e-6
VS2 12 s2 0
R2 s2 1 33e-2
VS3 3 s3 0
C3 s3 11 12e-4
VS4 6 s4 0
R4 s4 2 10e-2
VS5 8 s5 0
C5 s5 5 18e-5
VS6 13 s6 0
C6 s6 0 39e-4
VS7 1 s7 0
L7 s7 5 18e-2
VS8 13 s8 0
R8 s8 7 10e3
VS9 1 s9 0
L9 s9 0 27e-5
VS10 0 s10 0
V10 e10 s10 DC 0 AC 27e-1 -120
RI10 e10 3 22e-1
VS11 3 s11 0
R11 s11 6 18e3
VS12 0 s12 0
R12 s12 3 56e2
VS13 2 s13 0
L13 s13 1 33e-2
VS14 9 s14 0
C14 s14 10 39e-5
VS15 9 s15 0
V15 e15 s15 DC 0 AC 33e0 0
RI15 e15 7 68e-3
.control
set numdgt=17
ac lin 1 60 60
print v(1) v(2) v(3) v(4) v(5) v(6) v(7) v(8) v(9) v(10)
print v(11) v(12) v(13)
print i(vs0) i(vs1) i(vs2) i(vs3) i(vs4) i(vs5) i(vs6) i(vs7) i(vs8) i(vs9)
print i(vs10) i(vs11) i(vs12) i(vs13) i(vs14) i(vs15)
.endc
.end
