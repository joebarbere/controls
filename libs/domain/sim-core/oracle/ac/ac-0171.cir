controls oracle ac-0171
* Generated (plan F2.7, ADR 0012): do not edit; regenerate with `pnpm sim oracle regen`. ac seed 20261031 index 171 nodes 14 elements 21
.options sparse gmin=1e-12 noopac
RG1 1 0 1000000000000
RG2 2 0 1000000000000
RG3 3 0 1000000000000
RG4 4 0 1000000000000
RG5 5 0 1000000000000
RG6 6 0 1000000000000
RG7 7 0 1000000000000
RG8 8 0 1000000000000
RG9 9 0 1000000000000
RG10 10 0 1000000000000
RG11 11 0 1000000000000
RG12 12 0 1000000000000
RG13 13 0 1000000000000
VS0 4 s0 0
C0 s0 1 33e-6
VS1 13 s1 0
R1 s1 7 10e3
VS2 3 s2 0
C2 s2 11 12e-4
VS3 13 s3 0
C3 s3 0 39e-4
VS4 0 s4 0
V4 e4 s4 DC 0 AC 27e-1 -120
RI4 e4 3 22e-1
VS5 2 s5 0
L5 s5 1 33e-2
VS6 9 s6 0
C6 s6 10 39e-5
VS7 0 s7 0
R7 s7 3 56e2
VS8 1 s8 0
L8 s8 0 27e-5
VS9 10 s9 0
R9 s9 4 33e-1
VS10 13 s10 0
C10 s10 11 12e-4
VS11 0 s11 0
R11 s11 10 39e1
VS12 8 s12 0
C12 s12 5 18e-5
VS13 12 s13 0
C13 s13 1 18e-6
VS14 8 s14 0
L14 s14 2 82e-5
VS15 6 s15 0
R15 s15 2 10e-2
VS16 12 s16 0
R16 s16 1 33e-2
VS17 1 s17 0
L17 s17 5 18e-2
VS18 12 s18 0
R18 s18 13 27e-1
VS19 3 s19 0
R19 s19 6 18e3
VS20 9 s20 0
V20 e20 s20 DC 0 AC 33e0 0
RI20 e20 7 68e-3
.control
set numdgt=17
ac lin 1 60 60
print v(1) v(2) v(3) v(4) v(5) v(6) v(7) v(8) v(9) v(10)
print v(11) v(12) v(13)
print i(vs0) i(vs1) i(vs2) i(vs3) i(vs4) i(vs5) i(vs6) i(vs7) i(vs8) i(vs9)
print i(vs10) i(vs11) i(vs12) i(vs13) i(vs14) i(vs15) i(vs16) i(vs17) i(vs18) i(vs19)
print i(vs20)
.endc
.end
