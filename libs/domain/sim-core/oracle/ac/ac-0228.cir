controls oracle ac-0228
* Generated (plan F2.7, ADR 0012): do not edit; regenerate with `pnpm sim oracle regen`. ac seed 20261031 index 228 nodes 15 elements 26
.options sparse gmin=1e-12 noopac
RG1 1 0 1000000000000
RG2 2 0 1000000000000
RG3 3 0 1000000000000
RG4 4 0 1000000000000
RG5 5 0 1000000000000
RG6 6 0 1000000000000
RG7 7 0 1000000000000
RG8 8 0 1000000000000
RG9 9 0 1000000000000
RG10 10 0 1000000000000
RG11 11 0 1000000000000
RG12 12 0 1000000000000
RG13 13 0 1000000000000
RG14 14 0 1000000000000
VS0 0 s0 0
V0 e0 s0 DC 0 AC 33e1 -120
RI0 e0 1 22e-2
VS1 2 s1 0
R1 s1 14 47e3
VS2 4 s2 0
R2 s2 9 82e2
VS3 6 s3 0
C3 s3 2 39e-4
VS4 12 s4 0
R4 s4 3 39e-2
VS5 12 s5 0
R5 s5 2 47e0
VS6 9 s6 0
R6 s6 1 47e-2
VS7 6 s7 0
C7 s7 11 82e-6
VS8 13 s8 0
C8 s8 2 68e-6
VS9 6 s9 0
R9 s9 4 22e0
VS10 4 s10 0
C10 s10 8 12e-7
VS11 9 s11 0
C11 s11 1 39e-5
VS12 7 s12 0
L12 s12 0 68e-4
VS13 5 s13 0
R13 s13 6 47e3
VS14 4 s14 0
V14 e14 s14 DC 0 AC 68e1 0
RI14 e14 12 39e-1
VS15 7 s15 0
C15 s15 0 22e-5
VS16 10 s16 0
R16 s16 0 82e-2
VS17 7 s17 0
C17 s17 13 39e-5
VS18 14 s18 0
V18 e18 s18 DC 0 AC 68e-1 120
RI18 e18 4 39e-2
VS19 0 s19 0
L19 s19 3 15e-2
VS20 12 s20 0
C20 s20 9 39e-5
VS21 8 s21 0
V21 e21 s21 DC 0 AC 39e0 0
RI21 e21 10 68e-3
VS22 7 s22 0
R22 s22 9 33e3
VS23 12 s23 0
R23 s23 5 33e-2
VS24 11 s24 0
R24 s24 7 27e3
VS25 12 s25 0
R25 s25 8 33e-1
.control
set numdgt=17
ac lin 1 60 60
print v(1) v(2) v(3) v(4) v(5) v(6) v(7) v(8) v(9) v(10)
print v(11) v(12) v(13) v(14)
print i(vs0) i(vs1) i(vs2) i(vs3) i(vs4) i(vs5) i(vs6) i(vs7) i(vs8) i(vs9)
print i(vs10) i(vs11) i(vs12) i(vs13) i(vs14) i(vs15) i(vs16) i(vs17) i(vs18) i(vs19)
print i(vs20) i(vs21) i(vs22) i(vs23) i(vs24) i(vs25)
.endc
.end
