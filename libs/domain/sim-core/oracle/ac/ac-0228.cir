controls oracle ac-0228
* Generated (plan F2.7, ADR 0012): do not edit; regenerate with `pnpm sim oracle regen`. ac seed 20261031 index 228 nodes 15 elements 26
.options sparse gmin=1e-12 noopac
RG1 1 0 1000000000000
RG2 2 0 1000000000000
RG3 3 0 1000000000000
RG4 4 0 1000000000000
RG5 5 0 1000000000000
RG6 6 0 1000000000000
RG7 7 0 1000000000000
RG8 8 0 1000000000000
RG9 9 0 1000000000000
RG10 10 0 1000000000000
RG11 11 0 1000000000000
RG12 12 0 1000000000000
RG13 13 0 1000000000000
RG14 14 0 1000000000000
VS0 11 s0 0
R0 s0 6 12e-2
VS1 0 s1 0
V1 e1 s1 DC 0 AC 47e1 -120
RI1 e1 8 82e-3
VS2 4 s2 0
V2 e2 s2 DC 0 AC 68e1 0
RI2 e2 12 39e-1
VS3 13 s3 0
L3 s3 6 27e-3
VS4 7 s4 0
V4 e4 s4 DC 0 AC 39e-1 -120
RI4 e4 5 10e-1
VS5 8 s5 0
R5 s5 1 33e2
VS6 6 s6 0
L6 s6 4 56e-2
VS7 4 s7 0
C7 s7 7 12e-7
VS8 6 s8 0
L8 s8 0 18e-4
VS9 14 s9 0
L9 s9 6 22e-5
VS10 6 s10 0
C10 s10 2 47e-6
VS11 5 s11 0
V11 e11 s11 DC 0 AC 47e0 180
RI11 e11 10 10e-2
VS12 12 s12 0
V12 e12 s12 DC 0 AC 15e0 -120
RI12 e12 m12 68e-2
LI12 m12 9 27e-7
VS13 13 s13 0
L13 s13 9 15e-3
VS14 12 s14 0
R14 s14 6 27e2
VS15 10 s15 0
R15 s15 3 68e-2
VS16 9 s16 0
R16 s16 13 27e2
VS17 11 s17 0
L17 s17 4 15e-3
VS18 2 s18 0
R18 s18 4 15e-1
VS19 12 s19 0
C19 s19 5 68e-5
VS20 2 s20 0
R20 s20 0 27e2
VS21 14 s21 0
L21 s21 3 27e-3
VS22 9 s22 0
C22 s22 0 82e-5
VS23 13 s23 0
L23 s23 14 56e-3
VS24 1 s24 0
V24 e24 s24 DC 0 AC 15e0 180
RI24 e24 12 27e-1
VS25 8 s25 0
L25 s25 7 10e-2
.control
set numdgt=17
ac lin 1 60 60
print v(1) v(2) v(3) v(4) v(5) v(6) v(7) v(8) v(9) v(10)
print v(11) v(12) v(13) v(14)
print i(vs0) i(vs1) i(vs2) i(vs3) i(vs4) i(vs5) i(vs6) i(vs7) i(vs8) i(vs9)
print i(vs10) i(vs11) i(vs12) i(vs13) i(vs14) i(vs15) i(vs16) i(vs17) i(vs18) i(vs19)
print i(vs20) i(vs21) i(vs22) i(vs23) i(vs24) i(vs25)
.endc
.end
