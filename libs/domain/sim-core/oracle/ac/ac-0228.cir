controls oracle ac-0228
* Generated (plan F2.7, ADR 0012): do not edit; regenerate with `pnpm sim oracle regen`. ac seed 20261031 index 228 nodes 15 elements 24
.options sparse gmin=1e-12 noopac
RG1 1 0 1000000000000
RG2 2 0 1000000000000
RG3 3 0 1000000000000
RG4 4 0 1000000000000
RG5 5 0 1000000000000
RG6 6 0 1000000000000
RG7 7 0 1000000000000
RG8 8 0 1000000000000
RG9 9 0 1000000000000
RG10 10 0 1000000000000
RG11 11 0 1000000000000
RG12 12 0 1000000000000
RG13 13 0 1000000000000
RG14 14 0 1000000000000
VS0 14 s0 0
L0 s0 6 22e-5
VS1 6 s1 0
C1 s1 2 47e-6
VS2 0 s2 0
V2 e2 s2 DC 0 AC 68e1 0
RI2 e2 12 39e-1
VS3 7 s3 0
V3 e3 s3 DC 0 AC 47e1 -120
RI3 e3 8 82e-3
VS4 14 s4 0
L4 s4 3 27e-3
VS5 6 s5 0
L5 s5 7 18e-4
VS6 2 s6 0
R6 s6 7 27e2
VS7 1 s7 0
V7 e7 s7 DC 0 AC 15e0 180
RI7 e7 12 27e-1
VS8 4 s8 0
V8 e8 s8 DC 0 AC 39e-1 -120
RI8 e8 5 10e-1
VS9 9 s9 0
C9 s9 7 82e-5
VS10 2 s10 0
R10 s10 0 15e-1
VS11 12 s11 0
C11 s11 5 68e-5
VS12 11 s12 0
R12 s12 6 12e-2
VS13 5 s13 0
V13 e13 s13 DC 0 AC 47e0 180
RI13 e13 10 10e-2
VS14 13 s14 0
L14 s14 9 15e-3
VS15 0 s15 0
C15 s15 4 12e-7
VS16 8 s16 0
L16 s16 4 10e-2
VS17 12 s17 0
V17 e17 s17 DC 0 AC 15e0 -120
RI17 e17 9 68e-2
VS18 13 s18 0
L18 s18 6 27e-3
VS19 12 s19 0
R19 s19 6 27e2
VS20 13 s20 0
L20 s20 14 56e-3
VS21 9 s21 0
R21 s21 13 27e2
VS22 8 s22 0
R22 s22 1 33e2
VS23 6 s23 0
L23 s23 0 56e-2
.control
set numdgt=17
ac lin 1 60 60
print v(1) v(2) v(3) v(4) v(5) v(6) v(7) v(8) v(9) v(10)
print v(11) v(12) v(13) v(14)
print i(vs0) i(vs1) i(vs2) i(vs3) i(vs4) i(vs5) i(vs6) i(vs7) i(vs8) i(vs9)
print i(vs10) i(vs11) i(vs12) i(vs13) i(vs14) i(vs15) i(vs16) i(vs17) i(vs18) i(vs19)
print i(vs20) i(vs21) i(vs22) i(vs23)
.endc
.end
