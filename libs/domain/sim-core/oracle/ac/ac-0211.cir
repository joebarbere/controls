controls oracle ac-0211
* Generated (plan F2.7, ADR 0012): do not edit; regenerate with `pnpm sim oracle regen`. ac seed 20261031 index 211 nodes 8 elements 11
.options sparse gmin=1e-12 noopac
RG1 1 0 1000000000000
RG2 2 0 1000000000000
RG3 3 0 1000000000000
RG4 4 0 1000000000000
RG5 5 0 1000000000000
RG6 6 0 1000000000000
RG7 7 0 1000000000000
VS0 7 s0 0
R0 s0 1 82e2
VS1 0 s1 0
V1 e1 s1 DC 0 AC 15e-1 180
RI1 e1 1 12e-3
VS2 2 s2 0
R2 s2 6 68e3
VS3 4 s3 0
C3 s3 6 33e-7
VS4 0 s4 0
V4 e4 s4 DC 0 AC 15e-1 -120
RI4 e4 3 39e-3
VS5 7 s5 0
C5 s5 6 39e-7
VS6 5 s6 0
R6 s6 0 68e-2
VS7 5 s7 0
L7 s7 0 15e-2
VS8 4 s8 0
L8 s8 6 82e-2
VS9 1 s9 0
R9 s9 6 56e-2
VS10 0 s10 0
L10 s10 1 22e-4
.control
set numdgt=17
ac lin 1 60 60
print v(1) v(2) v(3) v(4) v(5) v(6) v(7)
print i(vs0) i(vs1) i(vs2) i(vs3) i(vs4) i(vs5) i(vs6) i(vs7) i(vs8) i(vs9)
print i(vs10)
.endc
.end
