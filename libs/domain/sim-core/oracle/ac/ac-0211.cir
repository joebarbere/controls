controls oracle ac-0211
* Generated (plan F2.7, ADR 0012): do not edit; regenerate with `pnpm sim oracle regen`. ac seed 20261031 index 211 nodes 8 elements 13
.options sparse gmin=1e-12 noopac
RG1 1 0 1000000000000
RG2 2 0 1000000000000
RG3 3 0 1000000000000
RG4 4 0 1000000000000
RG5 5 0 1000000000000
RG6 6 0 1000000000000
RG7 7 0 1000000000000
VS0 4 s0 0
C0 s0 6 33e-7
VS1 0 s1 0
V1 e1 s1 DC 0 AC 15e-1 -120
RI1 e1 n1 39e-3
H1 n1 h1 VS8 -39e-4
ED1 h1 3 d1 0 -22e-6
F1 0 d1 VS8 1
LD1 d1 0 1
VS2 5 s2 0
R2 s2 1 18e2
VS3 7 s3 0
C3 s3 6 39e-7
VS4 4 s4 0
L4 s4 6 82e-2
VS5 2 s5 0
R5 s5 3 68e1
VS6 5 s6 0
R6 s6 0 68e-2
VS7 7 s7 0
C7 s7 4 39e-6
VS8 0 s8 0
V8 e8 s8 DC 0 AC 15e-1 180
RI8 e8 n8 12e-3
H8 n8 h8 VS1 -39e-4
ED8 h8 1 d8 0 -22e-6
F8 0 d8 VS1 1
LD8 d8 0 1
VS9 1 s9 0
R9 s9 6 56e-2
VS10 7 s10 0
R10 s10 1 82e2
VS11 5 s11 0
L11 s11 0 15e-2
VS12 2 s12 0
R12 s12 6 68e3
.control
set numdgt=17
ac lin 1 60 60
print v(1) v(2) v(3) v(4) v(5) v(6) v(7)
print i(vs0) i(vs1) i(vs2) i(vs3) i(vs4) i(vs5) i(vs6) i(vs7) i(vs8) i(vs9)
print i(vs10) i(vs11) i(vs12)
.endc
.end
