controls oracle ac-0211
* Generated (plan F2.7, ADR 0012): do not edit; regenerate with `pnpm sim oracle regen`. ac seed 20261031 index 211 nodes 8 elements 12
.options sparse gmin=1e-12 noopac
RG1 1 0 1000000000000
RG2 2 0 1000000000000
RG3 3 0 1000000000000
RG4 4 0 1000000000000
RG5 5 0 1000000000000
RG6 6 0 1000000000000
RG7 7 0 1000000000000
VS0 0 s0 0
V0 e0 s0 DC 0 AC 15e-1 180
RI0 e0 m0 12e-3
LI0 m0 1 22e-6
VS1 4 s1 0
C1 s1 6 33e-7
VS2 1 s2 0
C2 s2 5 18e-7
VS3 2 s3 0
R3 s3 6 68e3
VS4 2 s4 0
R4 s4 3 68e1
VS5 1 s5 0
R5 s5 6 56e-2
VS6 7 s6 0
C6 s6 6 39e-7
VS7 7 s7 0
R7 s7 1 82e2
VS8 5 s8 0
R8 s8 0 68e-2
VS9 4 s9 0
L9 s9 6 82e-2
VS10 7 s10 0
C10 s10 4 39e-6
VS11 3 s11 0
L11 s11 0 39e-5
.control
set numdgt=17
ac lin 1 60 60
print v(1) v(2) v(3) v(4) v(5) v(6) v(7)
print i(vs0) i(vs1) i(vs2) i(vs3) i(vs4) i(vs5) i(vs6) i(vs7) i(vs8) i(vs9)
print i(vs10) i(vs11)
.endc
.end
