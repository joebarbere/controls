controls oracle ac-0009
* Generated (plan F2.7, ADR 0012): do not edit; regenerate with `pnpm sim oracle regen`. ac seed 20261031 index 9 nodes 3 elements 5
.options sparse gmin=1e-12 noopac
RG1 1 0 1000000000000
RG2 2 0 1000000000000
VS0 0 s0 0
V0 e0 s0 DC 0 AC 15e1 -120
RI0 e0 1 33e-3
VS1 0 s1 0
C1 s1 2 15e-4
VS2 1 s2 0
C2 s2 2 12e-7
VS3 1 s3 0
V3 e3 s3 DC 0 AC 68e0 -120
RI3 e3 2 47e-1
VS4 1 s4 0
L4 s4 2 22e-4
.control
set numdgt=17
ac lin 1 60 60
print v(1) v(2)
print i(vs0) i(vs1) i(vs2) i(vs3) i(vs4)
.endc
.end
