controls oracle ac-0009
* Generated (plan F2.7, ADR 0012): do not edit; regenerate with `pnpm sim oracle regen`. ac seed 20261031 index 9 nodes 3 elements 5
.options sparse gmin=1e-12 noopac
RG1 1 0 1000000000000
RG2 2 0 1000000000000
VS0 0 s0 0
L0 s0 1 33e-2
VS1 0 s1 0
V1 e1 s1 DC 0 AC 10e0 0
RI1 e1 2 39e-3
VS2 0 s2 0
L2 s2 1 82e-5
VS3 2 s3 0
L3 s3 1 47e-3
VS4 1 s4 0
V4 e4 s4 DC 0 AC 15e1 -120
RI4 e4 0 33e-3
.control
set numdgt=17
ac lin 1 60 60
print v(1) v(2)
print i(vs0) i(vs1) i(vs2) i(vs3) i(vs4)
.endc
.end
