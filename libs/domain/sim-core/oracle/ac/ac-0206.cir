controls oracle ac-0206
* Generated (plan F2.7, ADR 0012): do not edit; regenerate with `pnpm sim oracle regen`. ac seed 20261031 index 206 nodes 26 elements 39
.options sparse gmin=1e-12 noopac
RG1 1 0 1000000000000
RG2 2 0 1000000000000
RG3 3 0 1000000000000
RG4 4 0 1000000000000
RG5 5 0 1000000000000
RG6 6 0 1000000000000
RG7 7 0 1000000000000
RG8 8 0 1000000000000
RG9 9 0 1000000000000
RG10 10 0 1000000000000
RG11 11 0 1000000000000
RG12 12 0 1000000000000
RG13 13 0 1000000000000
RG14 14 0 1000000000000
RG15 15 0 1000000000000
RG16 16 0 1000000000000
RG17 17 0 1000000000000
RG18 18 0 1000000000000
RG19 19 0 1000000000000
RG20 20 0 1000000000000
RG21 21 0 1000000000000
RG22 22 0 1000000000000
RG23 23 0 1000000000000
RG24 24 0 1000000000000
RG25 25 0 1000000000000
VS0 0 s0 0
V0 e0 s0 DC 0 AC 12e1 -120
RI0 e0 2 12e-3
VS1 19 s1 0
C1 s1 16 47e-5
VS2 18 s2 0
R2 s2 19 33e0
VS3 11 s3 0
R3 s3 10 15e-2
VS4 18 s4 0
V4 e4 s4 DC 0 AC 68e0 0
RI4 e4 19 47e-3
VS5 6 s5 0
R5 s5 18 39e-2
VS6 3 s6 0
C6 s6 7 68e-4
VS7 22 s7 0
R7 s7 7 18e-2
VS8 23 s8 0
C8 s8 8 22e-5
VS9 24 s9 0
C9 s9 11 47e-5
VS10 21 s10 0
V10 e10 s10 DC 0 AC 15e1 0
RI10 e10 7 27e-2
VS11 14 s11 0
R11 s11 18 15e-2
VS12 12 s12 0
R12 s12 21 27e1
VS13 19 s13 0
R13 s13 6 18e-2
VS14 6 s14 0
R14 s14 14 47e3
VS15 25 s15 0
L15 s15 2 22e-2
VS16 7 s16 0
C16 s16 25 18e-5
VS17 17 s17 0
V17 e17 s17 DC 0 AC 15e0 0
RI17 e17 20 56e-3
VS18 9 s18 0
C18 s18 11 56e-6
VS19 25 s19 0
C19 s19 5 82e-7
VS20 8 s20 0
C20 s20 17 56e-6
VS21 5 s21 0
L21 s21 1 56e-2
VS22 8 s22 0
V22 e22 s22 DC 0 AC 12e1 0
RI22 e22 6 15e-1
VS23 19 s23 0
V23 e23 s23 DC 0 AC 82e-1 0
RI23 e23 12 56e-1
VS24 5 s24 0
L24 s24 0 22e-5
VS25 16 s25 0
V25 e25 s25 DC 0 AC 47e0 180
RI25 e25 24 33e-1
VS26 4 s26 0
V26 e26 s26 DC 0 AC 15e1 120
RI26 e26 14 18e-3
VS27 5 s27 0
V27 e27 s27 DC 0 AC 39e-1 0
RI27 e27 13 47e-2
VS28 17 s28 0
L28 s28 18 27e-5
VS29 7 s29 0
R29 s29 21 33e-1
VS30 23 s30 0
V30 e30 s30 DC 0 AC 10e1 180
RI30 e30 2 47e-3
VS31 22 s31 0
V31 e31 s31 DC 0 AC 82e0 120
RI31 e31 17 12e-2
VS32 19 s32 0
V32 e32 s32 DC 0 AC 18e1 0
RI32 e32 6 18e-1
VS33 14 s33 0
R33 s33 5 82e-2
VS34 1 s34 0
L34 s34 11 82e-4
VS35 7 s35 0
C35 s35 3 56e-6
VS36 21 s36 0
C36 s36 9 47e-6
VS37 7 s37 0
L37 s37 15 56e-5
VS38 12 s38 0
C38 s38 7 27e-7
.control
set numdgt=17
ac lin 1 60 60
print v(1) v(2) v(3) v(4) v(5) v(6) v(7) v(8) v(9) v(10)
print v(11) v(12) v(13) v(14) v(15) v(16) v(17) v(18) v(19) v(20)
print v(21) v(22) v(23) v(24) v(25)
print i(vs0) i(vs1) i(vs2) i(vs3) i(vs4) i(vs5) i(vs6) i(vs7) i(vs8) i(vs9)
print i(vs10) i(vs11) i(vs12) i(vs13) i(vs14) i(vs15) i(vs16) i(vs17) i(vs18) i(vs19)
print i(vs20) i(vs21) i(vs22) i(vs23) i(vs24) i(vs25) i(vs26) i(vs27) i(vs28) i(vs29)
print i(vs30) i(vs31) i(vs32) i(vs33) i(vs34) i(vs35) i(vs36) i(vs37) i(vs38)
.endc
.end
