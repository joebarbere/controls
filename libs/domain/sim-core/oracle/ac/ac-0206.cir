controls oracle ac-0206
* Generated (plan F2.7, ADR 0012): do not edit; regenerate with `pnpm sim oracle regen`. ac seed 20261031 index 206 nodes 26 elements 38
.options sparse gmin=1e-12 noopac
RG1 1 0 1000000000000
RG2 2 0 1000000000000
RG3 3 0 1000000000000
RG4 4 0 1000000000000
RG5 5 0 1000000000000
RG6 6 0 1000000000000
RG7 7 0 1000000000000
RG8 8 0 1000000000000
RG9 9 0 1000000000000
RG10 10 0 1000000000000
RG11 11 0 1000000000000
RG12 12 0 1000000000000
RG13 13 0 1000000000000
RG14 14 0 1000000000000
RG15 15 0 1000000000000
RG16 16 0 1000000000000
RG17 17 0 1000000000000
RG18 18 0 1000000000000
RG19 19 0 1000000000000
RG20 20 0 1000000000000
RG21 21 0 1000000000000
RG22 22 0 1000000000000
RG23 23 0 1000000000000
RG24 24 0 1000000000000
RG25 25 0 1000000000000
VS0 10 s0 0
L0 s0 17 47e-2
VS1 8 s1 0
L1 s1 19 22e-4
VS2 4 s2 0
L2 s2 17 15e-4
VS3 7 s3 0
C3 s3 1 15e-6
VS4 0 s4 0
V4 e4 s4 DC 0 AC 27e1 180
RI4 e4 m4 33e-1
LI4 m4 19 22e-6
VS5 15 s5 0
V5 e5 s5 DC 0 AC 18e-1 120
RI5 e5 m5 33e-1
LI5 m5 11 22e-5
VS6 7 s6 0
L6 s6 0 27e-4
VS7 22 s7 0
V7 e7 s7 DC 0 AC 82e-1 180
RI7 e7 m7 47e-2
LI7 m7 25 56e-5
VS8 10 s8 0
R8 s8 24 15e-2
VS9 24 s9 0
V9 e9 s9 DC 0 AC 47e1 120
RI9 e9 3 68e-2
VS10 25 s10 0
V10 e10 s10 DC 0 AC 27e0 120
RI10 e10 21 27e-3
VS11 3 s11 0
V11 e11 s11 DC 0 AC 68e0 -120
RI11 e11 m11 12e-3
LI11 m11 11 22e-5
VS12 19 s12 0
C12 s12 23 56e-5
VS13 20 s13 0
R13 s13 25 68e-2
VS14 5 s14 0
L14 s14 6 22e-5
VS15 21 s15 0
V15 e15 s15 DC 0 AC 18e0 0
RI15 e15 m15 82e-1
LI15 m15 3 18e-5
VS16 19 s16 0
R16 s16 22 18e-2
VS17 14 s17 0
R17 s17 5 82e-2
VS18 18 s18 0
V18 e18 s18 DC 0 AC 39e-1 -120
RI18 e18 m18 68e-2
LI18 m18 1 82e-7
VS19 22 s19 0
R19 s19 14 47e3
VS20 1 s20 0
L20 s20 23 27e-3
VS21 18 s21 0
R21 s21 19 33e0
VS22 11 s22 0
L22 s22 6 10e-2
VS23 17 s23 0
C23 s23 14 18e-5
VS24 19 s24 0
C24 s24 4 68e-4
VS25 13 s25 0
C25 s25 18 27e-7
VS26 9 s26 0
L26 s26 25 15e-4
VS27 12 s27 0
R27 s27 9 39e-2
VS28 8 s28 0
V28 e28 s28 DC 0 AC 56e1 180
RI28 e28 m28 15e-2
LI28 m28 20 10e-5
VS29 24 s29 0
R29 s29 2 15e2
VS30 16 s30 0
V30 e30 s30 DC 0 AC 22e1 -120
RI30 e30 4 15e-3
VS31 7 s31 0
V31 e31 s31 DC 0 AC 39e-1 180
RI31 e31 m31 22e-1
LI31 m31 25 15e-6
VS32 22 s32 0
L32 s32 2 27e-2
VS33 5 s33 0
V33 e33 s33 DC 0 AC 39e-1 0
RI33 e33 m33 47e-2
LI33 m33 13 12e-6
VS34 6 s34 0
L34 s34 16 27e-5
VS35 15 s35 0
R35 s35 22 15e1
VS36 25 s36 0
C36 s36 8 12e-7
VS37 12 s37 0
L37 s37 21 12e-3
.control
set numdgt=17
ac lin 1 60 60
print v(1) v(2) v(3) v(4) v(5) v(6) v(7) v(8) v(9) v(10)
print v(11) v(12) v(13) v(14) v(15) v(16) v(17) v(18) v(19) v(20)
print v(21) v(22) v(23) v(24) v(25)
print i(vs0) i(vs1) i(vs2) i(vs3) i(vs4) i(vs5) i(vs6) i(vs7) i(vs8) i(vs9)
print i(vs10) i(vs11) i(vs12) i(vs13) i(vs14) i(vs15) i(vs16) i(vs17) i(vs18) i(vs19)
print i(vs20) i(vs21) i(vs22) i(vs23) i(vs24) i(vs25) i(vs26) i(vs27) i(vs28) i(vs29)
print i(vs30) i(vs31) i(vs32) i(vs33) i(vs34) i(vs35) i(vs36) i(vs37)
.endc
.end
