controls oracle ac-0234
* Generated (plan F2.7, ADR 0012): do not edit; regenerate with `pnpm sim oracle regen`. ac seed 20261031 index 234 nodes 8 elements 14
.options sparse gmin=1e-12 noopac
RG1 1 0 1000000000000
RG2 2 0 1000000000000
RG3 3 0 1000000000000
RG4 4 0 1000000000000
RG5 5 0 1000000000000
RG6 6 0 1000000000000
RG7 7 0 1000000000000
VS0 0 s0 0
V0 e0 s0 DC 0 AC 68e-1 120
RI0 e0 1 15e-1
VS1 5 s1 0
L1 s1 4 22e-2
VS2 6 s2 0
C2 s2 2 22e-4
VS3 5 s3 0
V3 e3 s3 DC 0 AC 22e-1 0
RI3 e3 m3 10e-2
LI3 m3 6 82e-5
VS4 0 s4 0
R4 s4 3 10e3
VS5 2 s5 0
V5 e5 s5 DC 0 AC 33e-1 0
RI5 e5 1 15e-2
VS6 3 s6 0
V6 e6 s6 DC 0 AC 22e-1 120
RI6 e6 m6 27e-3
LI6 m6 1 39e-5
VS7 4 s7 0
V7 e7 s7 DC 0 AC 22e1 0
RI7 e7 m7 18e-3
LI7 m7 3 18e-6
VS8 1 s8 0
C8 s8 0 33e-4
VS9 4 s9 0
C9 s9 7 15e-7
VS10 7 s10 0
V10 e10 s10 DC 0 AC 15e0 180
RI10 e10 m10 82e-1
LI10 m10 6 22e-7
VS11 2 s11 0
C11 s11 6 47e-5
VS12 4 s12 0
L12 s12 0 15e-2
VS13 2 s13 0
L13 s13 7 15e-4
.control
set numdgt=17
ac lin 1 60 60
print v(1) v(2) v(3) v(4) v(5) v(6) v(7)
print i(vs0) i(vs1) i(vs2) i(vs3) i(vs4) i(vs5) i(vs6) i(vs7) i(vs8) i(vs9)
print i(vs10) i(vs11) i(vs12) i(vs13)
.endc
.end
