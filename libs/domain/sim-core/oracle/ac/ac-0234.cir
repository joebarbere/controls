controls oracle ac-0234
* Generated (plan F2.7, ADR 0012): do not edit; regenerate with `pnpm sim oracle regen`. ac seed 20261031 index 234 nodes 8 elements 12
.options sparse gmin=1e-12 noopac
RG1 1 0 1000000000000
RG2 2 0 1000000000000
RG3 3 0 1000000000000
RG4 4 0 1000000000000
RG5 5 0 1000000000000
RG6 6 0 1000000000000
RG7 7 0 1000000000000
VS0 7 s0 0
L0 s0 5 33e-5
VS1 3 s1 0
R1 s1 1 10e1
VS2 6 s2 0
R2 s2 2 15e-2
VS3 6 s3 0
R3 s3 5 39e0
VS4 0 s4 0
V4 e4 s4 DC 0 AC 22e1 0
RI4 e4 m4 18e-3
LI4 m4 3 22e-5
VS5 2 s5 0
V5 e5 s5 DC 0 AC 12e0 120
RI5 e5 6 68e-1
VS6 0 s6 0
R6 s6 7 15e0
VS7 0 s7 0
L7 s7 6 27e-3
VS8 4 s8 0
V8 e8 s8 DC 0 AC 10e-1 -120
RI8 e8 6 27e-1
VS9 4 s9 0
C9 s9 0 12e-5
VS10 1 s10 0
C10 s10 7 22e-5
VS11 2 s11 0
V11 e11 s11 DC 0 AC 15e1 0
RI11 e11 3 82e-2
.control
set numdgt=17
ac lin 1 60 60
print v(1) v(2) v(3) v(4) v(5) v(6) v(7)
print i(vs0) i(vs1) i(vs2) i(vs3) i(vs4) i(vs5) i(vs6) i(vs7) i(vs8) i(vs9)
print i(vs10) i(vs11)
.endc
.end
