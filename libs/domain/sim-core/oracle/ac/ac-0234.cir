controls oracle ac-0234
* Generated (plan F2.7, ADR 0012): do not edit; regenerate with `pnpm sim oracle regen`. ac seed 20261031 index 234 nodes 8 elements 11
.options sparse gmin=1e-12 noopac
RG1 1 0 1000000000000
RG2 2 0 1000000000000
RG3 3 0 1000000000000
RG4 4 0 1000000000000
RG5 5 0 1000000000000
RG6 6 0 1000000000000
RG7 7 0 1000000000000
VS0 0 s0 0
V0 e0 s0 DC 0 AC 22e1 0
RI0 e0 3 18e-3
VS1 4 s1 0
V1 e1 s1 DC 0 AC 10e-1 -120
RI1 e1 6 27e-1
VS2 1 s2 0
C2 s2 7 22e-5
VS3 2 s3 0
V3 e3 s3 DC 0 AC 12e0 120
RI3 e3 6 68e-1
VS4 4 s4 0
C4 s4 0 12e-5
VS5 6 s5 0
R5 s5 2 15e-2
VS6 0 s6 0
R6 s6 7 15e0
VS7 7 s7 0
L7 s7 5 33e-5
VS8 0 s8 0
L8 s8 6 27e-3
VS9 3 s9 0
R9 s9 1 10e1
VS10 2 s10 0
V10 e10 s10 DC 0 AC 15e1 0
RI10 e10 3 82e-2
.control
set numdgt=17
ac lin 1 60 60
print v(1) v(2) v(3) v(4) v(5) v(6) v(7)
print i(vs0) i(vs1) i(vs2) i(vs3) i(vs4) i(vs5) i(vs6) i(vs7) i(vs8) i(vs9)
print i(vs10)
.endc
.end
