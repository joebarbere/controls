controls oracle ac-0377
* Generated (plan F2.7, ADR 0012): do not edit; regenerate with `pnpm sim oracle regen`. ac seed 20261031 index 377 nodes 17 elements 30
.options sparse gmin=1e-12 noopac
RG1 1 0 1000000000000
RG2 2 0 1000000000000
RG3 3 0 1000000000000
RG4 4 0 1000000000000
RG5 5 0 1000000000000
RG6 6 0 1000000000000
RG7 7 0 1000000000000
RG8 8 0 1000000000000
RG9 9 0 1000000000000
RG10 10 0 1000000000000
RG11 11 0 1000000000000
RG12 12 0 1000000000000
RG13 13 0 1000000000000
RG14 14 0 1000000000000
RG15 15 0 1000000000000
RG16 16 0 1000000000000
VS0 0 s0 0
V0 e0 s0 DC 0 AC 27e-1 120
RI0 e0 6 56e-1
VS1 9 s1 0
C1 s1 8 39e-4
VS2 14 s2 0
V2 e2 s2 DC 0 AC 39e0 180
RI2 e2 13 68e-1
VS3 13 s3 0
V3 e3 s3 DC 0 AC 12e-1 0
RI3 e3 m3 33e-1
LI3 m3 5 15e-7
VS4 11 s4 0
R4 s4 12 47e1
VS5 4 s5 0
L5 s5 10 18e-3
VS6 6 s6 0
R6 s6 7 56e2
VS7 9 s7 0
R7 s7 2 47e0
VS8 16 s8 0
R8 s8 0 33e1
VS9 0 s9 0
V9 e9 s9 DC 0 AC 56e1 120
RI9 e9 m9 22e-1
LI9 m9 6 39e-5
VS10 1 s10 0
R10 s10 10 39e-2
VS11 3 s11 0
C11 s11 11 10e-5
VS12 6 s12 0
V12 e12 s12 DC 0 AC 12e0 0
RI12 e12 m12 82e-2
LI12 m12 13 22e-5
VS13 15 s13 0
R13 s13 14 47e2
VS14 10 s14 0
V14 e14 s14 DC 0 AC 15e1 -120
RI14 e14 m14 39e-2
LI14 m14 13 39e-5
VS15 4 s15 0
R15 s15 12 22e1
VS16 8 s16 0
R16 s16 3 82e-1
VS17 9 s17 0
L17 s17 6 68e-4
VS18 8 s18 0
V18 e18 s18 DC 0 AC 68e0 0
RI18 e18 11 27e-2
VS19 9 s19 0
R19 s19 8 82e1
VS20 1 s20 0
C20 s20 5 82e-7
VS21 11 s21 0
L21 s21 7 33e-2
VS22 4 s22 0
L22 s22 0 33e-2
VS23 0 s23 0
R23 s23 10 56e-1
VS24 11 s24 0
C24 s24 10 27e-5
VS25 10 s25 0
R25 s25 5 22e-1
VS26 15 s26 0
V26 e26 s26 DC 0 AC 47e-1 -120
RI26 e26 9 82e-2
VS27 2 s27 0
L27 s27 7 47e-2
VS28 16 s28 0
V28 e28 s28 DC 0 AC 82e1 180
RI28 e28 5 27e-3
VS29 0 s29 0
V29 e29 s29 DC 0 AC 39e1 0
RI29 e29 2 82e-3
.control
set numdgt=17
ac lin 1 60 60
print v(1) v(2) v(3) v(4) v(5) v(6) v(7) v(8) v(9) v(10)
print v(11) v(12) v(13) v(14) v(15) v(16)
print i(vs0) i(vs1) i(vs2) i(vs3) i(vs4) i(vs5) i(vs6) i(vs7) i(vs8) i(vs9)
print i(vs10) i(vs11) i(vs12) i(vs13) i(vs14) i(vs15) i(vs16) i(vs17) i(vs18) i(vs19)
print i(vs20) i(vs21) i(vs22) i(vs23) i(vs24) i(vs25) i(vs26) i(vs27) i(vs28) i(vs29)
.endc
.end
