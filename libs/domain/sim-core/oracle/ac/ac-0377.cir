controls oracle ac-0377
* Generated (plan F2.7, ADR 0012): do not edit; regenerate with `pnpm sim oracle regen`. ac seed 20261031 index 377 nodes 17 elements 29
.options sparse gmin=1e-12 noopac
RG1 1 0 1000000000000
RG2 2 0 1000000000000
RG3 3 0 1000000000000
RG4 4 0 1000000000000
RG5 5 0 1000000000000
RG6 6 0 1000000000000
RG7 7 0 1000000000000
RG8 8 0 1000000000000
RG9 9 0 1000000000000
RG10 10 0 1000000000000
RG11 11 0 1000000000000
RG12 12 0 1000000000000
RG13 13 0 1000000000000
RG14 14 0 1000000000000
RG15 15 0 1000000000000
RG16 16 0 1000000000000
VS0 15 s0 0
L0 s0 9 68e-5
VS1 0 s1 0
V1 e1 s1 DC 0 AC 39e1 180
RI1 e1 m1 82e-1
LI1 m1 9 18e-5
VS2 0 s2 0
V2 e2 s2 DC 0 AC 18e-1 -120
RI2 e2 m2 47e-2
LI2 m2 12 12e-7
VS3 6 s3 0
L3 s3 5 56e-4
VS4 12 s4 0
C4 s4 0 39e-6
VS5 0 s5 0
L5 s5 11 56e-2
VS6 16 s6 0
L6 s6 11 10e-2
VS7 2 s7 0
C7 s7 9 15e-4
VS8 10 s8 0
V8 e8 s8 DC 0 AC 15e-1 180
RI8 e8 13 10e-1
VS9 8 s9 0
C9 s9 6 10e-6
VS10 10 s10 0
C10 s10 12 15e-5
VS11 2 s11 0
V11 e11 s11 DC 0 AC 39e1 0
RI11 e11 10 82e-3
VS12 10 s12 0
L12 s12 5 56e-2
VS13 10 s13 0
L13 s13 11 68e-4
VS14 9 s14 0
L14 s14 13 56e-3
VS15 0 s15 0
C15 s15 12 47e-4
VS16 14 s16 0
C16 s16 12 68e-4
VS17 15 s17 0
R17 s17 14 15e2
VS18 7 s18 0
V18 e18 s18 DC 0 AC 82e-1 -120
RI18 e18 14 33e-3
VS19 0 s19 0
R19 s19 6 18e3
VS20 10 s20 0
C20 s20 7 39e-7
VS21 0 s21 0
R21 s21 1 15e0
VS22 14 s22 0
R22 s22 9 22e3
VS23 6 s23 0
R23 s23 15 82e-2
VS24 3 s24 0
V24 e24 s24 DC 0 AC 22e1 -120
RI24 e24 4 27e-3
VS25 11 s25 0
R25 s25 0 47e-2
VS26 1 s26 0
V26 e26 s26 DC 0 AC 22e1 -120
RI26 e26 16 27e-1
VS27 8 s27 0
V27 e27 s27 DC 0 AC 12e1 0
RI27 e27 m27 39e-3
LI27 m27 3 39e-6
VS28 10 s28 0
R28 s28 4 33e2
.control
set numdgt=17
ac lin 1 60 60
print v(1) v(2) v(3) v(4) v(5) v(6) v(7) v(8) v(9) v(10)
print v(11) v(12) v(13) v(14) v(15) v(16)
print i(vs0) i(vs1) i(vs2) i(vs3) i(vs4) i(vs5) i(vs6) i(vs7) i(vs8) i(vs9)
print i(vs10) i(vs11) i(vs12) i(vs13) i(vs14) i(vs15) i(vs16) i(vs17) i(vs18) i(vs19)
print i(vs20) i(vs21) i(vs22) i(vs23) i(vs24) i(vs25) i(vs26) i(vs27) i(vs28)
.endc
.end
