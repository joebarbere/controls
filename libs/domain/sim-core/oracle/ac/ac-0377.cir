controls oracle ac-0377
* Generated (plan F2.7, ADR 0012): do not edit; regenerate with `pnpm sim oracle regen`. ac seed 20261031 index 377 nodes 17 elements 26
.options sparse gmin=1e-12 noopac
RG1 1 0 1000000000000
RG2 2 0 1000000000000
RG3 3 0 1000000000000
RG4 4 0 1000000000000
RG5 5 0 1000000000000
RG6 6 0 1000000000000
RG7 7 0 1000000000000
RG8 8 0 1000000000000
RG9 9 0 1000000000000
RG10 10 0 1000000000000
RG11 11 0 1000000000000
RG12 12 0 1000000000000
RG13 13 0 1000000000000
RG14 14 0 1000000000000
RG15 15 0 1000000000000
RG16 16 0 1000000000000
VS0 0 s0 0
V0 e0 s0 DC 0 AC 82e1 180
RI0 e0 5 27e-3
VS1 15 s1 0
R1 s1 14 47e2
VS2 3 s2 0
C2 s2 11 10e-5
VS3 6 s3 0
R3 s3 7 56e2
VS4 11 s4 0
L4 s4 7 33e-2
VS5 15 s5 0
V5 e5 s5 DC 0 AC 47e-1 -120
RI5 e5 9 82e-2
VS6 9 s6 0
R6 s6 8 82e1
VS7 2 s7 0
V7 e7 s7 DC 0 AC 27e-1 120
RI7 e7 6 56e-1
VS8 4 s8 0
L8 s8 10 18e-3
VS9 9 s9 0
R9 s9 16 47e0
VS10 0 s10 0
R10 s10 2 33e1
VS11 1 s11 0
R11 s11 10 39e-2
VS12 16 s12 0
L12 s12 7 47e-2
VS13 13 s13 0
V13 e13 s13 DC 0 AC 12e-1 0
RI13 e13 5 33e-1
VS14 1 s14 0
C14 s14 5 82e-7
VS15 4 s15 0
L15 s15 2 33e-2
VS16 2 s16 0
V16 e16 s16 DC 0 AC 39e1 0
RI16 e16 16 82e-3
VS17 11 s17 0
R17 s17 12 47e1
VS18 10 s18 0
R18 s18 5 22e-1
VS19 9 s19 0
C19 s19 8 39e-4
VS20 10 s20 0
V20 e20 s20 DC 0 AC 15e1 -120
RI20 e20 13 39e-2
VS21 2 s21 0
R21 s21 10 56e-1
VS22 11 s22 0
C22 s22 10 27e-5
VS23 6 s23 0
V23 e23 s23 DC 0 AC 12e0 0
RI23 e23 13 82e-2
VS24 9 s24 0
L24 s24 6 68e-4
VS25 2 s25 0
V25 e25 s25 DC 0 AC 56e1 120
RI25 e25 6 22e-1
.control
set numdgt=17
ac lin 1 60 60
print v(1) v(2) v(3) v(4) v(5) v(6) v(7) v(8) v(9) v(10)
print v(11) v(12) v(13) v(14) v(15) v(16)
print i(vs0) i(vs1) i(vs2) i(vs3) i(vs4) i(vs5) i(vs6) i(vs7) i(vs8) i(vs9)
print i(vs10) i(vs11) i(vs12) i(vs13) i(vs14) i(vs15) i(vs16) i(vs17) i(vs18) i(vs19)
print i(vs20) i(vs21) i(vs22) i(vs23) i(vs24) i(vs25)
.endc
.end
