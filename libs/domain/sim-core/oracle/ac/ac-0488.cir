controls oracle ac-0488
* Generated (plan F2.7, ADR 0012): do not edit; regenerate with `pnpm sim oracle regen`. ac seed 20261031 index 488 nodes 27 elements 50
.options sparse gmin=1e-12 noopac
RG1 1 0 1000000000000
RG2 2 0 1000000000000
RG3 3 0 1000000000000
RG4 4 0 1000000000000
RG5 5 0 1000000000000
RG6 6 0 1000000000000
RG7 7 0 1000000000000
RG8 8 0 1000000000000
RG9 9 0 1000000000000
RG10 10 0 1000000000000
RG11 11 0 1000000000000
RG12 12 0 1000000000000
RG13 13 0 1000000000000
RG14 14 0 1000000000000
RG15 15 0 1000000000000
RG16 16 0 1000000000000
RG17 17 0 1000000000000
RG18 18 0 1000000000000
RG19 19 0 1000000000000
RG20 20 0 1000000000000
RG21 21 0 1000000000000
RG22 22 0 1000000000000
RG23 23 0 1000000000000
RG24 24 0 1000000000000
RG25 25 0 1000000000000
RG26 26 0 1000000000000
VS0 22 s0 0
R0 s0 25 56e2
VS1 24 s1 0
L1 s1 21 22e-5
VS2 26 s2 0
R2 s2 14 22e2
VS3 5 s3 0
C3 s3 9 12e-7
VS4 24 s4 0
L4 s4 17 15e-3
VS5 21 s5 0
C5 s5 7 22e-6
VS6 1 s6 0
R6 s6 0 82e-2
VS7 0 s7 0
V7 e7 s7 DC 0 AC 33e0 180
RI7 e7 12 10e-2
VS8 9 s8 0
L8 s8 20 39e-2
VS9 6 s9 0
L9 s9 16 68e-5
VS10 23 s10 0
R10 s10 4 27e0
VS11 12 s11 0
R11 s11 24 10e2
VS12 24 s12 0
C12 s12 14 68e-7
VS13 12 s13 0
V13 e13 s13 DC 0 AC 39e-1 180
RI13 e13 m13 10e-2
LI13 m13 7 18e-5
VS14 1 s14 0
L14 s14 13 15e-5
VS15 1 s15 0
R15 s15 6 82e2
VS16 3 s16 0
V16 e16 s16 DC 0 AC 39e1 180
RI16 e16 m16 10e-3
LI16 m16 1 68e-6
VS17 25 s17 0
C17 s17 14 56e-5
VS18 18 s18 0
C18 s18 3 33e-4
VS19 11 s19 0
R19 s19 19 27e-1
VS20 24 s20 0
L20 s20 16 18e-5
VS21 22 s21 0
C21 s21 1 18e-6
VS22 13 s22 0
R22 s22 21 27e-2
VS23 12 s23 0
L23 s23 25 56e-2
VS24 0 s24 0
L24 s24 15 47e-5
VS25 22 s25 0
R25 s25 19 22e-2
VS26 24 s26 0
L26 s26 6 68e-2
VS27 8 s27 0
C27 s27 2 33e-6
VS28 4 s28 0
R28 s28 5 12e2
VS29 8 s29 0
R29 s29 17 27e-1
VS30 9 s30 0
C30 s30 3 39e-4
VS31 22 s31 0
L31 s31 23 18e-4
VS32 5 s32 0
V32 e32 s32 DC 0 AC 22e-1 -120
RI32 e32 m32 33e-3
LI32 m32 9 22e-7
VS33 26 s33 0
V33 e33 s33 DC 0 AC 18e0 120
RI33 e33 m33 56e-2
LI33 m33 9 47e-7
VS34 1 s34 0
V34 e34 s34 DC 0 AC 10e1 -120
RI34 e34 5 68e-1
VS35 26 s35 0
C35 s35 9 18e-7
VS36 10 s36 0
V36 e36 s36 DC 0 AC 68e-1 120
RI36 e36 m36 56e-1
LI36 m36 11 39e-6
VS37 14 s37 0
V37 e37 s37 DC 0 AC 27e-1 120
RI37 e37 m37 33e-2
LI37 m37 3 47e-6
VS38 7 s38 0
R38 s38 16 47e0
VS39 4 s39 0
L39 s39 18 33e-5
VS40 10 s40 0
V40 e40 s40 DC 0 AC 68e1 180
RI40 e40 m40 82e-1
LI40 m40 12 56e-5
VS41 26 s41 0
C41 s41 21 39e-5
VS42 21 s42 0
C42 s42 7 18e-7
VS43 26 s43 0
R43 s43 22 18e-2
VS44 5 s44 0
R44 s44 22 12e0
VS45 25 s45 0
L45 s45 15 56e-4
VS46 20 s46 0
R46 s46 14 33e0
VS47 5 s47 0
V47 e47 s47 DC 0 AC 27e-1 120
RI47 e47 m47 15e-3
LI47 m47 3 18e-5
VS48 24 s48 0
L48 s48 2 68e-4
VS49 2 s49 0
R49 s49 19 27e-2
.control
set numdgt=17
ac lin 1 60 60
print v(1) v(2) v(3) v(4) v(5) v(6) v(7) v(8) v(9) v(10)
print v(11) v(12) v(13) v(14) v(15) v(16) v(17) v(18) v(19) v(20)
print v(21) v(22) v(23) v(24) v(25) v(26)
print i(vs0) i(vs1) i(vs2) i(vs3) i(vs4) i(vs5) i(vs6) i(vs7) i(vs8) i(vs9)
print i(vs10) i(vs11) i(vs12) i(vs13) i(vs14) i(vs15) i(vs16) i(vs17) i(vs18) i(vs19)
print i(vs20) i(vs21) i(vs22) i(vs23) i(vs24) i(vs25) i(vs26) i(vs27) i(vs28) i(vs29)
print i(vs30) i(vs31) i(vs32) i(vs33) i(vs34) i(vs35) i(vs36) i(vs37) i(vs38) i(vs39)
print i(vs40) i(vs41) i(vs42) i(vs43) i(vs44) i(vs45) i(vs46) i(vs47) i(vs48) i(vs49)
.endc
.end
