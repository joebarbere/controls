controls oracle ac-0488
* Generated (plan F2.7, ADR 0012): do not edit; regenerate with `pnpm sim oracle regen`. ac seed 20261031 index 488 nodes 27 elements 41
.options sparse gmin=1e-12 noopac
RG1 1 0 1000000000000
RG2 2 0 1000000000000
RG3 3 0 1000000000000
RG4 4 0 1000000000000
RG5 5 0 1000000000000
RG6 6 0 1000000000000
RG7 7 0 1000000000000
RG8 8 0 1000000000000
RG9 9 0 1000000000000
RG10 10 0 1000000000000
RG11 11 0 1000000000000
RG12 12 0 1000000000000
RG13 13 0 1000000000000
RG14 14 0 1000000000000
RG15 15 0 1000000000000
RG16 16 0 1000000000000
RG17 17 0 1000000000000
RG18 18 0 1000000000000
RG19 19 0 1000000000000
RG20 20 0 1000000000000
RG21 21 0 1000000000000
RG22 22 0 1000000000000
RG23 23 0 1000000000000
RG24 24 0 1000000000000
RG25 25 0 1000000000000
RG26 26 0 1000000000000
VS0 4 s0 0
C0 s0 12 39e-4
VS1 9 s1 0
R1 s1 23 18e-1
VS2 9 s2 0
R2 s2 22 82e-2
VS3 14 s3 0
R3 s3 21 18e-1
VS4 6 s4 0
R4 s4 21 22e1
VS5 12 s5 0
C5 s5 25 56e-4
VS6 24 s6 0
R6 s6 1 18e1
VS7 11 s7 0
R7 s7 5 15e0
VS8 8 s8 0
C8 s8 19 10e-5
VS9 0 s9 0
V9 e9 s9 DC 0 AC 68e1 180
RI9 e9 m9 82e-1
LI9 m9 n9 39e-7
H9 n9 h9 VS13 15e-4
ED9 h9 12 d9 0 -12e-7
F9 0 d9 VS13 1
LD9 d9 0 1
VS10 1 s10 0
L10 s10 3 33e-3
VS11 18 s11 0
R11 s11 16 22e2
VS12 16 s12 0
L12 s12 7 82e-4
VS13 12 s13 0
V13 e13 s13 DC 0 AC 18e1 180
RI13 e13 m13 27e-3
LI13 m13 n13 82e-5
H13 n13 h13 VS9 15e-4
ED13 h13 14 d13 0 -12e-7
F13 0 d13 VS9 1
LD13 d13 0 1
VS14 13 s14 0
R14 s14 23 68e0
VS15 8 s15 0
R15 s15 17 68e-2
VS16 5 s16 0
L16 s16 9 22e-5
VS17 14 s17 0
V17 e17 s17 DC 0 AC 39e-1 180
RI17 e17 m17 10e-2
LI17 m17 15 15e-7
VS18 22 s18 0
R18 s18 6 56e0
VS19 15 s19 0
C19 s19 11 15e-4
VS20 21 s20 0
R20 s20 14 22e2
VS21 2 s21 0
C21 s21 20 12e-4
VS22 14 s22 0
R22 s22 0 18e0
VS23 4 s23 0
R23 s23 10 27e1
VS24 5 s24 0
V24 e24 s24 DC 0 AC 22e-1 -120
RI24 e24 m24 12e-2
LI24 m24 23 47e-7
VS25 7 s25 0
V25 e25 s25 DC 0 AC 27e-1 120
RI25 e25 24 15e-3
VS26 13 s26 0
V26 e26 s26 DC 0 AC 22e-1 120
RI26 e26 2 15e-1
VS27 6 s27 0
C27 s27 7 15e-7
VS28 24 s28 0
L28 s28 1 47e-4
VS29 0 s29 0
V29 e29 s29 DC 0 AC 12e1 -120
RI29 e29 3 15e-1
VS30 22 s30 0
L30 s30 10 33e-4
VS31 6 s31 0
V31 e31 s31 DC 0 AC 15e1 180
RI31 e31 18 33e-3
VS32 0 s32 0
R32 s32 26 27e-2
VS33 24 s33 0
L33 s33 11 15e-3
VS34 5 s34 0
R34 s34 20 18e-1
VS35 12 s35 0
C35 s35 22 27e-5
VS36 11 s36 0
L36 s36 4 56e-5
VS37 17 s37 0
R37 s37 24 10e-1
VS38 24 s38 0
R38 s38 26 10e2
VS39 15 s39 0
L39 s39 6 68e-4
VS40 25 s40 0
V40 e40 s40 DC 0 AC 68e-1 120
RI40 e40 m40 56e-1
LI40 m40 19 15e-7
.control
set numdgt=17
ac lin 1 60 60
print v(1) v(2) v(3) v(4) v(5) v(6) v(7) v(8) v(9) v(10)
print v(11) v(12) v(13) v(14) v(15) v(16) v(17) v(18) v(19) v(20)
print v(21) v(22) v(23) v(24) v(25) v(26)
print i(vs0) i(vs1) i(vs2) i(vs3) i(vs4) i(vs5) i(vs6) i(vs7) i(vs8) i(vs9)
print i(vs10) i(vs11) i(vs12) i(vs13) i(vs14) i(vs15) i(vs16) i(vs17) i(vs18) i(vs19)
print i(vs20) i(vs21) i(vs22) i(vs23) i(vs24) i(vs25) i(vs26) i(vs27) i(vs28) i(vs29)
print i(vs30) i(vs31) i(vs32) i(vs33) i(vs34) i(vs35) i(vs36) i(vs37) i(vs38) i(vs39)
print i(vs40)
.endc
.end
