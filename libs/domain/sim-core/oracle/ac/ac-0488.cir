controls oracle ac-0488
* Generated (plan F2.7, ADR 0012): do not edit; regenerate with `pnpm sim oracle regen`. ac seed 20261031 index 488 nodes 27 elements 38
.options sparse gmin=1e-12 noopac
RG1 1 0 1000000000000
RG2 2 0 1000000000000
RG3 3 0 1000000000000
RG4 4 0 1000000000000
RG5 5 0 1000000000000
RG6 6 0 1000000000000
RG7 7 0 1000000000000
RG8 8 0 1000000000000
RG9 9 0 1000000000000
RG10 10 0 1000000000000
RG11 11 0 1000000000000
RG12 12 0 1000000000000
RG13 13 0 1000000000000
RG14 14 0 1000000000000
RG15 15 0 1000000000000
RG16 16 0 1000000000000
RG17 17 0 1000000000000
RG18 18 0 1000000000000
RG19 19 0 1000000000000
RG20 20 0 1000000000000
RG21 21 0 1000000000000
RG22 22 0 1000000000000
RG23 23 0 1000000000000
RG24 24 0 1000000000000
RG25 25 0 1000000000000
RG26 26 0 1000000000000
VS0 5 s0 0
R0 s0 20 18e-1
VS1 0 s1 0
V1 e1 s1 DC 0 AC 18e1 180
RI1 e1 14 27e-3
VS2 24 s2 0
L2 s2 11 15e-3
VS3 6 s3 0
V3 e3 s3 DC 0 AC 15e1 180
RI3 e3 18 33e-3
VS4 24 s4 0
R4 s4 1 18e1
VS5 11 s5 0
L5 s5 4 56e-5
VS6 2 s6 0
C6 s6 20 12e-4
VS7 12 s7 0
V7 e7 s7 DC 0 AC 68e1 180
RI7 e7 0 82e-1
VS8 24 s8 0
L8 s8 1 47e-4
VS9 15 s9 0
C9 s9 11 15e-4
VS10 7 s10 0
V10 e10 s10 DC 0 AC 27e-1 120
RI10 e10 24 15e-3
VS11 12 s11 0
R11 s11 26 27e-2
VS12 16 s12 0
L12 s12 7 82e-4
VS13 14 s13 0
R13 s13 12 18e0
VS14 8 s14 0
R14 s14 17 68e-2
VS15 0 s15 0
C15 s15 25 56e-4
VS16 5 s16 0
V16 e16 s16 DC 0 AC 22e-1 -120
RI16 e16 23 12e-2
VS17 14 s17 0
V17 e17 s17 DC 0 AC 39e-1 180
RI17 e17 15 10e-2
VS18 13 s18 0
R18 s18 23 68e0
VS19 14 s19 0
R19 s19 21 18e-1
VS20 15 s20 0
L20 s20 6 68e-4
VS21 13 s21 0
V21 e21 s21 DC 0 AC 22e-1 120
RI21 e21 2 15e-1
VS22 12 s22 0
V22 e22 s22 DC 0 AC 12e1 -120
RI22 e22 3 15e-1
VS23 6 s23 0
C23 s23 7 15e-7
VS24 25 s24 0
V24 e24 s24 DC 0 AC 68e-1 120
RI24 e24 19 56e-1
VS25 4 s25 0
R25 s25 10 27e1
VS26 0 s26 0
C26 s26 22 27e-5
VS27 4 s27 0
C27 s27 0 39e-4
VS28 1 s28 0
L28 s28 3 33e-3
VS29 21 s29 0
R29 s29 14 22e2
VS30 5 s30 0
L30 s30 9 22e-5
VS31 24 s31 0
R31 s31 26 10e2
VS32 22 s32 0
R32 s32 6 56e0
VS33 9 s33 0
R33 s33 22 82e-2
VS34 17 s34 0
R34 s34 24 10e-1
VS35 18 s35 0
R35 s35 16 22e2
VS36 22 s36 0
L36 s36 10 33e-4
VS37 11 s37 0
R37 s37 5 15e0
.control
set numdgt=17
ac lin 1 60 60
print v(1) v(2) v(3) v(4) v(5) v(6) v(7) v(8) v(9) v(10)
print v(11) v(12) v(13) v(14) v(15) v(16) v(17) v(18) v(19) v(20)
print v(21) v(22) v(23) v(24) v(25) v(26)
print i(vs0) i(vs1) i(vs2) i(vs3) i(vs4) i(vs5) i(vs6) i(vs7) i(vs8) i(vs9)
print i(vs10) i(vs11) i(vs12) i(vs13) i(vs14) i(vs15) i(vs16) i(vs17) i(vs18) i(vs19)
print i(vs20) i(vs21) i(vs22) i(vs23) i(vs24) i(vs25) i(vs26) i(vs27) i(vs28) i(vs29)
print i(vs30) i(vs31) i(vs32) i(vs33) i(vs34) i(vs35) i(vs36) i(vs37)
.endc
.end
