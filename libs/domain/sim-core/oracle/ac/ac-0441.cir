controls oracle ac-0441
* Generated (plan F2.7, ADR 0012): do not edit; regenerate with `pnpm sim oracle regen`. ac seed 20261031 index 441 nodes 27 elements 40
.options sparse gmin=1e-12 noopac
RG1 1 0 1000000000000
RG2 2 0 1000000000000
RG3 3 0 1000000000000
RG4 4 0 1000000000000
RG5 5 0 1000000000000
RG6 6 0 1000000000000
RG7 7 0 1000000000000
RG8 8 0 1000000000000
RG9 9 0 1000000000000
RG10 10 0 1000000000000
RG11 11 0 1000000000000
RG12 12 0 1000000000000
RG13 13 0 1000000000000
RG14 14 0 1000000000000
RG15 15 0 1000000000000
RG16 16 0 1000000000000
RG17 17 0 1000000000000
RG18 18 0 1000000000000
RG19 19 0 1000000000000
RG20 20 0 1000000000000
RG21 21 0 1000000000000
RG22 22 0 1000000000000
RG23 23 0 1000000000000
RG24 24 0 1000000000000
RG25 25 0 1000000000000
RG26 26 0 1000000000000
VS0 1 s0 0
L0 s0 12 12e-4
VS1 6 s1 0
C1 s1 10 68e-5
VS2 13 s2 0
L2 s2 4 22e-5
VS3 25 s3 0
C3 s3 20 10e-6
VS4 0 s4 0
V4 e4 s4 DC 0 AC 15e-1 180
RI4 e4 m4 47e-2
LI4 m4 7 33e-5
VS5 14 s5 0
V5 e5 s5 DC 0 AC 27e-1 -120
RI5 e5 22 68e-2
VS6 15 s6 0
L6 s6 20 18e-5
VS7 23 s7 0
L7 s7 12 68e-5
VS8 12 s8 0
R8 s8 16 82e2
VS9 26 s9 0
L9 s9 6 15e-2
VS10 12 s10 0
C10 s10 10 10e-7
VS11 24 s11 0
C11 s11 14 27e-5
VS12 13 s12 0
V12 e12 s12 DC 0 AC 22e1 120
RI12 e12 m12 22e-2
LI12 m12 19 56e-5
VS13 24 s13 0
R13 s13 5 56e1
VS14 4 s14 0
R14 s14 15 68e-2
VS15 21 s15 0
R15 s15 0 15e-1
VS16 11 s16 0
R16 s16 7 27e0
VS17 12 s17 0
L17 s17 6 10e-3
VS18 22 s18 0
V18 e18 s18 DC 0 AC 33e1 120
RI18 e18 5 27e-1
VS19 9 s19 0
R19 s19 20 22e-1
VS20 20 s20 0
L20 s20 2 22e-2
VS21 7 s21 0
C21 s21 6 82e-6
VS22 22 s22 0
R22 s22 25 18e2
VS23 17 s23 0
L23 s23 14 33e-5
VS24 14 s24 0
C24 s24 6 33e-7
VS25 26 s25 0
V25 e25 s25 DC 0 AC 56e0 0
RI25 e25 m25 68e-2
LI25 m25 6 27e-6
VS26 8 s26 0
L26 s26 22 47e-4
VS27 25 s27 0
L27 s27 11 12e-2
VS28 3 s28 0
C28 s28 10 68e-4
VS29 23 s29 0
R29 s29 0 18e1
VS30 18 s30 0
R30 s30 16 27e1
VS31 2 s31 0
C31 s31 12 39e-5
VS32 18 s32 0
L32 s32 7 68e-2
VS33 4 s33 0
R33 s33 20 12e1
VS34 12 s34 0
C34 s34 19 56e-4
VS35 24 s35 0
R35 s35 3 15e0
VS36 9 s36 0
R36 s36 12 15e-1
VS37 17 s37 0
R37 s37 8 22e3
VS38 21 s38 0
R38 s38 22 82e-2
VS39 26 s39 0
L39 s39 1 82e-5
.control
set numdgt=17
ac lin 1 60 60
print v(1) v(2) v(3) v(4) v(5) v(6) v(7) v(8) v(9) v(10)
print v(11) v(12) v(13) v(14) v(15) v(16) v(17) v(18) v(19) v(20)
print v(21) v(22) v(23) v(24) v(25) v(26)
print i(vs0) i(vs1) i(vs2) i(vs3) i(vs4) i(vs5) i(vs6) i(vs7) i(vs8) i(vs9)
print i(vs10) i(vs11) i(vs12) i(vs13) i(vs14) i(vs15) i(vs16) i(vs17) i(vs18) i(vs19)
print i(vs20) i(vs21) i(vs22) i(vs23) i(vs24) i(vs25) i(vs26) i(vs27) i(vs28) i(vs29)
print i(vs30) i(vs31) i(vs32) i(vs33) i(vs34) i(vs35) i(vs36) i(vs37) i(vs38) i(vs39)
.endc
.end
