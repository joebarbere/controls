controls oracle ac-0441
* Generated (plan F2.7, ADR 0012): do not edit; regenerate with `pnpm sim oracle regen`. ac seed 20261031 index 441 nodes 27 elements 31
.options sparse gmin=1e-12 noopac
RG1 1 0 1000000000000
RG2 2 0 1000000000000
RG3 3 0 1000000000000
RG4 4 0 1000000000000
RG5 5 0 1000000000000
RG6 6 0 1000000000000
RG7 7 0 1000000000000
RG8 8 0 1000000000000
RG9 9 0 1000000000000
RG10 10 0 1000000000000
RG11 11 0 1000000000000
RG12 12 0 1000000000000
RG13 13 0 1000000000000
RG14 14 0 1000000000000
RG15 15 0 1000000000000
RG16 16 0 1000000000000
RG17 17 0 1000000000000
RG18 18 0 1000000000000
RG19 19 0 1000000000000
RG20 20 0 1000000000000
RG21 21 0 1000000000000
RG22 22 0 1000000000000
RG23 23 0 1000000000000
RG24 24 0 1000000000000
RG25 25 0 1000000000000
RG26 26 0 1000000000000
VS0 18 s0 0
R0 s0 16 27e1
VS1 12 s1 0
C1 s1 19 56e-4
VS2 24 s2 0
R2 s2 5 56e1
VS3 2 s3 0
C3 s3 12 39e-5
VS4 0 s4 0
V4 e4 s4 DC 0 AC 15e-1 180
RI4 e4 7 47e-2
VS5 21 s5 0
R5 s5 22 82e-2
VS6 18 s6 0
L6 s6 7 68e-2
VS7 14 s7 0
V7 e7 s7 DC 0 AC 27e-1 -120
RI7 e7 22 68e-2
VS8 26 s8 0
V8 e8 s8 DC 0 AC 56e0 0
RI8 e8 6 68e-2
VS9 8 s9 0
L9 s9 22 47e-4
VS10 23 s10 0
R10 s10 0 18e1
VS11 7 s11 0
C11 s11 6 82e-6
VS12 17 s12 0
L12 s12 14 33e-5
VS13 12 s13 0
L13 s13 6 10e-3
VS14 4 s14 0
R14 s14 15 68e-2
VS15 26 s15 0
L15 s15 6 15e-2
VS16 14 s16 0
C16 s16 6 33e-7
VS17 13 s17 0
L17 s17 4 22e-5
VS18 11 s18 0
R18 s18 7 27e0
VS19 25 s19 0
C19 s19 20 10e-6
VS20 20 s20 0
L20 s20 2 22e-2
VS21 26 s21 0
L21 s21 1 82e-5
VS22 17 s22 0
R22 s22 8 22e3
VS23 21 s23 0
R23 s23 0 15e-1
VS24 24 s24 0
C24 s24 14 27e-5
VS25 1 s25 0
L25 s25 12 12e-4
VS26 12 s26 0
C26 s26 10 10e-7
VS27 24 s27 0
R27 s27 3 15e0
VS28 9 s28 0
R28 s28 12 15e-1
VS29 4 s29 0
R29 s29 20 12e1
VS30 6 s30 0
C30 s30 10 68e-5
.control
set numdgt=17
ac lin 1 60 60
print v(1) v(2) v(3) v(4) v(5) v(6) v(7) v(8) v(9) v(10)
print v(11) v(12) v(13) v(14) v(15) v(16) v(17) v(18) v(19) v(20)
print v(21) v(22) v(23) v(24) v(25) v(26)
print i(vs0) i(vs1) i(vs2) i(vs3) i(vs4) i(vs5) i(vs6) i(vs7) i(vs8) i(vs9)
print i(vs10) i(vs11) i(vs12) i(vs13) i(vs14) i(vs15) i(vs16) i(vs17) i(vs18) i(vs19)
print i(vs20) i(vs21) i(vs22) i(vs23) i(vs24) i(vs25) i(vs26) i(vs27) i(vs28) i(vs29)
print i(vs30)
.endc
.end
