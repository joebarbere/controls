controls oracle ac-0441
* Generated (plan F2.7, ADR 0012): do not edit; regenerate with `pnpm sim oracle regen`. ac seed 20261031 index 441 nodes 27 elements 45
.options sparse gmin=1e-12 noopac
RG1 1 0 1000000000000
RG2 2 0 1000000000000
RG3 3 0 1000000000000
RG4 4 0 1000000000000
RG5 5 0 1000000000000
RG6 6 0 1000000000000
RG7 7 0 1000000000000
RG8 8 0 1000000000000
RG9 9 0 1000000000000
RG10 10 0 1000000000000
RG11 11 0 1000000000000
RG12 12 0 1000000000000
RG13 13 0 1000000000000
RG14 14 0 1000000000000
RG15 15 0 1000000000000
RG16 16 0 1000000000000
RG17 17 0 1000000000000
RG18 18 0 1000000000000
RG19 19 0 1000000000000
RG20 20 0 1000000000000
RG21 21 0 1000000000000
RG22 22 0 1000000000000
RG23 23 0 1000000000000
RG24 24 0 1000000000000
RG25 25 0 1000000000000
RG26 26 0 1000000000000
VS0 22 s0 0
R0 s0 13 10e-1
VS1 26 s1 0
R1 s1 11 39e0
VS2 0 s2 0
V2 e2 s2 DC 0 AC 68e-1 120
RI2 e2 m2 27e-1
LI2 m2 14 22e-5
VS3 9 s3 0
R3 s3 13 18e-2
VS4 1 s4 0
L4 s4 5 82e-5
VS5 21 s5 0
R5 s5 6 15e-1
VS6 15 s6 0
L6 s6 11 27e-4
VS7 26 s7 0
V7 e7 s7 DC 0 AC 56e0 0
RI7 e7 24 68e-2
VS8 24 s8 0
R8 s8 11 68e-1
VS9 6 s9 0
R9 s9 10 22e1
VS10 5 s10 0
V10 e10 s10 DC 0 AC 56e1 120
RI10 e10 17 68e-2
VS11 14 s11 0
C11 s11 17 47e-4
VS12 1 s12 0
V12 e12 s12 DC 0 AC 56e0 0
RI12 e12 11 82e-2
VS13 2 s13 0
L13 s13 24 15e-2
VS14 0 s14 0
R14 s14 17 22e-2
VS15 14 s15 0
V15 e15 s15 DC 0 AC 12e-1 180
RI15 e15 m15 47e-1
LI15 m15 15 18e-5
VS16 12 s16 0
L16 s16 24 10e-3
VS17 7 s17 0
R17 s17 12 56e-1
VS18 2 s18 0
V18 e18 s18 DC 0 AC 82e0 180
RI18 e18 3 22e-3
VS19 22 s19 0
L19 s19 20 18e-5
VS20 23 s20 0
R20 s20 5 68e3
VS21 4 s21 0
L21 s21 7 56e-2
VS22 6 s22 0
C22 s22 11 10e-6
VS23 7 s23 0
V23 e23 s23 DC 0 AC 82e1 180
RI23 e23 21 18e-3
VS24 26 s24 0
L24 s24 12 68e-4
VS25 23 s25 0
L25 s25 16 68e-5
VS26 25 s26 0
V26 e26 s26 DC 0 AC 56e0 0
RI26 e26 22 47e-3
VS27 5 s27 0
R27 s27 20 47e-1
VS28 19 s28 0
C28 s28 20 12e-6
VS29 25 s29 0
R29 s29 11 15e-2
VS30 24 s30 0
R30 s30 10 15e1
VS31 6 s31 0
R31 s31 16 22e3
VS32 13 s32 0
R32 s32 11 47e0
VS33 18 s33 0
L33 s33 22 82e-2
VS34 18 s34 0
V34 e34 s34 DC 0 AC 15e0 -120
RI34 e34 4 10e-1
VS35 14 s35 0
C35 s35 24 33e-7
VS36 14 s36 0
V36 e36 s36 DC 0 AC 27e-1 -120
RI36 e36 22 68e-2
VS37 3 s37 0
L37 s37 4 10e-4
VS38 4 s38 0
L38 s38 8 39e-4
VS39 5 s39 0
R39 s39 8 15e-1
VS40 17 s40 0
R40 s40 9 39e-2
VS41 24 s41 0
V41 e41 s41 DC 0 AC 39e1 120
RI41 e41 m41 10e-2
LI41 m41 15 39e-7
VS42 5 s42 0
R42 s42 19 12e1
VS43 21 s43 0
V43 e43 s43 DC 0 AC 33e1 120
RI43 e43 6 27e-1
VS44 5 s44 0
L44 s44 21 68e-4
.control
set numdgt=17
ac lin 1 60 60
print v(1) v(2) v(3) v(4) v(5) v(6) v(7) v(8) v(9) v(10)
print v(11) v(12) v(13) v(14) v(15) v(16) v(17) v(18) v(19) v(20)
print v(21) v(22) v(23) v(24) v(25) v(26)
print i(vs0) i(vs1) i(vs2) i(vs3) i(vs4) i(vs5) i(vs6) i(vs7) i(vs8) i(vs9)
print i(vs10) i(vs11) i(vs12) i(vs13) i(vs14) i(vs15) i(vs16) i(vs17) i(vs18) i(vs19)
print i(vs20) i(vs21) i(vs22) i(vs23) i(vs24) i(vs25) i(vs26) i(vs27) i(vs28) i(vs29)
print i(vs30) i(vs31) i(vs32) i(vs33) i(vs34) i(vs35) i(vs36) i(vs37) i(vs38) i(vs39)
print i(vs40) i(vs41) i(vs42) i(vs43) i(vs44)
.endc
.end
