controls oracle ac-0433
* Generated (plan F2.7, ADR 0012): do not edit; regenerate with `pnpm sim oracle regen`. ac seed 20261031 index 433 nodes 14 elements 18
.options sparse gmin=1e-12 noopac
RG1 1 0 1000000000000
RG2 2 0 1000000000000
RG3 3 0 1000000000000
RG4 4 0 1000000000000
RG5 5 0 1000000000000
RG6 6 0 1000000000000
RG7 7 0 1000000000000
RG8 8 0 1000000000000
RG9 9 0 1000000000000
RG10 10 0 1000000000000
RG11 11 0 1000000000000
RG12 12 0 1000000000000
RG13 13 0 1000000000000
VS0 10 s0 0
R0 s0 7 12e0
VS1 0 s1 0
V1 e1 s1 DC 0 AC 39e-1 0
RI1 e1 12 47e-3
VS2 12 s2 0
C2 s2 8 47e-4
VS3 2 s3 0
V3 e3 s3 DC 0 AC 18e-1 0
RI3 e3 13 18e-1
VS4 7 s4 0
C4 s4 13 18e-5
VS5 4 s5 0
R5 s5 9 33e3
VS6 0 s6 0
L6 s6 6 27e-2
VS7 12 s7 0
C7 s7 6 82e-6
VS8 8 s8 0
R8 s8 4 18e-2
VS9 8 s9 0
R9 s9 5 22e1
VS10 13 s10 0
R10 s10 5 47e3
VS11 8 s11 0
C11 s11 3 47e-4
VS12 1 s12 0
L12 s12 3 47e-2
VS13 2 s13 0
R13 s13 5 56e-2
VS14 13 s14 0
C14 s14 5 18e-5
VS15 2 s15 0
C15 s15 1 10e-4
VS16 11 s16 0
R16 s16 8 10e3
VS17 0 s17 0
L17 s17 2 10e-2
.control
set numdgt=17
ac lin 1 60 60
print v(1) v(2) v(3) v(4) v(5) v(6) v(7) v(8) v(9) v(10)
print v(11) v(12) v(13)
print i(vs0) i(vs1) i(vs2) i(vs3) i(vs4) i(vs5) i(vs6) i(vs7) i(vs8) i(vs9)
print i(vs10) i(vs11) i(vs12) i(vs13) i(vs14) i(vs15) i(vs16) i(vs17)
.endc
.end
