controls oracle ac-0433
* Generated (plan F2.7, ADR 0012): do not edit; regenerate with `pnpm sim oracle regen`. ac seed 20261031 index 433 nodes 14 elements 22
.options sparse gmin=1e-12 noopac
RG1 1 0 1000000000000
RG2 2 0 1000000000000
RG3 3 0 1000000000000
RG4 4 0 1000000000000
RG5 5 0 1000000000000
RG6 6 0 1000000000000
RG7 7 0 1000000000000
RG8 8 0 1000000000000
RG9 9 0 1000000000000
RG10 10 0 1000000000000
RG11 11 0 1000000000000
RG12 12 0 1000000000000
RG13 13 0 1000000000000
VS0 8 s0 0
C0 s0 3 47e-4
VS1 5 s1 0
L1 s1 6 27e-2
VS2 12 s2 0
C2 s2 8 47e-4
VS3 8 s3 0
R3 s3 2 22e1
VS4 0 s4 0
C4 s4 1 10e-4
VS5 10 s5 0
C5 s5 9 68e-6
VS6 10 s6 0
R6 s6 7 12e0
VS7 11 s7 0
R7 s7 8 10e3
VS8 0 s8 0
V8 e8 s8 DC 0 AC 18e-1 0
RI8 e8 13 18e-1
VS9 12 s9 0
C9 s9 6 82e-6
VS10 4 s10 0
L10 s10 11 39e-4
VS11 5 s11 0
L11 s11 0 10e-2
VS12 9 s12 0
V12 e12 s12 DC 0 AC 12e0 -120
RI12 e12 8 18e-3
VS13 13 s13 0
C13 s13 2 18e-5
VS14 0 s14 0
R14 s14 4 39e1
VS15 0 s15 0
R15 s15 2 56e-2
VS16 4 s16 0
R16 s16 9 33e3
VS17 8 s17 0
R17 s17 4 18e-2
VS18 13 s18 0
R18 s18 2 47e3
VS19 7 s19 0
C19 s19 13 18e-5
VS20 1 s20 0
L20 s20 3 47e-2
VS21 5 s21 0
V21 e21 s21 DC 0 AC 39e-1 0
RI21 e21 12 47e-3
.control
set numdgt=17
ac lin 1 60 60
print v(1) v(2) v(3) v(4) v(5) v(6) v(7) v(8) v(9) v(10)
print v(11) v(12) v(13)
print i(vs0) i(vs1) i(vs2) i(vs3) i(vs4) i(vs5) i(vs6) i(vs7) i(vs8) i(vs9)
print i(vs10) i(vs11) i(vs12) i(vs13) i(vs14) i(vs15) i(vs16) i(vs17) i(vs18) i(vs19)
print i(vs20) i(vs21)
.endc
.end
