controls oracle ac-0433
* Generated (plan F2.7, ADR 0012): do not edit; regenerate with `pnpm sim oracle regen`. ac seed 20261031 index 433 nodes 14 elements 20
.options sparse gmin=1e-12 noopac
RG1 1 0 1000000000000
RG2 2 0 1000000000000
RG3 3 0 1000000000000
RG4 4 0 1000000000000
RG5 5 0 1000000000000
RG6 6 0 1000000000000
RG7 7 0 1000000000000
RG8 8 0 1000000000000
RG9 9 0 1000000000000
RG10 10 0 1000000000000
RG11 11 0 1000000000000
RG12 12 0 1000000000000
RG13 13 0 1000000000000
VS0 2 s0 0
C0 s0 1 10e-4
VS1 7 s1 0
C1 s1 13 18e-5
VS2 0 s2 0
V2 e2 s2 DC 0 AC 39e-1 0
RI2 e2 12 47e-3
VS3 11 s3 0
R3 s3 8 10e3
VS4 2 s4 0
V4 e4 s4 DC 0 AC 18e1 0
RI4 e4 m4 82e-2
LI4 m4 3 33e-6
VS5 8 s5 0
C5 s5 3 47e-4
VS6 9 s6 0
V6 e6 s6 DC 0 AC 10e1 120
RI6 e6 m6 15e-1
LI6 m6 8 18e-7
VS7 8 s7 0
R7 s7 5 22e1
VS8 7 s8 0
R8 s8 4 18e3
VS9 0 s9 0
L9 s9 6 27e-2
VS10 4 s10 0
R10 s10 9 33e3
VS11 12 s11 0
C11 s11 8 47e-4
VS12 10 s12 0
R12 s12 7 12e0
VS13 2 s13 0
R13 s13 5 56e-2
VS14 8 s14 0
R14 s14 4 18e-2
VS15 1 s15 0
R15 s15 10 56e-1
VS16 0 s16 0
L16 s16 2 10e-2
VS17 12 s17 0
C17 s17 6 82e-6
VS18 13 s18 0
C18 s18 5 18e-5
VS19 11 s19 0
C19 s19 7 27e-7
.control
set numdgt=17
ac lin 1 60 60
print v(1) v(2) v(3) v(4) v(5) v(6) v(7) v(8) v(9) v(10)
print v(11) v(12) v(13)
print i(vs0) i(vs1) i(vs2) i(vs3) i(vs4) i(vs5) i(vs6) i(vs7) i(vs8) i(vs9)
print i(vs10) i(vs11) i(vs12) i(vs13) i(vs14) i(vs15) i(vs16) i(vs17) i(vs18) i(vs19)
.endc
.end
