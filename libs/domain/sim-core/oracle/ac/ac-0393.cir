controls oracle ac-0393
* Generated (plan F2.7, ADR 0012): do not edit; regenerate with `pnpm sim oracle regen`. ac seed 20261031 index 393 nodes 17 elements 28
.options sparse gmin=1e-12 noopac
RG1 1 0 1000000000000
RG2 2 0 1000000000000
RG3 3 0 1000000000000
RG4 4 0 1000000000000
RG5 5 0 1000000000000
RG6 6 0 1000000000000
RG7 7 0 1000000000000
RG8 8 0 1000000000000
RG9 9 0 1000000000000
RG10 10 0 1000000000000
RG11 11 0 1000000000000
RG12 12 0 1000000000000
RG13 13 0 1000000000000
RG14 14 0 1000000000000
RG15 15 0 1000000000000
RG16 16 0 1000000000000
VS0 0 s0 0
V0 e0 s0 DC 0 AC 10e0 120
RI0 e0 7 12e-2
VS1 5 s1 0
C1 s1 11 39e-5
VS2 0 s2 0
R2 s2 10 18e-1
VS3 11 s3 0
V3 e3 s3 DC 0 AC 22e-1 180
RI3 e3 8 47e-1
VS4 3 s4 0
L4 s4 1 22e-4
VS5 15 s5 0
R5 s5 3 82e0
VS6 3 s6 0
R6 s6 2 39e2
VS7 4 s7 0
R7 s7 13 68e-1
VS8 1 s8 0
L8 s8 6 33e-2
VS9 14 s9 0
L9 s9 0 82e-2
VS10 13 s10 0
V10 e10 s10 DC 0 AC 47e1 120
RI10 e10 m10 82e-1
LI10 m10 9 56e-7
VS11 0 s11 0
C11 s11 16 56e-7
VS12 7 s12 0
C12 s12 12 82e-6
VS13 11 s13 0
R13 s13 12 39e2
VS14 5 s14 0
L14 s14 6 27e-5
VS15 11 s15 0
C15 s15 3 56e-4
VS16 11 s16 0
L16 s16 2 82e-3
VS17 5 s17 0
R17 s17 1 22e-2
VS18 15 s18 0
R18 s18 14 27e0
VS19 16 s19 0
V19 e19 s19 DC 0 AC 39e1 180
RI19 e19 m19 18e-1
LI19 m19 10 39e-5
VS20 10 s20 0
V20 e20 s20 DC 0 AC 12e0 0
RI20 e20 m20 10e-1
LI20 m20 14 82e-6
VS21 9 s21 0
R21 s21 5 18e1
VS22 4 s22 0
C22 s22 5 18e-7
VS23 13 s23 0
R23 s23 7 15e-2
VS24 8 s24 0
V24 e24 s24 DC 0 AC 10e0 -120
RI24 e24 4 22e-3
VS25 7 s25 0
R25 s25 11 68e1
VS26 14 s26 0
L26 s26 15 82e-3
VS27 3 s27 0
C27 s27 13 68e-7
.control
set numdgt=17
ac lin 1 60 60
print v(1) v(2) v(3) v(4) v(5) v(6) v(7) v(8) v(9) v(10)
print v(11) v(12) v(13) v(14) v(15) v(16)
print i(vs0) i(vs1) i(vs2) i(vs3) i(vs4) i(vs5) i(vs6) i(vs7) i(vs8) i(vs9)
print i(vs10) i(vs11) i(vs12) i(vs13) i(vs14) i(vs15) i(vs16) i(vs17) i(vs18) i(vs19)
print i(vs20) i(vs21) i(vs22) i(vs23) i(vs24) i(vs25) i(vs26) i(vs27)
.endc
.end
