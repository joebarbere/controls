controls oracle ac-0393
* Generated (plan F2.7, ADR 0012): do not edit; regenerate with `pnpm sim oracle regen`. ac seed 20261031 index 393 nodes 17 elements 25
.options sparse gmin=1e-12 noopac
RG1 1 0 1000000000000
RG2 2 0 1000000000000
RG3 3 0 1000000000000
RG4 4 0 1000000000000
RG5 5 0 1000000000000
RG6 6 0 1000000000000
RG7 7 0 1000000000000
RG8 8 0 1000000000000
RG9 9 0 1000000000000
RG10 10 0 1000000000000
RG11 11 0 1000000000000
RG12 12 0 1000000000000
RG13 13 0 1000000000000
RG14 14 0 1000000000000
RG15 15 0 1000000000000
RG16 16 0 1000000000000
VS0 14 s0 0
L0 s0 9 33e-4
VS1 1 s1 0
L1 s1 6 33e-2
VS2 10 s2 0
R2 s2 9 12e0
VS3 10 s3 0
R3 s3 0 68e0
VS4 14 s4 0
R4 s4 3 15e-1
VS5 1 s5 0
L5 s5 2 47e-4
VS6 0 s6 0
V6 e6 s6 DC 0 AC 22e-1 180
RI6 e6 n6 47e-1
H6 n6 h6 VS7 -68e-4
ED6 h6 8 d6 0 68e-5
F6 0 d6 VS7 1
LD6 d6 0 1
VS7 2 s7 0
V7 e7 s7 DC 0 AC 10e1 120
RI7 e7 n7 12e-3
H7 n7 h7 VS6 -68e-4
ED7 h7 8 d7 0 68e-5
F7 0 d7 VS6 1
LD7 d7 0 1
VS8 16 s8 0
C8 s8 4 82e-4
VS9 16 s9 0
R9 s9 15 68e1
VS10 3 s10 0
R10 s10 5 39e-1
VS11 7 s11 0
V11 e11 s11 DC 0 AC 33e0 -120
RI11 e11 11 33e-1
VS12 15 s12 0
R12 s12 3 82e0
VS13 0 s13 0
C13 s13 3 56e-4
VS14 6 s14 0
L14 s14 3 39e-4
VS15 7 s15 0
L15 s15 3 68e-5
VS16 8 s16 0
R16 s16 5 15e0
VS17 11 s17 0
R17 s17 0 68e1
VS18 12 s18 0
V18 e18 s18 DC 0 AC 82e1 -120
RI18 e18 m18 15e-3
LI18 m18 5 10e-7
VS19 4 s19 0
R19 s19 8 39e-2
VS20 11 s20 0
C20 s20 12 82e-6
VS21 9 s21 0
R21 s21 15 56e0
VS22 13 s22 0
R22 s22 15 10e1
VS23 3 s23 0
L23 s23 1 22e-4
VS24 13 s24 0
R24 s24 11 15e-2
.control
set numdgt=17
ac lin 1 60 60
print v(1) v(2) v(3) v(4) v(5) v(6) v(7) v(8) v(9) v(10)
print v(11) v(12) v(13) v(14) v(15) v(16)
print i(vs0) i(vs1) i(vs2) i(vs3) i(vs4) i(vs5) i(vs6) i(vs7) i(vs8) i(vs9)
print i(vs10) i(vs11) i(vs12) i(vs13) i(vs14) i(vs15) i(vs16) i(vs17) i(vs18) i(vs19)
print i(vs20) i(vs21) i(vs22) i(vs23) i(vs24)
.endc
.end
