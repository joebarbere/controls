controls oracle ac-0393
* Generated (plan F2.7, ADR 0012): do not edit; regenerate with `pnpm sim oracle regen`. ac seed 20261031 index 393 nodes 17 elements 20
.options sparse gmin=1e-12 noopac
RG1 1 0 1000000000000
RG2 2 0 1000000000000
RG3 3 0 1000000000000
RG4 4 0 1000000000000
RG5 5 0 1000000000000
RG6 6 0 1000000000000
RG7 7 0 1000000000000
RG8 8 0 1000000000000
RG9 9 0 1000000000000
RG10 10 0 1000000000000
RG11 11 0 1000000000000
RG12 12 0 1000000000000
RG13 13 0 1000000000000
RG14 14 0 1000000000000
RG15 15 0 1000000000000
RG16 16 0 1000000000000
VS0 14 s0 0
R0 s0 3 15e-1
VS1 15 s1 0
R1 s1 3 82e0
VS2 11 s2 0
R2 s2 0 68e1
VS3 0 s3 0
V3 e3 s3 DC 0 AC 22e-1 180
RI3 e3 8 47e-1
VS4 13 s4 0
R4 s4 11 15e-2
VS5 1 s5 0
L5 s5 2 47e-4
VS6 16 s6 0
C6 s6 4 82e-4
VS7 4 s7 0
R7 s7 8 39e-2
VS8 14 s8 0
L8 s8 9 33e-4
VS9 7 s9 0
L9 s9 3 68e-5
VS10 7 s10 0
V10 e10 s10 DC 0 AC 33e0 -120
RI10 e10 11 33e-1
VS11 8 s11 0
R11 s11 5 15e0
VS12 0 s12 0
C12 s12 3 56e-4
VS13 10 s13 0
R13 s13 0 68e0
VS14 2 s14 0
V14 e14 s14 DC 0 AC 10e1 120
RI14 e14 8 12e-3
VS15 9 s15 0
R15 s15 15 56e0
VS16 1 s16 0
L16 s16 6 33e-2
VS17 3 s17 0
R17 s17 5 39e-1
VS18 3 s18 0
L18 s18 1 22e-4
VS19 11 s19 0
C19 s19 12 82e-6
.control
set numdgt=17
ac lin 1 60 60
print v(1) v(2) v(3) v(4) v(5) v(6) v(7) v(8) v(9) v(10)
print v(11) v(12) v(13) v(14) v(15) v(16)
print i(vs0) i(vs1) i(vs2) i(vs3) i(vs4) i(vs5) i(vs6) i(vs7) i(vs8) i(vs9)
print i(vs10) i(vs11) i(vs12) i(vs13) i(vs14) i(vs15) i(vs16) i(vs17) i(vs18) i(vs19)
.endc
.end
