controls oracle ac-0352
* Generated (plan F2.7, ADR 0012): do not edit; regenerate with `pnpm sim oracle regen`. ac seed 20261031 index 352 nodes 21 elements 34
.options sparse gmin=1e-12 noopac
RG1 1 0 1000000000000
RG2 2 0 1000000000000
RG3 3 0 1000000000000
RG4 4 0 1000000000000
RG5 5 0 1000000000000
RG6 6 0 1000000000000
RG7 7 0 1000000000000
RG8 8 0 1000000000000
RG9 9 0 1000000000000
RG10 10 0 1000000000000
RG11 11 0 1000000000000
RG12 12 0 1000000000000
RG13 13 0 1000000000000
RG14 14 0 1000000000000
RG15 15 0 1000000000000
RG16 16 0 1000000000000
RG17 17 0 1000000000000
RG18 18 0 1000000000000
RG19 19 0 1000000000000
RG20 20 0 1000000000000
VS0 17 s0 0
C0 s0 8 12e-7
VS1 7 s1 0
L1 s1 14 15e-5
VS2 14 s2 0
C2 s2 4 10e-4
VS3 15 s3 0
C3 s3 0 47e-7
VS4 14 s4 0
L4 s4 3 56e-2
VS5 17 s5 0
C5 s5 1 56e-4
VS6 20 s6 0
L6 s6 0 10e-3
VS7 13 s7 0
R7 s7 2 22e3
VS8 18 s8 0
L8 s8 10 47e-4
VS9 1 s9 0
R9 s9 17 12e-2
VS10 12 s10 0
L10 s10 2 27e-4
VS11 9 s11 0
L11 s11 1 27e-4
VS12 18 s12 0
R12 s12 8 82e0
VS13 20 s13 0
R13 s13 19 56e0
VS14 3 s14 0
L14 s14 20 47e-3
VS15 3 s15 0
R15 s15 6 18e3
VS16 0 s16 0
V16 e16 s16 DC 0 AC 22e0 120
RI16 e16 n16 15e-2
H16 n16 h16 VS22 -33e-4
ED16 h16 14 d16 0 15e-6
F16 0 d16 VS22 1
LD16 d16 0 1
VS17 12 s17 0
L17 s17 15 33e-2
VS18 15 s18 0
R18 s18 7 10e0
VS19 12 s19 0
R19 s19 6 82e0
VS20 16 s20 0
L20 s20 11 10e-4
VS21 8 s21 0
L21 s21 12 22e-2
VS22 20 s22 0
V22 e22 s22 DC 0 AC 47e1 180
RI22 e22 n22 39e-3
H22 n22 h22 VS16 -33e-4
ED22 h22 19 d22 0 15e-6
F22 0 d22 VS16 1
LD22 d22 0 1
VS23 7 s23 0
L23 s23 19 22e-5
VS24 13 s24 0
R24 s24 5 15e1
VS25 4 s25 0
V25 e25 s25 DC 0 AC 39e1 120
RI25 e25 m25 82e-2
LI25 m25 8 47e-5
VS26 6 s26 0
L26 s26 3 10e-3
VS27 5 s27 0
C27 s27 1 47e-7
VS28 16 s28 0
L28 s28 3 68e-5
VS29 12 s29 0
R29 s29 19 18e1
VS30 7 s30 0
L30 s30 11 12e-5
VS31 10 s31 0
L31 s31 6 18e-3
VS32 20 s32 0
L32 s32 1 12e-4
VS33 12 s33 0
C33 s33 9 56e-6
.control
set numdgt=17
ac lin 1 60 60
print v(1) v(2) v(3) v(4) v(5) v(6) v(7) v(8) v(9) v(10)
print v(11) v(12) v(13) v(14) v(15) v(16) v(17) v(18) v(19) v(20)
print i(vs0) i(vs1) i(vs2) i(vs3) i(vs4) i(vs5) i(vs6) i(vs7) i(vs8) i(vs9)
print i(vs10) i(vs11) i(vs12) i(vs13) i(vs14) i(vs15) i(vs16) i(vs17) i(vs18) i(vs19)
print i(vs20) i(vs21) i(vs22) i(vs23) i(vs24) i(vs25) i(vs26) i(vs27) i(vs28) i(vs29)
print i(vs30) i(vs31) i(vs32) i(vs33)
.endc
.end
