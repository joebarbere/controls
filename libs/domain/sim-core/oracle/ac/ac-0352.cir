controls oracle ac-0352
* Generated (plan F2.7, ADR 0012): do not edit; regenerate with `pnpm sim oracle regen`. ac seed 20261031 index 352 nodes 21 elements 31
.options sparse gmin=1e-12 noopac
RG1 1 0 1000000000000
RG2 2 0 1000000000000
RG3 3 0 1000000000000
RG4 4 0 1000000000000
RG5 5 0 1000000000000
RG6 6 0 1000000000000
RG7 7 0 1000000000000
RG8 8 0 1000000000000
RG9 9 0 1000000000000
RG10 10 0 1000000000000
RG11 11 0 1000000000000
RG12 12 0 1000000000000
RG13 13 0 1000000000000
RG14 14 0 1000000000000
RG15 15 0 1000000000000
RG16 16 0 1000000000000
RG17 17 0 1000000000000
RG18 18 0 1000000000000
RG19 19 0 1000000000000
RG20 20 0 1000000000000
VS0 12 s0 0
L0 s0 2 27e-4
VS1 12 s1 0
L1 s1 15 33e-2
VS2 0 s2 0
V2 e2 s2 DC 0 AC 22e0 120
RI2 e2 14 15e-2
VS3 1 s3 0
R3 s3 17 12e-2
VS4 15 s4 0
C4 s4 0 47e-7
VS5 9 s5 0
L5 s5 1 27e-4
VS6 12 s6 0
C6 s6 9 56e-6
VS7 15 s7 0
R7 s7 7 10e0
VS8 12 s8 0
R8 s8 19 18e1
VS9 3 s9 0
R9 s9 6 18e3
VS10 17 s10 0
C10 s10 1 56e-4
VS11 7 s11 0
L11 s11 14 15e-5
VS12 20 s12 0
V12 e12 s12 DC 0 AC 47e1 180
RI12 e12 19 39e-3
VS13 7 s13 0
L13 s13 11 12e-5
VS14 7 s14 0
L14 s14 19 22e-5
VS15 20 s15 0
L15 s15 1 12e-4
VS16 14 s16 0
C16 s16 4 10e-4
VS17 10 s17 0
L17 s17 6 18e-3
VS18 13 s18 0
R18 s18 2 22e3
VS19 12 s19 0
R19 s19 6 82e0
VS20 8 s20 0
L20 s20 12 22e-2
VS21 13 s21 0
R21 s21 5 15e1
VS22 20 s22 0
R22 s22 19 56e0
VS23 6 s23 0
L23 s23 3 10e-3
VS24 20 s24 0
L24 s24 0 10e-3
VS25 18 s25 0
R25 s25 8 82e0
VS26 16 s26 0
L26 s26 11 10e-4
VS27 17 s27 0
C27 s27 8 12e-7
VS28 3 s28 0
L28 s28 20 47e-3
VS29 14 s29 0
L29 s29 3 56e-2
VS30 4 s30 0
V30 e30 s30 DC 0 AC 39e1 120
RI30 e30 8 82e-2
.control
set numdgt=17
ac lin 1 60 60
print v(1) v(2) v(3) v(4) v(5) v(6) v(7) v(8) v(9) v(10)
print v(11) v(12) v(13) v(14) v(15) v(16) v(17) v(18) v(19) v(20)
print i(vs0) i(vs1) i(vs2) i(vs3) i(vs4) i(vs5) i(vs6) i(vs7) i(vs8) i(vs9)
print i(vs10) i(vs11) i(vs12) i(vs13) i(vs14) i(vs15) i(vs16) i(vs17) i(vs18) i(vs19)
print i(vs20) i(vs21) i(vs22) i(vs23) i(vs24) i(vs25) i(vs26) i(vs27) i(vs28) i(vs29)
print i(vs30)
.endc
.end
