controls oracle ac-0352
* Generated (plan F2.7, ADR 0012): do not edit; regenerate with `pnpm sim oracle regen`. ac seed 20261031 index 352 nodes 21 elements 37
.options sparse gmin=1e-12 noopac
RG1 1 0 1000000000000
RG2 2 0 1000000000000
RG3 3 0 1000000000000
RG4 4 0 1000000000000
RG5 5 0 1000000000000
RG6 6 0 1000000000000
RG7 7 0 1000000000000
RG8 8 0 1000000000000
RG9 9 0 1000000000000
RG10 10 0 1000000000000
RG11 11 0 1000000000000
RG12 12 0 1000000000000
RG13 13 0 1000000000000
RG14 14 0 1000000000000
RG15 15 0 1000000000000
RG16 16 0 1000000000000
RG17 17 0 1000000000000
RG18 18 0 1000000000000
RG19 19 0 1000000000000
RG20 20 0 1000000000000
VS0 20 s0 0
C0 s0 9 56e-6
VS1 9 s1 0
C1 s1 14 82e-7
VS2 3 s2 0
L2 s2 0 47e-3
VS3 15 s3 0
C3 s3 12 47e-7
VS4 0 s4 0
R4 s4 19 56e0
VS5 0 s5 0
V5 e5 s5 DC 0 AC 47e1 180
RI5 e5 m5 39e-3
LI5 m5 19 12e-7
VS6 20 s6 0
L6 s6 15 33e-2
VS7 15 s7 0
R7 s7 7 10e0
VS8 6 s8 0
L8 s8 15 82e-4
VS9 6 s9 0
L9 s9 3 10e-3
VS10 9 s10 0
C10 s10 13 56e-4
VS11 4 s11 0
L11 s11 0 47e-4
VS12 10 s12 0
V12 e12 s12 DC 0 AC 82e-1 -120
RI12 e12 m12 27e-3
LI12 m12 11 56e-5
VS13 0 s13 0
L13 s13 1 12e-4
VS14 8 s14 0
L14 s14 20 22e-2
VS15 5 s15 0
R15 s15 6 33e-2
VS16 20 s16 0
R16 s16 6 82e0
VS17 16 s17 0
L17 s17 13 22e-5
VS18 10 s18 0
C18 s18 4 47e-5
VS19 7 s19 0
L19 s19 11 12e-5
VS20 17 s20 0
C20 s20 1 56e-4
VS21 1 s21 0
C21 s21 12 18e-5
VS22 20 s22 0
V22 e22 s22 DC 0 AC 68e1 0
RI22 e22 m22 82e-3
LI22 m22 17 12e-7
VS23 17 s23 0
C23 s23 8 12e-7
VS24 5 s24 0
R24 s24 19 39e2
VS25 19 s25 0
L25 s25 9 47e-3
VS26 17 s26 0
R26 s26 19 56e3
VS27 7 s27 0
L27 s27 19 22e-5
VS28 20 s28 0
L28 s28 2 27e-4
VS29 5 s29 0
V29 e29 s29 DC 0 AC 39e0 0
RI29 e29 m29 68e-3
LI29 m29 17 27e-5
VS30 2 s30 0
R30 s30 18 22e-2
VS31 4 s31 0
V31 e31 s31 DC 0 AC 39e1 120
RI31 e31 m31 82e-2
LI31 m31 8 33e-7
VS32 14 s32 0
L32 s32 3 56e-2
VS33 18 s33 0
L33 s33 16 56e-3
VS34 9 s34 0
L34 s34 1 27e-4
VS35 20 s35 0
R35 s35 19 18e1
VS36 3 s36 0
R36 s36 12 15e2
.control
set numdgt=17
ac lin 1 60 60
print v(1) v(2) v(3) v(4) v(5) v(6) v(7) v(8) v(9) v(10)
print v(11) v(12) v(13) v(14) v(15) v(16) v(17) v(18) v(19) v(20)
print i(vs0) i(vs1) i(vs2) i(vs3) i(vs4) i(vs5) i(vs6) i(vs7) i(vs8) i(vs9)
print i(vs10) i(vs11) i(vs12) i(vs13) i(vs14) i(vs15) i(vs16) i(vs17) i(vs18) i(vs19)
print i(vs20) i(vs21) i(vs22) i(vs23) i(vs24) i(vs25) i(vs26) i(vs27) i(vs28) i(vs29)
print i(vs30) i(vs31) i(vs32) i(vs33) i(vs34) i(vs35) i(vs36)
.endc
.end
