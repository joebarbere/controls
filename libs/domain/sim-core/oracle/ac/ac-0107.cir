controls oracle ac-0107
* Generated (plan F2.7, ADR 0012): do not edit; regenerate with `pnpm sim oracle regen`. ac seed 20261031 index 107 nodes 7 elements 13
.options sparse gmin=1e-12 noopac
RG1 1 0 1000000000000
RG2 2 0 1000000000000
RG3 3 0 1000000000000
RG4 4 0 1000000000000
RG5 5 0 1000000000000
RG6 6 0 1000000000000
VS0 1 s0 0
L0 s0 4 12e-5
VS1 2 s1 0
C1 s1 0 33e-4
VS2 0 s2 0
V2 e2 s2 DC 0 AC 68e1 -120
RI2 e2 m2 10e-3
LI2 m2 n2 12e-7
H2 n2 h2 VS5 -27e-4
ED2 h2 2 d2 0 39e-6
F2 0 d2 VS5 1
LD2 d2 0 1
VS3 2 s3 0
L3 s3 3 12e-5
VS4 3 s4 0
L4 s4 6 68e-2
VS5 4 s5 0
V5 e5 s5 DC 0 AC 10e1 120
RI5 e5 n5 68e-3
H5 n5 h5 VS2 -27e-4
ED5 h5 0 d5 0 39e-6
F5 0 d5 VS2 1
LD5 d5 0 1
VS6 1 s6 0
R6 s6 2 56e1
VS7 2 s7 0
L7 s7 0 56e-4
VS8 1 s8 0
C8 s8 5 12e-5
VS9 2 s9 0
V9 e9 s9 DC 0 AC 27e0 180
RI9 e9 m9 22e-3
LI9 m9 4 12e-7
VS10 6 s10 0
L10 s10 2 82e-4
VS11 2 s11 0
L11 s11 5 68e-4
VS12 5 s12 0
R12 s12 3 15e1
.control
set numdgt=17
ac lin 1 60 60
print v(1) v(2) v(3) v(4) v(5) v(6)
print i(vs0) i(vs1) i(vs2) i(vs3) i(vs4) i(vs5) i(vs6) i(vs7) i(vs8) i(vs9)
print i(vs10) i(vs11) i(vs12)
.endc
.end
