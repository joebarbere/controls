controls oracle ac-0005
* Generated (plan F2.7, ADR 0012): do not edit; regenerate with `pnpm sim oracle regen`. ac seed 20261031 index 5 nodes 24 elements 41
.options sparse gmin=1e-12 noopac
RG1 1 0 1000000000000
RG2 2 0 1000000000000
RG3 3 0 1000000000000
RG4 4 0 1000000000000
RG5 5 0 1000000000000
RG6 6 0 1000000000000
RG7 7 0 1000000000000
RG8 8 0 1000000000000
RG9 9 0 1000000000000
RG10 10 0 1000000000000
RG11 11 0 1000000000000
RG12 12 0 1000000000000
RG13 13 0 1000000000000
RG14 14 0 1000000000000
RG15 15 0 1000000000000
RG16 16 0 1000000000000
RG17 17 0 1000000000000
RG18 18 0 1000000000000
RG19 19 0 1000000000000
RG20 20 0 1000000000000
RG21 21 0 1000000000000
RG22 22 0 1000000000000
RG23 23 0 1000000000000
VS0 0 s0 0
V0 e0 s0 DC 0 AC 18e1 120
RI0 e0 m0 68e-3
LI0 m0 20 18e-5
VS1 20 s1 0
V1 e1 s1 DC 0 AC 12e0 120
RI1 e1 m1 18e-1
LI1 m1 12 27e-6
VS2 19 s2 0
R2 s2 7 68e-2
VS3 16 s3 0
R3 s3 17 18e2
VS4 11 s4 0
R4 s4 21 68e0
VS5 6 s5 0
R5 s5 7 47e-1
VS6 13 s6 0
R6 s6 21 22e2
VS7 12 s7 0
R7 s7 10 56e3
VS8 21 s8 0
L8 s8 1 18e-4
VS9 21 s9 0
R9 s9 8 10e2
VS10 0 s10 0
C10 s10 8 33e-7
VS11 4 s11 0
V11 e11 s11 DC 0 AC 47e0 0
RI11 e11 6 15e-3
VS12 13 s12 0
R12 s12 16 39e0
VS13 3 s13 0
R13 s13 14 15e2
VS14 5 s14 0
C14 s14 0 15e-5
VS15 3 s15 0
L15 s15 1 12e-5
VS16 3 s16 0
R16 s16 23 15e3
VS17 23 s17 0
L17 s17 17 56e-4
VS18 5 s18 0
R18 s18 15 68e-1
VS19 11 s19 0
R19 s19 10 12e-2
VS20 11 s20 0
V20 e20 s20 DC 0 AC 68e1 0
RI20 e20 m20 10e-3
LI20 m20 15 22e-7
VS21 13 s21 0
L21 s21 12 12e-4
VS22 13 s22 0
L22 s22 6 27e-5
VS23 22 s23 0
R23 s23 19 82e0
VS24 22 s24 0
C24 s24 1 56e-6
VS25 23 s25 0
R25 s25 7 15e0
VS26 2 s26 0
R26 s26 15 56e-2
VS27 16 s27 0
C27 s27 23 39e-4
VS28 21 s28 0
R28 s28 0 47e0
VS29 14 s29 0
R29 s29 23 10e-1
VS30 20 s30 0
V30 e30 s30 DC 0 AC 22e0 0
RI30 e30 2 18e-3
VS31 8 s31 0
L31 s31 9 10e-3
VS32 19 s32 0
V32 e32 s32 DC 0 AC 47e0 -120
RI32 e32 m32 12e-2
LI32 m32 21 15e-6
VS33 9 s33 0
V33 e33 s33 DC 0 AC 22e0 120
RI33 e33 7 15e-2
VS34 4 s34 0
L34 s34 11 27e-2
VS35 0 s35 0
C35 s35 3 10e-7
VS36 18 s36 0
C36 s36 22 22e-7
VS37 7 s37 0
R37 s37 19 12e2
VS38 2 s38 0
L38 s38 7 82e-3
VS39 8 s39 0
L39 s39 5 15e-2
VS40 18 s40 0
L40 s40 20 56e-2
.control
set numdgt=17
ac lin 1 60 60
print v(1) v(2) v(3) v(4) v(5) v(6) v(7) v(8) v(9) v(10)
print v(11) v(12) v(13) v(14) v(15) v(16) v(17) v(18) v(19) v(20)
print v(21) v(22) v(23)
print i(vs0) i(vs1) i(vs2) i(vs3) i(vs4) i(vs5) i(vs6) i(vs7) i(vs8) i(vs9)
print i(vs10) i(vs11) i(vs12) i(vs13) i(vs14) i(vs15) i(vs16) i(vs17) i(vs18) i(vs19)
print i(vs20) i(vs21) i(vs22) i(vs23) i(vs24) i(vs25) i(vs26) i(vs27) i(vs28) i(vs29)
print i(vs30) i(vs31) i(vs32) i(vs33) i(vs34) i(vs35) i(vs36) i(vs37) i(vs38) i(vs39)
print i(vs40)
.endc
.end
