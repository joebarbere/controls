controls oracle ac-0005
* Generated (plan F2.7, ADR 0012): do not edit; regenerate with `pnpm sim oracle regen`. ac seed 20261031 index 5 nodes 24 elements 32
.options sparse gmin=1e-12 noopac
RG1 1 0 1000000000000
RG2 2 0 1000000000000
RG3 3 0 1000000000000
RG4 4 0 1000000000000
RG5 5 0 1000000000000
RG6 6 0 1000000000000
RG7 7 0 1000000000000
RG8 8 0 1000000000000
RG9 9 0 1000000000000
RG10 10 0 1000000000000
RG11 11 0 1000000000000
RG12 12 0 1000000000000
RG13 13 0 1000000000000
RG14 14 0 1000000000000
RG15 15 0 1000000000000
RG16 16 0 1000000000000
RG17 17 0 1000000000000
RG18 18 0 1000000000000
RG19 19 0 1000000000000
RG20 20 0 1000000000000
RG21 21 0 1000000000000
RG22 22 0 1000000000000
RG23 23 0 1000000000000
VS0 17 s0 0
R0 s0 19 22e1
VS1 0 s1 0
V1 e1 s1 DC 0 AC 47e0 -120
RI1 e1 21 12e-2
VS2 21 s2 0
C2 s2 15 15e-5
VS3 6 s3 0
V3 e3 s3 DC 0 AC 22e0 120
RI3 e3 20 15e-2
VS4 9 s4 0
L4 s4 22 47e-5
VS5 12 s5 0
V5 e5 s5 DC 0 AC 56e0 0
RI5 e5 5 82e-1
VS6 23 s6 0
C6 s6 18 47e-5
VS7 10 s7 0
C7 s7 4 56e-6
VS8 11 s8 0
R8 s8 23 12e-2
VS9 21 s9 0
L9 s9 19 18e-4
VS10 15 s10 0
V10 e10 s10 DC 0 AC 68e0 120
RI10 e10 8 82e-1
VS11 22 s11 0
L11 s11 23 10e-2
VS12 13 s12 0
R12 s12 3 18e2
VS13 19 s13 0
R13 s13 8 39e1
VS14 21 s14 0
L14 s14 7 33e-5
VS15 13 s15 0
C15 s15 0 27e-7
VS16 20 s16 0
R16 s16 11 82e2
VS17 2 s17 0
L17 s17 17 27e-5
VS18 19 s18 0
C18 s18 16 82e-7
VS19 18 s19 0
V19 e19 s19 DC 0 AC 18e-1 -120
RI19 e19 13 27e-3
VS20 4 s20 0
V20 e20 s20 DC 0 AC 27e0 -120
RI20 e20 9 56e-3
VS21 9 s21 0
V21 e21 s21 DC 0 AC 27e1 -120
RI21 e21 1 47e-2
VS22 13 s22 0
R22 s22 7 10e1
VS23 19 s23 0
V23 e23 s23 DC 0 AC 39e1 0
RI23 e23 12 15e-3
VS24 2 s24 0
C24 s24 14 15e-6
VS25 21 s25 0
R25 s25 16 22e-2
VS26 8 s26 0
V26 e26 s26 DC 0 AC 68e1 180
RI26 e26 2 82e-1
VS27 3 s27 0
R27 s27 5 15e2
VS28 20 s28 0
V28 e28 s28 DC 0 AC 22e0 0
RI28 e28 2 18e-3
VS29 20 s29 0
R29 s29 10 27e-2
VS30 14 s30 0
R30 s30 6 56e3
VS31 2 s31 0
V31 e31 s31 DC 0 AC 33e-1 180
RI31 e31 1 12e-2
.control
set numdgt=17
ac lin 1 60 60
print v(1) v(2) v(3) v(4) v(5) v(6) v(7) v(8) v(9) v(10)
print v(11) v(12) v(13) v(14) v(15) v(16) v(17) v(18) v(19) v(20)
print v(21) v(22) v(23)
print i(vs0) i(vs1) i(vs2) i(vs3) i(vs4) i(vs5) i(vs6) i(vs7) i(vs8) i(vs9)
print i(vs10) i(vs11) i(vs12) i(vs13) i(vs14) i(vs15) i(vs16) i(vs17) i(vs18) i(vs19)
print i(vs20) i(vs21) i(vs22) i(vs23) i(vs24) i(vs25) i(vs26) i(vs27) i(vs28) i(vs29)
print i(vs30) i(vs31)
.endc
.end
