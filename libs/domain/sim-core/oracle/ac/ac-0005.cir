controls oracle ac-0005
* Generated (plan F2.7, ADR 0012): do not edit; regenerate with `pnpm sim oracle regen`. ac seed 20261031 index 5 nodes 24 elements 25
.options sparse gmin=1e-12 noopac
RG1 1 0 1000000000000
RG2 2 0 1000000000000
RG3 3 0 1000000000000
RG4 4 0 1000000000000
RG5 5 0 1000000000000
RG6 6 0 1000000000000
RG7 7 0 1000000000000
RG8 8 0 1000000000000
RG9 9 0 1000000000000
RG10 10 0 1000000000000
RG11 11 0 1000000000000
RG12 12 0 1000000000000
RG13 13 0 1000000000000
RG14 14 0 1000000000000
RG15 15 0 1000000000000
RG16 16 0 1000000000000
RG17 17 0 1000000000000
RG18 18 0 1000000000000
RG19 19 0 1000000000000
RG20 20 0 1000000000000
RG21 21 0 1000000000000
RG22 22 0 1000000000000
RG23 23 0 1000000000000
VS0 0 s0 0
V0 e0 s0 DC 0 AC 33e-1 180
RI0 e0 1 12e-2
VS1 21 s1 0
C1 s1 15 15e-5
VS2 18 s2 0
V2 e2 s2 DC 0 AC 18e-1 -120
RI2 e2 13 27e-3
VS3 10 s3 0
C3 s3 4 56e-6
VS4 19 s4 0
V4 e4 s4 DC 0 AC 47e0 -120
RI4 e4 21 12e-2
VS5 20 s5 0
V5 e5 s5 DC 0 AC 22e0 0
RI5 e5 0 18e-3
VS6 2 s6 0
R6 s6 8 39e1
VS7 9 s7 0
V7 e7 s7 DC 0 AC 27e1 -120
RI7 e7 1 47e-2
VS8 21 s8 0
R8 s8 16 22e-2
VS9 2 s9 0
V9 e9 s9 DC 0 AC 39e1 0
RI9 e9 12 15e-3
VS10 20 s10 0
R10 s10 11 82e2
VS11 14 s11 0
R11 s11 6 56e3
VS12 11 s12 0
R12 s12 23 12e-2
VS13 3 s13 0
R13 s13 5 15e2
VS14 23 s14 0
C14 s14 18 47e-5
VS15 4 s15 0
V15 e15 s15 DC 0 AC 27e0 -120
RI15 e15 9 56e-3
VS16 22 s16 0
L16 s16 23 10e-2
VS17 6 s17 0
V17 e17 s17 DC 0 AC 22e0 120
RI17 e17 20 15e-2
VS18 13 s18 0
C18 s18 19 27e-7
VS19 13 s19 0
R19 s19 7 10e1
VS20 13 s20 0
R20 s20 3 18e2
VS21 20 s21 0
R21 s21 10 27e-2
VS22 8 s22 0
V22 e22 s22 DC 0 AC 68e1 180
RI22 e22 0 82e-1
VS23 0 s23 0
L23 s23 17 27e-5
VS24 21 s24 0
L24 s24 2 18e-4
.control
set numdgt=17
ac lin 1 60 60
print v(1) v(2) v(3) v(4) v(5) v(6) v(7) v(8) v(9) v(10)
print v(11) v(12) v(13) v(14) v(15) v(16) v(17) v(18) v(19) v(20)
print v(21) v(22) v(23)
print i(vs0) i(vs1) i(vs2) i(vs3) i(vs4) i(vs5) i(vs6) i(vs7) i(vs8) i(vs9)
print i(vs10) i(vs11) i(vs12) i(vs13) i(vs14) i(vs15) i(vs16) i(vs17) i(vs18) i(vs19)
print i(vs20) i(vs21) i(vs22) i(vs23) i(vs24)
.endc
.end
