controls oracle ac-0091
* Generated (plan F2.7, ADR 0012): do not edit; regenerate with `pnpm sim oracle regen`. ac seed 20261031 index 91 nodes 29 elements 46
.options sparse gmin=1e-12 noopac
RG1 1 0 1000000000000
RG2 2 0 1000000000000
RG3 3 0 1000000000000
RG4 4 0 1000000000000
RG5 5 0 1000000000000
RG6 6 0 1000000000000
RG7 7 0 1000000000000
RG8 8 0 1000000000000
RG9 9 0 1000000000000
RG10 10 0 1000000000000
RG11 11 0 1000000000000
RG12 12 0 1000000000000
RG13 13 0 1000000000000
RG14 14 0 1000000000000
RG15 15 0 1000000000000
RG16 16 0 1000000000000
RG17 17 0 1000000000000
RG18 18 0 1000000000000
RG19 19 0 1000000000000
RG20 20 0 1000000000000
RG21 21 0 1000000000000
RG22 22 0 1000000000000
RG23 23 0 1000000000000
RG24 24 0 1000000000000
RG25 25 0 1000000000000
RG26 26 0 1000000000000
RG27 27 0 1000000000000
RG28 28 0 1000000000000
VS0 5 s0 0
R0 s0 28 68e-2
VS1 14 s1 0
L1 s1 10 18e-2
VS2 26 s2 0
C2 s2 16 68e-5
VS3 21 s3 0
R3 s3 5 18e0
VS4 0 s4 0
V4 e4 s4 DC 0 AC 10e1 -120
RI4 e4 23 10e-3
VS5 17 s5 0
R5 s5 7 27e1
VS6 12 s6 0
C6 s6 11 33e-7
VS7 3 s7 0
L7 s7 7 82e-2
VS8 8 s8 0
R8 s8 6 47e0
VS9 4 s9 0
L9 s9 17 22e-4
VS10 13 s10 0
L10 s10 0 39e-4
VS11 12 s11 0
L11 s11 16 82e-4
VS12 4 s12 0
C12 s12 9 12e-6
VS13 22 s13 0
L13 s13 28 56e-5
VS14 28 s14 0
L14 s14 14 15e-5
VS15 21 s15 0
V15 e15 s15 DC 0 AC 12e1 -120
RI15 e15 m15 47e-3
LI15 m15 9 39e-6
VS16 15 s16 0
L16 s16 0 10e-5
VS17 0 s17 0
R17 s17 15 15e1
VS18 9 s18 0
L18 s18 10 27e-4
VS19 20 s19 0
L19 s19 28 56e-4
VS20 6 s20 0
R20 s20 15 47e-1
VS21 8 s21 0
L21 s21 9 56e-5
VS22 14 s22 0
C22 s22 20 39e-7
VS23 16 s23 0
C23 s23 15 27e-5
VS24 28 s24 0
V24 e24 s24 DC 0 AC 56e-1 -120
RI24 e24 m24 18e-1
LI24 m24 2 68e-6
VS25 13 s25 0
C25 s25 20 39e-4
VS26 23 s26 0
C26 s26 16 12e-4
VS27 18 s27 0
C27 s27 1 27e-4
VS28 26 s28 0
R28 s28 7 15e-2
VS29 15 s29 0
R29 s29 17 15e3
VS30 21 s30 0
V30 e30 s30 DC 0 AC 27e0 180
RI30 e30 m30 18e-3
LI30 m30 19 47e-6
VS31 19 s31 0
L31 s31 23 68e-3
VS32 18 s32 0
R32 s32 28 10e-1
VS33 22 s33 0
V33 e33 s33 DC 0 AC 12e0 180
RI33 e33 2 47e-2
VS34 2 s34 0
L34 s34 3 27e-5
VS35 25 s35 0
V35 e35 s35 DC 0 AC 18e0 180
RI35 e35 1 68e-2
VS36 28 s36 0
V36 e36 s36 DC 0 AC 47e-1 120
RI36 e36 m36 18e-3
LI36 m36 26 12e-5
VS37 4 s37 0
C37 s37 24 22e-5
VS38 21 s38 0
C38 s38 26 68e-4
VS39 25 s39 0
R39 s39 28 33e0
VS40 21 s40 0
L40 s40 27 47e-4
VS41 12 s41 0
R41 s41 4 10e0
VS42 1 s42 0
L42 s42 20 56e-5
VS43 28 s43 0
C43 s43 24 33e-7
VS44 27 s44 0
R44 s44 17 39e1
VS45 11 s45 0
L45 s45 4 10e-3
.control
set numdgt=17
ac lin 1 60 60
print v(1) v(2) v(3) v(4) v(5) v(6) v(7) v(8) v(9) v(10)
print v(11) v(12) v(13) v(14) v(15) v(16) v(17) v(18) v(19) v(20)
print v(21) v(22) v(23) v(24) v(25) v(26) v(27) v(28)
print i(vs0) i(vs1) i(vs2) i(vs3) i(vs4) i(vs5) i(vs6) i(vs7) i(vs8) i(vs9)
print i(vs10) i(vs11) i(vs12) i(vs13) i(vs14) i(vs15) i(vs16) i(vs17) i(vs18) i(vs19)
print i(vs20) i(vs21) i(vs22) i(vs23) i(vs24) i(vs25) i(vs26) i(vs27) i(vs28) i(vs29)
print i(vs30) i(vs31) i(vs32) i(vs33) i(vs34) i(vs35) i(vs36) i(vs37) i(vs38) i(vs39)
print i(vs40) i(vs41) i(vs42) i(vs43) i(vs44) i(vs45)
.endc
.end
