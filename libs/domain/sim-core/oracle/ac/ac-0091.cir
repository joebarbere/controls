controls oracle ac-0091
* Generated (plan F2.7, ADR 0012): do not edit; regenerate with `pnpm sim oracle regen`. ac seed 20261031 index 91 nodes 29 elements 46
.options sparse gmin=1e-12 noopac
RG1 1 0 1000000000000
RG2 2 0 1000000000000
RG3 3 0 1000000000000
RG4 4 0 1000000000000
RG5 5 0 1000000000000
RG6 6 0 1000000000000
RG7 7 0 1000000000000
RG8 8 0 1000000000000
RG9 9 0 1000000000000
RG10 10 0 1000000000000
RG11 11 0 1000000000000
RG12 12 0 1000000000000
RG13 13 0 1000000000000
RG14 14 0 1000000000000
RG15 15 0 1000000000000
RG16 16 0 1000000000000
RG17 17 0 1000000000000
RG18 18 0 1000000000000
RG19 19 0 1000000000000
RG20 20 0 1000000000000
RG21 21 0 1000000000000
RG22 22 0 1000000000000
RG23 23 0 1000000000000
RG24 24 0 1000000000000
RG25 25 0 1000000000000
RG26 26 0 1000000000000
RG27 27 0 1000000000000
RG28 28 0 1000000000000
VS0 5 s0 0
R0 s0 28 68e-2
VS1 10 s1 0
C1 s1 4 15e-7
VS2 0 s2 0
L2 s2 7 33e-3
VS3 12 s3 0
R3 s3 3 33e3
VS4 28 s4 0
C4 s4 23 12e-5
VS5 0 s5 0
V5 e5 s5 DC 0 AC 68e0 0
RI5 e5 7 47e-1
VS6 13 s6 0
L6 s6 28 47e-2
VS7 2 s7 0
C7 s7 15 18e-7
VS8 8 s8 0
R8 s8 5 47e-2
VS9 4 s9 0
V9 e9 s9 DC 0 AC 82e-1 180
RI9 e9 5 33e-2
VS10 6 s10 0
L10 s10 13 39e-4
VS11 12 s11 0
C11 s11 17 18e-6
VS12 9 s12 0
V12 e12 s12 DC 0 AC 47e0 180
RI12 e12 20 27e-2
VS13 25 s13 0
V13 e13 s13 DC 0 AC 27e-1 180
RI13 e13 24 56e-1
VS14 14 s14 0
R14 s14 27 27e-1
VS15 12 s15 0
L15 s15 21 82e-2
VS16 6 s16 0
V16 e16 s16 DC 0 AC 56e-1 -120
RI16 e16 15 10e-1
VS17 4 s17 0
L17 s17 19 22e-5
VS18 16 s18 0
V18 e18 s18 DC 0 AC 27e-1 180
RI18 e18 9 27e-1
VS19 20 s19 0
L19 s19 28 56e-4
VS20 0 s20 0
R20 s20 15 47e-1
VS21 18 s21 0
L21 s21 7 47e-4
VS22 10 s22 0
R22 s22 14 39e3
VS23 0 s23 0
L23 s23 16 56e-4
VS24 28 s24 0
V24 e24 s24 DC 0 AC 56e-1 -120
RI24 e24 2 18e-1
VS25 6 s25 0
C25 s25 20 39e-4
VS26 25 s26 0
C26 s26 22 12e-6
VS27 25 s27 0
V27 e27 s27 DC 0 AC 10e0 120
RI27 e27 15 33e-3
VS28 9 s28 0
V28 e28 s28 DC 0 AC 47e-1 -120
RI28 e28 28 56e-3
VS29 15 s29 0
R29 s29 17 15e3
VS30 19 s30 0
R30 s30 13 33e2
VS31 11 s31 0
R31 s31 21 33e0
VS32 20 s32 0
L32 s32 18 15e-4
VS33 22 s33 0
C33 s33 1 27e-7
VS34 5 s34 0
R34 s34 3 22e-1
VS35 5 s35 0
C35 s35 26 39e-6
VS36 28 s36 0
V36 e36 s36 DC 0 AC 47e-1 120
RI36 e36 26 18e-3
VS37 23 s37 0
R37 s37 24 47e2
VS38 8 s38 0
V38 e38 s38 DC 0 AC 10e1 120
RI38 e38 11 56e-3
VS39 25 s39 0
L39 s39 6 47e-2
VS40 25 s40 0
C40 s40 19 56e-6
VS41 11 s41 0
V41 e41 s41 DC 0 AC 15e1 0
RI41 e41 0 15e-2
VS42 1 s42 0
L42 s42 20 56e-5
VS43 28 s43 0
C43 s43 16 22e-4
VS44 17 s44 0
L44 s44 27 47e-3
VS45 27 s45 0
R45 s45 11 56e-2
.control
set numdgt=17
ac lin 1 60 60
print v(1) v(2) v(3) v(4) v(5) v(6) v(7) v(8) v(9) v(10)
print v(11) v(12) v(13) v(14) v(15) v(16) v(17) v(18) v(19) v(20)
print v(21) v(22) v(23) v(24) v(25) v(26) v(27) v(28)
print i(vs0) i(vs1) i(vs2) i(vs3) i(vs4) i(vs5) i(vs6) i(vs7) i(vs8) i(vs9)
print i(vs10) i(vs11) i(vs12) i(vs13) i(vs14) i(vs15) i(vs16) i(vs17) i(vs18) i(vs19)
print i(vs20) i(vs21) i(vs22) i(vs23) i(vs24) i(vs25) i(vs26) i(vs27) i(vs28) i(vs29)
print i(vs30) i(vs31) i(vs32) i(vs33) i(vs34) i(vs35) i(vs36) i(vs37) i(vs38) i(vs39)
print i(vs40) i(vs41) i(vs42) i(vs43) i(vs44) i(vs45)
.endc
.end
