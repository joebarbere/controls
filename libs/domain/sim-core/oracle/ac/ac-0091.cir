controls oracle ac-0091
* Generated (plan F2.7, ADR 0012): do not edit; regenerate with `pnpm sim oracle regen`. ac seed 20261031 index 91 nodes 29 elements 43
.options sparse gmin=1e-12 noopac
RG1 1 0 1000000000000
RG2 2 0 1000000000000
RG3 3 0 1000000000000
RG4 4 0 1000000000000
RG5 5 0 1000000000000
RG6 6 0 1000000000000
RG7 7 0 1000000000000
RG8 8 0 1000000000000
RG9 9 0 1000000000000
RG10 10 0 1000000000000
RG11 11 0 1000000000000
RG12 12 0 1000000000000
RG13 13 0 1000000000000
RG14 14 0 1000000000000
RG15 15 0 1000000000000
RG16 16 0 1000000000000
RG17 17 0 1000000000000
RG18 18 0 1000000000000
RG19 19 0 1000000000000
RG20 20 0 1000000000000
RG21 21 0 1000000000000
RG22 22 0 1000000000000
RG23 23 0 1000000000000
RG24 24 0 1000000000000
RG25 25 0 1000000000000
RG26 26 0 1000000000000
RG27 27 0 1000000000000
RG28 28 0 1000000000000
VS0 0 s0 0
V0 e0 s0 DC 0 AC 56e-1 -120
RI0 e0 2 18e-1
VS1 0 s1 0
C1 s1 23 12e-5
VS2 8 s2 0
V2 e2 s2 DC 0 AC 10e1 120
RI2 e2 11 56e-3
VS3 5 s3 0
R3 s3 3 22e-1
VS4 11 s4 0
V4 e4 s4 DC 0 AC 15e1 0
RI4 e4 6 15e-2
VS5 5 s5 0
R5 s5 0 68e-2
VS6 27 s6 0
R6 s6 11 56e-2
VS7 5 s7 0
C7 s7 26 39e-6
VS8 12 s8 0
C8 s8 17 18e-6
VS9 25 s9 0
C9 s9 22 12e-6
VS10 6 s10 0
V10 e10 s10 DC 0 AC 68e0 0
RI10 e10 7 47e-1
VS11 9 s11 0
V11 e11 s11 DC 0 AC 47e0 180
RI11 e11 20 27e-2
VS12 10 s12 0
C12 s12 4 15e-7
VS13 17 s13 0
L13 s13 27 47e-3
VS14 12 s14 0
L14 s14 21 82e-2
VS15 13 s15 0
L15 s15 0 47e-2
VS16 28 s16 0
L16 s16 13 39e-4
VS17 20 s17 0
L17 s17 0 56e-4
VS18 6 s18 0
R18 s18 15 47e-1
VS19 6 s19 0
L19 s19 7 33e-3
VS20 10 s20 0
R20 s20 14 39e3
VS21 0 s21 0
C21 s21 16 22e-4
VS22 25 s22 0
V22 e22 s22 DC 0 AC 10e0 120
RI22 e22 15 33e-3
VS23 4 s23 0
L23 s23 19 22e-5
VS24 9 s24 0
V24 e24 s24 DC 0 AC 47e-1 -120
RI24 e24 0 56e-3
VS25 25 s25 0
C25 s25 19 56e-6
VS26 8 s26 0
R26 s26 5 47e-2
VS27 28 s27 0
C27 s27 20 39e-4
VS28 11 s28 0
R28 s28 21 33e0
VS29 20 s29 0
L29 s29 18 15e-4
VS30 28 s30 0
V30 e30 s30 DC 0 AC 56e-1 -120
RI30 e30 15 10e-1
VS31 1 s31 0
L31 s31 20 56e-5
VS32 15 s32 0
R32 s32 17 15e3
VS33 4 s33 0
V33 e33 s33 DC 0 AC 82e-1 180
RI33 e33 5 33e-2
VS34 18 s34 0
L34 s34 7 47e-4
VS35 19 s35 0
R35 s35 13 33e2
VS36 0 s36 0
V36 e36 s36 DC 0 AC 47e-1 120
RI36 e36 26 18e-3
VS37 22 s37 0
C37 s37 1 27e-7
VS38 14 s38 0
R38 s38 27 27e-1
VS39 25 s39 0
L39 s39 28 47e-2
VS40 6 s40 0
L40 s40 16 56e-4
VS41 23 s41 0
R41 s41 24 47e2
VS42 16 s42 0
V42 e42 s42 DC 0 AC 27e-1 180
RI42 e42 9 27e-1
.control
set numdgt=17
ac lin 1 60 60
print v(1) v(2) v(3) v(4) v(5) v(6) v(7) v(8) v(9) v(10)
print v(11) v(12) v(13) v(14) v(15) v(16) v(17) v(18) v(19) v(20)
print v(21) v(22) v(23) v(24) v(25) v(26) v(27) v(28)
print i(vs0) i(vs1) i(vs2) i(vs3) i(vs4) i(vs5) i(vs6) i(vs7) i(vs8) i(vs9)
print i(vs10) i(vs11) i(vs12) i(vs13) i(vs14) i(vs15) i(vs16) i(vs17) i(vs18) i(vs19)
print i(vs20) i(vs21) i(vs22) i(vs23) i(vs24) i(vs25) i(vs26) i(vs27) i(vs28) i(vs29)
print i(vs30) i(vs31) i(vs32) i(vs33) i(vs34) i(vs35) i(vs36) i(vs37) i(vs38) i(vs39)
print i(vs40) i(vs41) i(vs42)
.endc
.end
