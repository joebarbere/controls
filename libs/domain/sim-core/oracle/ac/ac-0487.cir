controls oracle ac-0487
* Generated (plan F2.7, ADR 0012): do not edit; regenerate with `pnpm sim oracle regen`. ac seed 20261031 index 487 nodes 28 elements 53
.options sparse gmin=1e-12 noopac
RG1 1 0 1000000000000
RG2 2 0 1000000000000
RG3 3 0 1000000000000
RG4 4 0 1000000000000
RG5 5 0 1000000000000
RG6 6 0 1000000000000
RG7 7 0 1000000000000
RG8 8 0 1000000000000
RG9 9 0 1000000000000
RG10 10 0 1000000000000
RG11 11 0 1000000000000
RG12 12 0 1000000000000
RG13 13 0 1000000000000
RG14 14 0 1000000000000
RG15 15 0 1000000000000
RG16 16 0 1000000000000
RG17 17 0 1000000000000
RG18 18 0 1000000000000
RG19 19 0 1000000000000
RG20 20 0 1000000000000
RG21 21 0 1000000000000
RG22 22 0 1000000000000
RG23 23 0 1000000000000
RG24 24 0 1000000000000
RG25 25 0 1000000000000
RG26 26 0 1000000000000
RG27 27 0 1000000000000
VS0 20 s0 0
R0 s0 4 10e0
VS1 1 s1 0
R1 s1 19 82e1
VS2 1 s2 0
C2 s2 22 27e-7
VS3 6 s3 0
L3 s3 8 15e-3
VS4 0 s4 0
V4 e4 s4 DC 0 AC 39e-1 180
RI4 e4 m4 27e-1
LI4 m4 21 15e-5
VS5 22 s5 0
R5 s5 14 10e0
VS6 15 s6 0
R6 s6 19 22e0
VS7 7 s7 0
L7 s7 22 39e-3
VS8 11 s8 0
L8 s8 26 56e-5
VS9 2 s9 0
V9 e9 s9 DC 0 AC 82e1 -120
RI9 e9 23 18e-1
VS10 25 s10 0
V10 e10 s10 DC 0 AC 15e1 120
RI10 e10 2 47e-3
VS11 24 s11 0
V11 e11 s11 DC 0 AC 27e0 180
RI11 e11 25 56e-2
VS12 3 s12 0
L12 s12 12 18e-5
VS13 9 s13 0
L13 s13 15 47e-4
VS14 16 s14 0
R14 s14 21 39e3
VS15 24 s15 0
R15 s15 5 18e2
VS16 14 s16 0
R16 s16 27 22e0
VS17 11 s17 0
R17 s17 8 39e2
VS18 5 s18 0
L18 s18 10 68e-5
VS19 10 s19 0
V19 e19 s19 DC 0 AC 33e-1 0
RI19 e19 m19 10e-1
LI19 m19 26 27e-6
VS20 0 s20 0
C20 s20 12 47e-4
VS21 5 s21 0
R21 s21 2 18e2
VS22 26 s22 0
R22 s22 10 47e1
VS23 8 s23 0
R23 s23 4 39e2
VS24 17 s24 0
R24 s24 2 10e1
VS25 19 s25 0
C25 s25 5 27e-4
VS26 5 s26 0
R26 s26 1 56e-2
VS27 12 s27 0
R27 s27 6 27e2
VS28 21 s28 0
V28 e28 s28 DC 0 AC 22e-1 0
RI28 e28 5 15e-1
VS29 21 s29 0
R29 s29 11 22e0
VS30 18 s30 0
V30 e30 s30 DC 0 AC 56e-1 0
RI30 e30 13 68e-3
VS31 24 s31 0
L31 s31 8 27e-4
VS32 26 s32 0
R32 s32 2 33e-1
VS33 6 s33 0
L33 s33 4 33e-5
VS34 27 s34 0
V34 e34 s34 DC 0 AC 68e-1 0
RI34 e34 m34 68e-3
LI34 m34 1 12e-5
VS35 4 s35 0
R35 s35 3 82e-1
VS36 21 s36 0
R36 s36 23 47e1
VS37 9 s37 0
V37 e37 s37 DC 0 AC 33e-1 180
RI37 e37 22 68e-2
VS38 14 s38 0
V38 e38 s38 DC 0 AC 68e0 120
RI38 e38 2 15e-3
VS39 27 s39 0
L39 s39 7 22e-5
VS40 14 s40 0
R40 s40 15 82e0
VS41 2 s41 0
C41 s41 6 22e-5
VS42 20 s42 0
R42 s42 5 82e-1
VS43 1 s43 0
V43 e43 s43 DC 0 AC 15e1 120
RI43 e43 m43 12e-2
LI43 m43 0 27e-7
VS44 17 s44 0
C44 s44 8 33e-7
VS45 9 s45 0
R45 s45 13 10e3
VS46 25 s46 0
R46 s46 2 56e1
VS47 16 s47 0
V47 e47 s47 DC 0 AC 68e-1 -120
RI47 e47 23 12e-1
VS48 9 s48 0
R48 s48 20 56e-1
VS49 18 s49 0
C49 s49 0 18e-7
VS50 13 s50 0
V50 e50 s50 DC 0 AC 47e0 180
RI50 e50 m50 15e-2
LI50 m50 15 12e-7
VS51 15 s51 0
C51 s51 16 18e-4
VS52 0 s52 0
C52 s52 8 12e-5
.control
set numdgt=17
ac lin 1 60 60
print v(1) v(2) v(3) v(4) v(5) v(6) v(7) v(8) v(9) v(10)
print v(11) v(12) v(13) v(14) v(15) v(16) v(17) v(18) v(19) v(20)
print v(21) v(22) v(23) v(24) v(25) v(26) v(27)
print i(vs0) i(vs1) i(vs2) i(vs3) i(vs4) i(vs5) i(vs6) i(vs7) i(vs8) i(vs9)
print i(vs10) i(vs11) i(vs12) i(vs13) i(vs14) i(vs15) i(vs16) i(vs17) i(vs18) i(vs19)
print i(vs20) i(vs21) i(vs22) i(vs23) i(vs24) i(vs25) i(vs26) i(vs27) i(vs28) i(vs29)
print i(vs30) i(vs31) i(vs32) i(vs33) i(vs34) i(vs35) i(vs36) i(vs37) i(vs38) i(vs39)
print i(vs40) i(vs41) i(vs42) i(vs43) i(vs44) i(vs45) i(vs46) i(vs47) i(vs48) i(vs49)
print i(vs50) i(vs51) i(vs52)
.endc
.end
