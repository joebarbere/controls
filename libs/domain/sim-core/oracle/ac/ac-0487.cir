controls oracle ac-0487
* Generated (plan F2.7, ADR 0012): do not edit; regenerate with `pnpm sim oracle regen`. ac seed 20261031 index 487 nodes 28 elements 52
.options sparse gmin=1e-12 noopac
RG1 1 0 1000000000000
RG2 2 0 1000000000000
RG3 3 0 1000000000000
RG4 4 0 1000000000000
RG5 5 0 1000000000000
RG6 6 0 1000000000000
RG7 7 0 1000000000000
RG8 8 0 1000000000000
RG9 9 0 1000000000000
RG10 10 0 1000000000000
RG11 11 0 1000000000000
RG12 12 0 1000000000000
RG13 13 0 1000000000000
RG14 14 0 1000000000000
RG15 15 0 1000000000000
RG16 16 0 1000000000000
RG17 17 0 1000000000000
RG18 18 0 1000000000000
RG19 19 0 1000000000000
RG20 20 0 1000000000000
RG21 21 0 1000000000000
RG22 22 0 1000000000000
RG23 23 0 1000000000000
RG24 24 0 1000000000000
RG25 25 0 1000000000000
RG26 26 0 1000000000000
RG27 27 0 1000000000000
VS0 0 s0 0
V0 e0 s0 DC 0 AC 22e-1 0
RI0 e0 5 15e-1
VS1 15 s1 0
R1 s1 19 22e0
VS2 8 s2 0
R2 s2 4 39e2
VS3 1 s3 0
C3 s3 22 27e-7
VS4 9 s4 0
L4 s4 15 47e-4
VS5 13 s5 0
V5 e5 s5 DC 0 AC 47e0 180
RI5 e5 15 15e-2
VS6 9 s6 0
R6 s6 13 10e3
VS7 27 s7 0
L7 s7 7 22e-5
VS8 21 s8 0
R8 s8 2 10e1
VS9 16 s9 0
R9 s9 0 39e3
VS10 4 s10 0
R10 s10 3 82e-1
VS11 17 s11 0
V11 e11 s11 DC 0 AC 39e-1 180
RI11 e11 0 27e-1
VS12 17 s12 0
C12 s12 8 12e-5
VS13 14 s13 0
V13 e13 s13 DC 0 AC 68e0 120
RI13 e13 2 15e-3
VS14 15 s14 0
C14 s14 16 18e-4
VS15 0 s15 0
R15 s15 11 22e0
VS16 6 s16 0
L16 s16 8 15e-3
VS17 19 s17 0
C17 s17 5 27e-4
VS18 3 s18 0
L18 s18 12 18e-5
VS19 18 s19 0
C19 s19 17 18e-7
VS20 26 s20 0
R20 s20 2 33e-1
VS21 21 s21 0
C21 s21 8 33e-7
VS22 7 s22 0
L22 s22 22 39e-3
VS23 25 s23 0
V23 e23 s23 DC 0 AC 15e1 120
RI23 e23 2 47e-3
VS24 17 s24 0
C24 s24 12 47e-4
VS25 11 s25 0
L25 s25 26 56e-5
VS26 16 s26 0
V26 e26 s26 DC 0 AC 68e-1 -120
RI26 e26 23 12e-1
VS27 6 s27 0
L27 s27 4 33e-5
VS28 2 s28 0
C28 s28 6 22e-5
VS29 5 s29 0
L29 s29 10 68e-5
VS30 9 s30 0
V30 e30 s30 DC 0 AC 33e-1 180
RI30 e30 22 68e-2
VS31 25 s31 0
R31 s31 2 56e1
VS32 22 s32 0
R32 s32 14 10e0
VS33 12 s33 0
R33 s33 6 27e2
VS34 27 s34 0
V34 e34 s34 DC 0 AC 68e-1 0
RI34 e34 1 68e-3
VS35 20 s35 0
R35 s35 5 82e-1
VS36 20 s36 0
R36 s36 4 10e0
VS37 14 s37 0
R37 s37 15 82e0
VS38 11 s38 0
R38 s38 8 39e2
VS39 10 s39 0
V39 e39 s39 DC 0 AC 33e-1 0
RI39 e39 26 10e-1
VS40 24 s40 0
L40 s40 8 27e-4
VS41 24 s41 0
R41 s41 5 18e2
VS42 14 s42 0
R42 s42 27 22e0
VS43 1 s43 0
V43 e43 s43 DC 0 AC 15e1 120
RI43 e43 17 12e-2
VS44 5 s44 0
R44 s44 1 56e-2
VS45 2 s45 0
V45 e45 s45 DC 0 AC 82e1 -120
RI45 e45 23 18e-1
VS46 9 s46 0
R46 s46 20 56e-1
VS47 0 s47 0
R47 s47 23 47e1
VS48 1 s48 0
R48 s48 19 82e1
VS49 5 s49 0
R49 s49 2 18e2
VS50 18 s50 0
V50 e50 s50 DC 0 AC 56e-1 0
RI50 e50 13 68e-3
VS51 26 s51 0
R51 s51 10 47e1
.control
set numdgt=17
ac lin 1 60 60
print v(1) v(2) v(3) v(4) v(5) v(6) v(7) v(8) v(9) v(10)
print v(11) v(12) v(13) v(14) v(15) v(16) v(17) v(18) v(19) v(20)
print v(21) v(22) v(23) v(24) v(25) v(26) v(27)
print i(vs0) i(vs1) i(vs2) i(vs3) i(vs4) i(vs5) i(vs6) i(vs7) i(vs8) i(vs9)
print i(vs10) i(vs11) i(vs12) i(vs13) i(vs14) i(vs15) i(vs16) i(vs17) i(vs18) i(vs19)
print i(vs20) i(vs21) i(vs22) i(vs23) i(vs24) i(vs25) i(vs26) i(vs27) i(vs28) i(vs29)
print i(vs30) i(vs31) i(vs32) i(vs33) i(vs34) i(vs35) i(vs36) i(vs37) i(vs38) i(vs39)
print i(vs40) i(vs41) i(vs42) i(vs43) i(vs44) i(vs45) i(vs46) i(vs47) i(vs48) i(vs49)
print i(vs50) i(vs51)
.endc
.end
