controls oracle ac-0487
* Generated (plan F2.7, ADR 0012): do not edit; regenerate with `pnpm sim oracle regen`. ac seed 20261031 index 487 nodes 28 elements 44
.options sparse gmin=1e-12 noopac
RG1 1 0 1000000000000
RG2 2 0 1000000000000
RG3 3 0 1000000000000
RG4 4 0 1000000000000
RG5 5 0 1000000000000
RG6 6 0 1000000000000
RG7 7 0 1000000000000
RG8 8 0 1000000000000
RG9 9 0 1000000000000
RG10 10 0 1000000000000
RG11 11 0 1000000000000
RG12 12 0 1000000000000
RG13 13 0 1000000000000
RG14 14 0 1000000000000
RG15 15 0 1000000000000
RG16 16 0 1000000000000
RG17 17 0 1000000000000
RG18 18 0 1000000000000
RG19 19 0 1000000000000
RG20 20 0 1000000000000
RG21 21 0 1000000000000
RG22 22 0 1000000000000
RG23 23 0 1000000000000
RG24 24 0 1000000000000
RG25 25 0 1000000000000
RG26 26 0 1000000000000
RG27 27 0 1000000000000
VS0 8 s0 0
C0 s0 13 47e-7
VS1 0 s1 0
V1 e1 s1 DC 0 AC 39e-1 180
RI1 e1 m1 27e-1
LI1 m1 8 12e-5
VS2 5 s2 0
R2 s2 4 27e2
VS3 18 s3 0
R3 s3 7 12e3
VS4 3 s4 0
L4 s4 1 12e-5
VS5 24 s5 0
R5 s5 5 68e-2
VS6 6 s6 0
L6 s6 4 15e-4
VS7 22 s7 0
C7 s7 19 12e-5
VS8 26 s8 0
C8 s8 21 82e-4
VS9 26 s9 0
C9 s9 9 10e-6
VS10 14 s10 0
V10 e10 s10 DC 0 AC 10e0 0
RI10 e10 m10 33e-3
LI10 m10 24 10e-5
VS11 26 s11 0
V11 e11 s11 DC 0 AC 27e1 -120
RI11 e11 2 22e-1
VS12 15 s12 0
L12 s12 18 27e-4
VS13 16 s13 0
C13 s13 17 10e-6
VS14 6 s14 0
R14 s14 19 47e1
VS15 10 s15 0
C15 s15 2 56e-5
VS16 21 s16 0
L16 s16 11 56e-3
VS17 6 s17 0
R17 s17 5 56e3
VS18 27 s18 0
C18 s18 3 15e-4
VS19 12 s19 0
L19 s19 10 39e-5
VS20 7 s20 0
V20 e20 s20 DC 0 AC 15e1 120
RI20 e20 5 47e-3
VS21 4 s21 0
L21 s21 2 22e-5
VS22 17 s22 0
C22 s22 0 22e-5
VS23 26 s23 0
R23 s23 21 56e1
VS24 18 s24 0
R24 s24 24 18e3
VS25 21 s25 0
L25 s25 0 47e-5
VS26 26 s26 0
V26 e26 s26 DC 0 AC 56e1 120
RI26 e26 m26 39e-1
LI26 m26 1 82e-7
VS27 20 s27 0
R27 s27 23 22e0
VS28 16 s28 0
L28 s28 21 39e-5
VS29 6 s29 0
C29 s29 9 82e-6
VS30 17 s30 0
C30 s30 23 15e-6
VS31 1 s31 0
R31 s31 2 10e1
VS32 26 s32 0
R32 s32 5 15e-1
VS33 2 s33 0
C33 s33 6 22e-5
VS34 8 s34 0
L34 s34 6 33e-5
VS35 14 s35 0
V35 e35 s35 DC 0 AC 68e0 120
RI35 e35 m35 15e-3
LI35 m35 2 15e-7
VS36 25 s36 0
R36 s36 22 33e-2
VS37 2 s37 0
V37 e37 s37 DC 0 AC 15e0 -120
RI37 e37 m37 18e-1
LI37 m37 20 27e-5
VS38 12 s38 0
R38 s38 10 68e0
VS39 4 s39 0
R39 s39 15 39e2
VS40 13 s40 0
C40 s40 27 82e-4
VS41 15 s41 0
C41 s41 6 39e-4
VS42 11 s42 0
R42 s42 25 82e1
VS43 12 s43 0
L43 s43 17 68e-4
.control
set numdgt=17
ac lin 1 60 60
print v(1) v(2) v(3) v(4) v(5) v(6) v(7) v(8) v(9) v(10)
print v(11) v(12) v(13) v(14) v(15) v(16) v(17) v(18) v(19) v(20)
print v(21) v(22) v(23) v(24) v(25) v(26) v(27)
print i(vs0) i(vs1) i(vs2) i(vs3) i(vs4) i(vs5) i(vs6) i(vs7) i(vs8) i(vs9)
print i(vs10) i(vs11) i(vs12) i(vs13) i(vs14) i(vs15) i(vs16) i(vs17) i(vs18) i(vs19)
print i(vs20) i(vs21) i(vs22) i(vs23) i(vs24) i(vs25) i(vs26) i(vs27) i(vs28) i(vs29)
print i(vs30) i(vs31) i(vs32) i(vs33) i(vs34) i(vs35) i(vs36) i(vs37) i(vs38) i(vs39)
print i(vs40) i(vs41) i(vs42) i(vs43)
.endc
.end
