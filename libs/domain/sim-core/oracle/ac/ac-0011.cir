controls oracle ac-0011
* Generated (plan F2.7, ADR 0012): do not edit; regenerate with `pnpm sim oracle regen`. ac seed 20261031 index 11 nodes 14 elements 21
.options sparse gmin=1e-12 noopac
RG1 1 0 1000000000000
RG2 2 0 1000000000000
RG3 3 0 1000000000000
RG4 4 0 1000000000000
RG5 5 0 1000000000000
RG6 6 0 1000000000000
RG7 7 0 1000000000000
RG8 8 0 1000000000000
RG9 9 0 1000000000000
RG10 10 0 1000000000000
RG11 11 0 1000000000000
RG12 12 0 1000000000000
RG13 13 0 1000000000000
VS0 9 s0 0
L0 s0 2 47e-2
VS1 11 s1 0
R1 s1 10 12e1
VS2 0 s2 0
V2 e2 s2 DC 0 AC 12e1 -120
RI2 e2 m2 47e-1
LI2 m2 n2 15e-7
H2 n2 h2 VS3 -22e-3
ED2 h2 12 d2 0 18e-6
F2 0 d2 VS3 1
LD2 d2 0 1
VS3 1 s3 0
V3 e3 s3 DC 0 AC 39e0 180
RI3 e3 m3 27e-2
LI3 m3 n3 27e-6
H3 n3 h3 VS2 -22e-3
ED3 h3 7 d3 0 18e-6
F3 0 d3 VS2 1
LD3 d3 0 1
VS4 3 s4 0
L4 s4 4 56e-2
VS5 3 s5 0
R5 s5 7 56e3
VS6 10 s6 0
C6 s6 6 39e-6
VS7 7 s7 0
R7 s7 11 18e3
VS8 12 s8 0
C8 s8 9 27e-5
VS9 13 s9 0
C9 s9 0 18e-4
VS10 5 s10 0
R10 s10 12 47e3
VS11 4 s11 0
R11 s11 10 15e-2
VS12 8 s12 0
L12 s12 4 27e-3
VS13 9 s13 0
C13 s13 8 39e-7
VS14 10 s14 0
R14 s14 2 82e2
VS15 1 s15 0
R15 s15 4 27e0
VS16 6 s16 0
C16 s16 12 39e-5
VS17 4 s17 0
V17 e17 s17 DC 0 AC 15e1 -120
RI17 e17 m17 47e-2
LI17 m17 0 10e-6
VS18 7 s18 0
R18 s18 5 82e-2
VS19 4 s19 0
R19 s19 13 68e-2
VS20 4 s20 0
R20 s20 8 18e-1
.control
set numdgt=17
ac lin 1 60 60
print v(1) v(2) v(3) v(4) v(5) v(6) v(7) v(8) v(9) v(10)
print v(11) v(12) v(13)
print i(vs0) i(vs1) i(vs2) i(vs3) i(vs4) i(vs5) i(vs6) i(vs7) i(vs8) i(vs9)
print i(vs10) i(vs11) i(vs12) i(vs13) i(vs14) i(vs15) i(vs16) i(vs17) i(vs18) i(vs19)
print i(vs20)
.endc
.end
