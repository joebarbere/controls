controls oracle ac-0011
* Generated (plan F2.7, ADR 0012): do not edit; regenerate with `pnpm sim oracle regen`. ac seed 20261031 index 11 nodes 14 elements 16
.options sparse gmin=1e-12 noopac
RG1 1 0 1000000000000
RG2 2 0 1000000000000
RG3 3 0 1000000000000
RG4 4 0 1000000000000
RG5 5 0 1000000000000
RG6 6 0 1000000000000
RG7 7 0 1000000000000
RG8 8 0 1000000000000
RG9 9 0 1000000000000
RG10 10 0 1000000000000
RG11 11 0 1000000000000
RG12 12 0 1000000000000
RG13 13 0 1000000000000
VS0 1 s0 0
R0 s0 13 68e-2
VS1 7 s1 0
R1 s1 11 18e3
VS2 3 s2 0
R2 s2 7 56e3
VS3 0 s3 0
V3 e3 s3 DC 0 AC 39e0 180
RI3 e3 7 27e-2
VS4 9 s4 0
L4 s4 2 47e-2
VS5 7 s5 0
R5 s5 5 82e-2
VS6 6 s6 0
C6 s6 12 39e-5
VS7 3 s7 0
L7 s7 1 56e-2
VS8 13 s8 0
C8 s8 4 18e-4
VS9 10 s9 0
R9 s9 2 82e2
VS10 1 s10 0
R10 s10 10 15e-2
VS11 8 s11 0
L11 s11 1 27e-3
VS12 4 s12 0
V12 e12 s12 DC 0 AC 12e1 -120
RI12 e12 12 47e-1
VS13 12 s13 0
C13 s13 9 27e-5
VS14 1 s14 0
R14 s14 8 18e-1
VS15 1 s15 0
V15 e15 s15 DC 0 AC 15e1 -120
RI15 e15 4 47e-2
.control
set numdgt=17
ac lin 1 60 60
print v(1) v(2) v(3) v(4) v(5) v(6) v(7) v(8) v(9) v(10)
print v(11) v(12) v(13)
print i(vs0) i(vs1) i(vs2) i(vs3) i(vs4) i(vs5) i(vs6) i(vs7) i(vs8) i(vs9)
print i(vs10) i(vs11) i(vs12) i(vs13) i(vs14) i(vs15)
.endc
.end
