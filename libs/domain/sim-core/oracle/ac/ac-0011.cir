controls oracle ac-0011
* Generated (plan F2.7, ADR 0012): do not edit; regenerate with `pnpm sim oracle regen`. ac seed 20261031 index 11 nodes 14 elements 25
.options sparse gmin=1e-12 noopac
RG1 1 0 1000000000000
RG2 2 0 1000000000000
RG3 3 0 1000000000000
RG4 4 0 1000000000000
RG5 5 0 1000000000000
RG6 6 0 1000000000000
RG7 7 0 1000000000000
RG8 8 0 1000000000000
RG9 9 0 1000000000000
RG10 10 0 1000000000000
RG11 11 0 1000000000000
RG12 12 0 1000000000000
RG13 13 0 1000000000000
VS0 0 s0 0
V0 e0 s0 DC 0 AC 56e1 -120
RI0 e0 m0 15e-3
LI0 m0 3 15e-5
VS1 11 s1 0
V1 e1 s1 DC 0 AC 10e1 0
RI1 e1 m1 15e-3
LI1 m1 9 56e-6
VS2 12 s2 0
V2 e2 s2 DC 0 AC 12e1 0
RI2 e2 m2 56e-2
LI2 m2 10 15e-5
VS3 2 s3 0
L3 s3 10 33e-5
VS4 5 s4 0
V4 e4 s4 DC 0 AC 27e0 -120
RI4 e4 m4 68e-3
LI4 m4 11 33e-5
VS5 7 s5 0
L5 s5 8 68e-5
VS6 3 s6 0
V6 e6 s6 DC 0 AC 39e1 120
RI6 e6 12 39e-2
VS7 0 s7 0
C7 s7 12 47e-4
VS8 11 s8 0
L8 s8 2 47e-2
VS9 1 s9 0
R9 s9 4 56e1
VS10 9 s10 0
R10 s10 0 22e-2
VS11 2 s11 0
R11 s11 12 82e0
VS12 3 s12 0
R12 s12 13 27e1
VS13 12 s13 0
V13 e13 s13 DC 0 AC 15e1 -120
RI13 e13 4 47e-2
VS14 8 s14 0
L14 s14 12 27e-3
VS15 9 s15 0
R15 s15 1 18e0
VS16 7 s16 0
L16 s16 4 27e-4
VS17 5 s17 0
L17 s17 2 15e-2
VS18 8 s18 0
L18 s18 9 18e-4
VS19 3 s19 0
L19 s19 12 56e-2
VS20 13 s20 0
L20 s20 6 39e-2
VS21 12 s21 0
V21 e21 s21 DC 0 AC 10e0 -120
RI21 e21 13 82e-2
VS22 13 s22 0
R22 s22 1 82e-2
VS23 6 s23 0
R23 s23 1 56e0
VS24 2 s24 0
L24 s24 10 82e-2
.control
set numdgt=17
ac lin 1 60 60
print v(1) v(2) v(3) v(4) v(5) v(6) v(7) v(8) v(9) v(10)
print v(11) v(12) v(13)
print i(vs0) i(vs1) i(vs2) i(vs3) i(vs4) i(vs5) i(vs6) i(vs7) i(vs8) i(vs9)
print i(vs10) i(vs11) i(vs12) i(vs13) i(vs14) i(vs15) i(vs16) i(vs17) i(vs18) i(vs19)
print i(vs20) i(vs21) i(vs22) i(vs23) i(vs24)
.endc
.end
