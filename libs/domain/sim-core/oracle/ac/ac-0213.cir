controls oracle ac-0213
* Generated (plan F2.7, ADR 0012): do not edit; regenerate with `pnpm sim oracle regen`. ac seed 20261031 index 213 nodes 28 elements 39
.options sparse gmin=1e-12 noopac
RG1 1 0 1000000000000
RG2 2 0 1000000000000
RG3 3 0 1000000000000
RG4 4 0 1000000000000
RG5 5 0 1000000000000
RG6 6 0 1000000000000
RG7 7 0 1000000000000
RG8 8 0 1000000000000
RG9 9 0 1000000000000
RG10 10 0 1000000000000
RG11 11 0 1000000000000
RG12 12 0 1000000000000
RG13 13 0 1000000000000
RG14 14 0 1000000000000
RG15 15 0 1000000000000
RG16 16 0 1000000000000
RG17 17 0 1000000000000
RG18 18 0 1000000000000
RG19 19 0 1000000000000
RG20 20 0 1000000000000
RG21 21 0 1000000000000
RG22 22 0 1000000000000
RG23 23 0 1000000000000
RG24 24 0 1000000000000
RG25 25 0 1000000000000
RG26 26 0 1000000000000
RG27 27 0 1000000000000
VS0 5 s0 0
C0 s0 16 82e-4
VS1 26 s1 0
R1 s1 20 27e0
VS2 3 s2 0
L2 s2 24 15e-2
VS3 25 s3 0
R3 s3 11 18e2
VS4 7 s4 0
C4 s4 25 15e-6
VS5 14 s5 0
R5 s5 12 27e2
VS6 25 s6 0
C6 s6 17 15e-4
VS7 0 s7 0
V7 e7 s7 DC 0 AC 56e1 0
RI7 e7 26 68e-2
VS8 22 s8 0
L8 s8 19 68e-4
VS9 14 s9 0
C9 s9 3 82e-4
VS10 22 s10 0
V10 e10 s10 DC 0 AC 47e-1 -120
RI10 e10 13 18e-1
VS11 0 s11 0
L11 s11 21 33e-2
VS12 5 s12 0
R12 s12 11 68e2
VS13 27 s13 0
R13 s13 19 10e2
VS14 23 s14 0
L14 s14 3 10e-3
VS15 11 s15 0
V15 e15 s15 DC 0 AC 33e0 180
RI15 e15 26 68e-1
VS16 1 s16 0
R16 s16 21 82e2
VS17 14 s17 0
V17 e17 s17 DC 0 AC 68e1 180
RI17 e17 5 82e-3
VS18 4 s18 0
R18 s18 20 56e-1
VS19 4 s19 0
R19 s19 9 27e2
VS20 11 s20 0
R20 s20 8 15e-2
VS21 2 s21 0
C21 s21 12 15e-4
VS22 9 s22 0
R22 s22 12 12e3
VS23 1 s23 0
R23 s23 14 33e-2
VS24 22 s24 0
V24 e24 s24 DC 0 AC 82e1 120
RI24 e24 2 39e-2
VS25 25 s25 0
R25 s25 9 56e0
VS26 2 s26 0
R26 s26 6 56e-2
VS27 22 s27 0
L27 s27 7 56e-4
VS28 14 s28 0
R28 s28 19 15e1
VS29 16 s29 0
R29 s29 15 10e1
VS30 9 s30 0
R30 s30 15 22e2
VS31 22 s31 0
R31 s31 25 27e-2
VS32 4 s32 0
R32 s32 18 10e-2
VS33 23 s33 0
L33 s33 4 12e-3
VS34 7 s34 0
C34 s34 14 82e-6
VS35 12 s35 0
V35 e35 s35 DC 0 AC 22e1 120
RI35 e35 17 10e-3
VS36 16 s36 0
C36 s36 10 56e-6
VS37 27 s37 0
V37 e37 s37 DC 0 AC 12e-1 180
RI37 e37 23 18e-2
VS38 0 s38 0
L38 s38 2 82e-2
.control
set numdgt=17
ac lin 1 60 60
print v(1) v(2) v(3) v(4) v(5) v(6) v(7) v(8) v(9) v(10)
print v(11) v(12) v(13) v(14) v(15) v(16) v(17) v(18) v(19) v(20)
print v(21) v(22) v(23) v(24) v(25) v(26) v(27)
print i(vs0) i(vs1) i(vs2) i(vs3) i(vs4) i(vs5) i(vs6) i(vs7) i(vs8) i(vs9)
print i(vs10) i(vs11) i(vs12) i(vs13) i(vs14) i(vs15) i(vs16) i(vs17) i(vs18) i(vs19)
print i(vs20) i(vs21) i(vs22) i(vs23) i(vs24) i(vs25) i(vs26) i(vs27) i(vs28) i(vs29)
print i(vs30) i(vs31) i(vs32) i(vs33) i(vs34) i(vs35) i(vs36) i(vs37) i(vs38)
.endc
.end
