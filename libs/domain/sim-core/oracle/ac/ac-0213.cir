controls oracle ac-0213
* Generated (plan F2.7, ADR 0012): do not edit; regenerate with `pnpm sim oracle regen`. ac seed 20261031 index 213 nodes 28 elements 51
.options sparse gmin=1e-12 noopac
RG1 1 0 1000000000000
RG2 2 0 1000000000000
RG3 3 0 1000000000000
RG4 4 0 1000000000000
RG5 5 0 1000000000000
RG6 6 0 1000000000000
RG7 7 0 1000000000000
RG8 8 0 1000000000000
RG9 9 0 1000000000000
RG10 10 0 1000000000000
RG11 11 0 1000000000000
RG12 12 0 1000000000000
RG13 13 0 1000000000000
RG14 14 0 1000000000000
RG15 15 0 1000000000000
RG16 16 0 1000000000000
RG17 17 0 1000000000000
RG18 18 0 1000000000000
RG19 19 0 1000000000000
RG20 20 0 1000000000000
RG21 21 0 1000000000000
RG22 22 0 1000000000000
RG23 23 0 1000000000000
RG24 24 0 1000000000000
RG25 25 0 1000000000000
RG26 26 0 1000000000000
RG27 27 0 1000000000000
VS0 0 s0 0
V0 e0 s0 DC 0 AC 27e1 120
RI0 e0 11 12e-2
VS1 15 s1 0
L1 s1 4 27e-2
VS2 8 s2 0
V2 e2 s2 DC 0 AC 22e0 0
RI2 e2 m2 82e-3
LI2 m2 1 47e-7
VS3 8 s3 0
C3 s3 13 22e-6
VS4 0 s4 0
L4 s4 17 10e-2
VS5 4 s5 0
L5 s5 27 39e-5
VS6 8 s6 0
R6 s6 11 47e2
VS7 11 s7 0
V7 e7 s7 DC 0 AC 15e-1 -120
RI7 e7 22 10e-2
VS8 8 s8 0
L8 s8 13 22e-4
VS9 20 s9 0
L9 s9 27 56e-4
VS10 4 s10 0
L10 s10 9 22e-5
VS11 26 s11 0
L11 s11 16 10e-5
VS12 16 s12 0
C12 s12 18 33e-6
VS13 11 s13 0
V13 e13 s13 DC 0 AC 33e0 180
RI13 e13 26 68e-1
VS14 5 s14 0
V14 e14 s14 DC 0 AC 15e0 0
RI14 e14 25 15e-3
VS15 0 s15 0
C15 s15 23 10e-5
VS16 24 s16 0
L16 s16 16 82e-4
VS17 17 s17 0
R17 s17 6 68e0
VS18 9 s18 0
C18 s18 5 68e-6
VS19 10 s19 0
C19 s19 15 39e-7
VS20 15 s20 0
R20 s20 14 82e2
VS21 3 s21 0
V21 e21 s21 DC 0 AC 47e-1 120
RI21 e21 2 22e-2
VS22 14 s22 0
V22 e22 s22 DC 0 AC 22e1 180
RI22 e22 m22 22e-1
LI22 m22 5 15e-7
VS23 2 s23 0
C23 s23 23 27e-5
VS24 22 s24 0
C24 s24 0 47e-4
VS25 11 s25 0
C25 s25 14 18e-7
VS26 23 s26 0
C26 s26 14 22e-5
VS27 25 s27 0
L27 s27 7 68e-4
VS28 12 s28 0
V28 e28 s28 DC 0 AC 56e1 120
RI28 e28 14 47e-1
VS29 16 s29 0
C29 s29 0 10e-5
VS30 21 s30 0
R30 s30 8 18e-1
VS31 11 s31 0
C31 s31 5 56e-6
VS32 1 s32 0
V32 e32 s32 DC 0 AC 27e1 -120
RI32 e32 5 68e-2
VS33 13 s33 0
R33 s33 7 10e3
VS34 2 s34 0
C34 s34 12 27e-7
VS35 3 s35 0
V35 e35 s35 DC 0 AC 33e1 120
RI35 e35 m35 33e-2
LI35 m35 7 10e-7
VS36 4 s36 0
L36 s36 5 10e-5
VS37 5 s37 0
C37 s37 1 56e-6
VS38 7 s38 0
C38 s38 14 82e-6
VS39 20 s39 0
R39 s39 12 18e2
VS40 12 s40 0
L40 s40 19 18e-3
VS41 14 s41 0
L41 s41 20 56e-3
VS42 8 s42 0
C42 s42 14 27e-4
VS43 21 s43 0
L43 s43 12 27e-3
VS44 17 s44 0
R44 s44 25 47e0
VS45 10 s45 0
R45 s45 6 18e1
VS46 19 s46 0
R46 s46 15 33e-2
VS47 20 s47 0
C47 s47 24 39e-5
VS48 12 s48 0
V48 e48 s48 DC 0 AC 22e1 120
RI48 e48 17 10e-3
VS49 5 s49 0
C49 s49 18 39e-7
VS50 13 s50 0
C50 s50 26 10e-5
.control
set numdgt=17
ac lin 1 60 60
print v(1) v(2) v(3) v(4) v(5) v(6) v(7) v(8) v(9) v(10)
print v(11) v(12) v(13) v(14) v(15) v(16) v(17) v(18) v(19) v(20)
print v(21) v(22) v(23) v(24) v(25) v(26) v(27)
print i(vs0) i(vs1) i(vs2) i(vs3) i(vs4) i(vs5) i(vs6) i(vs7) i(vs8) i(vs9)
print i(vs10) i(vs11) i(vs12) i(vs13) i(vs14) i(vs15) i(vs16) i(vs17) i(vs18) i(vs19)
print i(vs20) i(vs21) i(vs22) i(vs23) i(vs24) i(vs25) i(vs26) i(vs27) i(vs28) i(vs29)
print i(vs30) i(vs31) i(vs32) i(vs33) i(vs34) i(vs35) i(vs36) i(vs37) i(vs38) i(vs39)
print i(vs40) i(vs41) i(vs42) i(vs43) i(vs44) i(vs45) i(vs46) i(vs47) i(vs48) i(vs49)
print i(vs50)
.endc
.end
