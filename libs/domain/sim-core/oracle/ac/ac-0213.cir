controls oracle ac-0213
* Generated (plan F2.7, ADR 0012): do not edit; regenerate with `pnpm sim oracle regen`. ac seed 20261031 index 213 nodes 28 elements 45
.options sparse gmin=1e-12 noopac
RG1 1 0 1000000000000
RG2 2 0 1000000000000
RG3 3 0 1000000000000
RG4 4 0 1000000000000
RG5 5 0 1000000000000
RG6 6 0 1000000000000
RG7 7 0 1000000000000
RG8 8 0 1000000000000
RG9 9 0 1000000000000
RG10 10 0 1000000000000
RG11 11 0 1000000000000
RG12 12 0 1000000000000
RG13 13 0 1000000000000
RG14 14 0 1000000000000
RG15 15 0 1000000000000
RG16 16 0 1000000000000
RG17 17 0 1000000000000
RG18 18 0 1000000000000
RG19 19 0 1000000000000
RG20 20 0 1000000000000
RG21 21 0 1000000000000
RG22 22 0 1000000000000
RG23 23 0 1000000000000
RG24 24 0 1000000000000
RG25 25 0 1000000000000
RG26 26 0 1000000000000
RG27 27 0 1000000000000
VS0 21 s0 0
R0 s0 24 22e-2
VS1 0 s1 0
V1 e1 s1 DC 0 AC 68e1 180
RI1 e1 5 82e-3
VS2 22 s2 0
V2 e2 s2 DC 0 AC 82e1 120
RI2 e2 2 39e-2
VS3 16 s3 0
R3 s3 15 10e1
VS4 11 s4 0
R4 s4 8 15e-2
VS5 22 s5 0
V5 e5 s5 DC 0 AC 47e-1 -120
RI5 e5 m5 18e-1
LI5 m5 13 12e-6
VS6 5 s6 0
R6 s6 11 68e2
VS7 7 s7 0
C7 s7 25 15e-6
VS8 26 s8 0
V8 e8 s8 DC 0 AC 56e1 0
RI8 e8 14 68e-2
VS9 18 s9 0
C9 s9 2 22e-7
VS10 1 s10 0
R10 s10 0 33e-2
VS11 10 s11 0
C11 s11 8 56e-4
VS12 1 s12 0
R12 s12 21 82e2
VS13 25 s13 0
C13 s13 17 15e-4
VS14 23 s14 0
L14 s14 3 10e-3
VS15 9 s15 0
R15 s15 15 22e2
VS16 4 s16 0
R16 s16 20 56e-1
VS17 2 s17 0
R17 s17 6 56e-2
VS18 0 s18 0
R18 s18 12 27e2
VS19 12 s19 0
V19 e19 s19 DC 0 AC 22e1 120
RI19 e19 m19 10e-3
LI19 m19 17 82e-5
VS20 22 s20 0
L20 s20 7 56e-4
VS21 6 s21 0
C21 s21 10 15e-7
VS22 3 s22 0
L22 s22 24 15e-2
VS23 25 s23 0
R23 s23 11 18e2
VS24 22 s24 0
R24 s24 25 27e-2
VS25 2 s25 0
C25 s25 12 15e-4
VS26 23 s26 0
L26 s26 4 12e-3
VS27 26 s27 0
L27 s27 21 33e-2
VS28 5 s28 0
C28 s28 16 82e-4
VS29 9 s29 0
R29 s29 12 12e3
VS30 27 s30 0
R30 s30 19 10e2
VS31 4 s31 0
R31 s31 18 10e-2
VS32 16 s32 0
C32 s32 10 56e-6
VS33 11 s33 0
V33 e33 s33 DC 0 AC 33e0 180
RI33 e33 14 68e-1
VS34 13 s34 0
R34 s34 5 47e1
VS35 22 s35 0
L35 s35 19 68e-4
VS36 25 s36 0
R36 s36 9 56e0
VS37 0 s37 0
C37 s37 3 82e-4
VS38 7 s38 0
C38 s38 0 82e-6
VS39 14 s39 0
R39 s39 20 27e0
VS40 26 s40 0
L40 s40 2 82e-2
VS41 4 s41 0
R41 s41 9 27e2
VS42 27 s42 0
V42 e42 s42 DC 0 AC 12e-1 180
RI42 e42 m42 18e-2
LI42 m42 23 56e-6
VS43 6 s43 0
R43 s43 23 39e-1
VS44 0 s44 0
R44 s44 19 15e1
.control
set numdgt=17
ac lin 1 60 60
print v(1) v(2) v(3) v(4) v(5) v(6) v(7) v(8) v(9) v(10)
print v(11) v(12) v(13) v(14) v(15) v(16) v(17) v(18) v(19) v(20)
print v(21) v(22) v(23) v(24) v(25) v(26) v(27)
print i(vs0) i(vs1) i(vs2) i(vs3) i(vs4) i(vs5) i(vs6) i(vs7) i(vs8) i(vs9)
print i(vs10) i(vs11) i(vs12) i(vs13) i(vs14) i(vs15) i(vs16) i(vs17) i(vs18) i(vs19)
print i(vs20) i(vs21) i(vs22) i(vs23) i(vs24) i(vs25) i(vs26) i(vs27) i(vs28) i(vs29)
print i(vs30) i(vs31) i(vs32) i(vs33) i(vs34) i(vs35) i(vs36) i(vs37) i(vs38) i(vs39)
print i(vs40) i(vs41) i(vs42) i(vs43) i(vs44)
.endc
.end
