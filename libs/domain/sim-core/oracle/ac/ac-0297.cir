controls oracle ac-0297
* Generated (plan F2.7, ADR 0012): do not edit; regenerate with `pnpm sim oracle regen`. ac seed 20261031 index 297 nodes 9 elements 13
.options sparse gmin=1e-12 noopac
RG1 1 0 1000000000000
RG2 2 0 1000000000000
RG3 3 0 1000000000000
RG4 4 0 1000000000000
RG5 5 0 1000000000000
RG6 6 0 1000000000000
RG7 7 0 1000000000000
RG8 8 0 1000000000000
VS0 3 s0 0
L0 s0 2 10e-3
VS1 7 s1 0
R1 s1 4 39e-2
VS2 2 s2 0
C2 s2 8 56e-5
VS3 0 s3 0
V3 e3 s3 DC 0 AC 15e-1 180
RI3 e3 4 27e-1
VS4 3 s4 0
C4 s4 7 56e-6
VS5 1 s5 0
V5 e5 s5 DC 0 AC 39e0 -120
RI5 e5 0 68e-3
VS6 2 s6 0
L6 s6 5 15e-2
VS7 5 s7 0
V7 e7 s7 DC 0 AC 56e0 120
RI7 e7 7 12e-1
VS8 6 s8 0
R8 s8 1 33e2
VS9 0 s9 0
R9 s9 2 22e1
VS10 6 s10 0
V10 e10 s10 DC 0 AC 56e0 -120
RI10 e10 1 68e-1
VS11 2 s11 0
C11 s11 7 10e-6
VS12 1 s12 0
L12 s12 8 39e-3
.control
set numdgt=17
ac lin 1 60 60
print v(1) v(2) v(3) v(4) v(5) v(6) v(7) v(8)
print i(vs0) i(vs1) i(vs2) i(vs3) i(vs4) i(vs5) i(vs6) i(vs7) i(vs8) i(vs9)
print i(vs10) i(vs11) i(vs12)
.endc
.end
