controls oracle ac-0297
* Generated (plan F2.7, ADR 0012): do not edit; regenerate with `pnpm sim oracle regen`. ac seed 20261031 index 297 nodes 9 elements 14
.options sparse gmin=1e-12 noopac
RG1 1 0 1000000000000
RG2 2 0 1000000000000
RG3 3 0 1000000000000
RG4 4 0 1000000000000
RG5 5 0 1000000000000
RG6 6 0 1000000000000
RG7 7 0 1000000000000
RG8 8 0 1000000000000
VS0 0 s0 0
R0 s0 2 22e1
VS1 3 s1 0
L1 s1 2 10e-3
VS2 0 s2 0
V2 e2 s2 DC 0 AC 15e-1 180
RI2 e2 n2 27e-1
H2 n2 h2 VS10 18e-4
ED2 h2 4 d2 0 22e-7
F2 0 d2 VS10 1
LD2 d2 0 1
VS3 2 s3 0
L3 s3 5 15e-2
VS4 6 s4 0
R4 s4 3 39e3
VS5 2 s5 0
C5 s5 7 10e-6
VS6 1 s6 0
L6 s6 8 39e-3
VS7 2 s7 0
C7 s7 8 56e-5
VS8 7 s8 0
R8 s8 4 39e-2
VS9 3 s9 0
C9 s9 7 56e-6
VS10 1 s10 0
V10 e10 s10 DC 0 AC 39e0 -120
RI10 e10 n10 68e-3
H10 n10 h10 VS2 18e-4
ED10 h10 0 d10 0 22e-7
F10 0 d10 VS2 1
LD10 d10 0 1
VS11 6 s11 0
R11 s11 1 33e2
VS12 6 s12 0
V12 e12 s12 DC 0 AC 56e0 -120
RI12 e12 1 68e-1
VS13 5 s13 0
V13 e13 s13 DC 0 AC 56e0 120
RI13 e13 7 12e-1
.control
set numdgt=17
ac lin 1 60 60
print v(1) v(2) v(3) v(4) v(5) v(6) v(7) v(8)
print i(vs0) i(vs1) i(vs2) i(vs3) i(vs4) i(vs5) i(vs6) i(vs7) i(vs8) i(vs9)
print i(vs10) i(vs11) i(vs12) i(vs13)
.endc
.end
