controls oracle ac-0297
* Generated (plan F2.7, ADR 0012): do not edit; regenerate with `pnpm sim oracle regen`. ac seed 20261031 index 297 nodes 9 elements 18
.options sparse gmin=1e-12 noopac
RG1 1 0 1000000000000
RG2 2 0 1000000000000
RG3 3 0 1000000000000
RG4 4 0 1000000000000
RG5 5 0 1000000000000
RG6 6 0 1000000000000
RG7 7 0 1000000000000
RG8 8 0 1000000000000
VS0 0 s0 0
V0 e0 s0 DC 0 AC 33e0 -120
RI0 e0 7 27e-1
VS1 2 s1 0
L1 s1 1 27e-5
VS2 4 s2 0
L2 s2 2 12e-4
VS3 1 s3 0
V3 e3 s3 DC 0 AC 39e0 -120
RI3 e3 m3 68e-3
LI3 m3 8 33e-6
VS4 1 s4 0
C4 s4 3 12e-6
VS5 4 s5 0
V5 e5 s5 DC 0 AC 18e1 120
RI5 e5 m5 18e-2
LI5 m5 6 22e-5
VS6 6 s6 0
R6 s6 2 68e3
VS7 4 s7 0
L7 s7 8 18e-2
VS8 5 s8 0
C8 s8 1 33e-5
VS9 5 s9 0
R9 s9 7 15e3
VS10 8 s10 0
L10 s10 0 68e-2
VS11 4 s11 0
C11 s11 3 10e-6
VS12 1 s12 0
R12 s12 7 12e2
VS13 6 s13 0
L13 s13 5 22e-4
VS14 2 s14 0
C14 s14 0 15e-6
VS15 5 s15 0
C15 s15 6 15e-5
VS16 7 s16 0
V16 e16 s16 DC 0 AC 33e0 -120
RI16 e16 m16 27e-3
LI16 m16 4 82e-6
VS17 8 s17 0
V17 e17 s17 DC 0 AC 15e-1 180
RI17 e17 4 27e-1
.control
set numdgt=17
ac lin 1 60 60
print v(1) v(2) v(3) v(4) v(5) v(6) v(7) v(8)
print i(vs0) i(vs1) i(vs2) i(vs3) i(vs4) i(vs5) i(vs6) i(vs7) i(vs8) i(vs9)
print i(vs10) i(vs11) i(vs12) i(vs13) i(vs14) i(vs15) i(vs16) i(vs17)
.endc
.end
