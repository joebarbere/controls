controls oracle ac-0027
* Generated (plan F2.7, ADR 0012): do not edit; regenerate with `pnpm sim oracle regen`. ac seed 20261031 index 27 nodes 9 elements 16
.options sparse gmin=1e-12 noopac
RG1 1 0 1000000000000
RG2 2 0 1000000000000
RG3 3 0 1000000000000
RG4 4 0 1000000000000
RG5 5 0 1000000000000
RG6 6 0 1000000000000
RG7 7 0 1000000000000
RG8 8 0 1000000000000
VS0 3 s0 0
L0 s0 1 15e-2
VS1 1 s1 0
L1 s1 4 10e-4
VS2 2 s2 0
C2 s2 5 82e-7
VS3 5 s3 0
R3 s3 2 39e1
VS4 7 s4 0
R4 s4 6 82e1
VS5 0 s5 0
V5 e5 s5 DC 0 AC 82e1 0
RI5 e5 8 39e-3
VS6 7 s6 0
R6 s6 1 22e-1
VS7 6 s7 0
L7 s7 1 33e-4
VS8 0 s8 0
R8 s8 1 56e2
VS9 5 s9 0
L9 s9 8 27e-5
VS10 7 s10 0
C10 s10 3 82e-6
VS11 6 s11 0
L11 s11 1 27e-5
VS12 1 s12 0
R12 s12 8 22e-1
VS13 1 s13 0
R13 s13 2 10e1
VS14 5 s14 0
R14 s14 4 18e1
VS15 3 s15 0
L15 s15 2 12e-2
.control
set numdgt=17
ac lin 1 60 60
print v(1) v(2) v(3) v(4) v(5) v(6) v(7) v(8)
print i(vs0) i(vs1) i(vs2) i(vs3) i(vs4) i(vs5) i(vs6) i(vs7) i(vs8) i(vs9)
print i(vs10) i(vs11) i(vs12) i(vs13) i(vs14) i(vs15)
.endc
.end
