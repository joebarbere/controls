controls oracle ac-0027
* Generated (plan F2.7, ADR 0012): do not edit; regenerate with `pnpm sim oracle regen`. ac seed 20261031 index 27 nodes 9 elements 16
.options sparse gmin=1e-12 noopac
RG1 1 0 1000000000000
RG2 2 0 1000000000000
RG3 3 0 1000000000000
RG4 4 0 1000000000000
RG5 5 0 1000000000000
RG6 6 0 1000000000000
RG7 7 0 1000000000000
RG8 8 0 1000000000000
VS0 0 s0 0
V0 e0 s0 DC 0 AC 82e1 0
RI0 e0 m0 47e-3
LI0 m0 n0 68e-5
H0 n0 h0 VS6 -10e-4
ED0 h0 2 d0 0 -12e-7
F0 0 d0 VS6 1
LD0 d0 0 1
VS1 1 s1 0
C1 s1 6 18e-6
VS2 5 s2 0
C2 s2 2 12e-4
VS3 0 s3 0
R3 s3 2 39e1
VS4 4 s4 0
C4 s4 7 12e-7
VS5 0 s5 0
R5 s5 5 15e3
VS6 1 s6 0
V6 e6 s6 DC 0 AC 82e1 0
RI6 e6 n6 39e-3
H6 n6 h6 VS0 -10e-4
ED6 h6 8 d6 0 -12e-7
F6 0 d6 VS0 1
LD6 d6 0 1
VS7 8 s7 0
L7 s7 6 12e-3
VS8 0 s8 0
C8 s8 4 68e-7
VS9 5 s9 0
R9 s9 2 10e1
VS10 7 s10 0
R10 s10 5 22e-1
VS11 7 s11 0
R11 s11 3 12e0
VS12 3 s12 0
L12 s12 5 15e-2
VS13 1 s13 0
R13 s13 5 56e2
VS14 7 s14 0
C14 s14 2 68e-7
VS15 8 s15 0
R15 s15 0 39e1
.control
set numdgt=17
ac lin 1 60 60
print v(1) v(2) v(3) v(4) v(5) v(6) v(7) v(8)
print i(vs0) i(vs1) i(vs2) i(vs3) i(vs4) i(vs5) i(vs6) i(vs7) i(vs8) i(vs9)
print i(vs10) i(vs11) i(vs12) i(vs13) i(vs14) i(vs15)
.endc
.end
