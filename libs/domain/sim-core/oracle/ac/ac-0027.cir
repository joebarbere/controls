controls oracle ac-0027
* Generated (plan F2.7, ADR 0012): do not edit; regenerate with `pnpm sim oracle regen`. ac seed 20261031 index 27 nodes 9 elements 13
.options sparse gmin=1e-12 noopac
RG1 1 0 1000000000000
RG2 2 0 1000000000000
RG3 3 0 1000000000000
RG4 4 0 1000000000000
RG5 5 0 1000000000000
RG6 6 0 1000000000000
RG7 7 0 1000000000000
RG8 8 0 1000000000000
VS0 7 s0 0
R0 s0 5 22e-1
VS1 3 s1 0
L1 s1 5 15e-2
VS2 8 s2 0
L2 s2 6 12e-3
VS3 1 s3 0
C3 s3 6 18e-6
VS4 0 s4 0
V4 e4 s4 DC 0 AC 82e1 0
RI4 e4 2 47e-3
VS5 0 s5 0
R5 s5 5 15e3
VS6 0 s6 0
C6 s6 4 68e-7
VS7 1 s7 0
R7 s7 5 56e2
VS8 0 s8 0
R8 s8 2 39e1
VS9 7 s9 0
C9 s9 2 68e-7
VS10 5 s10 0
R10 s10 2 10e1
VS11 5 s11 0
C11 s11 2 12e-4
VS12 1 s12 0
V12 e12 s12 DC 0 AC 82e1 0
RI12 e12 8 39e-3
.control
set numdgt=17
ac lin 1 60 60
print v(1) v(2) v(3) v(4) v(5) v(6) v(7) v(8)
print i(vs0) i(vs1) i(vs2) i(vs3) i(vs4) i(vs5) i(vs6) i(vs7) i(vs8) i(vs9)
print i(vs10) i(vs11) i(vs12)
.endc
.end
