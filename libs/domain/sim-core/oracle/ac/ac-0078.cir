controls oracle ac-0078
* Generated (plan F2.7, ADR 0012): do not edit; regenerate with `pnpm sim oracle regen`. ac seed 20261031 index 78 nodes 8 elements 13
.options sparse gmin=1e-12 noopac
RG1 1 0 1000000000000
RG2 2 0 1000000000000
RG3 3 0 1000000000000
RG4 4 0 1000000000000
RG5 5 0 1000000000000
RG6 6 0 1000000000000
RG7 7 0 1000000000000
VS0 6 s0 0
L0 s0 5 39e-3
VS1 1 s1 0
R1 s1 4 12e3
VS2 0 s2 0
V2 e2 s2 DC 0 AC 10e-1 0
RI2 e2 m2 68e-2
LI2 m2 4 68e-6
VS3 2 s3 0
L3 s3 1 15e-3
VS4 2 s4 0
R4 s4 0 27e-1
VS5 0 s5 0
R5 s5 7 56e0
VS6 7 s6 0
R6 s6 1 68e0
VS7 5 s7 0
V7 e7 s7 DC 0 AC 15e1 -120
RI7 e7 m7 22e-2
LI7 m7 6 27e-7
VS8 1 s8 0
L8 s8 3 10e-3
VS9 5 s9 0
C9 s9 1 39e-7
VS10 0 s10 0
L10 s10 3 22e-2
VS11 0 s11 0
L11 s11 1 15e-3
VS12 6 s12 0
C12 s12 2 15e-6
.control
set numdgt=17
ac lin 1 60 60
print v(1) v(2) v(3) v(4) v(5) v(6) v(7)
print i(vs0) i(vs1) i(vs2) i(vs3) i(vs4) i(vs5) i(vs6) i(vs7) i(vs8) i(vs9)
print i(vs10) i(vs11) i(vs12)
.endc
.end
