controls oracle ac-0078
* Generated (plan F2.7, ADR 0012): do not edit; regenerate with `pnpm sim oracle regen`. ac seed 20261031 index 78 nodes 8 elements 15
.options sparse gmin=1e-12 noopac
RG1 1 0 1000000000000
RG2 2 0 1000000000000
RG3 3 0 1000000000000
RG4 4 0 1000000000000
RG5 5 0 1000000000000
RG6 6 0 1000000000000
RG7 7 0 1000000000000
VS0 0 s0 0
R0 s0 4 12e3
VS1 0 s1 0
V1 e1 s1 DC 0 AC 82e0 120
RI1 e1 3 15e-2
VS2 5 s2 0
V2 e2 s2 DC 0 AC 15e1 -120
RI2 e2 6 22e-2
VS3 6 s3 0
L3 s3 5 39e-3
VS4 2 s4 0
L4 s4 0 15e-3
VS5 3 s5 0
R5 s5 7 56e0
VS6 2 s6 0
R6 s6 3 27e-1
VS7 4 s7 0
C7 s7 2 39e-5
VS8 5 s8 0
R8 s8 1 39e0
VS9 3 s9 0
L9 s9 1 22e-2
VS10 3 s10 0
V10 e10 s10 DC 0 AC 10e-1 0
RI10 e10 4 68e-2
VS11 2 s11 0
V11 e11 s11 DC 0 AC 82e0 180
RI11 e11 0 39e-2
VS12 7 s12 0
R12 s12 0 68e0
VS13 6 s13 0
C13 s13 2 15e-6
VS14 4 s14 0
R14 s14 1 12e1
.control
set numdgt=17
ac lin 1 60 60
print v(1) v(2) v(3) v(4) v(5) v(6) v(7)
print i(vs0) i(vs1) i(vs2) i(vs3) i(vs4) i(vs5) i(vs6) i(vs7) i(vs8) i(vs9)
print i(vs10) i(vs11) i(vs12) i(vs13) i(vs14)
.endc
.end
