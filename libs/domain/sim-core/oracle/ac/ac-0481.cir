controls oracle ac-0481
* Generated (plan F2.7, ADR 0012): do not edit; regenerate with `pnpm sim oracle regen`. ac seed 20261031 index 481 nodes 26 elements 41
.options sparse gmin=1e-12 noopac
RG1 1 0 1000000000000
RG2 2 0 1000000000000
RG3 3 0 1000000000000
RG4 4 0 1000000000000
RG5 5 0 1000000000000
RG6 6 0 1000000000000
RG7 7 0 1000000000000
RG8 8 0 1000000000000
RG9 9 0 1000000000000
RG10 10 0 1000000000000
RG11 11 0 1000000000000
RG12 12 0 1000000000000
RG13 13 0 1000000000000
RG14 14 0 1000000000000
RG15 15 0 1000000000000
RG16 16 0 1000000000000
RG17 17 0 1000000000000
RG18 18 0 1000000000000
RG19 19 0 1000000000000
RG20 20 0 1000000000000
RG21 21 0 1000000000000
RG22 22 0 1000000000000
RG23 23 0 1000000000000
RG24 24 0 1000000000000
RG25 25 0 1000000000000
VS0 12 s0 0
L0 s0 0 27e-2
VS1 0 s1 0
V1 e1 s1 DC 0 AC 33e0 0
RI1 e1 m1 18e-1
LI1 m1 n1 27e-7
H1 n1 h1 VS2 15e-4
ED1 h1 21 d1 0 -10e-7
F1 0 d1 VS2 1
LD1 d1 0 1
VS2 13 s2 0
V2 e2 s2 DC 0 AC 68e-1 -120
RI2 e2 n2 12e-3
H2 n2 h2 VS1 15e-4
ED2 h2 7 d2 0 -10e-7
F2 0 d2 VS1 1
LD2 d2 0 1
VS3 11 s3 0
R3 s3 16 15e3
VS4 17 s4 0
C4 s4 2 18e-5
VS5 16 s5 0
V5 e5 s5 DC 0 AC 15e1 180
RI5 e5 m5 12e-2
LI5 m5 4 33e-5
VS6 20 s6 0
V6 e6 s6 DC 0 AC 39e0 0
RI6 e6 m6 22e-3
LI6 m6 25 10e-7
VS7 5 s7 0
V7 e7 s7 DC 0 AC 82e1 180
RI7 e7 m7 56e-3
LI7 m7 7 15e-6
VS8 18 s8 0
V8 e8 s8 DC 0 AC 15e1 0
RI8 e8 m8 39e-2
LI8 m8 12 15e-6
VS9 20 s9 0
L9 s9 21 82e-2
VS10 2 s10 0
V10 e10 s10 DC 0 AC 12e-1 180
RI10 e10 1 22e-2
VS11 3 s11 0
R11 s11 16 15e0
VS12 7 s12 0
V12 e12 s12 DC 0 AC 10e0 -120
RI12 e12 24 47e-2
VS13 21 s13 0
C13 s13 5 15e-6
VS14 20 s14 0
C14 s14 17 39e-4
VS15 12 s15 0
R15 s15 19 27e3
VS16 6 s16 0
V16 e16 s16 DC 0 AC 39e-1 180
RI16 e16 7 39e-1
VS17 8 s17 0
L17 s17 0 22e-4
VS18 0 s18 0
V18 e18 s18 DC 0 AC 18e-1 120
RI18 e18 19 39e-3
VS19 2 s19 0
V19 e19 s19 DC 0 AC 18e0 -120
RI19 e19 m19 10e-2
LI19 m19 19 27e-7
VS20 1 s20 0
R20 s20 9 12e2
VS21 2 s21 0
C21 s21 8 68e-7
VS22 24 s22 0
C22 s22 13 39e-7
VS23 11 s23 0
R23 s23 15 15e-2
VS24 16 s24 0
R24 s24 19 56e-1
VS25 19 s25 0
R25 s25 23 82e2
VS26 13 s26 0
C26 s26 23 82e-6
VS27 15 s27 0
C27 s27 10 10e-5
VS28 22 s28 0
L28 s28 23 39e-2
VS29 19 s29 0
R29 s29 14 12e-1
VS30 16 s30 0
R30 s30 25 39e3
VS31 9 s31 0
R31 s31 3 15e-2
VS32 4 s32 0
C32 s32 6 18e-4
VS33 17 s33 0
V33 e33 s33 DC 0 AC 22e-1 -120
RI33 e33 15 15e-2
VS34 10 s34 0
R34 s34 14 56e1
VS35 0 s35 0
C35 s35 9 22e-6
VS36 7 s36 0
C36 s36 21 47e-6
VS37 18 s37 0
C37 s37 3 82e-7
VS38 10 s38 0
L38 s38 19 10e-2
VS39 2 s39 0
C39 s39 21 68e-5
VS40 22 s40 0
V40 e40 s40 DC 0 AC 33e1 0
RI40 e40 19 82e-1
.control
set numdgt=17
ac lin 1 60 60
print v(1) v(2) v(3) v(4) v(5) v(6) v(7) v(8) v(9) v(10)
print v(11) v(12) v(13) v(14) v(15) v(16) v(17) v(18) v(19) v(20)
print v(21) v(22) v(23) v(24) v(25)
print i(vs0) i(vs1) i(vs2) i(vs3) i(vs4) i(vs5) i(vs6) i(vs7) i(vs8) i(vs9)
print i(vs10) i(vs11) i(vs12) i(vs13) i(vs14) i(vs15) i(vs16) i(vs17) i(vs18) i(vs19)
print i(vs20) i(vs21) i(vs22) i(vs23) i(vs24) i(vs25) i(vs26) i(vs27) i(vs28) i(vs29)
print i(vs30) i(vs31) i(vs32) i(vs33) i(vs34) i(vs35) i(vs36) i(vs37) i(vs38) i(vs39)
print i(vs40)
.endc
.end
