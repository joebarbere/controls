controls oracle ac-0481
* Generated (plan F2.7, ADR 0012): do not edit; regenerate with `pnpm sim oracle regen`. ac seed 20261031 index 481 nodes 26 elements 31
.options sparse gmin=1e-12 noopac
RG1 1 0 1000000000000
RG2 2 0 1000000000000
RG3 3 0 1000000000000
RG4 4 0 1000000000000
RG5 5 0 1000000000000
RG6 6 0 1000000000000
RG7 7 0 1000000000000
RG8 8 0 1000000000000
RG9 9 0 1000000000000
RG10 10 0 1000000000000
RG11 11 0 1000000000000
RG12 12 0 1000000000000
RG13 13 0 1000000000000
RG14 14 0 1000000000000
RG15 15 0 1000000000000
RG16 16 0 1000000000000
RG17 17 0 1000000000000
RG18 18 0 1000000000000
RG19 19 0 1000000000000
RG20 20 0 1000000000000
RG21 21 0 1000000000000
RG22 22 0 1000000000000
RG23 23 0 1000000000000
RG24 24 0 1000000000000
RG25 25 0 1000000000000
VS0 17 s0 0
C0 s0 0 18e-5
VS1 22 s1 0
L1 s1 23 39e-2
VS2 0 s2 0
V2 e2 s2 DC 0 AC 12e-1 180
RI2 e2 1 22e-2
VS3 7 s3 0
C3 s3 21 47e-6
VS4 5 s4 0
V4 e4 s4 DC 0 AC 82e1 180
RI4 e4 7 56e-3
VS5 22 s5 0
V5 e5 s5 DC 0 AC 33e1 0
RI5 e5 19 82e-1
VS6 11 s6 0
R6 s6 15 15e-2
VS7 17 s7 0
V7 e7 s7 DC 0 AC 22e-1 -120
RI7 e7 15 15e-2
VS8 12 s8 0
L8 s8 2 27e-2
VS9 10 s9 0
L9 s9 19 10e-2
VS10 16 s10 0
R10 s10 19 56e-1
VS11 7 s11 0
V11 e11 s11 DC 0 AC 10e0 -120
RI11 e11 24 47e-2
VS12 0 s12 0
V12 e12 s12 DC 0 AC 18e0 -120
RI12 e12 19 10e-2
VS13 24 s13 0
C13 s13 13 39e-7
VS14 19 s14 0
R14 s14 23 82e2
VS15 16 s15 0
R15 s15 25 39e3
VS16 19 s16 0
R16 s16 14 12e-1
VS17 2 s17 0
V17 e17 s17 DC 0 AC 18e-1 120
RI17 e17 19 39e-3
VS18 16 s18 0
V18 e18 s18 DC 0 AC 15e1 180
RI18 e18 4 12e-2
VS19 9 s19 0
R19 s19 3 15e-2
VS20 12 s20 0
R20 s20 19 27e3
VS21 20 s21 0
C21 s21 17 39e-4
VS22 2 s22 0
V22 e22 s22 DC 0 AC 33e0 0
RI22 e22 21 18e-1
VS23 8 s23 0
L23 s23 2 22e-4
VS24 0 s24 0
C24 s24 21 68e-5
VS25 11 s25 0
R25 s25 16 15e3
VS26 6 s26 0
V26 e26 s26 DC 0 AC 39e-1 180
RI26 e26 7 39e-1
VS27 4 s27 0
C27 s27 6 18e-4
VS28 18 s28 0
V28 e28 s28 DC 0 AC 15e1 0
RI28 e28 12 39e-2
VS29 3 s29 0
R29 s29 16 15e0
VS30 2 s30 0
C30 s30 9 22e-6
.control
set numdgt=17
ac lin 1 60 60
print v(1) v(2) v(3) v(4) v(5) v(6) v(7) v(8) v(9) v(10)
print v(11) v(12) v(13) v(14) v(15) v(16) v(17) v(18) v(19) v(20)
print v(21) v(22) v(23) v(24) v(25)
print i(vs0) i(vs1) i(vs2) i(vs3) i(vs4) i(vs5) i(vs6) i(vs7) i(vs8) i(vs9)
print i(vs10) i(vs11) i(vs12) i(vs13) i(vs14) i(vs15) i(vs16) i(vs17) i(vs18) i(vs19)
print i(vs20) i(vs21) i(vs22) i(vs23) i(vs24) i(vs25) i(vs26) i(vs27) i(vs28) i(vs29)
print i(vs30)
.endc
.end
