controls oracle ac-0188
* Generated (plan F2.7, ADR 0012): do not edit; regenerate with `pnpm sim oracle regen`. ac seed 20261031 index 188 nodes 29 elements 44
.options sparse gmin=1e-12 noopac
RG1 1 0 1000000000000
RG2 2 0 1000000000000
RG3 3 0 1000000000000
RG4 4 0 1000000000000
RG5 5 0 1000000000000
RG6 6 0 1000000000000
RG7 7 0 1000000000000
RG8 8 0 1000000000000
RG9 9 0 1000000000000
RG10 10 0 1000000000000
RG11 11 0 1000000000000
RG12 12 0 1000000000000
RG13 13 0 1000000000000
RG14 14 0 1000000000000
RG15 15 0 1000000000000
RG16 16 0 1000000000000
RG17 17 0 1000000000000
RG18 18 0 1000000000000
RG19 19 0 1000000000000
RG20 20 0 1000000000000
RG21 21 0 1000000000000
RG22 22 0 1000000000000
RG23 23 0 1000000000000
RG24 24 0 1000000000000
RG25 25 0 1000000000000
RG26 26 0 1000000000000
RG27 27 0 1000000000000
RG28 28 0 1000000000000
VS0 7 s0 0
R0 s0 28 56e-2
VS1 19 s1 0
L1 s1 13 47e-3
VS2 0 s2 0
V2 e2 s2 DC 0 AC 15e0 180
RI2 e2 15 10e-3
VS3 20 s3 0
C3 s3 23 22e-7
VS4 10 s4 0
R4 s4 11 10e-1
VS5 19 s5 0
C5 s5 14 10e-6
VS6 10 s6 0
V6 e6 s6 DC 0 AC 68e0 180
RI6 e6 16 39e-3
VS7 2 s7 0
R7 s7 0 27e1
VS8 1 s8 0
L8 s8 9 18e-4
VS9 21 s9 0
C9 s9 10 22e-7
VS10 16 s10 0
V10 e10 s10 DC 0 AC 12e0 180
RI10 e10 28 47e-1
VS11 10 s11 0
V11 e11 s11 DC 0 AC 18e1 0
RI11 e11 14 15e-2
VS12 4 s12 0
R12 s12 21 22e2
VS13 15 s13 0
R13 s13 25 15e2
VS14 8 s14 0
C14 s14 24 33e-5
VS15 21 s15 0
V15 e15 s15 DC 0 AC 56e1 120
RI15 e15 2 22e-1
VS16 24 s16 0
L16 s16 25 33e-5
VS17 9 s17 0
C17 s17 10 10e-4
VS18 0 s18 0
R18 s18 26 33e3
VS19 11 s19 0
R19 s19 12 47e3
VS20 21 s20 0
R20 s20 6 15e-2
VS21 0 s21 0
R21 s21 23 82e2
VS22 6 s22 0
L22 s22 1 33e-2
VS23 10 s23 0
L23 s23 3 12e-3
VS24 26 s24 0
V24 e24 s24 DC 0 AC 12e0 180
RI24 e24 3 56e-3
VS25 16 s25 0
V25 e25 s25 DC 0 AC 82e-1 180
RI25 e25 19 18e-2
VS26 27 s26 0
R26 s26 19 15e3
VS27 17 s27 0
R27 s27 26 33e1
VS28 0 s28 0
V28 e28 s28 DC 0 AC 10e1 120
RI28 e28 24 33e-3
VS29 28 s29 0
L29 s29 18 22e-3
VS30 11 s30 0
C30 s30 8 10e-5
VS31 10 s31 0
R31 s31 13 47e3
VS32 26 s32 0
C32 s32 25 15e-4
VS33 26 s33 0
L33 s33 27 22e-4
VS34 26 s34 0
R34 s34 7 22e-2
VS35 11 s35 0
R35 s35 0 22e0
VS36 5 s36 0
R36 s36 1 15e-2
VS37 20 s37 0
C37 s37 4 12e-5
VS38 20 s38 0
R38 s38 22 68e1
VS39 11 s39 0
R39 s39 4 56e-1
VS40 4 s40 0
L40 s40 27 68e-3
VS41 1 s41 0
C41 s41 0 56e-6
VS42 15 s42 0
L42 s42 14 22e-5
VS43 16 s43 0
L43 s43 7 15e-3
.control
set numdgt=17
ac lin 1 60 60
print v(1) v(2) v(3) v(4) v(5) v(6) v(7) v(8) v(9) v(10)
print v(11) v(12) v(13) v(14) v(15) v(16) v(17) v(18) v(19) v(20)
print v(21) v(22) v(23) v(24) v(25) v(26) v(27) v(28)
print i(vs0) i(vs1) i(vs2) i(vs3) i(vs4) i(vs5) i(vs6) i(vs7) i(vs8) i(vs9)
print i(vs10) i(vs11) i(vs12) i(vs13) i(vs14) i(vs15) i(vs16) i(vs17) i(vs18) i(vs19)
print i(vs20) i(vs21) i(vs22) i(vs23) i(vs24) i(vs25) i(vs26) i(vs27) i(vs28) i(vs29)
print i(vs30) i(vs31) i(vs32) i(vs33) i(vs34) i(vs35) i(vs36) i(vs37) i(vs38) i(vs39)
print i(vs40) i(vs41) i(vs42) i(vs43)
.endc
.end
