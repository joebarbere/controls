controls oracle ac-0188
* Generated (plan F2.7, ADR 0012): do not edit; regenerate with `pnpm sim oracle regen`. ac seed 20261031 index 188 nodes 29 elements 51
.options sparse gmin=1e-12 noopac
RG1 1 0 1000000000000
RG2 2 0 1000000000000
RG3 3 0 1000000000000
RG4 4 0 1000000000000
RG5 5 0 1000000000000
RG6 6 0 1000000000000
RG7 7 0 1000000000000
RG8 8 0 1000000000000
RG9 9 0 1000000000000
RG10 10 0 1000000000000
RG11 11 0 1000000000000
RG12 12 0 1000000000000
RG13 13 0 1000000000000
RG14 14 0 1000000000000
RG15 15 0 1000000000000
RG16 16 0 1000000000000
RG17 17 0 1000000000000
RG18 18 0 1000000000000
RG19 19 0 1000000000000
RG20 20 0 1000000000000
RG21 21 0 1000000000000
RG22 22 0 1000000000000
RG23 23 0 1000000000000
RG24 24 0 1000000000000
RG25 25 0 1000000000000
RG26 26 0 1000000000000
RG27 27 0 1000000000000
RG28 28 0 1000000000000
VS0 23 s0 0
L0 s0 7 39e-5
VS1 13 s1 0
R1 s1 10 15e-2
VS2 3 s2 0
L2 s2 1 68e-5
VS3 27 s3 0
R3 s3 19 15e3
VS4 10 s4 0
C4 s4 18 10e-7
VS5 0 s5 0
V5 e5 s5 DC 0 AC 27e-1 -120
RI5 e5 10 15e-1
VS6 6 s6 0
R6 s6 26 12e3
VS7 7 s7 0
R7 s7 21 27e0
VS8 16 s8 0
C8 s8 10 33e-7
VS9 25 s9 0
V9 e9 s9 DC 0 AC 39e-1 180
RI9 e9 28 47e-2
VS10 23 s10 0
R10 s10 4 33e-2
VS11 7 s11 0
L11 s11 22 27e-4
VS12 26 s12 0
L12 s12 27 22e-4
VS13 21 s13 0
V13 e13 s13 DC 0 AC 82e-1 180
RI13 e13 m13 82e-2
LI13 m13 28 12e-7
VS14 1 s14 0
C14 s14 0 22e-7
VS15 27 s15 0
L15 s15 3 68e-2
VS16 11 s16 0
L16 s16 6 27e-3
VS17 21 s17 0
V17 e17 s17 DC 0 AC 82e-1 0
RI17 e17 m17 15e-3
LI17 m17 12 10e-5
VS18 3 s18 0
L18 s18 6 18e-3
VS19 17 s19 0
V19 e19 s19 DC 0 AC 12e-1 0
RI19 e19 2 33e-2
VS20 7 s20 0
V20 e20 s20 DC 0 AC 68e0 180
RI20 e20 m20 39e-3
LI20 m20 16 56e-5
VS21 20 s21 0
C21 s21 4 12e-5
VS22 4 s22 0
C22 s22 5 33e-5
VS23 21 s23 0
R23 s23 3 39e-2
VS24 11 s24 0
L24 s24 5 68e-2
VS25 3 s25 0
L25 s25 6 10e-4
VS26 16 s26 0
R26 s26 13 27e2
VS27 24 s27 0
R27 s27 8 39e2
VS28 7 s28 0
L28 s28 3 12e-3
VS29 11 s29 0
R29 s29 19 33e0
VS30 15 s30 0
V30 e30 s30 DC 0 AC 82e1 0
RI30 e30 7 10e-3
VS31 9 s31 0
L31 s31 3 15e-4
VS32 1 s32 0
C32 s32 0 15e-7
VS33 4 s33 0
R33 s33 21 22e2
VS34 14 s34 0
L34 s34 22 15e-2
VS35 7 s35 0
R35 s35 5 15e2
VS36 8 s36 0
L36 s36 28 33e-4
VS37 9 s37 0
C37 s37 24 18e-6
VS38 25 s38 0
V38 e38 s38 DC 0 AC 15e1 0
RI38 e38 m38 47e-1
LI38 m38 27 10e-6
VS39 1 s39 0
L39 s39 17 22e-5
VS40 18 s40 0
V40 e40 s40 DC 0 AC 56e1 0
RI40 e40 m40 10e-3
LI40 m40 21 15e-6
VS41 26 s41 0
L41 s41 6 12e-3
VS42 14 s42 0
L42 s42 21 82e-3
VS43 14 s43 0
C43 s43 10 47e-7
VS44 0 s44 0
R44 s44 12 33e-2
VS45 21 s45 0
L45 s45 7 27e-2
VS46 16 s46 0
V46 e46 s46 DC 0 AC 22e1 120
RI46 e46 2 47e-3
VS47 15 s47 0
C47 s47 4 33e-4
VS48 20 s48 0
L48 s48 16 22e-3
VS49 0 s49 0
R49 s49 28 56e-2
VS50 4 s50 0
V50 e50 s50 DC 0 AC 22e-1 120
RI50 e50 m50 22e-2
LI50 m50 25 33e-7
.control
set numdgt=17
ac lin 1 60 60
print v(1) v(2) v(3) v(4) v(5) v(6) v(7) v(8) v(9) v(10)
print v(11) v(12) v(13) v(14) v(15) v(16) v(17) v(18) v(19) v(20)
print v(21) v(22) v(23) v(24) v(25) v(26) v(27) v(28)
print i(vs0) i(vs1) i(vs2) i(vs3) i(vs4) i(vs5) i(vs6) i(vs7) i(vs8) i(vs9)
print i(vs10) i(vs11) i(vs12) i(vs13) i(vs14) i(vs15) i(vs16) i(vs17) i(vs18) i(vs19)
print i(vs20) i(vs21) i(vs22) i(vs23) i(vs24) i(vs25) i(vs26) i(vs27) i(vs28) i(vs29)
print i(vs30) i(vs31) i(vs32) i(vs33) i(vs34) i(vs35) i(vs36) i(vs37) i(vs38) i(vs39)
print i(vs40) i(vs41) i(vs42) i(vs43) i(vs44) i(vs45) i(vs46) i(vs47) i(vs48) i(vs49)
print i(vs50)
.endc
.end
