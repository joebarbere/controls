controls oracle ac-0188
* Generated (plan F2.7, ADR 0012): do not edit; regenerate with `pnpm sim oracle regen`. ac seed 20261031 index 188 nodes 29 elements 49
.options sparse gmin=1e-12 noopac
RG1 1 0 1000000000000
RG2 2 0 1000000000000
RG3 3 0 1000000000000
RG4 4 0 1000000000000
RG5 5 0 1000000000000
RG6 6 0 1000000000000
RG7 7 0 1000000000000
RG8 8 0 1000000000000
RG9 9 0 1000000000000
RG10 10 0 1000000000000
RG11 11 0 1000000000000
RG12 12 0 1000000000000
RG13 13 0 1000000000000
RG14 14 0 1000000000000
RG15 15 0 1000000000000
RG16 16 0 1000000000000
RG17 17 0 1000000000000
RG18 18 0 1000000000000
RG19 19 0 1000000000000
RG20 20 0 1000000000000
RG21 21 0 1000000000000
RG22 22 0 1000000000000
RG23 23 0 1000000000000
RG24 24 0 1000000000000
RG25 25 0 1000000000000
RG26 26 0 1000000000000
RG27 27 0 1000000000000
RG28 28 0 1000000000000
VS0 20 s0 0
C0 s0 23 22e-7
VS1 15 s1 0
R1 s1 25 15e2
VS2 26 s2 0
L2 s2 27 22e-4
VS3 6 s3 0
L3 s3 1 33e-2
VS4 19 s4 0
L4 s4 13 47e-3
VS5 7 s5 0
R5 s5 28 56e-2
VS6 8 s6 0
C6 s6 5 47e-5
VS7 8 s7 0
C7 s7 24 33e-5
VS8 0 s8 0
L8 s8 7 15e-3
VS9 0 s9 0
V9 e9 s9 DC 0 AC 82e-1 180
RI9 e9 n9 18e-2
H9 n9 h9 VS19 -82e-4
ED9 h9 19 d9 0 -47e-7
F9 0 d9 VS19 1
LD9 d9 0 1
VS10 27 s10 0
R10 s10 19 15e3
VS11 10 s11 0
R11 s11 26 33e3
VS12 16 s12 0
R12 s12 11 10e-1
VS13 16 s13 0
L13 s13 3 12e-3
VS14 6 s14 0
R14 s14 22 33e3
VS15 28 s15 0
L15 s15 18 22e-3
VS16 11 s16 0
R16 s16 10 22e0
VS17 5 s17 0
R17 s17 1 15e-2
VS18 16 s18 0
R18 s18 13 47e3
VS19 10 s19 0
V19 e19 s19 DC 0 AC 10e1 120
RI19 e19 m19 33e-3
LI19 m19 n19 39e-7
H19 n19 h19 VS9 -82e-4
ED19 h19 24 d19 0 -47e-7
F19 0 d19 VS9 1
LD19 d19 0 1
VS20 24 s20 0
L20 s20 25 33e-5
VS21 21 s21 0
V21 e21 s21 DC 0 AC 56e1 120
RI21 e21 2 22e-1
VS22 26 s22 0
V22 e22 s22 DC 0 AC 12e0 180
RI22 e22 3 56e-3
VS23 11 s23 0
C23 s23 8 10e-5
VS24 10 s24 0
R24 s24 23 82e2
VS25 22 s25 0
V25 e25 s25 DC 0 AC 15e1 0
RI25 e25 12 47e-1
VS26 19 s26 0
L26 s26 18 39e-5
VS27 17 s27 0
R27 s27 26 33e1
VS28 4 s28 0
L28 s28 27 68e-3
VS29 11 s29 0
R29 s29 4 56e-1
VS30 16 s30 0
V30 e30 s30 DC 0 AC 18e1 0
RI30 e30 14 15e-2
VS31 20 s31 0
R31 s31 22 68e1
VS32 2 s32 0
R32 s32 10 27e1
VS33 4 s33 0
R33 s33 21 22e2
VS34 26 s34 0
C34 s34 25 15e-4
VS35 17 s35 0
V35 e35 s35 DC 0 AC 47e0 120
RI35 e35 0 68e-1
VS36 9 s36 0
C36 s36 16 10e-4
VS37 19 s37 0
C37 s37 14 10e-6
VS38 1 s38 0
L38 s38 9 18e-4
VS39 21 s39 0
C39 s39 16 22e-7
VS40 21 s40 0
R40 s40 6 15e-2
VS41 15 s41 0
L41 s41 14 22e-5
VS42 1 s42 0
C42 s42 10 56e-6
VS43 10 s43 0
V43 e43 s43 DC 0 AC 15e0 180
RI43 e43 m43 10e-3
LI43 m43 15 10e-7
VS44 16 s44 0
V44 e44 s44 DC 0 AC 68e0 180
RI44 e44 0 39e-3
VS45 20 s45 0
C45 s45 4 12e-5
VS46 26 s46 0
R46 s46 7 22e-2
VS47 11 s47 0
R47 s47 12 47e3
VS48 0 s48 0
V48 e48 s48 DC 0 AC 12e0 180
RI48 e48 m48 47e-1
LI48 m48 28 39e-5
.control
set numdgt=17
ac lin 1 60 60
print v(1) v(2) v(3) v(4) v(5) v(6) v(7) v(8) v(9) v(10)
print v(11) v(12) v(13) v(14) v(15) v(16) v(17) v(18) v(19) v(20)
print v(21) v(22) v(23) v(24) v(25) v(26) v(27) v(28)
print i(vs0) i(vs1) i(vs2) i(vs3) i(vs4) i(vs5) i(vs6) i(vs7) i(vs8) i(vs9)
print i(vs10) i(vs11) i(vs12) i(vs13) i(vs14) i(vs15) i(vs16) i(vs17) i(vs18) i(vs19)
print i(vs20) i(vs21) i(vs22) i(vs23) i(vs24) i(vs25) i(vs26) i(vs27) i(vs28) i(vs29)
print i(vs30) i(vs31) i(vs32) i(vs33) i(vs34) i(vs35) i(vs36) i(vs37) i(vs38) i(vs39)
print i(vs40) i(vs41) i(vs42) i(vs43) i(vs44) i(vs45) i(vs46) i(vs47) i(vs48)
.endc
.end
