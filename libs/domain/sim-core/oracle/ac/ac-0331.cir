controls oracle ac-0331
* Generated (plan F2.7, ADR 0012): do not edit; regenerate with `pnpm sim oracle regen`. ac seed 20261031 index 331 nodes 3 elements 5
.options sparse gmin=1e-12 noopac
RG1 1 0 1000000000000
RG2 2 0 1000000000000
VS0 2 s0 0
R0 s0 0 27e3
VS1 0 s1 0
L1 s1 1 18e-5
VS2 1 s2 0
R2 s2 2 12e3
VS3 0 s3 0
V3 e3 s3 DC 0 AC 12e1 -120
RI3 e3 1 39e-2
VS4 1 s4 0
R4 s4 0 22e-1
.control
set numdgt=17
ac lin 1 60 60
print v(1) v(2)
print i(vs0) i(vs1) i(vs2) i(vs3) i(vs4)
.endc
.end
