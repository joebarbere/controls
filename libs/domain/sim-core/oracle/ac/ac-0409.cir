controls oracle ac-0409
* Generated (plan F2.7, ADR 0012): do not edit; regenerate with `pnpm sim oracle regen`. ac seed 20261031 index 409 nodes 27 elements 41
.options sparse gmin=1e-12 noopac
RG1 1 0 1000000000000
RG2 2 0 1000000000000
RG3 3 0 1000000000000
RG4 4 0 1000000000000
RG5 5 0 1000000000000
RG6 6 0 1000000000000
RG7 7 0 1000000000000
RG8 8 0 1000000000000
RG9 9 0 1000000000000
RG10 10 0 1000000000000
RG11 11 0 1000000000000
RG12 12 0 1000000000000
RG13 13 0 1000000000000
RG14 14 0 1000000000000
RG15 15 0 1000000000000
RG16 16 0 1000000000000
RG17 17 0 1000000000000
RG18 18 0 1000000000000
RG19 19 0 1000000000000
RG20 20 0 1000000000000
RG21 21 0 1000000000000
RG22 22 0 1000000000000
RG23 23 0 1000000000000
RG24 24 0 1000000000000
RG25 25 0 1000000000000
RG26 26 0 1000000000000
VS0 19 s0 0
C0 s0 15 10e-6
VS1 0 s1 0
V1 e1 s1 DC 0 AC 15e1 -120
RI1 e1 4 39e-1
VS2 17 s2 0
C2 s2 11 39e-4
VS3 0 s3 0
R3 s3 4 18e-1
VS4 16 s4 0
R4 s4 18 22e-2
VS5 22 s5 0
L5 s5 8 33e-3
VS6 10 s6 0
L6 s6 8 27e-4
VS7 22 s7 0
R7 s7 14 82e-1
VS8 1 s8 0
R8 s8 3 12e0
VS9 14 s9 0
V9 e9 s9 DC 0 AC 18e-1 120
RI9 e9 13 47e-3
VS10 20 s10 0
R10 s10 25 47e-1
VS11 18 s11 0
C11 s11 2 10e-4
VS12 25 s12 0
V12 e12 s12 DC 0 AC 39e-1 120
RI12 e12 23 15e-3
VS13 9 s13 0
V13 e13 s13 DC 0 AC 12e1 180
RI13 e13 11 39e-1
VS14 19 s14 0
L14 s14 26 12e-3
VS15 14 s15 0
L15 s15 2 33e-2
VS16 5 s16 0
L16 s16 7 18e-5
VS17 18 s17 0
C17 s17 11 82e-6
VS18 24 s18 0
R18 s18 25 18e-1
VS19 26 s19 0
L19 s19 10 47e-5
VS20 23 s20 0
R20 s20 7 12e2
VS21 11 s21 0
R21 s21 4 27e2
VS22 2 s22 0
L22 s22 10 22e-2
VS23 5 s23 0
L23 s23 21 27e-3
VS24 20 s24 0
L24 s24 3 22e-5
VS25 3 s25 0
C25 s25 10 27e-7
VS26 8 s26 0
V26 e26 s26 DC 0 AC 39e-1 -120
RI26 e26 15 47e-3
VS27 13 s27 0
C27 s27 9 33e-4
VS28 16 s28 0
L28 s28 21 18e-2
VS29 23 s29 0
C29 s29 12 39e-4
VS30 21 s30 0
R30 s30 12 68e2
VS31 0 s31 0
L31 s31 18 15e-4
VS32 4 s32 0
R32 s32 22 27e-1
VS33 6 s33 0
R33 s33 20 22e3
VS34 1 s34 0
L34 s34 26 82e-2
VS35 18 s35 0
V35 e35 s35 DC 0 AC 18e-1 120
RI35 e35 10 22e-2
VS36 24 s36 0
C36 s36 21 12e-4
VS37 6 s37 0
C37 s37 25 39e-7
VS38 14 s38 0
V38 e38 s38 DC 0 AC 33e-1 120
RI38 e38 m38 27e-3
LI38 m38 4 27e-7
VS39 23 s39 0
L39 s39 2 27e-2
VS40 10 s40 0
C40 s40 17 47e-5
.control
set numdgt=17
ac lin 1 60 60
print v(1) v(2) v(3) v(4) v(5) v(6) v(7) v(8) v(9) v(10)
print v(11) v(12) v(13) v(14) v(15) v(16) v(17) v(18) v(19) v(20)
print v(21) v(22) v(23) v(24) v(25) v(26)
print i(vs0) i(vs1) i(vs2) i(vs3) i(vs4) i(vs5) i(vs6) i(vs7) i(vs8) i(vs9)
print i(vs10) i(vs11) i(vs12) i(vs13) i(vs14) i(vs15) i(vs16) i(vs17) i(vs18) i(vs19)
print i(vs20) i(vs21) i(vs22) i(vs23) i(vs24) i(vs25) i(vs26) i(vs27) i(vs28) i(vs29)
print i(vs30) i(vs31) i(vs32) i(vs33) i(vs34) i(vs35) i(vs36) i(vs37) i(vs38) i(vs39)
print i(vs40)
.endc
.end
