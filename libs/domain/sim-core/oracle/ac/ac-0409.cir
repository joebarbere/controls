controls oracle ac-0409
* Generated (plan F2.7, ADR 0012): do not edit; regenerate with `pnpm sim oracle regen`. ac seed 20261031 index 409 nodes 27 elements 42
.options sparse gmin=1e-12 noopac
RG1 1 0 1000000000000
RG2 2 0 1000000000000
RG3 3 0 1000000000000
RG4 4 0 1000000000000
RG5 5 0 1000000000000
RG6 6 0 1000000000000
RG7 7 0 1000000000000
RG8 8 0 1000000000000
RG9 9 0 1000000000000
RG10 10 0 1000000000000
RG11 11 0 1000000000000
RG12 12 0 1000000000000
RG13 13 0 1000000000000
RG14 14 0 1000000000000
RG15 15 0 1000000000000
RG16 16 0 1000000000000
RG17 17 0 1000000000000
RG18 18 0 1000000000000
RG19 19 0 1000000000000
RG20 20 0 1000000000000
RG21 21 0 1000000000000
RG22 22 0 1000000000000
RG23 23 0 1000000000000
RG24 24 0 1000000000000
RG25 25 0 1000000000000
RG26 26 0 1000000000000
VS0 19 s0 0
L0 s0 26 12e-3
VS1 0 s1 0
V1 e1 s1 DC 0 AC 33e1 120
RI1 e1 m1 10e-1
LI1 m1 n1 15e-5
H1 n1 h1 VS4 33e-3
ED1 h1 19 d1 0 -82e-5
F1 0 d1 VS4 1
LD1 d1 0 1
VS2 4 s2 0
R2 s2 6 12e2
VS3 18 s3 0
R3 s3 22 18e3
VS4 10 s4 0
V4 e4 s4 DC 0 AC 33e-1 0
RI4 e4 m4 12e-2
LI4 m4 n4 18e-6
H4 n4 h4 VS1 33e-3
ED4 h4 7 d4 0 -82e-5
F4 0 d4 VS1 1
LD4 d4 0 1
VS5 5 s5 0
V5 e5 s5 DC 0 AC 39e1 120
RI5 e5 m5 47e-1
LI5 m5 8 22e-5
VS6 22 s6 0
L6 s6 6 39e-4
VS7 10 s7 0
R7 s7 23 15e2
VS8 10 s8 0
V8 e8 s8 DC 0 AC 68e1 120
RI8 e8 m8 15e-2
LI8 m8 17 33e-7
VS9 2 s9 0
R9 s9 18 22e-2
VS10 17 s10 0
L10 s10 15 68e-3
VS11 14 s11 0
L11 s11 18 39e-4
VS12 16 s12 0
R12 s12 4 18e-1
VS13 14 s13 0
R13 s13 21 18e1
VS14 20 s14 0
C14 s14 3 33e-5
VS15 1 s15 0
C15 s15 17 33e-6
VS16 18 s16 0
C16 s16 0 10e-4
VS17 8 s17 0
R17 s17 24 10e2
VS18 23 s18 0
L18 s18 0 27e-2
VS19 4 s19 0
R19 s19 22 27e-1
VS20 4 s20 0
R20 s20 2 39e0
VS21 25 s21 0
L21 s21 9 56e-2
VS22 14 s22 0
V22 e22 s22 DC 0 AC 33e-1 120
RI22 e22 4 27e-3
VS23 7 s23 0
C23 s23 17 27e-5
VS24 22 s24 0
V24 e24 s24 DC 0 AC 10e-1 0
RI24 e24 m24 47e-3
LI24 m24 15 56e-5
VS25 20 s25 0
L25 s25 3 22e-5
VS26 14 s26 0
L26 s26 0 33e-2
VS27 0 s27 0
V27 e27 s27 DC 0 AC 22e0 -120
RI27 e27 m27 56e-2
LI27 m27 13 33e-7
VS28 0 s28 0
V28 e28 s28 DC 0 AC 12e1 180
RI28 e28 16 47e-2
VS29 0 s29 0
L29 s29 10 22e-2
VS30 14 s30 0
R30 s30 11 27e3
VS31 4 s31 0
C31 s31 20 68e-5
VS32 24 s32 0
L32 s32 21 22e-3
VS33 21 s33 0
R33 s33 12 68e2
VS34 8 s34 0
R34 s34 18 22e0
VS35 5 s35 0
R35 s35 10 47e2
VS36 1 s36 0
L36 s36 11 39e-4
VS37 25 s37 0
V37 e37 s37 DC 0 AC 39e-1 120
RI37 e37 23 15e-3
VS38 3 s38 0
V38 e38 s38 DC 0 AC 18e1 180
RI38 e38 m38 10e-3
LI38 m38 16 12e-5
VS39 8 s39 0
R39 s39 12 39e-1
VS40 26 s40 0
L40 s40 10 47e-5
VS41 13 s41 0
C41 s41 9 33e-4
.control
set numdgt=17
ac lin 1 60 60
print v(1) v(2) v(3) v(4) v(5) v(6) v(7) v(8) v(9) v(10)
print v(11) v(12) v(13) v(14) v(15) v(16) v(17) v(18) v(19) v(20)
print v(21) v(22) v(23) v(24) v(25) v(26)
print i(vs0) i(vs1) i(vs2) i(vs3) i(vs4) i(vs5) i(vs6) i(vs7) i(vs8) i(vs9)
print i(vs10) i(vs11) i(vs12) i(vs13) i(vs14) i(vs15) i(vs16) i(vs17) i(vs18) i(vs19)
print i(vs20) i(vs21) i(vs22) i(vs23) i(vs24) i(vs25) i(vs26) i(vs27) i(vs28) i(vs29)
print i(vs30) i(vs31) i(vs32) i(vs33) i(vs34) i(vs35) i(vs36) i(vs37) i(vs38) i(vs39)
print i(vs40) i(vs41)
.endc
.end
