controls oracle ac-0409
* Generated (plan F2.7, ADR 0012): do not edit; regenerate with `pnpm sim oracle regen`. ac seed 20261031 index 409 nodes 27 elements 34
.options sparse gmin=1e-12 noopac
RG1 1 0 1000000000000
RG2 2 0 1000000000000
RG3 3 0 1000000000000
RG4 4 0 1000000000000
RG5 5 0 1000000000000
RG6 6 0 1000000000000
RG7 7 0 1000000000000
RG8 8 0 1000000000000
RG9 9 0 1000000000000
RG10 10 0 1000000000000
RG11 11 0 1000000000000
RG12 12 0 1000000000000
RG13 13 0 1000000000000
RG14 14 0 1000000000000
RG15 15 0 1000000000000
RG16 16 0 1000000000000
RG17 17 0 1000000000000
RG18 18 0 1000000000000
RG19 19 0 1000000000000
RG20 20 0 1000000000000
RG21 21 0 1000000000000
RG22 22 0 1000000000000
RG23 23 0 1000000000000
RG24 24 0 1000000000000
RG25 25 0 1000000000000
RG26 26 0 1000000000000
VS0 8 s0 0
R0 s0 12 39e-1
VS1 0 s1 0
V1 e1 s1 DC 0 AC 22e0 -120
RI1 e1 13 56e-2
VS2 16 s2 0
R2 s2 4 18e-1
VS3 23 s3 0
L3 s3 0 27e-2
VS4 2 s4 0
R4 s4 18 22e-2
VS5 8 s5 0
R5 s5 18 22e0
VS6 14 s6 0
L6 s6 0 33e-2
VS7 1 s7 0
L7 s7 11 39e-4
VS8 3 s8 0
V8 e8 s8 DC 0 AC 18e1 180
RI8 e8 16 10e-3
VS9 10 s9 0
V9 e9 s9 DC 0 AC 68e1 120
RI9 e9 17 15e-2
VS10 19 s10 0
L10 s10 26 12e-3
VS11 18 s11 0
R11 s11 22 18e3
VS12 4 s12 0
R12 s12 22 27e-1
VS13 5 s13 0
V13 e13 s13 DC 0 AC 39e1 120
RI13 e13 8 47e-1
VS14 22 s14 0
V14 e14 s14 DC 0 AC 10e-1 0
RI14 e14 15 47e-3
VS15 8 s15 0
R15 s15 24 10e2
VS16 14 s16 0
L16 s16 18 39e-4
VS17 14 s17 0
V17 e17 s17 DC 0 AC 33e-1 120
RI17 e17 4 27e-3
VS18 20 s18 0
L18 s18 3 22e-5
VS19 4 s19 0
R19 s19 6 12e2
VS20 13 s20 0
C20 s20 9 33e-4
VS21 0 s21 0
L21 s21 10 22e-2
VS22 18 s22 0
C22 s22 0 10e-4
VS23 4 s23 0
R23 s23 2 39e0
VS24 20 s24 0
C24 s24 3 33e-5
VS25 10 s25 0
V25 e25 s25 DC 0 AC 33e-1 0
RI25 e25 7 12e-2
VS26 0 s26 0
V26 e26 s26 DC 0 AC 12e1 180
RI26 e26 16 47e-2
VS27 25 s27 0
V27 e27 s27 DC 0 AC 39e-1 120
RI27 e27 23 15e-3
VS28 25 s28 0
L28 s28 9 56e-2
VS29 26 s29 0
L29 s29 10 47e-5
VS30 21 s30 0
R30 s30 12 68e2
VS31 10 s31 0
R31 s31 23 15e2
VS32 14 s32 0
R32 s32 21 18e1
VS33 1 s33 0
C33 s33 17 33e-6
.control
set numdgt=17
ac lin 1 60 60
print v(1) v(2) v(3) v(4) v(5) v(6) v(7) v(8) v(9) v(10)
print v(11) v(12) v(13) v(14) v(15) v(16) v(17) v(18) v(19) v(20)
print v(21) v(22) v(23) v(24) v(25) v(26)
print i(vs0) i(vs1) i(vs2) i(vs3) i(vs4) i(vs5) i(vs6) i(vs7) i(vs8) i(vs9)
print i(vs10) i(vs11) i(vs12) i(vs13) i(vs14) i(vs15) i(vs16) i(vs17) i(vs18) i(vs19)
print i(vs20) i(vs21) i(vs22) i(vs23) i(vs24) i(vs25) i(vs26) i(vs27) i(vs28) i(vs29)
print i(vs30) i(vs31) i(vs32) i(vs33)
.endc
.end
