controls oracle ac-0119
* Generated (plan F2.7, ADR 0012): do not edit; regenerate with `pnpm sim oracle regen`. ac seed 20261031 index 119 nodes 14 elements 21
.options sparse gmin=1e-12 noopac
RG1 1 0 1000000000000
RG2 2 0 1000000000000
RG3 3 0 1000000000000
RG4 4 0 1000000000000
RG5 5 0 1000000000000
RG6 6 0 1000000000000
RG7 7 0 1000000000000
RG8 8 0 1000000000000
RG9 9 0 1000000000000
RG10 10 0 1000000000000
RG11 11 0 1000000000000
RG12 12 0 1000000000000
RG13 13 0 1000000000000
VS0 0 s0 0
L0 s0 4 82e-4
VS1 10 s1 0
L1 s1 11 39e-3
VS2 0 s2 0
V2 e2 s2 DC 0 AC 18e-1 0
RI2 e2 7 22e-2
VS3 6 s3 0
L3 s3 1 15e-3
VS4 5 s4 0
L4 s4 2 82e-4
VS5 6 s5 0
V5 e5 s5 DC 0 AC 56e0 180
RI5 e5 13 22e-1
VS6 11 s6 0
V6 e6 s6 DC 0 AC 22e0 180
RI6 e6 13 56e-3
VS7 4 s7 0
R7 s7 2 18e-1
VS8 8 s8 0
V8 e8 s8 DC 0 AC 22e1 180
RI8 e8 9 56e-1
VS9 13 s9 0
R9 s9 4 10e2
VS10 0 s10 0
V10 e10 s10 DC 0 AC 82e-1 0
RI10 e10 8 18e-1
VS11 0 s11 0
C11 s11 9 82e-5
VS12 7 s12 0
R12 s12 6 47e2
VS13 12 s13 0
R13 s13 2 33e2
VS14 5 s14 0
R14 s14 13 12e2
VS15 9 s15 0
V15 e15 s15 DC 0 AC 22e1 0
RI15 e15 1 47e-1
VS16 11 s16 0
R16 s16 5 82e0
VS17 3 s17 0
R17 s17 8 18e0
VS18 7 s18 0
R18 s18 0 15e0
VS19 0 s19 0
V19 e19 s19 DC 0 AC 27e1 -120
RI19 e19 5 47e-3
VS20 1 s20 0
R20 s20 4 47e0
.control
set numdgt=17
ac lin 1 60 60
print v(1) v(2) v(3) v(4) v(5) v(6) v(7) v(8) v(9) v(10)
print v(11) v(12) v(13)
print i(vs0) i(vs1) i(vs2) i(vs3) i(vs4) i(vs5) i(vs6) i(vs7) i(vs8) i(vs9)
print i(vs10) i(vs11) i(vs12) i(vs13) i(vs14) i(vs15) i(vs16) i(vs17) i(vs18) i(vs19)
print i(vs20)
.endc
.end
