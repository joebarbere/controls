controls oracle ac-0119
* Generated (plan F2.7, ADR 0012): do not edit; regenerate with `pnpm sim oracle regen`. ac seed 20261031 index 119 nodes 14 elements 23
.options sparse gmin=1e-12 noopac
RG1 1 0 1000000000000
RG2 2 0 1000000000000
RG3 3 0 1000000000000
RG4 4 0 1000000000000
RG5 5 0 1000000000000
RG6 6 0 1000000000000
RG7 7 0 1000000000000
RG8 8 0 1000000000000
RG9 9 0 1000000000000
RG10 10 0 1000000000000
RG11 11 0 1000000000000
RG12 12 0 1000000000000
RG13 13 0 1000000000000
VS0 0 s0 0
V0 e0 s0 DC 0 AC 22e0 180
RI0 e0 m0 56e-3
LI0 m0 13 68e-6
VS1 11 s1 0
R1 s1 4 47e0
VS2 6 s2 0
V2 e2 s2 DC 0 AC 56e0 180
RI2 e2 m2 22e-1
LI2 m2 13 15e-5
VS3 9 s3 0
V3 e3 s3 DC 0 AC 22e1 0
RI3 e3 m3 47e-1
LI3 m3 11 82e-6
VS4 3 s4 0
R4 s4 8 18e0
VS5 1 s5 0
C5 s5 9 82e-5
VS6 3 s6 0
R6 s6 12 12e1
VS7 1 s7 0
V7 e7 s7 DC 0 AC 82e-1 0
RI7 e7 m7 18e-1
LI7 m7 8 10e-6
VS8 13 s8 0
R8 s8 4 10e2
VS9 12 s9 0
R9 s9 2 33e2
VS10 0 s10 0
R10 s10 5 82e0
VS11 1 s11 0
L11 s11 4 82e-4
VS12 10 s12 0
L12 s12 0 39e-3
VS13 6 s13 0
L13 s13 11 15e-3
VS14 5 s14 0
L14 s14 2 82e-4
VS15 7 s15 0
R15 s15 6 47e2
VS16 1 s16 0
V16 e16 s16 DC 0 AC 18e-1 0
RI16 e16 m16 22e-2
LI16 m16 7 15e-5
VS17 4 s17 0
R17 s17 2 18e-1
VS18 7 s18 0
R18 s18 1 15e0
VS19 1 s19 0
V19 e19 s19 DC 0 AC 27e1 -120
RI19 e19 m19 47e-3
LI19 m19 5 27e-6
VS20 5 s20 0
R20 s20 13 12e2
VS21 8 s21 0
V21 e21 s21 DC 0 AC 22e1 180
RI21 e21 9 56e-1
VS22 8 s22 0
C22 s22 10 10e-6
.control
set numdgt=17
ac lin 1 60 60
print v(1) v(2) v(3) v(4) v(5) v(6) v(7) v(8) v(9) v(10)
print v(11) v(12) v(13)
print i(vs0) i(vs1) i(vs2) i(vs3) i(vs4) i(vs5) i(vs6) i(vs7) i(vs8) i(vs9)
print i(vs10) i(vs11) i(vs12) i(vs13) i(vs14) i(vs15) i(vs16) i(vs17) i(vs18) i(vs19)
print i(vs20) i(vs21) i(vs22)
.endc
.end
