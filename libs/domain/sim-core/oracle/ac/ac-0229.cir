controls oracle ac-0229
* Generated (plan F2.7, ADR 0012): do not edit; regenerate with `pnpm sim oracle regen`. ac seed 20261031 index 229 nodes 28 elements 37
.options sparse gmin=1e-12 noopac
RG1 1 0 1000000000000
RG2 2 0 1000000000000
RG3 3 0 1000000000000
RG4 4 0 1000000000000
RG5 5 0 1000000000000
RG6 6 0 1000000000000
RG7 7 0 1000000000000
RG8 8 0 1000000000000
RG9 9 0 1000000000000
RG10 10 0 1000000000000
RG11 11 0 1000000000000
RG12 12 0 1000000000000
RG13 13 0 1000000000000
RG14 14 0 1000000000000
RG15 15 0 1000000000000
RG16 16 0 1000000000000
RG17 17 0 1000000000000
RG18 18 0 1000000000000
RG19 19 0 1000000000000
RG20 20 0 1000000000000
RG21 21 0 1000000000000
RG22 22 0 1000000000000
RG23 23 0 1000000000000
RG24 24 0 1000000000000
RG25 25 0 1000000000000
RG26 26 0 1000000000000
RG27 27 0 1000000000000
VS0 0 s0 0
V0 e0 s0 DC 0 AC 15e0 120
RI0 e0 17 12e-1
VS1 25 s1 0
R1 s1 7 68e3
VS2 9 s2 0
R2 s2 2 33e1
VS3 12 s3 0
R3 s3 23 33e3
VS4 2 s4 0
R4 s4 20 15e3
VS5 3 s5 0
V5 e5 s5 DC 0 AC 15e-1 0
RI5 e5 4 18e-1
VS6 18 s6 0
V6 e6 s6 DC 0 AC 10e0 180
RI6 e6 25 15e-2
VS7 12 s7 0
C7 s7 6 47e-6
VS8 1 s8 0
L8 s8 25 10e-4
VS9 19 s9 0
V9 e9 s9 DC 0 AC 68e0 0
RI9 e9 14 56e-1
VS10 26 s10 0
R10 s10 18 39e3
VS11 4 s11 0
L11 s11 8 18e-4
VS12 12 s12 0
C12 s12 25 39e-4
VS13 20 s13 0
C13 s13 24 12e-4
VS14 13 s14 0
C14 s14 16 68e-5
VS15 12 s15 0
L15 s15 3 12e-2
VS16 25 s16 0
R16 s16 23 47e-2
VS17 17 s17 0
R17 s17 9 39e0
VS18 8 s18 0
L18 s18 6 10e-2
VS19 25 s19 0
C19 s19 11 68e-5
VS20 21 s20 0
L20 s20 8 33e-4
VS21 12 s21 0
C21 s21 9 33e-5
VS22 7 s22 0
R22 s22 2 12e1
VS23 0 s23 0
R23 s23 16 82e-2
VS24 6 s24 0
R24 s24 15 18e2
VS25 12 s25 0
V25 e25 s25 DC 0 AC 12e-1 180
RI25 e25 0 39e-3
VS26 25 s26 0
L26 s26 10 82e-2
VS27 23 s27 0
R27 s27 22 33e0
VS28 23 s28 0
R28 s28 8 82e-1
VS29 1 s29 0
R29 s29 8 10e0
VS30 11 s30 0
C30 s30 13 27e-6
VS31 12 s31 0
C31 s31 14 39e-6
VS32 27 s32 0
C32 s32 22 56e-5
VS33 19 s33 0
C33 s33 10 56e-7
VS34 5 s34 0
C34 s34 7 82e-6
VS35 9 s35 0
V35 e35 s35 DC 0 AC 27e1 0
RI35 e35 19 82e-2
VS36 25 s36 0
C36 s36 3 12e-6
.control
set numdgt=17
ac lin 1 60 60
print v(1) v(2) v(3) v(4) v(5) v(6) v(7) v(8) v(9) v(10)
print v(11) v(12) v(13) v(14) v(15) v(16) v(17) v(18) v(19) v(20)
print v(21) v(22) v(23) v(24) v(25) v(26) v(27)
print i(vs0) i(vs1) i(vs2) i(vs3) i(vs4) i(vs5) i(vs6) i(vs7) i(vs8) i(vs9)
print i(vs10) i(vs11) i(vs12) i(vs13) i(vs14) i(vs15) i(vs16) i(vs17) i(vs18) i(vs19)
print i(vs20) i(vs21) i(vs22) i(vs23) i(vs24) i(vs25) i(vs26) i(vs27) i(vs28) i(vs29)
print i(vs30) i(vs31) i(vs32) i(vs33) i(vs34) i(vs35) i(vs36)
.endc
.end
