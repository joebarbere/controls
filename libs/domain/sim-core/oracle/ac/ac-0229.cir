controls oracle ac-0229
* Generated (plan F2.7, ADR 0012): do not edit; regenerate with `pnpm sim oracle regen`. ac seed 20261031 index 229 nodes 28 elements 43
.options sparse gmin=1e-12 noopac
RG1 1 0 1000000000000
RG2 2 0 1000000000000
RG3 3 0 1000000000000
RG4 4 0 1000000000000
RG5 5 0 1000000000000
RG6 6 0 1000000000000
RG7 7 0 1000000000000
RG8 8 0 1000000000000
RG9 9 0 1000000000000
RG10 10 0 1000000000000
RG11 11 0 1000000000000
RG12 12 0 1000000000000
RG13 13 0 1000000000000
RG14 14 0 1000000000000
RG15 15 0 1000000000000
RG16 16 0 1000000000000
RG17 17 0 1000000000000
RG18 18 0 1000000000000
RG19 19 0 1000000000000
RG20 20 0 1000000000000
RG21 21 0 1000000000000
RG22 22 0 1000000000000
RG23 23 0 1000000000000
RG24 24 0 1000000000000
RG25 25 0 1000000000000
RG26 26 0 1000000000000
RG27 27 0 1000000000000
VS0 25 s0 0
R0 s0 23 47e-2
VS1 0 s1 0
V1 e1 s1 DC 0 AC 18e-1 180
RI1 e1 27 68e-1
VS2 9 s2 0
R2 s2 2 33e1
VS3 7 s3 0
R3 s3 2 12e1
VS4 5 s4 0
R4 s4 16 82e-2
VS5 12 s5 0
V5 e5 s5 DC 0 AC 12e-1 180
RI5 e5 m5 39e-3
LI5 m5 5 15e-7
VS6 1 s6 0
C6 s6 15 27e-7
VS7 26 s7 0
L7 s7 23 56e-3
VS8 0 s8 0
R8 s8 3 68e2
VS9 25 s9 0
C9 s9 3 12e-6
VS10 21 s10 0
R10 s10 17 15e2
VS11 12 s11 0
C11 s11 9 33e-5
VS12 9 s12 0
V12 e12 s12 DC 0 AC 27e1 0
RI12 e12 19 82e-2
VS13 12 s13 0
C13 s13 6 47e-6
VS14 21 s14 0
L14 s14 8 33e-4
VS15 23 s15 0
R15 s15 22 33e0
VS16 23 s16 0
R16 s16 8 82e-1
VS17 13 s17 0
C17 s17 16 68e-5
VS18 25 s18 0
C18 s18 11 68e-5
VS19 19 s19 0
V19 e19 s19 DC 0 AC 68e0 0
RI19 e19 m19 56e-1
LI19 m19 14 27e-7
VS20 1 s20 0
L20 s20 25 10e-4
VS21 5 s21 0
V21 e21 s21 DC 0 AC 15e0 120
RI21 e21 m21 12e-1
LI21 m21 17 22e-7
VS22 2 s22 0
R22 s22 20 15e3
VS23 25 s23 0
L23 s23 10 82e-2
VS24 26 s24 0
R24 s24 18 39e3
VS25 17 s25 0
R25 s25 9 39e0
VS26 12 s26 0
R26 s26 23 33e3
VS27 25 s27 0
R27 s27 7 68e3
VS28 0 s28 0
C28 s28 7 82e-6
VS29 20 s29 0
C29 s29 24 12e-4
VS30 8 s30 0
L30 s30 6 10e-2
VS31 18 s31 0
V31 e31 s31 DC 0 AC 10e0 180
RI31 e31 m31 15e-2
LI31 m31 25 33e-5
VS32 4 s32 0
L32 s32 8 18e-4
VS33 19 s33 0
C33 s33 10 56e-7
VS34 11 s34 0
C34 s34 13 27e-6
VS35 6 s35 0
R35 s35 15 18e2
VS36 12 s36 0
C36 s36 14 39e-6
VS37 7 s37 0
R37 s37 24 12e2
VS38 12 s38 0
C38 s38 25 39e-4
VS39 1 s39 0
R39 s39 8 10e0
VS40 3 s40 0
V40 e40 s40 DC 0 AC 15e-1 0
RI40 e40 4 18e-1
VS41 27 s41 0
C41 s41 22 56e-5
VS42 12 s42 0
L42 s42 3 12e-2
.control
set numdgt=17
ac lin 1 60 60
print v(1) v(2) v(3) v(4) v(5) v(6) v(7) v(8) v(9) v(10)
print v(11) v(12) v(13) v(14) v(15) v(16) v(17) v(18) v(19) v(20)
print v(21) v(22) v(23) v(24) v(25) v(26) v(27)
print i(vs0) i(vs1) i(vs2) i(vs3) i(vs4) i(vs5) i(vs6) i(vs7) i(vs8) i(vs9)
print i(vs10) i(vs11) i(vs12) i(vs13) i(vs14) i(vs15) i(vs16) i(vs17) i(vs18) i(vs19)
print i(vs20) i(vs21) i(vs22) i(vs23) i(vs24) i(vs25) i(vs26) i(vs27) i(vs28) i(vs29)
print i(vs30) i(vs31) i(vs32) i(vs33) i(vs34) i(vs35) i(vs36) i(vs37) i(vs38) i(vs39)
print i(vs40) i(vs41) i(vs42)
.endc
.end
