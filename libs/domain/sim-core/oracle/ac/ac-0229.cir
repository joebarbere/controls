controls oracle ac-0229
* Generated (plan F2.7, ADR 0012): do not edit; regenerate with `pnpm sim oracle regen`. ac seed 20261031 index 229 nodes 28 elements 51
.options sparse gmin=1e-12 noopac
RG1 1 0 1000000000000
RG2 2 0 1000000000000
RG3 3 0 1000000000000
RG4 4 0 1000000000000
RG5 5 0 1000000000000
RG6 6 0 1000000000000
RG7 7 0 1000000000000
RG8 8 0 1000000000000
RG9 9 0 1000000000000
RG10 10 0 1000000000000
RG11 11 0 1000000000000
RG12 12 0 1000000000000
RG13 13 0 1000000000000
RG14 14 0 1000000000000
RG15 15 0 1000000000000
RG16 16 0 1000000000000
RG17 17 0 1000000000000
RG18 18 0 1000000000000
RG19 19 0 1000000000000
RG20 20 0 1000000000000
RG21 21 0 1000000000000
RG22 22 0 1000000000000
RG23 23 0 1000000000000
RG24 24 0 1000000000000
RG25 25 0 1000000000000
RG26 26 0 1000000000000
RG27 27 0 1000000000000
VS0 19 s0 0
C0 s0 12 82e-5
VS1 3 s1 0
C1 s1 16 12e-5
VS2 0 s2 0
V2 e2 s2 DC 0 AC 22e0 180
RI2 e2 m2 68e-1
LI2 m2 25 27e-6
VS3 6 s3 0
V3 e3 s3 DC 0 AC 27e1 -120
RI3 e3 m3 68e-3
LI3 m3 25 47e-6
VS4 14 s4 0
L4 s4 6 27e-4
VS5 3 s5 0
R5 s5 14 10e-1
VS6 13 s6 0
R6 s6 21 12e-2
VS7 14 s7 0
R7 s7 5 10e-1
VS8 7 s8 0
R8 s8 22 68e1
VS9 25 s9 0
V9 e9 s9 DC 0 AC 15e-1 120
RI9 e9 12 33e-3
VS10 1 s10 0
C10 s10 16 27e-5
VS11 16 s11 0
L11 s11 17 68e-4
VS12 19 s12 0
V12 e12 s12 DC 0 AC 47e1 0
RI12 e12 m12 33e-2
LI12 m12 0 56e-5
VS13 18 s13 0
V13 e13 s13 DC 0 AC 18e-1 180
RI13 e13 4 22e-3
VS14 11 s14 0
R14 s14 12 15e-2
VS15 1 s15 0
C15 s15 9 33e-5
VS16 25 s16 0
C16 s16 4 10e-5
VS17 13 s17 0
R17 s17 23 39e0
VS18 13 s18 0
R18 s18 22 39e2
VS19 15 s19 0
R19 s19 19 18e1
VS20 24 s20 0
V20 e20 s20 DC 0 AC 10e-1 0
RI20 e20 17 68e-3
VS21 17 s21 0
C21 s21 20 15e-7
VS22 25 s22 0
R22 s22 7 82e-1
VS23 12 s23 0
V23 e23 s23 DC 0 AC 12e-1 180
RI23 e23 m23 39e-3
LI23 m23 3 68e-7
VS24 26 s24 0
L24 s24 27 82e-4
VS25 18 s25 0
R25 s25 25 12e1
VS26 11 s26 0
V26 e26 s26 DC 0 AC 27e-1 120
RI26 e26 m26 10e-1
LI26 m26 20 12e-6
VS27 12 s27 0
R27 s27 9 68e-1
VS28 10 s28 0
L28 s28 9 27e-3
VS29 21 s29 0
C29 s29 22 82e-4
VS30 24 s30 0
C30 s30 26 33e-6
VS31 7 s31 0
L31 s31 19 18e-3
VS32 18 s32 0
V32 e32 s32 DC 0 AC 68e1 -120
RI32 e32 m32 82e-2
LI32 m32 15 12e-7
VS33 2 s33 0
C33 s33 5 39e-7
VS34 8 s34 0
R34 s34 23 22e1
VS35 6 s35 0
R35 s35 18 27e-2
VS36 17 s36 0
V36 e36 s36 DC 0 AC 68e0 0
RI36 e36 9 68e-1
VS37 18 s37 0
R37 s37 9 18e-2
VS38 8 s38 0
V38 e38 s38 DC 0 AC 39e-1 120
RI38 e38 25 15e-1
VS39 25 s39 0
V39 e39 s39 DC 0 AC 33e-1 -120
RI39 e39 m39 15e-2
LI39 m39 7 56e-6
VS40 26 s40 0
R40 s40 13 10e-1
VS41 23 s41 0
C41 s41 16 56e-7
VS42 16 s42 0
R42 s42 19 82e0
VS43 16 s43 0
L43 s43 2 15e-3
VS44 7 s44 0
C44 s44 18 27e-4
VS45 3 s45 0
V45 e45 s45 DC 0 AC 15e0 120
RI45 e45 m45 12e-1
LI45 m45 17 68e-6
VS46 23 s46 0
L46 s46 25 39e-5
VS47 10 s47 0
R47 s47 27 39e-1
VS48 10 s48 0
C48 s48 20 39e-5
VS49 2 s49 0
R49 s49 19 27e-1
VS50 12 s50 0
L50 s50 26 56e-5
.control
set numdgt=17
ac lin 1 60 60
print v(1) v(2) v(3) v(4) v(5) v(6) v(7) v(8) v(9) v(10)
print v(11) v(12) v(13) v(14) v(15) v(16) v(17) v(18) v(19) v(20)
print v(21) v(22) v(23) v(24) v(25) v(26) v(27)
print i(vs0) i(vs1) i(vs2) i(vs3) i(vs4) i(vs5) i(vs6) i(vs7) i(vs8) i(vs9)
print i(vs10) i(vs11) i(vs12) i(vs13) i(vs14) i(vs15) i(vs16) i(vs17) i(vs18) i(vs19)
print i(vs20) i(vs21) i(vs22) i(vs23) i(vs24) i(vs25) i(vs26) i(vs27) i(vs28) i(vs29)
print i(vs30) i(vs31) i(vs32) i(vs33) i(vs34) i(vs35) i(vs36) i(vs37) i(vs38) i(vs39)
print i(vs40) i(vs41) i(vs42) i(vs43) i(vs44) i(vs45) i(vs46) i(vs47) i(vs48) i(vs49)
print i(vs50)
.endc
.end
