controls oracle ac-0383
* Generated (plan F2.7, ADR 0012): do not edit; regenerate with `pnpm sim oracle regen`. ac seed 20261031 index 383 nodes 8 elements 12
.options sparse gmin=1e-12 noopac
RG1 1 0 1000000000000
RG2 2 0 1000000000000
RG3 3 0 1000000000000
RG4 4 0 1000000000000
RG5 5 0 1000000000000
RG6 6 0 1000000000000
RG7 7 0 1000000000000
VS0 5 s0 0
C0 s0 1 33e-5
VS1 3 s1 0
C1 s1 4 27e-6
VS2 0 s2 0
R2 s2 6 82e0
VS3 0 s3 0
V3 e3 s3 DC 0 AC 82e-1 -120
RI3 e3 2 18e-3
VS4 1 s4 0
R4 s4 3 10e0
VS5 6 s5 0
R5 s5 5 27e2
VS6 0 s6 0
R6 s6 6 27e1
VS7 5 s7 0
C7 s7 7 12e-4
VS8 6 s8 0
R8 s8 5 68e-2
VS9 3 s9 0
L9 s9 6 47e-3
VS10 2 s10 0
C10 s10 4 12e-4
VS11 1 s11 0
V11 e11 s11 DC 0 AC 82e1 0
RI11 e11 m11 27e-3
LI11 m11 7 12e-7
.control
set numdgt=17
ac lin 1 60 60
print v(1) v(2) v(3) v(4) v(5) v(6) v(7)
print i(vs0) i(vs1) i(vs2) i(vs3) i(vs4) i(vs5) i(vs6) i(vs7) i(vs8) i(vs9)
print i(vs10) i(vs11)
.endc
.end
