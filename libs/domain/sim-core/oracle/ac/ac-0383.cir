controls oracle ac-0383
* Generated (plan F2.7, ADR 0012): do not edit; regenerate with `pnpm sim oracle regen`. ac seed 20261031 index 383 nodes 8 elements 12
.options sparse gmin=1e-12 noopac
RG1 1 0 1000000000000
RG2 2 0 1000000000000
RG3 3 0 1000000000000
RG4 4 0 1000000000000
RG5 5 0 1000000000000
RG6 6 0 1000000000000
RG7 7 0 1000000000000
VS0 0 s0 0
V0 e0 s0 DC 0 AC 27e1 0
RI0 e0 3 82e-1
VS1 7 s1 0
R1 s1 5 22e3
VS2 5 s2 0
R2 s2 4 10e1
VS3 3 s3 0
C3 s3 1 33e-5
VS4 1 s4 0
R4 s4 7 68e-1
VS5 6 s5 0
R5 s5 3 68e-2
VS6 0 s6 0
L6 s6 6 47e-3
VS7 5 s7 0
V7 e7 s7 DC 0 AC 27e0 180
RI7 e7 3 15e-3
VS8 5 s8 0
R8 s8 6 27e1
VS9 5 s9 0
V9 e9 s9 DC 0 AC 82e-1 -120
RI9 e9 2 18e-3
VS10 1 s10 0
R10 s10 7 68e1
VS11 0 s11 0
C11 s11 4 27e-6
.control
set numdgt=17
ac lin 1 60 60
print v(1) v(2) v(3) v(4) v(5) v(6) v(7)
print i(vs0) i(vs1) i(vs2) i(vs3) i(vs4) i(vs5) i(vs6) i(vs7) i(vs8) i(vs9)
print i(vs10) i(vs11)
.endc
.end
