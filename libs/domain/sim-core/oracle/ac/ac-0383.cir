controls oracle ac-0383
* Generated (plan F2.7, ADR 0012): do not edit; regenerate with `pnpm sim oracle regen`. ac seed 20261031 index 383 nodes 8 elements 13
.options sparse gmin=1e-12 noopac
RG1 1 0 1000000000000
RG2 2 0 1000000000000
RG3 3 0 1000000000000
RG4 4 0 1000000000000
RG5 5 0 1000000000000
RG6 6 0 1000000000000
RG7 7 0 1000000000000
VS0 5 s0 0
C0 s0 1 33e-5
VS1 6 s1 0
R1 s1 5 68e-2
VS2 0 s2 0
V2 e2 s2 DC 0 AC 82e-1 -120
RI2 e2 n2 18e-3
H2 n2 h2 VS3 15e-4
ED2 h2 2 d2 0 10e-7
F2 0 d2 VS3 1
LD2 d2 0 1
VS3 3 s3 0
V3 e3 s3 DC 0 AC 27e1 0
RI3 e3 m3 82e-1
LI3 m3 n3 56e-7
H3 n3 h3 VS2 15e-4
ED3 h3 5 d3 0 10e-7
F3 0 d3 VS2 1
LD3 d3 0 1
VS4 3 s4 0
C4 s4 4 27e-6
VS5 0 s5 0
V5 e5 s5 DC 0 AC 27e0 180
RI5 e5 m5 15e-3
LI5 m5 5 18e-5
VS6 0 s6 0
R6 s6 6 27e1
VS7 1 s7 0
R7 s7 7 68e1
VS8 1 s8 0
R8 s8 7 68e-1
VS9 3 s9 0
L9 s9 6 47e-3
VS10 7 s10 0
R10 s10 0 22e3
VS11 2 s11 0
C11 s11 4 33e-5
VS12 0 s12 0
R12 s12 4 10e1
.control
set numdgt=17
ac lin 1 60 60
print v(1) v(2) v(3) v(4) v(5) v(6) v(7)
print i(vs0) i(vs1) i(vs2) i(vs3) i(vs4) i(vs5) i(vs6) i(vs7) i(vs8) i(vs9)
print i(vs10) i(vs11) i(vs12)
.endc
.end
