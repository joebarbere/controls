controls oracle ac-0144
* Generated (plan F2.7, ADR 0012): do not edit; regenerate with `pnpm sim oracle regen`. ac seed 20261031 index 144 nodes 16 elements 24
.options sparse gmin=1e-12 noopac
RG1 1 0 1000000000000
RG2 2 0 1000000000000
RG3 3 0 1000000000000
RG4 4 0 1000000000000
RG5 5 0 1000000000000
RG6 6 0 1000000000000
RG7 7 0 1000000000000
RG8 8 0 1000000000000
RG9 9 0 1000000000000
RG10 10 0 1000000000000
RG11 11 0 1000000000000
RG12 12 0 1000000000000
RG13 13 0 1000000000000
RG14 14 0 1000000000000
RG15 15 0 1000000000000
VS0 3 s0 0
L0 s0 7 18e-4
VS1 0 s1 0
V1 e1 s1 DC 0 AC 56e-1 -120
RI1 e1 3 33e-2
VS2 0 s2 0
L2 s2 2 82e-5
VS3 12 s3 0
R3 s3 14 27e-2
VS4 11 s4 0
R4 s4 4 27e-1
VS5 8 s5 0
L5 s5 9 12e-4
VS6 5 s6 0
R6 s6 6 22e0
VS7 14 s7 0
L7 s7 15 27e-3
VS8 12 s8 0
R8 s8 14 39e2
VS9 2 s9 0
C9 s9 10 22e-4
VS10 5 s10 0
V10 e10 s10 DC 0 AC 12e1 0
RI10 e10 0 39e-2
VS11 13 s11 0
V11 e11 s11 DC 0 AC 12e0 180
RI11 e11 10 10e-3
VS12 10 s12 0
C12 s12 8 39e-5
VS13 0 s13 0
R13 s13 4 10e1
VS14 10 s14 0
R14 s14 14 56e3
VS15 7 s15 0
R15 s15 6 68e0
VS16 1 s16 0
V16 e16 s16 DC 0 AC 39e1 -120
RI16 e16 2 10e-3
VS17 15 s17 0
R17 s17 12 27e3
VS18 13 s18 0
L18 s18 11 47e-3
VS19 15 s19 0
V19 e19 s19 DC 0 AC 56e0 -120
RI19 e19 m19 27e-3
LI19 m19 9 18e-6
VS20 4 s20 0
C20 s20 10 39e-6
VS21 15 s21 0
R21 s21 1 82e0
VS22 7 s22 0
C22 s22 4 82e-4
VS23 13 s23 0
V23 e23 s23 DC 0 AC 82e1 -120
RI23 e23 m23 82e-1
LI23 m23 10 10e-5
.control
set numdgt=17
ac lin 1 60 60
print v(1) v(2) v(3) v(4) v(5) v(6) v(7) v(8) v(9) v(10)
print v(11) v(12) v(13) v(14) v(15)
print i(vs0) i(vs1) i(vs2) i(vs3) i(vs4) i(vs5) i(vs6) i(vs7) i(vs8) i(vs9)
print i(vs10) i(vs11) i(vs12) i(vs13) i(vs14) i(vs15) i(vs16) i(vs17) i(vs18) i(vs19)
print i(vs20) i(vs21) i(vs22) i(vs23)
.endc
.end
