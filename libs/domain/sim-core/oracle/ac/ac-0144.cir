controls oracle ac-0144
* Generated (plan F2.7, ADR 0012): do not edit; regenerate with `pnpm sim oracle regen`. ac seed 20261031 index 144 nodes 16 elements 31
.options sparse gmin=1e-12 noopac
RG1 1 0 1000000000000
RG2 2 0 1000000000000
RG3 3 0 1000000000000
RG4 4 0 1000000000000
RG5 5 0 1000000000000
RG6 6 0 1000000000000
RG7 7 0 1000000000000
RG8 8 0 1000000000000
RG9 9 0 1000000000000
RG10 10 0 1000000000000
RG11 11 0 1000000000000
RG12 12 0 1000000000000
RG13 13 0 1000000000000
RG14 14 0 1000000000000
RG15 15 0 1000000000000
VS0 15 s0 0
R0 s0 3 82e3
VS1 15 s1 0
L1 s1 12 22e-3
VS2 8 s2 0
C2 s2 12 47e-4
VS3 15 s3 0
R3 s3 12 56e1
VS4 0 s4 0
V4 e4 s4 DC 0 AC 33e0 120
RI4 e4 12 68e-3
VS5 6 s5 0
C5 s5 3 82e-5
VS6 3 s6 0
R6 s6 6 12e2
VS7 14 s7 0
L7 s7 15 27e-3
VS8 6 s8 0
L8 s8 10 27e-2
VS9 13 s9 0
C9 s9 4 39e-4
VS10 7 s10 0
R10 s10 6 68e0
VS11 7 s11 0
C11 s11 13 82e-4
VS12 0 s12 0
R12 s12 14 68e2
VS13 3 s13 0
L13 s13 4 56e-2
VS14 6 s14 0
V14 e14 s14 DC 0 AC 33e1 180
RI14 e14 5 12e-2
VS15 13 s15 0
C15 s15 10 39e-6
VS16 11 s16 0
R16 s16 13 27e-1
VS17 11 s17 0
R17 s17 14 82e2
VS18 10 s18 0
L18 s18 0 22e-4
VS19 7 s19 0
C19 s19 5 22e-7
VS20 15 s20 0
V20 e20 s20 DC 0 AC 15e-1 120
RI20 e20 3 56e-1
VS21 8 s21 0
V21 e21 s21 DC 0 AC 15e0 180
RI21 e21 9 15e-1
VS22 1 s22 0
V22 e22 s22 DC 0 AC 39e1 -120
RI22 e22 2 10e-3
VS23 15 s23 0
R23 s23 12 27e3
VS24 2 s24 0
C24 s24 10 22e-4
VS25 14 s25 0
V25 e25 s25 DC 0 AC 27e1 0
RI25 e25 5 47e-3
VS26 4 s26 0
V26 e26 s26 DC 0 AC 56e-1 -120
RI26 e26 8 33e-2
VS27 4 s27 0
R27 s27 13 10e1
VS28 8 s28 0
L28 s28 14 39e-4
VS29 15 s29 0
C29 s29 13 56e-4
VS30 10 s30 0
R30 s30 14 56e3
.control
set numdgt=17
ac lin 1 60 60
print v(1) v(2) v(3) v(4) v(5) v(6) v(7) v(8) v(9) v(10)
print v(11) v(12) v(13) v(14) v(15)
print i(vs0) i(vs1) i(vs2) i(vs3) i(vs4) i(vs5) i(vs6) i(vs7) i(vs8) i(vs9)
print i(vs10) i(vs11) i(vs12) i(vs13) i(vs14) i(vs15) i(vs16) i(vs17) i(vs18) i(vs19)
print i(vs20) i(vs21) i(vs22) i(vs23) i(vs24) i(vs25) i(vs26) i(vs27) i(vs28) i(vs29)
print i(vs30)
.endc
.end
