controls oracle ac-0144
* Generated (plan F2.7, ADR 0012): do not edit; regenerate with `pnpm sim oracle regen`. ac seed 20261031 index 144 nodes 16 elements 33
.options sparse gmin=1e-12 noopac
RG1 1 0 1000000000000
RG2 2 0 1000000000000
RG3 3 0 1000000000000
RG4 4 0 1000000000000
RG5 5 0 1000000000000
RG6 6 0 1000000000000
RG7 7 0 1000000000000
RG8 8 0 1000000000000
RG9 9 0 1000000000000
RG10 10 0 1000000000000
RG11 11 0 1000000000000
RG12 12 0 1000000000000
RG13 13 0 1000000000000
RG14 14 0 1000000000000
RG15 15 0 1000000000000
VS0 0 s0 0
V0 e0 s0 DC 0 AC 27e1 0
RI0 e0 m0 47e-3
LI0 m0 5 82e-6
VS1 4 s1 0
R1 s1 14 10e1
VS2 13 s2 0
R2 s2 0 68e2
VS3 8 s3 0
L3 s3 0 39e-4
VS4 6 s4 0
C4 s4 3 82e-5
VS5 15 s5 0
C5 s5 14 56e-4
VS6 10 s6 0
R6 s6 0 56e3
VS7 15 s7 0
V7 e7 s7 DC 0 AC 15e-1 120
RI7 e7 m7 56e-1
LI7 m7 3 47e-7
VS8 15 s8 0
L8 s8 9 56e-5
VS9 8 s9 0
V9 e9 s9 DC 0 AC 15e0 180
RI9 e9 m9 15e-1
LI9 m9 9 10e-6
VS10 1 s10 0
V10 e10 s10 DC 0 AC 39e1 -120
RI10 e10 m10 10e-3
LI10 m10 2 82e-7
VS11 11 s11 0
R11 s11 0 82e2
VS12 15 s12 0
R12 s12 12 27e3
VS13 6 s13 0
L13 s13 10 27e-2
VS14 0 s14 0
L14 s14 15 27e-3
VS15 7 s15 0
C15 s15 14 82e-4
VS16 8 s16 0
C16 s16 12 47e-4
VS17 2 s17 0
C17 s17 10 22e-4
VS18 11 s18 0
R18 s18 14 27e-1
VS19 15 s19 0
R19 s19 3 82e3
VS20 15 s20 0
R20 s20 12 56e1
VS21 6 s21 0
V21 e21 s21 DC 0 AC 33e1 180
RI21 e21 m21 12e-2
LI21 m21 5 12e-6
VS22 4 s22 0
V22 e22 s22 DC 0 AC 56e-1 -120
RI22 e22 m22 33e-2
LI22 m22 8 10e-7
VS23 7 s23 0
C23 s23 5 22e-7
VS24 7 s24 0
R24 s24 6 68e0
VS25 14 s25 0
C25 s25 4 39e-4
VS26 12 s26 0
R26 s26 1 33e1
VS27 3 s27 0
L27 s27 4 56e-2
VS28 14 s28 0
C28 s28 10 39e-6
VS29 15 s29 0
L29 s29 12 22e-3
VS30 3 s30 0
R30 s30 6 12e2
VS31 13 s31 0
V31 e31 s31 DC 0 AC 33e0 120
RI31 e31 12 68e-3
VS32 10 s32 0
L32 s32 13 22e-4
.control
set numdgt=17
ac lin 1 60 60
print v(1) v(2) v(3) v(4) v(5) v(6) v(7) v(8) v(9) v(10)
print v(11) v(12) v(13) v(14) v(15)
print i(vs0) i(vs1) i(vs2) i(vs3) i(vs4) i(vs5) i(vs6) i(vs7) i(vs8) i(vs9)
print i(vs10) i(vs11) i(vs12) i(vs13) i(vs14) i(vs15) i(vs16) i(vs17) i(vs18) i(vs19)
print i(vs20) i(vs21) i(vs22) i(vs23) i(vs24) i(vs25) i(vs26) i(vs27) i(vs28) i(vs29)
print i(vs30) i(vs31) i(vs32)
.endc
.end
