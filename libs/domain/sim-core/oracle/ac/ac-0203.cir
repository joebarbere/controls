controls oracle ac-0203
* Generated (plan F2.7, ADR 0012): do not edit; regenerate with `pnpm sim oracle regen`. ac seed 20261031 index 203 nodes 19 elements 30
.options sparse gmin=1e-12 noopac
RG1 1 0 1000000000000
RG2 2 0 1000000000000
RG3 3 0 1000000000000
RG4 4 0 1000000000000
RG5 5 0 1000000000000
RG6 6 0 1000000000000
RG7 7 0 1000000000000
RG8 8 0 1000000000000
RG9 9 0 1000000000000
RG10 10 0 1000000000000
RG11 11 0 1000000000000
RG12 12 0 1000000000000
RG13 13 0 1000000000000
RG14 14 0 1000000000000
RG15 15 0 1000000000000
RG16 16 0 1000000000000
RG17 17 0 1000000000000
RG18 18 0 1000000000000
VS0 0 s0 0
C0 s0 10 47e-7
VS1 2 s1 0
R1 s1 3 82e0
VS2 1 s2 0
R2 s2 4 39e2
VS3 6 s3 0
R3 s3 5 15e2
VS4 0 s4 0
R4 s4 16 10e-2
VS5 11 s5 0
L5 s5 2 39e-4
VS6 0 s6 0
V6 e6 s6 DC 0 AC 18e1 120
RI6 e6 1 56e-3
VS7 16 s7 0
V7 e7 s7 DC 0 AC 18e1 -120
RI7 e7 18 12e-1
VS8 0 s8 0
R8 s8 11 10e-1
VS9 3 s9 0
R9 s9 2 82e2
VS10 0 s10 0
L10 s10 12 82e-2
VS11 9 s11 0
V11 e11 s11 DC 0 AC 12e-1 0
RI11 e11 18 18e-3
VS12 11 s12 0
L12 s12 8 27e-5
VS13 1 s13 0
V13 e13 s13 DC 0 AC 15e0 0
RI13 e13 15 10e-2
VS14 7 s14 0
V14 e14 s14 DC 0 AC 47e-1 0
RI14 e14 13 56e-2
VS15 14 s15 0
R15 s15 16 39e3
VS16 3 s16 0
C16 s16 5 33e-5
VS17 3 s17 0
L17 s17 7 56e-5
VS18 3 s18 0
L18 s18 8 47e-5
VS19 1 s19 0
L19 s19 12 15e-2
VS20 3 s20 0
R20 s20 4 18e2
VS21 11 s21 0
L21 s21 2 33e-5
VS22 3 s22 0
R22 s22 4 22e0
VS23 6 s23 0
C23 s23 4 15e-4
VS24 2 s24 0
R24 s24 0 27e-2
VS25 0 s25 0
L25 s25 5 47e-2
VS26 1 s26 0
C26 s26 17 22e-7
VS27 9 s27 0
R27 s27 18 15e3
VS28 6 s28 0
V28 e28 s28 DC 0 AC 22e-1 0
RI28 e28 7 18e-1
VS29 8 s29 0
L29 s29 12 39e-5
.control
set numdgt=17
ac lin 1 60 60
print v(1) v(2) v(3) v(4) v(5) v(6) v(7) v(8) v(9) v(10)
print v(11) v(12) v(13) v(14) v(15) v(16) v(17) v(18)
print i(vs0) i(vs1) i(vs2) i(vs3) i(vs4) i(vs5) i(vs6) i(vs7) i(vs8) i(vs9)
print i(vs10) i(vs11) i(vs12) i(vs13) i(vs14) i(vs15) i(vs16) i(vs17) i(vs18) i(vs19)
print i(vs20) i(vs21) i(vs22) i(vs23) i(vs24) i(vs25) i(vs26) i(vs27) i(vs28) i(vs29)
.endc
.end
