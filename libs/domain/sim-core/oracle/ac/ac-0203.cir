controls oracle ac-0203
* Generated (plan F2.7, ADR 0012): do not edit; regenerate with `pnpm sim oracle regen`. ac seed 20261031 index 203 nodes 19 elements 40
.options sparse gmin=1e-12 noopac
RG1 1 0 1000000000000
RG2 2 0 1000000000000
RG3 3 0 1000000000000
RG4 4 0 1000000000000
RG5 5 0 1000000000000
RG6 6 0 1000000000000
RG7 7 0 1000000000000
RG8 8 0 1000000000000
RG9 9 0 1000000000000
RG10 10 0 1000000000000
RG11 11 0 1000000000000
RG12 12 0 1000000000000
RG13 13 0 1000000000000
RG14 14 0 1000000000000
RG15 15 0 1000000000000
RG16 16 0 1000000000000
RG17 17 0 1000000000000
RG18 18 0 1000000000000
VS0 17 s0 0
L0 s0 12 12e-3
VS1 2 s1 0
R1 s1 4 27e-2
VS2 3 s2 0
L2 s2 7 56e-5
VS3 18 s3 0
R3 s3 10 10e-1
VS4 17 s4 0
R4 s4 4 18e-2
VS5 2 s5 0
R5 s5 3 82e0
VS6 0 s6 0
V6 e6 s6 DC 0 AC 33e-1 -120
RI6 e6 m6 68e-2
LI6 m6 7 56e-5
VS7 4 s7 0
C7 s7 10 47e-7
VS8 1 s8 0
L8 s8 12 15e-2
VS9 7 s9 0
R9 s9 1 18e-1
VS10 1 s10 0
C10 s10 4 39e-7
VS11 6 s11 0
V11 e11 s11 DC 0 AC 10e0 -120
RI11 e11 m11 18e-2
LI11 m11 16 47e-7
VS12 11 s12 0
C12 s12 4 12e-4
VS13 6 s13 0
V13 e13 s13 DC 0 AC 22e-1 0
RI13 e13 7 18e-1
VS14 3 s14 0
L14 s14 8 47e-5
VS15 7 s15 0
V15 e15 s15 DC 0 AC 10e0 0
RI15 e15 15 39e-1
VS16 3 s16 0
R16 s16 2 82e2
VS17 6 s17 0
R17 s17 5 15e2
VS18 14 s18 0
L18 s18 9 12e-4
VS19 4 s19 0
R19 s19 11 10e-1
VS20 1 s20 0
R20 s20 0 39e2
VS21 4 s21 0
L21 s21 12 82e-2
VS22 6 s22 0
V22 e22 s22 DC 0 AC 47e-1 0
RI22 e22 5 56e-2
VS23 18 s23 0
R23 s23 10 15e3
VS24 11 s24 0
L24 s24 2 33e-5
VS25 11 s25 0
C25 s25 9 33e-5
VS26 3 s26 0
R26 s26 0 18e2
VS27 3 s27 0
R27 s27 4 18e1
VS28 8 s28 0
R28 s28 1 68e1
VS29 4 s29 0
V29 e29 s29 DC 0 AC 18e1 120
RI29 e29 m29 56e-3
LI29 m29 1 33e-6
VS30 13 s30 0
V30 e30 s30 DC 0 AC 47e-1 0
RI30 e30 1 56e-1
VS31 1 s31 0
C31 s31 0 15e-4
VS32 2 s32 0
R32 s32 14 10e-2
VS33 5 s33 0
V33 e33 s33 DC 0 AC 15e-1 -120
RI33 e33 m33 39e-3
LI33 m33 16 82e-7
VS34 11 s34 0
C34 s34 12 27e-5
VS35 2 s35 0
C35 s35 5 33e-6
VS36 0 s36 0
L36 s36 13 82e-5
VS37 8 s37 0
C37 s37 2 10e-4
VS38 15 s38 0
R38 s38 2 33e3
VS39 14 s39 0
R39 s39 18 27e-1
.control
set numdgt=17
ac lin 1 60 60
print v(1) v(2) v(3) v(4) v(5) v(6) v(7) v(8) v(9) v(10)
print v(11) v(12) v(13) v(14) v(15) v(16) v(17) v(18)
print i(vs0) i(vs1) i(vs2) i(vs3) i(vs4) i(vs5) i(vs6) i(vs7) i(vs8) i(vs9)
print i(vs10) i(vs11) i(vs12) i(vs13) i(vs14) i(vs15) i(vs16) i(vs17) i(vs18) i(vs19)
print i(vs20) i(vs21) i(vs22) i(vs23) i(vs24) i(vs25) i(vs26) i(vs27) i(vs28) i(vs29)
print i(vs30) i(vs31) i(vs32) i(vs33) i(vs34) i(vs35) i(vs36) i(vs37) i(vs38) i(vs39)
.endc
.end
