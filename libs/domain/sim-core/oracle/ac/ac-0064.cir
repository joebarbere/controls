controls oracle ac-0064
* Generated (plan F2.7, ADR 0012): do not edit; regenerate with `pnpm sim oracle regen`. ac seed 20261031 index 64 nodes 18 elements 36
.options sparse gmin=1e-12 noopac
RG1 1 0 1000000000000
RG2 2 0 1000000000000
RG3 3 0 1000000000000
RG4 4 0 1000000000000
RG5 5 0 1000000000000
RG6 6 0 1000000000000
RG7 7 0 1000000000000
RG8 8 0 1000000000000
RG9 9 0 1000000000000
RG10 10 0 1000000000000
RG11 11 0 1000000000000
RG12 12 0 1000000000000
RG13 13 0 1000000000000
RG14 14 0 1000000000000
RG15 15 0 1000000000000
RG16 16 0 1000000000000
RG17 17 0 1000000000000
VS0 0 s0 0
V0 e0 s0 DC 0 AC 56e-1 -120
RI0 e0 m0 18e-3
LI0 m0 2 22e-5
VS1 6 s1 0
C1 s1 13 33e-7
VS2 14 s2 0
R2 s2 12 15e-1
VS3 16 s3 0
R3 s3 9 68e-2
VS4 4 s4 0
V4 e4 s4 DC 0 AC 10e-1 0
RI4 e4 15 68e-1
VS5 3 s5 0
R5 s5 13 22e-1
VS6 8 s6 0
C6 s6 14 39e-5
VS7 1 s7 0
L7 s7 9 27e-3
VS8 2 s8 0
L8 s8 8 15e-5
VS9 8 s9 0
L9 s9 12 56e-5
VS10 15 s10 0
V10 e10 s10 DC 0 AC 18e0 -120
RI10 e10 m10 47e-1
LI10 m10 14 22e-7
VS11 3 s11 0
R11 s11 2 15e3
VS12 11 s12 0
C12 s12 16 15e-6
VS13 9 s13 0
R13 s13 2 15e2
VS14 17 s14 0
L14 s14 10 22e-3
VS15 5 s15 0
V15 e15 s15 DC 0 AC 56e-1 180
RI15 e15 m15 33e-1
LI15 m15 6 12e-6
VS16 9 s16 0
V16 e16 s16 DC 0 AC 27e0 180
RI16 e16 13 10e-2
VS17 6 s17 0
R17 s17 17 82e3
VS18 15 s18 0
V18 e18 s18 DC 0 AC 22e1 0
RI18 e18 11 18e-2
VS19 2 s19 0
R19 s19 8 56e-1
VS20 15 s20 0
V20 e20 s20 DC 0 AC 15e1 -120
RI20 e20 m20 10e-3
LI20 m20 2 33e-6
VS21 11 s21 0
C21 s21 3 82e-7
VS22 11 s22 0
V22 e22 s22 DC 0 AC 56e0 0
RI22 e22 1 12e-1
VS23 16 s23 0
V23 e23 s23 DC 0 AC 33e-1 -120
RI23 e23 15 18e-1
VS24 12 s24 0
V24 e24 s24 DC 0 AC 82e-1 0
RI24 e24 10 33e-2
VS25 2 s25 0
R25 s25 7 47e1
VS26 16 s26 0
V26 e26 s26 DC 0 AC 82e-1 120
RI26 e26 m26 82e-3
LI26 m26 14 12e-7
VS27 9 s27 0
R27 s27 5 68e0
VS28 14 s28 0
V28 e28 s28 DC 0 AC 22e0 -120
RI28 e28 16 12e-2
VS29 17 s29 0
L29 s29 12 18e-4
VS30 16 s30 0
L30 s30 7 27e-5
VS31 4 s31 0
R31 s31 15 10e-2
VS32 9 s32 0
R32 s32 2 82e0
VS33 10 s33 0
L33 s33 4 27e-2
VS34 4 s34 0
L34 s34 7 47e-2
VS35 8 s35 0
L35 s35 0 27e-4
.control
set numdgt=17
ac lin 1 60 60
print v(1) v(2) v(3) v(4) v(5) v(6) v(7) v(8) v(9) v(10)
print v(11) v(12) v(13) v(14) v(15) v(16) v(17)
print i(vs0) i(vs1) i(vs2) i(vs3) i(vs4) i(vs5) i(vs6) i(vs7) i(vs8) i(vs9)
print i(vs10) i(vs11) i(vs12) i(vs13) i(vs14) i(vs15) i(vs16) i(vs17) i(vs18) i(vs19)
print i(vs20) i(vs21) i(vs22) i(vs23) i(vs24) i(vs25) i(vs26) i(vs27) i(vs28) i(vs29)
print i(vs30) i(vs31) i(vs32) i(vs33) i(vs34) i(vs35)
.endc
.end
