controls oracle ac-0064
* Generated (plan F2.7, ADR 0012): do not edit; regenerate with `pnpm sim oracle regen`. ac seed 20261031 index 64 nodes 18 elements 19
.options sparse gmin=1e-12 noopac
RG1 1 0 1000000000000
RG2 2 0 1000000000000
RG3 3 0 1000000000000
RG4 4 0 1000000000000
RG5 5 0 1000000000000
RG6 6 0 1000000000000
RG7 7 0 1000000000000
RG8 8 0 1000000000000
RG9 9 0 1000000000000
RG10 10 0 1000000000000
RG11 11 0 1000000000000
RG12 12 0 1000000000000
RG13 13 0 1000000000000
RG14 14 0 1000000000000
RG15 15 0 1000000000000
RG16 16 0 1000000000000
RG17 17 0 1000000000000
VS0 5 s0 0
R0 s0 1 68e3
VS1 8 s1 0
L1 s1 15 39e-2
VS2 0 s2 0
V2 e2 s2 DC 0 AC 56e0 0
RI2 e2 15 12e-1
VS3 0 s3 0
V3 e3 s3 DC 0 AC 22e0 180
RI3 e3 11 27e-2
VS4 3 s4 0
R4 s4 8 68e-2
VS5 16 s5 0
L5 s5 17 12e-2
VS6 6 s6 0
L6 s6 5 68e-3
VS7 13 s7 0
R7 s7 14 12e3
VS8 10 s8 0
R8 s8 8 22e3
VS9 14 s9 0
L9 s9 2 39e-4
VS10 9 s10 0
R10 s10 1 22e-2
VS11 8 s11 0
C11 s11 17 82e-4
VS12 15 s12 0
L12 s12 1 22e-2
VS13 1 s13 0
R13 s13 7 27e0
VS14 14 s14 0
V14 e14 s14 DC 0 AC 27e-1 0
RI14 e14 12 10e-1
VS15 14 s15 0
V15 e15 s15 DC 0 AC 22e0 -120
RI15 e15 17 12e-2
VS16 14 s16 0
V16 e16 s16 DC 0 AC 18e1 0
RI16 e16 4 18e-3
VS17 14 s17 0
L17 s17 11 82e-3
VS18 17 s18 0
R18 s18 9 68e-2
.control
set numdgt=17
ac lin 1 60 60
print v(1) v(2) v(3) v(4) v(5) v(6) v(7) v(8) v(9) v(10)
print v(11) v(12) v(13) v(14) v(15) v(16) v(17)
print i(vs0) i(vs1) i(vs2) i(vs3) i(vs4) i(vs5) i(vs6) i(vs7) i(vs8) i(vs9)
print i(vs10) i(vs11) i(vs12) i(vs13) i(vs14) i(vs15) i(vs16) i(vs17) i(vs18)
.endc
.end
