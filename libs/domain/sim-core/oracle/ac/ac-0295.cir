controls oracle ac-0295
* Generated (plan F2.7, ADR 0012): do not edit; regenerate with `pnpm sim oracle regen`. ac seed 20261031 index 295 nodes 11 elements 17
.options sparse gmin=1e-12 noopac
RG1 1 0 1000000000000
RG2 2 0 1000000000000
RG3 3 0 1000000000000
RG4 4 0 1000000000000
RG5 5 0 1000000000000
RG6 6 0 1000000000000
RG7 7 0 1000000000000
RG8 8 0 1000000000000
RG9 9 0 1000000000000
RG10 10 0 1000000000000
VS0 10 s0 0
C0 s0 1 22e-4
VS1 0 s1 0
V1 e1 s1 DC 0 AC 18e-1 0
RI1 e1 8 56e-2
VS2 1 s2 0
L2 s2 6 56e-5
VS3 8 s3 0
V3 e3 s3 DC 0 AC 47e1 120
RI3 e3 1 22e-1
VS4 4 s4 0
L4 s4 0 15e-3
VS5 9 s5 0
C5 s5 2 27e-5
VS6 6 s6 0
C6 s6 3 10e-7
VS7 1 s7 0
C7 s7 4 12e-6
VS8 1 s8 0
R8 s8 3 33e0
VS9 9 s9 0
R9 s9 4 15e3
VS10 5 s10 0
C10 s10 7 39e-4
VS11 9 s11 0
L11 s11 1 12e-5
VS12 8 s12 0
R12 s12 7 12e-1
VS13 5 s13 0
R13 s13 10 27e-2
VS14 10 s14 0
R14 s14 7 22e1
VS15 9 s15 0
R15 s15 0 56e-1
VS16 6 s16 0
R16 s16 2 22e0
.control
set numdgt=17
ac lin 1 60 60
print v(1) v(2) v(3) v(4) v(5) v(6) v(7) v(8) v(9) v(10)
print i(vs0) i(vs1) i(vs2) i(vs3) i(vs4) i(vs5) i(vs6) i(vs7) i(vs8) i(vs9)
print i(vs10) i(vs11) i(vs12) i(vs13) i(vs14) i(vs15) i(vs16)
.endc
.end
