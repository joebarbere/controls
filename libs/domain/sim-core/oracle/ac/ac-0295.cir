controls oracle ac-0295
* Generated (plan F2.7, ADR 0012): do not edit; regenerate with `pnpm sim oracle regen`. ac seed 20261031 index 295 nodes 11 elements 13
.options sparse gmin=1e-12 noopac
RG1 1 0 1000000000000
RG2 2 0 1000000000000
RG3 3 0 1000000000000
RG4 4 0 1000000000000
RG5 5 0 1000000000000
RG6 6 0 1000000000000
RG7 7 0 1000000000000
RG8 8 0 1000000000000
RG9 9 0 1000000000000
RG10 10 0 1000000000000
VS0 1 s0 0
C0 s0 4 12e-6
VS1 9 s1 0
R1 s1 4 15e3
VS2 9 s2 0
R2 s2 10 56e-1
VS3 8 s3 0
C3 s3 1 22e-4
VS4 9 s4 0
C4 s4 2 27e-5
VS5 1 s5 0
L5 s5 6 56e-5
VS6 0 s6 0
R6 s6 7 12e-1
VS7 8 s7 0
R7 s7 7 22e1
VS8 1 s8 0
R8 s8 3 33e0
VS9 0 s9 0
V9 e9 s9 DC 0 AC 47e1 120
RI9 e9 1 22e-1
VS10 5 s10 0
R10 s10 8 27e-2
VS11 9 s11 0
L11 s11 1 12e-5
VS12 6 s12 0
C12 s12 3 10e-7
.control
set numdgt=17
ac lin 1 60 60
print v(1) v(2) v(3) v(4) v(5) v(6) v(7) v(8) v(9) v(10)
print i(vs0) i(vs1) i(vs2) i(vs3) i(vs4) i(vs5) i(vs6) i(vs7) i(vs8) i(vs9)
print i(vs10) i(vs11) i(vs12)
.endc
.end
