controls oracle ac-0376
* Generated (plan F2.7, ADR 0012): do not edit; regenerate with `pnpm sim oracle regen`. ac seed 20261031 index 376 nodes 27 elements 41
.options sparse gmin=1e-12 noopac
RG1 1 0 1000000000000
RG2 2 0 1000000000000
RG3 3 0 1000000000000
RG4 4 0 1000000000000
RG5 5 0 1000000000000
RG6 6 0 1000000000000
RG7 7 0 1000000000000
RG8 8 0 1000000000000
RG9 9 0 1000000000000
RG10 10 0 1000000000000
RG11 11 0 1000000000000
RG12 12 0 1000000000000
RG13 13 0 1000000000000
RG14 14 0 1000000000000
RG15 15 0 1000000000000
RG16 16 0 1000000000000
RG17 17 0 1000000000000
RG18 18 0 1000000000000
RG19 19 0 1000000000000
RG20 20 0 1000000000000
RG21 21 0 1000000000000
RG22 22 0 1000000000000
RG23 23 0 1000000000000
RG24 24 0 1000000000000
RG25 25 0 1000000000000
RG26 26 0 1000000000000
VS0 0 s0 0
V0 e0 s0 DC 0 AC 82e-1 0
RI0 e0 13 47e-3
VS1 7 s1 0
L1 s1 3 18e-5
VS2 15 s2 0
C2 s2 11 10e-5
VS3 2 s3 0
L3 s3 6 12e-3
VS4 4 s4 0
R4 s4 21 56e-2
VS5 23 s5 0
L5 s5 15 10e-2
VS6 14 s6 0
V6 e6 s6 DC 0 AC 22e1 120
RI6 e6 m6 82e-2
LI6 m6 2 22e-5
VS7 8 s7 0
R7 s7 24 33e3
VS8 17 s8 0
V8 e8 s8 DC 0 AC 27e1 -120
RI8 e8 m8 18e-2
LI8 m8 25 33e-7
VS9 20 s9 0
C9 s9 5 12e-6
VS10 8 s10 0
C10 s10 26 82e-4
VS11 26 s11 0
L11 s11 4 15e-5
VS12 18 s12 0
V12 e12 s12 DC 0 AC 47e1 -120
RI12 e12 m12 56e-1
LI12 m12 8 47e-7
VS13 6 s13 0
L13 s13 22 39e-5
VS14 21 s14 0
L14 s14 8 56e-2
VS15 8 s15 0
C15 s15 3 15e-4
VS16 1 s16 0
L16 s16 12 33e-5
VS17 19 s17 0
R17 s17 21 47e1
VS18 25 s18 0
V18 e18 s18 DC 0 AC 82e0 0
RI18 e18 m18 12e-2
LI18 m18 1 22e-7
VS19 9 s19 0
R19 s19 16 82e1
VS20 2 s20 0
L20 s20 13 82e-4
VS21 22 s21 0
R21 s21 13 15e-1
VS22 0 s22 0
V22 e22 s22 DC 0 AC 18e-1 120
RI22 e22 m22 27e-2
LI22 m22 23 68e-7
VS23 22 s23 0
C23 s23 5 27e-6
VS24 3 s24 0
R24 s24 20 22e1
VS25 7 s25 0
L25 s25 25 39e-5
VS26 2 s26 0
C26 s26 0 68e-5
VS27 0 s27 0
R27 s27 22 12e-2
VS28 19 s28 0
L28 s28 0 56e-3
VS29 18 s29 0
C29 s29 11 47e-5
VS30 23 s30 0
L30 s30 10 39e-5
VS31 14 s31 0
R31 s31 26 47e2
VS32 0 s32 0
R32 s32 10 47e0
VS33 17 s33 0
C33 s33 12 27e-7
VS34 26 s34 0
V34 e34 s34 DC 0 AC 56e1 -120
RI34 e34 25 56e-2
VS35 8 s35 0
R35 s35 9 27e3
VS36 16 s36 0
C36 s36 20 56e-5
VS37 22 s37 0
V37 e37 s37 DC 0 AC 27e1 180
RI37 e37 11 56e-1
VS38 2 s38 0
C38 s38 21 68e-7
VS39 24 s39 0
V39 e39 s39 DC 0 AC 39e-1 120
RI39 e39 13 27e-1
VS40 12 s40 0
L40 s40 11 15e-4
.control
set numdgt=17
ac lin 1 60 60
print v(1) v(2) v(3) v(4) v(5) v(6) v(7) v(8) v(9) v(10)
print v(11) v(12) v(13) v(14) v(15) v(16) v(17) v(18) v(19) v(20)
print v(21) v(22) v(23) v(24) v(25) v(26)
print i(vs0) i(vs1) i(vs2) i(vs3) i(vs4) i(vs5) i(vs6) i(vs7) i(vs8) i(vs9)
print i(vs10) i(vs11) i(vs12) i(vs13) i(vs14) i(vs15) i(vs16) i(vs17) i(vs18) i(vs19)
print i(vs20) i(vs21) i(vs22) i(vs23) i(vs24) i(vs25) i(vs26) i(vs27) i(vs28) i(vs29)
print i(vs30) i(vs31) i(vs32) i(vs33) i(vs34) i(vs35) i(vs36) i(vs37) i(vs38) i(vs39)
print i(vs40)
.endc
.end
