controls oracle ac-0376
* Generated (plan F2.7, ADR 0012): do not edit; regenerate with `pnpm sim oracle regen`. ac seed 20261031 index 376 nodes 27 elements 46
.options sparse gmin=1e-12 noopac
RG1 1 0 1000000000000
RG2 2 0 1000000000000
RG3 3 0 1000000000000
RG4 4 0 1000000000000
RG5 5 0 1000000000000
RG6 6 0 1000000000000
RG7 7 0 1000000000000
RG8 8 0 1000000000000
RG9 9 0 1000000000000
RG10 10 0 1000000000000
RG11 11 0 1000000000000
RG12 12 0 1000000000000
RG13 13 0 1000000000000
RG14 14 0 1000000000000
RG15 15 0 1000000000000
RG16 16 0 1000000000000
RG17 17 0 1000000000000
RG18 18 0 1000000000000
RG19 19 0 1000000000000
RG20 20 0 1000000000000
RG21 21 0 1000000000000
RG22 22 0 1000000000000
RG23 23 0 1000000000000
RG24 24 0 1000000000000
RG25 25 0 1000000000000
RG26 26 0 1000000000000
VS0 14 s0 0
L0 s0 17 18e-2
VS1 10 s1 0
L1 s1 8 10e-2
VS2 2 s2 0
C2 s2 0 39e-6
VS3 0 s3 0
V3 e3 s3 DC 0 AC 10e0 -120
RI3 e3 18 56e-1
VS4 10 s4 0
R4 s4 14 39e3
VS5 3 s5 0
C5 s5 25 22e-4
VS6 21 s6 0
V6 e6 s6 DC 0 AC 56e1 -120
RI6 e6 19 22e-3
VS7 8 s7 0
L7 s7 20 33e-2
VS8 25 s8 0
V8 e8 s8 DC 0 AC 47e1 120
RI8 e8 17 39e-2
VS9 12 s9 0
L9 s9 11 12e-2
VS10 15 s10 0
V10 e10 s10 DC 0 AC 39e1 -120
RI10 e10 19 27e-2
VS11 3 s11 0
R11 s11 20 33e2
VS12 15 s12 0
R12 s12 10 22e-2
VS13 7 s13 0
R13 s13 16 68e-1
VS14 2 s14 0
C14 s14 5 68e-5
VS15 5 s15 0
V15 e15 s15 DC 0 AC 18e-1 120
RI15 e15 23 27e-2
VS16 7 s16 0
V16 e16 s16 DC 0 AC 39e-1 -120
RI16 e16 2 18e-2
VS17 8 s17 0
R17 s17 1 47e-1
VS18 5 s18 0
C18 s18 12 82e-6
VS19 18 s19 0
C19 s19 16 39e-7
VS20 9 s20 0
C20 s20 10 12e-7
VS21 11 s21 0
L21 s21 17 39e-4
VS22 5 s22 0
R22 s22 22 12e-2
VS23 24 s23 0
V23 e23 s23 DC 0 AC 82e1 0
RI23 e23 6 47e-1
VS24 21 s24 0
R24 s24 3 10e3
VS25 4 s25 0
L25 s25 7 12e-5
VS26 25 s26 0
C26 s26 17 22e-7
VS27 8 s27 0
L27 s27 5 56e-4
VS28 21 s28 0
V28 e28 s28 DC 0 AC 27e1 180
RI28 e28 13 22e-1
VS29 6 s29 0
R29 s29 2 15e-1
VS30 22 s30 0
V30 e30 s30 DC 0 AC 27e1 180
RI30 e30 11 56e-1
VS31 20 s31 0
C31 s31 0 12e-6
VS32 0 s32 0
C32 s32 26 68e-4
VS33 6 s33 0
V33 e33 s33 DC 0 AC 33e1 -120
RI33 e33 22 22e-2
VS34 15 s34 0
R34 s34 14 82e2
VS35 21 s35 0
C35 s35 24 18e-5
VS36 8 s36 0
R36 s36 3 18e0
VS37 4 s37 0
L37 s37 19 18e-3
VS38 3 s38 0
V38 e38 s38 DC 0 AC 18e1 -120
RI38 e38 16 39e-2
VS39 4 s39 0
L39 s39 9 12e-2
VS40 15 s40 0
C40 s40 26 39e-6
VS41 1 s41 0
L41 s41 14 18e-2
VS42 22 s42 0
C42 s42 0 27e-6
VS43 13 s43 0
C43 s43 4 12e-6
VS44 3 s44 0
L44 s44 20 18e-3
VS45 16 s45 0
R45 s45 18 56e1
.control
set numdgt=17
ac lin 1 60 60
print v(1) v(2) v(3) v(4) v(5) v(6) v(7) v(8) v(9) v(10)
print v(11) v(12) v(13) v(14) v(15) v(16) v(17) v(18) v(19) v(20)
print v(21) v(22) v(23) v(24) v(25) v(26)
print i(vs0) i(vs1) i(vs2) i(vs3) i(vs4) i(vs5) i(vs6) i(vs7) i(vs8) i(vs9)
print i(vs10) i(vs11) i(vs12) i(vs13) i(vs14) i(vs15) i(vs16) i(vs17) i(vs18) i(vs19)
print i(vs20) i(vs21) i(vs22) i(vs23) i(vs24) i(vs25) i(vs26) i(vs27) i(vs28) i(vs29)
print i(vs30) i(vs31) i(vs32) i(vs33) i(vs34) i(vs35) i(vs36) i(vs37) i(vs38) i(vs39)
print i(vs40) i(vs41) i(vs42) i(vs43) i(vs44) i(vs45)
.endc
.end
