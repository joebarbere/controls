controls oracle ac-0376
* Generated (plan F2.7, ADR 0012): do not edit; regenerate with `pnpm sim oracle regen`. ac seed 20261031 index 376 nodes 27 elements 47
.options sparse gmin=1e-12 noopac
RG1 1 0 1000000000000
RG2 2 0 1000000000000
RG3 3 0 1000000000000
RG4 4 0 1000000000000
RG5 5 0 1000000000000
RG6 6 0 1000000000000
RG7 7 0 1000000000000
RG8 8 0 1000000000000
RG9 9 0 1000000000000
RG10 10 0 1000000000000
RG11 11 0 1000000000000
RG12 12 0 1000000000000
RG13 13 0 1000000000000
RG14 14 0 1000000000000
RG15 15 0 1000000000000
RG16 16 0 1000000000000
RG17 17 0 1000000000000
RG18 18 0 1000000000000
RG19 19 0 1000000000000
RG20 20 0 1000000000000
RG21 21 0 1000000000000
RG22 22 0 1000000000000
RG23 23 0 1000000000000
RG24 24 0 1000000000000
RG25 25 0 1000000000000
RG26 26 0 1000000000000
VS0 10 s0 0
L0 s0 8 10e-2
VS1 3 s1 0
R1 s1 20 33e2
VS2 0 s2 0
V2 e2 s2 DC 0 AC 39e-1 -120
RI2 e2 m2 18e-2
LI2 m2 n2 18e-6
H2 n2 h2 VS5 -12e-3
ED2 h2 2 d2 0 -12e-5
F2 0 d2 VS5 1
LD2 d2 0 1
VS3 22 s3 0
C3 s3 5 27e-6
VS4 9 s4 0
C4 s4 10 12e-7
VS5 3 s5 0
V5 e5 s5 DC 0 AC 18e1 -120
RI5 e5 n5 39e-2
H5 n5 h5 VS2 -12e-3
ED5 h5 16 d5 0 -12e-5
F5 0 d5 VS2 1
LD5 d5 0 1
VS6 12 s6 0
L6 s6 11 12e-2
VS7 2 s7 0
C7 s7 5 39e-6
VS8 16 s8 0
R8 s8 18 56e1
VS9 8 s9 0
L9 s9 7 56e-4
VS10 25 s10 0
V10 e10 s10 DC 0 AC 47e1 120
RI10 e10 m10 39e-2
LI10 m10 17 10e-6
VS11 4 s11 0
L11 s11 0 12e-5
VS12 7 s12 0
C12 s12 12 82e-6
VS13 21 s13 0
V13 e13 s13 DC 0 AC 27e1 180
RI13 e13 m13 22e-1
LI13 m13 13 12e-5
VS14 4 s14 0
L14 s14 19 18e-3
VS15 6 s15 0
R15 s15 2 15e-1
VS16 3 s16 0
C16 s16 25 22e-4
VS17 20 s17 0
C17 s17 5 12e-6
VS18 15 s18 0
R18 s18 14 82e2
VS19 8 s19 0
R19 s19 1 47e-1
VS20 14 s20 0
L20 s20 17 18e-2
VS21 10 s21 0
R21 s21 14 39e3
VS22 11 s22 0
L22 s22 17 39e-4
VS23 3 s23 0
L23 s23 20 18e-3
VS24 4 s24 0
L24 s24 9 12e-2
VS25 5 s25 0
C25 s25 26 68e-4
VS26 21 s26 0
V26 e26 s26 DC 0 AC 56e1 -120
RI26 e26 19 22e-3
VS27 0 s27 0
R27 s27 16 68e-1
VS28 25 s28 0
C28 s28 17 22e-7
VS29 21 s29 0
C29 s29 24 18e-5
VS30 21 s30 0
R30 s30 3 10e3
VS31 8 s31 0
L31 s31 20 33e-2
VS32 5 s32 0
V32 e32 s32 DC 0 AC 10e0 -120
RI32 e32 m32 56e-1
LI32 m32 18 15e-6
VS33 7 s33 0
V33 e33 s33 DC 0 AC 18e-1 120
RI33 e33 23 27e-2
VS34 22 s34 0
V34 e34 s34 DC 0 AC 27e1 180
RI34 e34 m34 56e-1
LI34 m34 11 47e-7
VS35 7 s35 0
R35 s35 22 12e-2
VS36 6 s36 0
V36 e36 s36 DC 0 AC 33e1 -120
RI36 e36 22 22e-2
VS37 2 s37 0
C37 s37 7 68e-5
VS38 13 s38 0
C38 s38 4 12e-6
VS39 24 s39 0
V39 e39 s39 DC 0 AC 82e1 0
RI39 e39 m39 47e-1
LI39 m39 6 47e-6
VS40 15 s40 0
R40 s40 10 22e-2
VS41 23 s41 0
L41 s41 17 12e-3
VS42 1 s42 0
L42 s42 14 18e-2
VS43 18 s43 0
C43 s43 16 39e-7
VS44 8 s44 0
R44 s44 3 18e0
VS45 15 s45 0
V45 e45 s45 DC 0 AC 39e1 -120
RI45 e45 19 27e-2
VS46 15 s46 0
C46 s46 26 39e-6
.control
set numdgt=17
ac lin 1 60 60
print v(1) v(2) v(3) v(4) v(5) v(6) v(7) v(8) v(9) v(10)
print v(11) v(12) v(13) v(14) v(15) v(16) v(17) v(18) v(19) v(20)
print v(21) v(22) v(23) v(24) v(25) v(26)
print i(vs0) i(vs1) i(vs2) i(vs3) i(vs4) i(vs5) i(vs6) i(vs7) i(vs8) i(vs9)
print i(vs10) i(vs11) i(vs12) i(vs13) i(vs14) i(vs15) i(vs16) i(vs17) i(vs18) i(vs19)
print i(vs20) i(vs21) i(vs22) i(vs23) i(vs24) i(vs25) i(vs26) i(vs27) i(vs28) i(vs29)
print i(vs30) i(vs31) i(vs32) i(vs33) i(vs34) i(vs35) i(vs36) i(vs37) i(vs38) i(vs39)
print i(vs40) i(vs41) i(vs42) i(vs43) i(vs44) i(vs45) i(vs46)
.endc
.end
