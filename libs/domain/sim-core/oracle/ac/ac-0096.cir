controls oracle ac-0096
* Generated (plan F2.7, ADR 0012): do not edit; regenerate with `pnpm sim oracle regen`. ac seed 20261031 index 96 nodes 29 elements 41
.options sparse gmin=1e-12 noopac
RG1 1 0 1000000000000
RG2 2 0 1000000000000
RG3 3 0 1000000000000
RG4 4 0 1000000000000
RG5 5 0 1000000000000
RG6 6 0 1000000000000
RG7 7 0 1000000000000
RG8 8 0 1000000000000
RG9 9 0 1000000000000
RG10 10 0 1000000000000
RG11 11 0 1000000000000
RG12 12 0 1000000000000
RG13 13 0 1000000000000
RG14 14 0 1000000000000
RG15 15 0 1000000000000
RG16 16 0 1000000000000
RG17 17 0 1000000000000
RG18 18 0 1000000000000
RG19 19 0 1000000000000
RG20 20 0 1000000000000
RG21 21 0 1000000000000
RG22 22 0 1000000000000
RG23 23 0 1000000000000
RG24 24 0 1000000000000
RG25 25 0 1000000000000
RG26 26 0 1000000000000
RG27 27 0 1000000000000
RG28 28 0 1000000000000
VS0 10 s0 0
L0 s0 21 47e-2
VS1 7 s1 0
C1 s1 21 56e-7
VS2 3 s2 0
L2 s2 26 33e-3
VS3 21 s3 0
L3 s3 27 18e-4
VS4 9 s4 0
R4 s4 16 56e-1
VS5 27 s5 0
C5 s5 26 27e-4
VS6 19 s6 0
L6 s6 11 33e-4
VS7 18 s7 0
C7 s7 10 27e-7
VS8 0 s8 0
V8 e8 s8 DC 0 AC 56e-1 0
RI8 e8 24 15e-2
VS9 27 s9 0
R9 s9 7 39e1
VS10 21 s10 0
R10 s10 17 18e-1
VS11 25 s11 0
C11 s11 9 56e-6
VS12 11 s12 0
C12 s12 13 47e-7
VS13 16 s13 0
C13 s13 4 47e-4
VS14 6 s14 0
R14 s14 24 56e0
VS15 11 s15 0
R15 s15 0 12e-1
VS16 28 s16 0
R16 s16 21 82e0
VS17 21 s17 0
L17 s17 20 56e-3
VS18 15 s18 0
R18 s18 18 12e2
VS19 17 s19 0
R19 s19 10 56e-2
VS20 6 s20 0
R20 s20 14 15e1
VS21 7 s21 0
C21 s21 14 33e-6
VS22 11 s22 0
C22 s22 18 56e-6
VS23 0 s23 0
C23 s23 23 56e-4
VS24 27 s24 0
R24 s24 28 12e1
VS25 24 s25 0
L25 s25 5 33e-4
VS26 0 s26 0
L26 s26 22 10e-2
VS27 13 s27 0
C27 s27 6 22e-7
VS28 14 s28 0
C28 s28 1 33e-7
VS29 3 s29 0
L29 s29 18 27e-4
VS30 28 s30 0
L30 s30 22 39e-3
VS31 6 s31 0
V31 e31 s31 DC 0 AC 47e1 120
RI31 e31 23 82e-2
VS32 3 s32 0
R32 s32 9 39e2
VS33 11 s33 0
R33 s33 5 18e3
VS34 0 s34 0
R34 s34 8 22e0
VS35 9 s35 0
C35 s35 21 22e-4
VS36 26 s36 0
C36 s36 2 27e-5
VS37 24 s37 0
L37 s37 12 12e-4
VS38 24 s38 0
V38 e38 s38 DC 0 AC 56e1 180
RI38 e38 13 12e-1
VS39 22 s39 0
C39 s39 0 22e-7
VS40 18 s40 0
V40 e40 s40 DC 0 AC 47e0 180
RI40 e40 28 22e-2
.control
set numdgt=17
ac lin 1 60 60
print v(1) v(2) v(3) v(4) v(5) v(6) v(7) v(8) v(9) v(10)
print v(11) v(12) v(13) v(14) v(15) v(16) v(17) v(18) v(19) v(20)
print v(21) v(22) v(23) v(24) v(25) v(26) v(27) v(28)
print i(vs0) i(vs1) i(vs2) i(vs3) i(vs4) i(vs5) i(vs6) i(vs7) i(vs8) i(vs9)
print i(vs10) i(vs11) i(vs12) i(vs13) i(vs14) i(vs15) i(vs16) i(vs17) i(vs18) i(vs19)
print i(vs20) i(vs21) i(vs22) i(vs23) i(vs24) i(vs25) i(vs26) i(vs27) i(vs28) i(vs29)
print i(vs30) i(vs31) i(vs32) i(vs33) i(vs34) i(vs35) i(vs36) i(vs37) i(vs38) i(vs39)
print i(vs40)
.endc
.end
