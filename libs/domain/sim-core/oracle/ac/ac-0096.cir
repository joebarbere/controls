controls oracle ac-0096
* Generated (plan F2.7, ADR 0012): do not edit; regenerate with `pnpm sim oracle regen`. ac seed 20261031 index 96 nodes 29 elements 50
.options sparse gmin=1e-12 noopac
RG1 1 0 1000000000000
RG2 2 0 1000000000000
RG3 3 0 1000000000000
RG4 4 0 1000000000000
RG5 5 0 1000000000000
RG6 6 0 1000000000000
RG7 7 0 1000000000000
RG8 8 0 1000000000000
RG9 9 0 1000000000000
RG10 10 0 1000000000000
RG11 11 0 1000000000000
RG12 12 0 1000000000000
RG13 13 0 1000000000000
RG14 14 0 1000000000000
RG15 15 0 1000000000000
RG16 16 0 1000000000000
RG17 17 0 1000000000000
RG18 18 0 1000000000000
RG19 19 0 1000000000000
RG20 20 0 1000000000000
RG21 21 0 1000000000000
RG22 22 0 1000000000000
RG23 23 0 1000000000000
RG24 24 0 1000000000000
RG25 25 0 1000000000000
RG26 26 0 1000000000000
RG27 27 0 1000000000000
RG28 28 0 1000000000000
VS0 0 s0 0
V0 e0 s0 DC 0 AC 33e1 0
RI0 e0 n0 39e-3
H0 n0 h0 VS15 22e-4
ED0 h0 15 d0 0 10e-7
F0 0 d0 VS15 1
LD0 d0 0 1
VS1 10 s1 0
L1 s1 0 47e-2
VS2 7 s2 0
C2 s2 14 33e-6
VS3 11 s3 0
R3 s3 5 18e3
VS4 11 s4 0
R4 s4 21 12e-1
VS5 28 s5 0
R5 s5 0 82e0
VS6 22 s6 0
C6 s6 21 22e-7
VS7 4 s7 0
R7 s7 9 22e0
VS8 8 s8 0
R8 s8 6 15e1
VS9 6 s9 0
R9 s9 24 56e0
VS10 28 s10 0
L10 s10 22 39e-3
VS11 3 s11 0
L11 s11 18 27e-4
VS12 24 s12 0
L12 s12 12 12e-4
VS13 11 s13 0
C13 s13 13 47e-7
VS14 13 s14 0
C14 s14 6 22e-7
VS15 25 s15 0
V15 e15 s15 DC 0 AC 18e1 180
RI15 e15 n15 82e-1
H15 n15 h15 VS0 22e-4
ED15 h15 12 d15 0 10e-7
F15 0 d15 VS0 1
LD15 d15 0 1
VS16 14 s16 0
C16 s16 1 33e-7
VS17 0 s17 0
L17 s17 20 56e-3
VS18 26 s18 0
C18 s18 2 27e-5
VS19 24 s19 0
V19 e19 s19 DC 0 AC 56e1 180
RI19 e19 13 12e-1
VS20 11 s20 0
C20 s20 18 56e-6
VS21 6 s21 0
V21 e21 s21 DC 0 AC 47e1 120
RI21 e21 23 82e-2
VS22 16 s22 0
R22 s22 10 15e2
VS23 6 s23 0
R23 s23 14 15e1
VS24 16 s24 0
C24 s24 4 47e-4
VS25 19 s25 0
L25 s25 11 33e-4
VS26 18 s26 0
V26 e26 s26 DC 0 AC 47e0 180
RI26 e26 28 22e-2
VS27 25 s27 0
C27 s27 9 56e-6
VS28 19 s28 0
R28 s28 26 47e2
VS29 3 s29 0
R29 s29 9 39e2
VS30 9 s30 0
C30 s30 0 22e-4
VS31 27 s31 0
R31 s31 7 39e1
VS32 15 s32 0
R32 s32 18 12e2
VS33 18 s33 0
C33 s33 10 27e-7
VS34 21 s34 0
V34 e34 s34 DC 0 AC 56e-1 0
RI34 e34 24 15e-2
VS35 9 s35 0
V35 e35 s35 DC 0 AC 12e-1 0
RI35 e35 m35 10e-2
LI35 m35 1 12e-6
VS36 17 s36 0
R36 s36 10 56e-2
VS37 20 s37 0
C37 s37 15 68e-5
VS38 27 s38 0
R38 s38 28 12e1
VS39 24 s39 0
L39 s39 5 33e-4
VS40 9 s40 0
R40 s40 16 56e-1
VS41 7 s41 0
C41 s41 0 56e-7
VS42 21 s42 0
C42 s42 23 56e-4
VS43 0 s43 0
L43 s43 27 18e-4
VS44 21 s44 0
L44 s44 22 10e-2
VS45 27 s45 0
C45 s45 26 27e-4
VS46 0 s46 0
R46 s46 17 18e-1
VS47 22 s47 0
R47 s47 2 12e-1
VS48 3 s48 0
L48 s48 26 33e-3
VS49 21 s49 0
R49 s49 8 22e0
.control
set numdgt=17
ac lin 1 60 60
print v(1) v(2) v(3) v(4) v(5) v(6) v(7) v(8) v(9) v(10)
print v(11) v(12) v(13) v(14) v(15) v(16) v(17) v(18) v(19) v(20)
print v(21) v(22) v(23) v(24) v(25) v(26) v(27) v(28)
print i(vs0) i(vs1) i(vs2) i(vs3) i(vs4) i(vs5) i(vs6) i(vs7) i(vs8) i(vs9)
print i(vs10) i(vs11) i(vs12) i(vs13) i(vs14) i(vs15) i(vs16) i(vs17) i(vs18) i(vs19)
print i(vs20) i(vs21) i(vs22) i(vs23) i(vs24) i(vs25) i(vs26) i(vs27) i(vs28) i(vs29)
print i(vs30) i(vs31) i(vs32) i(vs33) i(vs34) i(vs35) i(vs36) i(vs37) i(vs38) i(vs39)
print i(vs40) i(vs41) i(vs42) i(vs43) i(vs44) i(vs45) i(vs46) i(vs47) i(vs48) i(vs49)
.endc
.end
