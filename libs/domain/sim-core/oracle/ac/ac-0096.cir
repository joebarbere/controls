controls oracle ac-0096
* Generated (plan F2.7, ADR 0012): do not edit; regenerate with `pnpm sim oracle regen`. ac seed 20261031 index 96 nodes 29 elements 43
.options sparse gmin=1e-12 noopac
RG1 1 0 1000000000000
RG2 2 0 1000000000000
RG3 3 0 1000000000000
RG4 4 0 1000000000000
RG5 5 0 1000000000000
RG6 6 0 1000000000000
RG7 7 0 1000000000000
RG8 8 0 1000000000000
RG9 9 0 1000000000000
RG10 10 0 1000000000000
RG11 11 0 1000000000000
RG12 12 0 1000000000000
RG13 13 0 1000000000000
RG14 14 0 1000000000000
RG15 15 0 1000000000000
RG16 16 0 1000000000000
RG17 17 0 1000000000000
RG18 18 0 1000000000000
RG19 19 0 1000000000000
RG20 20 0 1000000000000
RG21 21 0 1000000000000
RG22 22 0 1000000000000
RG23 23 0 1000000000000
RG24 24 0 1000000000000
RG25 25 0 1000000000000
RG26 26 0 1000000000000
RG27 27 0 1000000000000
RG28 28 0 1000000000000
VS0 5 s0 0
R0 s0 3 27e1
VS1 14 s1 0
R1 s1 17 22e2
VS2 8 s2 0
C2 s2 11 18e-4
VS3 28 s3 0
L3 s3 22 39e-3
VS4 12 s4 0
C4 s4 21 33e-4
VS5 2 s5 0
R5 s5 13 68e1
VS6 23 s6 0
L6 s6 2 18e-5
VS7 10 s7 0
R7 s7 9 47e1
VS8 13 s8 0
L8 s8 14 12e-2
VS9 25 s9 0
C9 s9 8 82e-6
VS10 20 s10 0
L10 s10 27 33e-3
VS11 0 s11 0
V11 e11 s11 DC 0 AC 18e-1 0
RI11 e11 14 12e-3
VS12 19 s12 0
L12 s12 1 82e-5
VS13 0 s13 0
C13 s13 3 27e-6
VS14 16 s14 0
C14 s14 7 39e-6
VS15 9 s15 0
L15 s15 19 12e-5
VS16 18 s16 0
V16 e16 s16 DC 0 AC 47e0 180
RI16 e16 28 22e-2
VS17 25 s17 0
C17 s17 7 15e-5
VS18 28 s18 0
C18 s18 6 56e-5
VS19 7 s19 0
R19 s19 17 22e0
VS20 28 s20 0
R20 s20 21 82e0
VS21 24 s21 0
L21 s21 4 27e-2
VS22 23 s22 0
V22 e22 s22 DC 0 AC 22e-1 -120
RI22 e22 m22 56e-1
LI22 m22 18 18e-5
VS23 11 s23 0
R23 s23 3 12e-1
VS24 26 s24 0
R24 s24 9 18e-1
VS25 21 s25 0
C25 s25 19 56e-5
VS26 7 s26 0
V26 e26 s26 DC 0 AC 27e-1 0
RI26 e26 m26 22e-1
LI26 m26 15 33e-5
VS27 1 s27 0
C27 s27 2 22e-5
VS28 10 s28 0
C28 s28 20 15e-6
VS29 3 s29 0
L29 s29 22 10e-2
VS30 27 s30 0
C30 s30 26 27e-4
VS31 21 s31 0
L31 s31 27 18e-4
VS32 7 s32 0
L32 s32 3 56e-4
VS33 6 s33 0
L33 s33 19 27e-4
VS34 14 s34 0
R34 s34 16 47e2
VS35 5 s35 0
R35 s35 14 12e-2
VS36 9 s36 0
R36 s36 4 68e2
VS37 22 s37 0
V37 e37 s37 DC 0 AC 56e-1 -120
RI37 e37 m37 18e-1
LI37 m37 24 56e-7
VS38 12 s38 0
V38 e38 s38 DC 0 AC 47e-1 -120
RI38 e38 26 47e-1
VS39 15 s39 0
L39 s39 25 12e-3
VS40 7 s40 0
L40 s40 4 39e-3
VS41 25 s41 0
L41 s41 3 68e-4
VS42 2 s42 0
V42 e42 s42 DC 0 AC 33e-1 120
RI42 e42 1 56e-1
.control
set numdgt=17
ac lin 1 60 60
print v(1) v(2) v(3) v(4) v(5) v(6) v(7) v(8) v(9) v(10)
print v(11) v(12) v(13) v(14) v(15) v(16) v(17) v(18) v(19) v(20)
print v(21) v(22) v(23) v(24) v(25) v(26) v(27) v(28)
print i(vs0) i(vs1) i(vs2) i(vs3) i(vs4) i(vs5) i(vs6) i(vs7) i(vs8) i(vs9)
print i(vs10) i(vs11) i(vs12) i(vs13) i(vs14) i(vs15) i(vs16) i(vs17) i(vs18) i(vs19)
print i(vs20) i(vs21) i(vs22) i(vs23) i(vs24) i(vs25) i(vs26) i(vs27) i(vs28) i(vs29)
print i(vs30) i(vs31) i(vs32) i(vs33) i(vs34) i(vs35) i(vs36) i(vs37) i(vs38) i(vs39)
print i(vs40) i(vs41) i(vs42)
.endc
.end
