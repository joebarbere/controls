controls oracle ac-0351
* Generated (plan F2.7, ADR 0012): do not edit; regenerate with `pnpm sim oracle regen`. ac seed 20261031 index 351 nodes 6 elements 9
.options sparse gmin=1e-12 noopac
RG1 1 0 1000000000000
RG2 2 0 1000000000000
RG3 3 0 1000000000000
RG4 4 0 1000000000000
RG5 5 0 1000000000000
VS0 3 s0 0
R0 s0 4 56e-1
VS1 0 s1 0
L1 s1 2 33e-3
VS2 5 s2 0
C2 s2 1 56e-6
VS3 1 s3 0
R3 s3 3 56e2
VS4 1 s4 0
R4 s4 2 47e1
VS5 3 s5 0
L5 s5 2 47e-2
VS6 0 s6 0
L6 s6 5 15e-4
VS7 0 s7 0
V7 e7 s7 DC 0 AC 18e-1 120
RI7 e7 m7 27e-1
LI7 m7 1 33e-6
VS8 4 s8 0
L8 s8 0 22e-3
.control
set numdgt=17
ac lin 1 60 60
print v(1) v(2) v(3) v(4) v(5)
print i(vs0) i(vs1) i(vs2) i(vs3) i(vs4) i(vs5) i(vs6) i(vs7) i(vs8)
.endc
.end
