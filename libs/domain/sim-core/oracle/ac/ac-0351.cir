controls oracle ac-0351
* Generated (plan F2.7, ADR 0012): do not edit; regenerate with `pnpm sim oracle regen`. ac seed 20261031 index 351 nodes 6 elements 8
.options sparse gmin=1e-12 noopac
RG1 1 0 1000000000000
RG2 2 0 1000000000000
RG3 3 0 1000000000000
RG4 4 0 1000000000000
RG5 5 0 1000000000000
VS0 3 s0 0
C0 s0 0 39e-6
VS1 2 s1 0
L1 s1 5 15e-4
VS2 0 s2 0
V2 e2 s2 DC 0 AC 18e-1 120
RI2 e2 1 27e-1
VS3 2 s3 0
C3 s3 5 12e-4
VS4 4 s4 0
L4 s4 0 22e-3
VS5 2 s5 0
C5 s5 4 33e-7
VS6 0 s6 0
R6 s6 1 12e-2
VS7 0 s7 0
L7 s7 2 33e-3
.control
set numdgt=17
ac lin 1 60 60
print v(1) v(2) v(3) v(4) v(5)
print i(vs0) i(vs1) i(vs2) i(vs3) i(vs4) i(vs5) i(vs6) i(vs7)
.endc
.end
