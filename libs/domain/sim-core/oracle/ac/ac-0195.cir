controls oracle ac-0195
* Generated (plan F2.7, ADR 0012): do not edit; regenerate with `pnpm sim oracle regen`. ac seed 20261031 index 195 nodes 25 elements 39
.options sparse gmin=1e-12 noopac
RG1 1 0 1000000000000
RG2 2 0 1000000000000
RG3 3 0 1000000000000
RG4 4 0 1000000000000
RG5 5 0 1000000000000
RG6 6 0 1000000000000
RG7 7 0 1000000000000
RG8 8 0 1000000000000
RG9 9 0 1000000000000
RG10 10 0 1000000000000
RG11 11 0 1000000000000
RG12 12 0 1000000000000
RG13 13 0 1000000000000
RG14 14 0 1000000000000
RG15 15 0 1000000000000
RG16 16 0 1000000000000
RG17 17 0 1000000000000
RG18 18 0 1000000000000
RG19 19 0 1000000000000
RG20 20 0 1000000000000
RG21 21 0 1000000000000
RG22 22 0 1000000000000
RG23 23 0 1000000000000
RG24 24 0 1000000000000
VS0 5 s0 0
C0 s0 10 33e-6
VS1 1 s1 0
C1 s1 22 82e-4
VS2 19 s2 0
R2 s2 24 22e2
VS3 8 s3 0
R3 s3 9 18e0
VS4 0 s4 0
V4 e4 s4 DC 0 AC 33e0 120
RI4 e4 15 56e-1
VS5 14 s5 0
L5 s5 0 10e-2
VS6 14 s6 0
C6 s6 1 27e-7
VS7 5 s7 0
C7 s7 24 56e-6
VS8 0 s8 0
L8 s8 9 68e-2
VS9 14 s9 0
L9 s9 20 15e-4
VS10 16 s10 0
R10 s10 23 18e2
VS11 1 s11 0
C11 s11 0 39e-7
VS12 11 s12 0
R12 s12 12 56e3
VS13 5 s13 0
C13 s13 11 82e-6
VS14 0 s14 0
V14 e14 s14 DC 0 AC 39e-1 120
RI14 e14 4 56e-3
VS15 2 s15 0
V15 e15 s15 DC 0 AC 56e0 -120
RI15 e15 20 22e-2
VS16 17 s16 0
R16 s16 3 22e3
VS17 10 s17 0
R17 s17 21 18e2
VS18 7 s18 0
R18 s18 5 68e-1
VS19 1 s19 0
R19 s19 21 56e-1
VS20 14 s20 0
R20 s20 8 18e-1
VS21 11 s21 0
C21 s21 14 27e-6
VS22 19 s22 0
R22 s22 11 47e3
VS23 17 s23 0
L23 s23 5 56e-2
VS24 2 s24 0
R24 s24 4 56e0
VS25 23 s25 0
V25 e25 s25 DC 0 AC 33e-1 120
RI25 e25 20 39e-3
VS26 12 s26 0
V26 e26 s26 DC 0 AC 33e-1 120
RI26 e26 15 68e-3
VS27 22 s27 0
C27 s27 23 33e-6
VS28 16 s28 0
R28 s28 2 10e1
VS29 3 s29 0
C29 s29 18 18e-7
VS30 13 s30 0
L30 s30 4 56e-5
VS31 3 s31 0
R31 s31 13 12e-2
VS32 6 s32 0
V32 e32 s32 DC 0 AC 15e1 -120
RI32 e32 23 15e-1
VS33 7 s33 0
R33 s33 23 56e-2
VS34 16 s34 0
L34 s34 6 18e-2
VS35 3 s35 0
V35 e35 s35 DC 0 AC 39e0 180
RI35 e35 11 18e-1
VS36 18 s36 0
V36 e36 s36 DC 0 AC 12e0 180
RI36 e36 14 10e-2
VS37 15 s37 0
L37 s37 2 68e-4
VS38 21 s38 0
V38 e38 s38 DC 0 AC 22e0 -120
RI38 e38 11 68e-1
.control
set numdgt=17
ac lin 1 60 60
print v(1) v(2) v(3) v(4) v(5) v(6) v(7) v(8) v(9) v(10)
print v(11) v(12) v(13) v(14) v(15) v(16) v(17) v(18) v(19) v(20)
print v(21) v(22) v(23) v(24)
print i(vs0) i(vs1) i(vs2) i(vs3) i(vs4) i(vs5) i(vs6) i(vs7) i(vs8) i(vs9)
print i(vs10) i(vs11) i(vs12) i(vs13) i(vs14) i(vs15) i(vs16) i(vs17) i(vs18) i(vs19)
print i(vs20) i(vs21) i(vs22) i(vs23) i(vs24) i(vs25) i(vs26) i(vs27) i(vs28) i(vs29)
print i(vs30) i(vs31) i(vs32) i(vs33) i(vs34) i(vs35) i(vs36) i(vs37) i(vs38)
.endc
.end
