controls oracle ac-0195
* Generated (plan F2.7, ADR 0012): do not edit; regenerate with `pnpm sim oracle regen`. ac seed 20261031 index 195 nodes 25 elements 34
.options sparse gmin=1e-12 noopac
RG1 1 0 1000000000000
RG2 2 0 1000000000000
RG3 3 0 1000000000000
RG4 4 0 1000000000000
RG5 5 0 1000000000000
RG6 6 0 1000000000000
RG7 7 0 1000000000000
RG8 8 0 1000000000000
RG9 9 0 1000000000000
RG10 10 0 1000000000000
RG11 11 0 1000000000000
RG12 12 0 1000000000000
RG13 13 0 1000000000000
RG14 14 0 1000000000000
RG15 15 0 1000000000000
RG16 16 0 1000000000000
RG17 17 0 1000000000000
RG18 18 0 1000000000000
RG19 19 0 1000000000000
RG20 20 0 1000000000000
RG21 21 0 1000000000000
RG22 22 0 1000000000000
RG23 23 0 1000000000000
RG24 24 0 1000000000000
VS0 19 s0 0
R0 s0 11 47e3
VS1 0 s1 0
V1 e1 s1 DC 0 AC 33e-1 120
RI1 e1 20 39e-3
VS2 2 s2 0
V2 e2 s2 DC 0 AC 56e0 -120
RI2 e2 20 22e-2
VS3 16 s3 0
R3 s3 0 18e2
VS4 5 s4 0
C4 s4 24 56e-6
VS5 1 s5 0
C5 s5 22 82e-4
VS6 21 s6 0
V6 e6 s6 DC 0 AC 22e0 -120
RI6 e6 11 68e-1
VS7 14 s7 0
L7 s7 20 15e-4
VS8 23 s8 0
R8 s8 0 56e-2
VS9 3 s9 0
V9 e9 s9 DC 0 AC 39e0 180
RI9 e9 11 18e-1
VS10 3 s10 0
R10 s10 13 12e-2
VS11 17 s11 0
R11 s11 3 22e3
VS12 13 s12 0
L12 s12 4 56e-5
VS13 7 s13 0
V13 e13 s13 DC 0 AC 33e0 120
RI13 e13 15 56e-1
VS14 11 s14 0
C14 s14 14 27e-6
VS15 7 s15 0
L15 s15 9 68e-2
VS16 17 s16 0
L16 s16 5 56e-2
VS17 19 s17 0
R17 s17 24 22e2
VS18 5 s18 0
C18 s18 11 82e-6
VS19 2 s19 0
R19 s19 4 56e0
VS20 23 s20 0
R20 s20 5 68e-1
VS21 14 s21 0
C21 s21 1 27e-7
VS22 18 s22 0
V22 e22 s22 DC 0 AC 12e0 180
RI22 e22 14 10e-2
VS23 1 s23 0
R23 s23 21 56e-1
VS24 6 s24 0
V24 e24 s24 DC 0 AC 15e1 -120
RI24 e24 0 15e-1
VS25 11 s25 0
R25 s25 12 56e3
VS26 10 s26 0
R26 s26 21 18e2
VS27 8 s27 0
R27 s27 9 18e0
VS28 1 s28 0
C28 s28 7 39e-7
VS29 14 s29 0
L29 s29 7 10e-2
VS30 7 s30 0
V30 e30 s30 DC 0 AC 39e-1 120
RI30 e30 4 56e-3
VS31 16 s31 0
R31 s31 2 10e1
VS32 3 s32 0
C32 s32 18 18e-7
VS33 16 s33 0
L33 s33 6 18e-2
.control
set numdgt=17
ac lin 1 60 60
print v(1) v(2) v(3) v(4) v(5) v(6) v(7) v(8) v(9) v(10)
print v(11) v(12) v(13) v(14) v(15) v(16) v(17) v(18) v(19) v(20)
print v(21) v(22) v(23) v(24)
print i(vs0) i(vs1) i(vs2) i(vs3) i(vs4) i(vs5) i(vs6) i(vs7) i(vs8) i(vs9)
print i(vs10) i(vs11) i(vs12) i(vs13) i(vs14) i(vs15) i(vs16) i(vs17) i(vs18) i(vs19)
print i(vs20) i(vs21) i(vs22) i(vs23) i(vs24) i(vs25) i(vs26) i(vs27) i(vs28) i(vs29)
print i(vs30) i(vs31) i(vs32) i(vs33)
.endc
.end
