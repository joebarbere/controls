controls oracle ac-0382
* Generated (plan F2.7, ADR 0012): do not edit; regenerate with `pnpm sim oracle regen`. ac seed 20261031 index 382 nodes 18 elements 34
.options sparse gmin=1e-12 noopac
RG1 1 0 1000000000000
RG2 2 0 1000000000000
RG3 3 0 1000000000000
RG4 4 0 1000000000000
RG5 5 0 1000000000000
RG6 6 0 1000000000000
RG7 7 0 1000000000000
RG8 8 0 1000000000000
RG9 9 0 1000000000000
RG10 10 0 1000000000000
RG11 11 0 1000000000000
RG12 12 0 1000000000000
RG13 13 0 1000000000000
RG14 14 0 1000000000000
RG15 15 0 1000000000000
RG16 16 0 1000000000000
RG17 17 0 1000000000000
VS0 11 s0 0
R0 s0 8 12e1
VS1 4 s1 0
L1 s1 6 22e-5
VS2 7 s2 0
R2 s2 8 68e3
VS3 16 s3 0
L3 s3 10 10e-3
VS4 11 s4 0
L4 s4 17 12e-3
VS5 0 s5 0
V5 e5 s5 DC 0 AC 47e-1 0
RI5 e5 17 39e-2
VS6 2 s6 0
L6 s6 10 10e-4
VS7 14 s7 0
L7 s7 5 82e-4
VS8 8 s8 0
C8 s8 3 18e-7
VS9 14 s9 0
V9 e9 s9 DC 0 AC 15e-1 -120
RI9 e9 5 68e-3
VS10 16 s10 0
L10 s10 0 12e-4
VS11 0 s11 0
L11 s11 4 33e-4
VS12 10 s12 0
L12 s12 9 10e-5
VS13 7 s13 0
L13 s13 10 39e-4
VS14 11 s14 0
L14 s14 6 47e-4
VS15 15 s15 0
C15 s15 9 27e-5
VS16 12 s16 0
V16 e16 s16 DC 0 AC 15e0 120
RI16 e16 15 12e-3
VS17 5 s17 0
R17 s17 17 18e-2
VS18 7 s18 0
L18 s18 12 15e-4
VS19 8 s19 0
C19 s19 9 39e-7
VS20 16 s20 0
L20 s20 3 12e-4
VS21 7 s21 0
C21 s21 17 82e-5
VS22 7 s22 0
L22 s22 14 56e-5
VS23 5 s23 0
V23 e23 s23 DC 0 AC 22e1 120
RI23 e23 15 68e-2
VS24 12 s24 0
R24 s24 16 56e0
VS25 15 s25 0
V25 e25 s25 DC 0 AC 22e0 120
RI25 e25 16 47e-3
VS26 8 s26 0
C26 s26 14 68e-7
VS27 10 s27 0
R27 s27 4 56e-2
VS28 13 s28 0
C28 s28 7 27e-5
VS29 3 s29 0
R29 s29 1 33e0
VS30 9 s30 0
R30 s30 11 27e1
VS31 0 s31 0
L31 s31 9 82e-4
VS32 17 s32 0
V32 e32 s32 DC 0 AC 82e0 120
RI32 e32 12 56e-2
VS33 13 s33 0
V33 e33 s33 DC 0 AC 33e1 180
RI33 e33 0 68e-3
.control
set numdgt=17
ac lin 1 60 60
print v(1) v(2) v(3) v(4) v(5) v(6) v(7) v(8) v(9) v(10)
print v(11) v(12) v(13) v(14) v(15) v(16) v(17)
print i(vs0) i(vs1) i(vs2) i(vs3) i(vs4) i(vs5) i(vs6) i(vs7) i(vs8) i(vs9)
print i(vs10) i(vs11) i(vs12) i(vs13) i(vs14) i(vs15) i(vs16) i(vs17) i(vs18) i(vs19)
print i(vs20) i(vs21) i(vs22) i(vs23) i(vs24) i(vs25) i(vs26) i(vs27) i(vs28) i(vs29)
print i(vs30) i(vs31) i(vs32) i(vs33)
.endc
.end
