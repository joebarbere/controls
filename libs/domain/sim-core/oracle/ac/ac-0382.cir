controls oracle ac-0382
* Generated (plan F2.7, ADR 0012): do not edit; regenerate with `pnpm sim oracle regen`. ac seed 20261031 index 382 nodes 18 elements 36
.options sparse gmin=1e-12 noopac
RG1 1 0 1000000000000
RG2 2 0 1000000000000
RG3 3 0 1000000000000
RG4 4 0 1000000000000
RG5 5 0 1000000000000
RG6 6 0 1000000000000
RG7 7 0 1000000000000
RG8 8 0 1000000000000
RG9 9 0 1000000000000
RG10 10 0 1000000000000
RG11 11 0 1000000000000
RG12 12 0 1000000000000
RG13 13 0 1000000000000
RG14 14 0 1000000000000
RG15 15 0 1000000000000
RG16 16 0 1000000000000
RG17 17 0 1000000000000
VS0 7 s0 0
L0 s0 14 56e-5
VS1 7 s1 0
L1 s1 10 39e-4
VS2 16 s2 0
L2 s2 10 10e-3
VS3 11 s3 0
R3 s3 17 12e1
VS4 16 s4 0
L4 s4 3 12e-4
VS5 11 s5 0
L5 s5 6 47e-4
VS6 9 s6 0
R6 s6 11 27e1
VS7 17 s7 0
C7 s7 9 39e-7
VS8 13 s8 0
C8 s8 7 27e-5
VS9 0 s9 0
V9 e9 s9 DC 0 AC 82e0 120
RI9 e9 n9 56e-2
H9 n9 h9 VS10 10e-4
ED9 h9 12 d9 0 33e-7
F9 0 d9 VS10 1
LD9 d9 0 1
VS10 2 s10 0
V10 e10 s10 DC 0 AC 47e1 180
RI10 e10 m10 39e-3
LI10 m10 n10 56e-6
H10 n10 h10 VS9 10e-4
ED10 h10 0 d10 0 33e-7
F10 0 d10 VS9 1
LD10 d10 0 1
VS11 13 s11 0
V11 e11 s11 DC 0 AC 33e1 180
RI11 e11 8 68e-3
VS12 10 s12 0
L12 s12 9 10e-5
VS13 8 s13 0
L13 s13 4 33e-4
VS14 6 s14 0
L14 s14 1 22e-2
VS15 15 s15 0
C15 s15 9 27e-5
VS16 7 s16 0
C16 s16 0 82e-5
VS17 7 s17 0
R17 s17 17 68e3
VS18 16 s18 0
L18 s18 8 12e-4
VS19 17 s19 0
C19 s19 14 68e-7
VS20 4 s20 0
L20 s20 6 22e-5
VS21 17 s21 0
C21 s21 3 18e-7
VS22 11 s22 0
L22 s22 0 12e-3
VS23 14 s23 0
L23 s23 5 82e-4
VS24 12 s24 0
R24 s24 16 56e0
VS25 5 s25 0
V25 e25 s25 DC 0 AC 22e1 120
RI25 e25 m25 68e-2
LI25 m25 15 47e-5
VS26 8 s26 0
V26 e26 s26 DC 0 AC 47e-1 0
RI26 e26 0 39e-2
VS27 2 s27 0
L27 s27 10 10e-4
VS28 15 s28 0
V28 e28 s28 DC 0 AC 22e0 120
RI28 e28 16 47e-3
VS29 8 s29 0
L29 s29 9 82e-4
VS30 10 s30 0
R30 s30 4 56e-2
VS31 7 s31 0
L31 s31 12 15e-4
VS32 5 s32 0
R32 s32 0 18e-2
VS33 3 s33 0
R33 s33 1 33e0
VS34 14 s34 0
V34 e34 s34 DC 0 AC 15e-1 -120
RI34 e34 5 68e-3
VS35 12 s35 0
V35 e35 s35 DC 0 AC 15e0 120
RI35 e35 15 12e-3
.control
set numdgt=17
ac lin 1 60 60
print v(1) v(2) v(3) v(4) v(5) v(6) v(7) v(8) v(9) v(10)
print v(11) v(12) v(13) v(14) v(15) v(16) v(17)
print i(vs0) i(vs1) i(vs2) i(vs3) i(vs4) i(vs5) i(vs6) i(vs7) i(vs8) i(vs9)
print i(vs10) i(vs11) i(vs12) i(vs13) i(vs14) i(vs15) i(vs16) i(vs17) i(vs18) i(vs19)
print i(vs20) i(vs21) i(vs22) i(vs23) i(vs24) i(vs25) i(vs26) i(vs27) i(vs28) i(vs29)
print i(vs30) i(vs31) i(vs32) i(vs33) i(vs34) i(vs35)
.endc
.end
