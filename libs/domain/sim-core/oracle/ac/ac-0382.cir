controls oracle ac-0382
* Generated (plan F2.7, ADR 0012): do not edit; regenerate with `pnpm sim oracle regen`. ac seed 20261031 index 382 nodes 18 elements 28
.options sparse gmin=1e-12 noopac
RG1 1 0 1000000000000
RG2 2 0 1000000000000
RG3 3 0 1000000000000
RG4 4 0 1000000000000
RG5 5 0 1000000000000
RG6 6 0 1000000000000
RG7 7 0 1000000000000
RG8 8 0 1000000000000
RG9 9 0 1000000000000
RG10 10 0 1000000000000
RG11 11 0 1000000000000
RG12 12 0 1000000000000
RG13 13 0 1000000000000
RG14 14 0 1000000000000
RG15 15 0 1000000000000
RG16 16 0 1000000000000
RG17 17 0 1000000000000
VS0 6 s0 0
R0 s0 15 47e0
VS1 2 s1 0
L1 s1 3 39e-5
VS2 0 s2 0
C2 s2 9 27e-5
VS3 15 s3 0
C3 s3 14 68e-7
VS4 0 s4 0
V4 e4 s4 DC 0 AC 22e0 120
RI4 e4 16 47e-3
VS5 15 s5 0
C5 s5 3 18e-7
VS6 13 s6 0
R6 s6 11 12e-2
VS7 8 s7 0
R7 s7 5 22e0
VS8 6 s8 0
L8 s8 11 12e-4
VS9 13 s9 0
V9 e9 s9 DC 0 AC 33e1 180
RI9 e9 m9 68e-3
LI9 m9 8 47e-7
VS10 4 s10 0
V10 e10 s10 DC 0 AC 18e1 180
RI10 e10 12 68e-1
VS11 12 s11 0
L11 s11 17 39e-3
VS12 7 s12 0
C12 s12 17 82e-5
VS13 11 s13 0
L13 s13 17 12e-3
VS14 8 s14 0
L14 s14 9 82e-4
VS15 5 s15 0
R15 s15 3 82e2
VS16 15 s16 0
C16 s16 9 39e-7
VS17 5 s17 0
R17 s17 17 18e-2
VS18 14 s18 0
C18 s18 16 33e-7
VS19 10 s19 0
L19 s19 9 10e-5
VS20 3 s20 0
R20 s20 1 33e0
VS21 2 s21 0
L21 s21 10 10e-4
VS22 9 s22 0
L22 s22 13 12e-4
VS23 7 s23 0
V23 e23 s23 DC 0 AC 82e1 180
RI23 e23 m23 68e-2
LI23 m23 3 12e-5
VS24 12 s24 0
V24 e24 s24 DC 0 AC 22e0 180
RI24 e24 15 68e-2
VS25 3 s25 0
R25 s25 17 39e-1
VS26 4 s26 0
L26 s26 17 12e-3
VS27 1 s27 0
R27 s27 10 10e-1
.control
set numdgt=17
ac lin 1 60 60
print v(1) v(2) v(3) v(4) v(5) v(6) v(7) v(8) v(9) v(10)
print v(11) v(12) v(13) v(14) v(15) v(16) v(17)
print i(vs0) i(vs1) i(vs2) i(vs3) i(vs4) i(vs5) i(vs6) i(vs7) i(vs8) i(vs9)
print i(vs10) i(vs11) i(vs12) i(vs13) i(vs14) i(vs15) i(vs16) i(vs17) i(vs18) i(vs19)
print i(vs20) i(vs21) i(vs22) i(vs23) i(vs24) i(vs25) i(vs26) i(vs27)
.endc
.end
