controls oracle ac-0007
* Generated (plan F2.7, ADR 0012): do not edit; regenerate with `pnpm sim oracle regen`. ac seed 20261031 index 7 nodes 29 elements 36
.options sparse gmin=1e-12 noopac
RG1 1 0 1000000000000
RG2 2 0 1000000000000
RG3 3 0 1000000000000
RG4 4 0 1000000000000
RG5 5 0 1000000000000
RG6 6 0 1000000000000
RG7 7 0 1000000000000
RG8 8 0 1000000000000
RG9 9 0 1000000000000
RG10 10 0 1000000000000
RG11 11 0 1000000000000
RG12 12 0 1000000000000
RG13 13 0 1000000000000
RG14 14 0 1000000000000
RG15 15 0 1000000000000
RG16 16 0 1000000000000
RG17 17 0 1000000000000
RG18 18 0 1000000000000
RG19 19 0 1000000000000
RG20 20 0 1000000000000
RG21 21 0 1000000000000
RG22 22 0 1000000000000
RG23 23 0 1000000000000
RG24 24 0 1000000000000
RG25 25 0 1000000000000
RG26 26 0 1000000000000
RG27 27 0 1000000000000
RG28 28 0 1000000000000
VS0 0 s0 0
V0 e0 s0 DC 0 AC 47e-1 120
RI0 e0 12 47e-3
VS1 6 s1 0
L1 s1 23 12e-3
VS2 18 s2 0
C2 s2 5 10e-4
VS3 25 s3 0
R3 s3 19 22e-1
VS4 10 s4 0
C4 s4 1 18e-6
VS5 5 s5 0
C5 s5 28 82e-4
VS6 4 s6 0
C6 s6 9 39e-4
VS7 27 s7 0
R7 s7 18 68e-2
VS8 11 s8 0
C8 s8 6 22e-6
VS9 6 s9 0
V9 e9 s9 DC 0 AC 47e1 0
RI9 e9 15 56e-2
VS10 11 s10 0
R10 s10 16 68e0
VS11 16 s11 0
R11 s11 0 12e2
VS12 13 s12 0
R12 s12 21 12e3
VS13 1 s13 0
R13 s13 8 10e2
VS14 22 s14 0
R14 s14 28 33e0
VS15 16 s15 0
L15 s15 10 15e-5
VS16 1 s16 0
C16 s16 17 82e-4
VS17 9 s17 0
C17 s17 15 68e-7
VS18 11 s18 0
R18 s18 14 12e0
VS19 4 s19 0
L19 s19 16 10e-4
VS20 15 s20 0
L20 s20 5 18e-3
VS21 17 s21 0
R21 s21 10 12e0
VS22 24 s22 0
L22 s22 16 82e-3
VS23 16 s23 0
R23 s23 18 39e3
VS24 10 s24 0
L24 s24 15 27e-2
VS25 15 s25 0
R25 s25 21 27e-1
VS26 15 s26 0
V26 e26 s26 DC 0 AC 56e0 120
RI26 e26 2 39e-2
VS27 23 s27 0
C27 s27 16 10e-6
VS28 27 s28 0
V28 e28 s28 DC 0 AC 18e0 0
RI28 e28 26 47e-3
VS29 20 s29 0
R29 s29 8 33e0
VS30 26 s30 0
R30 s30 25 15e-1
VS31 25 s31 0
R31 s31 1 47e0
VS32 7 s32 0
V32 e32 s32 DC 0 AC 68e-1 0
RI32 e32 26 10e-3
VS33 3 s33 0
R33 s33 28 68e2
VS34 8 s34 0
R34 s34 4 18e2
VS35 18 s35 0
V35 e35 s35 DC 0 AC 68e-1 120
RI35 e35 4 33e-3
.control
set numdgt=17
ac lin 1 60 60
print v(1) v(2) v(3) v(4) v(5) v(6) v(7) v(8) v(9) v(10)
print v(11) v(12) v(13) v(14) v(15) v(16) v(17) v(18) v(19) v(20)
print v(21) v(22) v(23) v(24) v(25) v(26) v(27) v(28)
print i(vs0) i(vs1) i(vs2) i(vs3) i(vs4) i(vs5) i(vs6) i(vs7) i(vs8) i(vs9)
print i(vs10) i(vs11) i(vs12) i(vs13) i(vs14) i(vs15) i(vs16) i(vs17) i(vs18) i(vs19)
print i(vs20) i(vs21) i(vs22) i(vs23) i(vs24) i(vs25) i(vs26) i(vs27) i(vs28) i(vs29)
print i(vs30) i(vs31) i(vs32) i(vs33) i(vs34) i(vs35)
.endc
.end
