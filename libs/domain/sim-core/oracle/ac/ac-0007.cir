controls oracle ac-0007
* Generated (plan F2.7, ADR 0012): do not edit; regenerate with `pnpm sim oracle regen`. ac seed 20261031 index 7 nodes 29 elements 45
.options sparse gmin=1e-12 noopac
RG1 1 0 1000000000000
RG2 2 0 1000000000000
RG3 3 0 1000000000000
RG4 4 0 1000000000000
RG5 5 0 1000000000000
RG6 6 0 1000000000000
RG7 7 0 1000000000000
RG8 8 0 1000000000000
RG9 9 0 1000000000000
RG10 10 0 1000000000000
RG11 11 0 1000000000000
RG12 12 0 1000000000000
RG13 13 0 1000000000000
RG14 14 0 1000000000000
RG15 15 0 1000000000000
RG16 16 0 1000000000000
RG17 17 0 1000000000000
RG18 18 0 1000000000000
RG19 19 0 1000000000000
RG20 20 0 1000000000000
RG21 21 0 1000000000000
RG22 22 0 1000000000000
RG23 23 0 1000000000000
RG24 24 0 1000000000000
RG25 25 0 1000000000000
RG26 26 0 1000000000000
RG27 27 0 1000000000000
RG28 28 0 1000000000000
VS0 9 s0 0
C0 s0 15 68e-7
VS1 23 s1 0
C1 s1 16 10e-6
VS2 19 s2 0
R2 s2 16 82e1
VS3 10 s3 0
C3 s3 1 18e-6
VS4 5 s4 0
C4 s4 28 82e-4
VS5 13 s5 0
R5 s5 21 12e3
VS6 0 s6 0
V6 e6 s6 DC 0 AC 47e-1 120
RI6 e6 12 47e-3
VS7 25 s7 0
R7 s7 1 47e0
VS8 16 s8 0
R8 s8 18 39e3
VS9 11 s9 0
C9 s9 6 22e-6
VS10 26 s10 0
R10 s10 25 15e-1
VS11 27 s11 0
R11 s11 18 68e-2
VS12 15 s12 0
L12 s12 5 18e-3
VS13 11 s13 0
R13 s13 16 68e0
VS14 17 s14 0
R14 s14 14 18e3
VS15 2 s15 0
L15 s15 11 12e-4
VS16 15 s16 0
R16 s16 21 27e-1
VS17 18 s17 0
V17 e17 s17 DC 0 AC 68e-1 120
RI17 e17 4 33e-3
VS18 11 s18 0
R18 s18 14 12e0
VS19 1 s19 0
C19 s19 17 82e-4
VS20 24 s20 0
R20 s20 8 82e2
VS21 6 s21 0
L21 s21 23 12e-3
VS22 20 s22 0
R22 s22 8 33e0
VS23 17 s23 0
R23 s23 10 12e0
VS24 18 s24 0
C24 s24 5 10e-4
VS25 12 s25 0
R25 s25 7 33e3
VS26 4 s26 0
C26 s26 9 39e-4
VS27 20 s27 0
R27 s27 3 82e0
VS28 8 s28 0
R28 s28 4 18e2
VS29 4 s29 0
L29 s29 16 10e-4
VS30 24 s30 0
L30 s30 16 82e-3
VS31 22 s31 0
R31 s31 28 33e0
VS32 15 s32 0
V32 e32 s32 DC 0 AC 56e0 120
RI32 e32 2 39e-2
VS33 3 s33 0
R33 s33 28 68e2
VS34 1 s34 0
R34 s34 8 10e2
VS35 6 s35 0
V35 e35 s35 DC 0 AC 47e1 0
RI35 e35 15 56e-2
VS36 20 s36 0
V36 e36 s36 DC 0 AC 22e-1 -120
RI36 e36 13 39e-2
VS37 25 s37 0
R37 s37 19 22e-1
VS38 5 s38 0
R38 s38 22 15e2
VS39 27 s39 0
V39 e39 s39 DC 0 AC 18e0 0
RI39 e39 26 47e-3
VS40 10 s40 0
L40 s40 15 27e-2
VS41 7 s41 0
V41 e41 s41 DC 0 AC 68e-1 0
RI41 e41 26 10e-3
VS42 16 s42 0
R42 s42 0 12e2
VS43 16 s43 0
L43 s43 10 15e-5
VS44 27 s44 0
V44 e44 s44 DC 0 AC 39e1 120
RI44 e44 20 15e-2
.control
set numdgt=17
ac lin 1 60 60
print v(1) v(2) v(3) v(4) v(5) v(6) v(7) v(8) v(9) v(10)
print v(11) v(12) v(13) v(14) v(15) v(16) v(17) v(18) v(19) v(20)
print v(21) v(22) v(23) v(24) v(25) v(26) v(27) v(28)
print i(vs0) i(vs1) i(vs2) i(vs3) i(vs4) i(vs5) i(vs6) i(vs7) i(vs8) i(vs9)
print i(vs10) i(vs11) i(vs12) i(vs13) i(vs14) i(vs15) i(vs16) i(vs17) i(vs18) i(vs19)
print i(vs20) i(vs21) i(vs22) i(vs23) i(vs24) i(vs25) i(vs26) i(vs27) i(vs28) i(vs29)
print i(vs30) i(vs31) i(vs32) i(vs33) i(vs34) i(vs35) i(vs36) i(vs37) i(vs38) i(vs39)
print i(vs40) i(vs41) i(vs42) i(vs43) i(vs44)
.endc
.end
