controls oracle ac-0007
* Generated (plan F2.7, ADR 0012): do not edit; regenerate with `pnpm sim oracle regen`. ac seed 20261031 index 7 nodes 29 elements 42
.options sparse gmin=1e-12 noopac
RG1 1 0 1000000000000
RG2 2 0 1000000000000
RG3 3 0 1000000000000
RG4 4 0 1000000000000
RG5 5 0 1000000000000
RG6 6 0 1000000000000
RG7 7 0 1000000000000
RG8 8 0 1000000000000
RG9 9 0 1000000000000
RG10 10 0 1000000000000
RG11 11 0 1000000000000
RG12 12 0 1000000000000
RG13 13 0 1000000000000
RG14 14 0 1000000000000
RG15 15 0 1000000000000
RG16 16 0 1000000000000
RG17 17 0 1000000000000
RG18 18 0 1000000000000
RG19 19 0 1000000000000
RG20 20 0 1000000000000
RG21 21 0 1000000000000
RG22 22 0 1000000000000
RG23 23 0 1000000000000
RG24 24 0 1000000000000
RG25 25 0 1000000000000
RG26 26 0 1000000000000
RG27 27 0 1000000000000
RG28 28 0 1000000000000
VS0 11 s0 0
C0 s0 23 27e-6
VS1 10 s1 0
R1 s1 26 56e1
VS2 8 s2 0
R2 s2 25 39e-1
VS3 17 s3 0
R3 s3 21 68e-2
VS4 0 s4 0
V4 e4 s4 DC 0 AC 47e-1 120
RI4 e4 12 47e-3
VS5 20 s5 0
L5 s5 11 12e-4
VS6 16 s6 0
L6 s6 10 15e-5
VS7 3 s7 0
C7 s7 16 39e-4
VS8 17 s8 0
V8 e8 s8 DC 0 AC 47e-1 -120
RI8 e8 26 15e-3
VS9 18 s9 0
V9 e9 s9 DC 0 AC 56e0 120
RI9 e9 m9 39e-2
LI9 m9 27 68e-6
VS10 10 s10 0
L10 s10 15 27e-2
VS11 3 s11 0
R11 s11 19 68e1
VS12 14 s12 0
R12 s12 11 12e3
VS13 21 s13 0
R13 s13 0 39e-2
VS14 23 s14 0
C14 s14 6 15e-7
VS15 11 s15 0
R15 s15 16 68e0
VS16 11 s16 0
R16 s16 13 22e-1
VS17 10 s17 0
R17 s17 4 27e-1
VS18 14 s18 0
R18 s18 4 82e-2
VS19 24 s19 0
L19 s19 6 68e-2
VS20 28 s20 0
R20 s20 27 15e3
VS21 25 s21 0
V21 e21 s21 DC 0 AC 82e0 -120
RI21 e21 m21 18e-2
LI21 m21 22 12e-5
VS22 15 s22 0
V22 e22 s22 DC 0 AC 27e0 0
RI22 e22 m22 10e-2
LI22 m22 7 33e-5
VS23 28 s23 0
L23 s23 0 12e-3
VS24 16 s24 0
R24 s24 0 12e2
VS25 12 s25 0
R25 s25 13 15e0
VS26 22 s26 0
V26 e26 s26 DC 0 AC 15e-1 -120
RI26 e26 m26 10e-1
LI26 m26 16 47e-6
VS27 8 s27 0
L27 s27 9 68e-2
VS28 5 s28 0
V28 e28 s28 DC 0 AC 12e1 -120
RI28 e28 m28 68e-3
LI28 m28 4 68e-7
VS29 28 s29 0
L29 s29 5 33e-3
VS30 24 s30 0
R30 s30 15 68e3
VS31 18 s31 0
R31 s31 0 39e-2
VS32 9 s32 0
C32 s32 20 56e-7
VS33 11 s33 0
V33 e33 s33 DC 0 AC 33e0 -120
RI33 e33 m33 82e-1
LI33 m33 2 10e-6
VS34 4 s34 0
C34 s34 26 10e-5
VS35 10 s35 0
R35 s35 1 15e-1
VS36 7 s36 0
V36 e36 s36 DC 0 AC 18e-1 180
RI36 e36 0 10e-2
VS37 2 s37 0
R37 s37 8 82e2
VS38 25 s38 0
R38 s38 11 22e3
VS39 12 s39 0
R39 s39 9 22e-1
VS40 1 s40 0
L40 s40 6 82e-2
VS41 19 s41 0
R41 s41 0 15e-1
.control
set numdgt=17
ac lin 1 60 60
print v(1) v(2) v(3) v(4) v(5) v(6) v(7) v(8) v(9) v(10)
print v(11) v(12) v(13) v(14) v(15) v(16) v(17) v(18) v(19) v(20)
print v(21) v(22) v(23) v(24) v(25) v(26) v(27) v(28)
print i(vs0) i(vs1) i(vs2) i(vs3) i(vs4) i(vs5) i(vs6) i(vs7) i(vs8) i(vs9)
print i(vs10) i(vs11) i(vs12) i(vs13) i(vs14) i(vs15) i(vs16) i(vs17) i(vs18) i(vs19)
print i(vs20) i(vs21) i(vs22) i(vs23) i(vs24) i(vs25) i(vs26) i(vs27) i(vs28) i(vs29)
print i(vs30) i(vs31) i(vs32) i(vs33) i(vs34) i(vs35) i(vs36) i(vs37) i(vs38) i(vs39)
print i(vs40) i(vs41)
.endc
.end
