controls oracle ac-0183
* Generated (plan F2.7, ADR 0012): do not edit; regenerate with `pnpm sim oracle regen`. ac seed 20261031 index 183 nodes 18 elements 27
.options sparse gmin=1e-12 noopac
RG1 1 0 1000000000000
RG2 2 0 1000000000000
RG3 3 0 1000000000000
RG4 4 0 1000000000000
RG5 5 0 1000000000000
RG6 6 0 1000000000000
RG7 7 0 1000000000000
RG8 8 0 1000000000000
RG9 9 0 1000000000000
RG10 10 0 1000000000000
RG11 11 0 1000000000000
RG12 12 0 1000000000000
RG13 13 0 1000000000000
RG14 14 0 1000000000000
RG15 15 0 1000000000000
RG16 16 0 1000000000000
RG17 17 0 1000000000000
VS0 2 s0 0
C0 s0 8 68e-5
VS1 0 s1 0
V1 e1 s1 DC 0 AC 10e-1 0
RI1 e1 6 33e-1
VS2 8 s2 0
L2 s2 14 18e-3
VS3 5 s3 0
L3 s3 4 15e-4
VS4 2 s4 0
C4 s4 14 27e-5
VS5 3 s5 0
R5 s5 8 82e1
VS6 9 s6 0
C6 s6 10 18e-4
VS7 10 s7 0
R7 s7 7 39e-2
VS8 0 s8 0
R8 s8 14 68e-1
VS9 11 s9 0
R9 s9 12 27e1
VS10 16 s10 0
R10 s10 14 56e2
VS11 9 s11 0
C11 s11 15 22e-6
VS12 8 s12 0
R12 s12 5 82e0
VS13 7 s13 0
R13 s13 13 82e0
VS14 6 s14 0
C14 s14 11 12e-5
VS15 17 s15 0
C15 s15 9 10e-7
VS16 7 s16 0
C16 s16 1 22e-4
VS17 14 s17 0
R17 s17 7 56e0
VS18 2 s18 0
L18 s18 11 27e-2
VS19 12 s19 0
R19 s19 1 27e2
VS20 4 s20 0
C20 s20 11 68e-5
VS21 4 s21 0
L21 s21 7 18e-2
VS22 3 s22 0
C22 s22 16 18e-5
VS23 8 s23 0
V23 e23 s23 DC 0 AC 10e0 180
RI23 e23 15 10e-1
VS24 11 s24 0
R24 s24 17 15e0
VS25 1 s25 0
L25 s25 3 10e-4
VS26 0 s26 0
R26 s26 13 56e3
.control
set numdgt=17
ac lin 1 60 60
print v(1) v(2) v(3) v(4) v(5) v(6) v(7) v(8) v(9) v(10)
print v(11) v(12) v(13) v(14) v(15) v(16) v(17)
print i(vs0) i(vs1) i(vs2) i(vs3) i(vs4) i(vs5) i(vs6) i(vs7) i(vs8) i(vs9)
print i(vs10) i(vs11) i(vs12) i(vs13) i(vs14) i(vs15) i(vs16) i(vs17) i(vs18) i(vs19)
print i(vs20) i(vs21) i(vs22) i(vs23) i(vs24) i(vs25) i(vs26)
.endc
.end
