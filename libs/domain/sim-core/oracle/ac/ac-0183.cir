controls oracle ac-0183
* Generated (plan F2.7, ADR 0012): do not edit; regenerate with `pnpm sim oracle regen`. ac seed 20261031 index 183 nodes 18 elements 32
.options sparse gmin=1e-12 noopac
RG1 1 0 1000000000000
RG2 2 0 1000000000000
RG3 3 0 1000000000000
RG4 4 0 1000000000000
RG5 5 0 1000000000000
RG6 6 0 1000000000000
RG7 7 0 1000000000000
RG8 8 0 1000000000000
RG9 9 0 1000000000000
RG10 10 0 1000000000000
RG11 11 0 1000000000000
RG12 12 0 1000000000000
RG13 13 0 1000000000000
RG14 14 0 1000000000000
RG15 15 0 1000000000000
RG16 16 0 1000000000000
RG17 17 0 1000000000000
VS0 8 s0 0
R0 s0 5 82e0
VS1 14 s1 0
C1 s1 15 12e-4
VS2 2 s2 0
C2 s2 17 22e-4
VS3 3 s3 0
R3 s3 8 82e1
VS4 15 s4 0
R4 s4 7 18e3
VS5 13 s5 0
C5 s5 14 22e-7
VS6 4 s6 0
C6 s6 11 68e-5
VS7 0 s7 0
V7 e7 s7 DC 0 AC 82e0 -120
RI7 e7 m7 18e-3
LI7 m7 13 33e-7
VS8 11 s8 0
R8 s8 12 27e1
VS9 14 s9 0
R9 s9 10 56e3
VS10 6 s10 0
C10 s10 11 33e-4
VS11 17 s11 0
R11 s11 9 39e-2
VS12 0 s12 0
L12 s12 8 15e-3
VS13 4 s13 0
R13 s13 14 10e2
VS14 6 s14 0
R14 s14 15 47e3
VS15 0 s15 0
L15 s15 5 47e-2
VS16 7 s16 0
L16 s16 3 10e-4
VS17 3 s17 0
V17 e17 s17 DC 0 AC 27e-1 0
RI17 e17 m17 68e-1
LI17 m17 1 15e-7
VS18 8 s18 0
L18 s18 14 18e-3
VS19 2 s19 0
L19 s19 16 82e-2
VS20 16 s20 0
L20 s20 1 56e-4
VS21 10 s21 0
L21 s21 15 47e-4
VS22 12 s22 0
R22 s22 7 27e2
VS23 2 s23 0
R23 s23 4 56e2
VS24 9 s24 0
C24 s24 8 22e-6
VS25 11 s25 0
V25 e25 s25 DC 0 AC 12e-1 180
RI25 e25 9 15e-1
VS26 7 s26 0
L26 s26 13 15e-4
VS27 14 s27 0
C27 s27 15 22e-4
VS28 0 s28 0
R28 s28 7 15e2
VS29 13 s29 0
C29 s29 11 68e-7
VS30 8 s30 0
V30 e30 s30 DC 0 AC 10e0 180
RI30 e30 15 10e-1
VS31 5 s31 0
L31 s31 1 39e-2
.control
set numdgt=17
ac lin 1 60 60
print v(1) v(2) v(3) v(4) v(5) v(6) v(7) v(8) v(9) v(10)
print v(11) v(12) v(13) v(14) v(15) v(16) v(17)
print i(vs0) i(vs1) i(vs2) i(vs3) i(vs4) i(vs5) i(vs6) i(vs7) i(vs8) i(vs9)
print i(vs10) i(vs11) i(vs12) i(vs13) i(vs14) i(vs15) i(vs16) i(vs17) i(vs18) i(vs19)
print i(vs20) i(vs21) i(vs22) i(vs23) i(vs24) i(vs25) i(vs26) i(vs27) i(vs28) i(vs29)
print i(vs30) i(vs31)
.endc
.end
