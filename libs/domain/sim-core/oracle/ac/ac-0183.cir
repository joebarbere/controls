controls oracle ac-0183
* Generated (plan F2.7, ADR 0012): do not edit; regenerate with `pnpm sim oracle regen`. ac seed 20261031 index 183 nodes 18 elements 25
.options sparse gmin=1e-12 noopac
RG1 1 0 1000000000000
RG2 2 0 1000000000000
RG3 3 0 1000000000000
RG4 4 0 1000000000000
RG5 5 0 1000000000000
RG6 6 0 1000000000000
RG7 7 0 1000000000000
RG8 8 0 1000000000000
RG9 9 0 1000000000000
RG10 10 0 1000000000000
RG11 11 0 1000000000000
RG12 12 0 1000000000000
RG13 13 0 1000000000000
RG14 14 0 1000000000000
RG15 15 0 1000000000000
RG16 16 0 1000000000000
RG17 17 0 1000000000000
VS0 5 s0 0
L0 s0 4 15e-4
VS1 0 s1 0
R1 s1 5 82e0
VS2 2 s2 0
L2 s2 11 27e-2
VS3 11 s3 0
R3 s3 12 27e1
VS4 0 s4 0
V4 e4 s4 DC 0 AC 10e0 180
RI4 e4 15 10e-1
VS5 4 s5 0
C5 s5 11 68e-5
VS6 7 s6 0
C6 s6 8 22e-4
VS7 1 s7 0
R7 s7 13 56e3
VS8 2 s8 0
C8 s8 0 68e-5
VS9 9 s9 0
C9 s9 15 22e-6
VS10 8 s10 0
L10 s10 3 10e-4
VS11 9 s11 0
C11 s11 10 18e-4
VS12 3 s12 0
C12 s12 16 18e-5
VS13 2 s13 0
C13 s13 14 27e-5
VS14 0 s14 0
L14 s14 14 18e-3
VS15 3 s15 0
R15 s15 0 82e1
VS16 11 s16 0
R16 s16 17 15e0
VS17 12 s17 0
R17 s17 8 27e2
VS18 17 s18 0
C18 s18 9 10e-7
VS19 14 s19 0
R19 s19 7 56e0
VS20 4 s20 0
L20 s20 7 18e-2
VS21 10 s21 0
R21 s21 7 39e-2
VS22 1 s22 0
R22 s22 14 68e-1
VS23 6 s23 0
C23 s23 11 12e-5
VS24 16 s24 0
R24 s24 14 56e2
.control
set numdgt=17
ac lin 1 60 60
print v(1) v(2) v(3) v(4) v(5) v(6) v(7) v(8) v(9) v(10)
print v(11) v(12) v(13) v(14) v(15) v(16) v(17)
print i(vs0) i(vs1) i(vs2) i(vs3) i(vs4) i(vs5) i(vs6) i(vs7) i(vs8) i(vs9)
print i(vs10) i(vs11) i(vs12) i(vs13) i(vs14) i(vs15) i(vs16) i(vs17) i(vs18) i(vs19)
print i(vs20) i(vs21) i(vs22) i(vs23) i(vs24)
.endc
.end
