controls oracle ac-0454
* Generated (plan F2.7, ADR 0012): do not edit; regenerate with `pnpm sim oracle regen`. ac seed 20261031 index 454 nodes 19 elements 36
.options sparse gmin=1e-12 noopac
RG1 1 0 1000000000000
RG2 2 0 1000000000000
RG3 3 0 1000000000000
RG4 4 0 1000000000000
RG5 5 0 1000000000000
RG6 6 0 1000000000000
RG7 7 0 1000000000000
RG8 8 0 1000000000000
RG9 9 0 1000000000000
RG10 10 0 1000000000000
RG11 11 0 1000000000000
RG12 12 0 1000000000000
RG13 13 0 1000000000000
RG14 14 0 1000000000000
RG15 15 0 1000000000000
RG16 16 0 1000000000000
RG17 17 0 1000000000000
RG18 18 0 1000000000000
VS0 5 s0 0
L0 s0 16 27e-2
VS1 14 s1 0
R1 s1 7 12e1
VS2 0 s2 0
V2 e2 s2 DC 0 AC 82e0 0
RI2 e2 m2 15e-1
LI2 m2 n2 33e-6
H2 n2 h2 VS8 -33e-2
ED2 h2 1 d2 0 -33e-5
F2 0 d2 VS8 1
LD2 d2 0 1
VS3 18 s3 0
C3 s3 7 18e-7
VS4 7 s4 0
L4 s4 4 82e-5
VS5 18 s5 0
L5 s5 2 47e-3
VS6 11 s6 0
C6 s6 10 33e-5
VS7 9 s7 0
L7 s7 8 22e-4
VS8 3 s8 0
V8 e8 s8 DC 0 AC 47e0 -120
RI8 e8 n8 10e-1
H8 n8 h8 VS2 -33e-2
ED8 h8 17 d8 0 -33e-5
F8 0 d8 VS2 1
LD8 d8 0 1
VS9 5 s9 0
V9 e9 s9 DC 0 AC 33e0 120
RI9 e9 m9 15e-1
LI9 m9 6 82e-7
VS10 0 s10 0
L10 s10 2 39e-4
VS11 4 s11 0
L11 s11 11 27e-3
VS12 12 s12 0
R12 s12 13 27e-2
VS13 5 s13 0
R13 s13 14 12e-1
VS14 7 s14 0
R14 s14 18 33e-2
VS15 10 s15 0
V15 e15 s15 DC 0 AC 22e0 120
RI15 e15 m15 22e-3
LI15 m15 9 10e-6
VS16 18 s16 0
R16 s16 11 33e1
VS17 11 s17 0
V17 e17 s17 DC 0 AC 47e-1 120
RI17 e17 m17 68e-2
LI17 m17 5 10e-7
VS18 5 s18 0
R18 s18 3 56e1
VS19 8 s19 0
L19 s19 5 56e-4
VS20 3 s20 0
L20 s20 10 10e-4
VS21 0 s21 0
L21 s21 11 12e-3
VS22 16 s22 0
R22 s22 3 10e-1
VS23 7 s23 0
R23 s23 12 15e2
VS24 7 s24 0
C24 s24 15 10e-4
VS25 4 s25 0
L25 s25 0 18e-5
VS26 3 s26 0
R26 s26 6 18e1
VS27 13 s27 0
L27 s27 11 12e-4
VS28 1 s28 0
C28 s28 16 47e-6
VS29 2 s29 0
C29 s29 17 56e-7
VS30 18 s30 0
V30 e30 s30 DC 0 AC 47e-1 0
RI30 e30 3 18e-2
VS31 7 s31 0
V31 e31 s31 DC 0 AC 15e-1 0
RI31 e31 5 33e-3
VS32 15 s32 0
R32 s32 2 56e-1
VS33 18 s33 0
L33 s33 5 33e-5
VS34 12 s34 0
R34 s34 16 33e-2
VS35 2 s35 0
R35 s35 4 56e-1
.control
set numdgt=17
ac lin 1 60 60
print v(1) v(2) v(3) v(4) v(5) v(6) v(7) v(8) v(9) v(10)
print v(11) v(12) v(13) v(14) v(15) v(16) v(17) v(18)
print i(vs0) i(vs1) i(vs2) i(vs3) i(vs4) i(vs5) i(vs6) i(vs7) i(vs8) i(vs9)
print i(vs10) i(vs11) i(vs12) i(vs13) i(vs14) i(vs15) i(vs16) i(vs17) i(vs18) i(vs19)
print i(vs20) i(vs21) i(vs22) i(vs23) i(vs24) i(vs25) i(vs26) i(vs27) i(vs28) i(vs29)
print i(vs30) i(vs31) i(vs32) i(vs33) i(vs34) i(vs35)
.endc
.end
