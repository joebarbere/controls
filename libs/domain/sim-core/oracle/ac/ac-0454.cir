controls oracle ac-0454
* Generated (plan F2.7, ADR 0012): do not edit; regenerate with `pnpm sim oracle regen`. ac seed 20261031 index 454 nodes 19 elements 31
.options sparse gmin=1e-12 noopac
RG1 1 0 1000000000000
RG2 2 0 1000000000000
RG3 3 0 1000000000000
RG4 4 0 1000000000000
RG5 5 0 1000000000000
RG6 6 0 1000000000000
RG7 7 0 1000000000000
RG8 8 0 1000000000000
RG9 9 0 1000000000000
RG10 10 0 1000000000000
RG11 11 0 1000000000000
RG12 12 0 1000000000000
RG13 13 0 1000000000000
RG14 14 0 1000000000000
RG15 15 0 1000000000000
RG16 16 0 1000000000000
RG17 17 0 1000000000000
RG18 18 0 1000000000000
VS0 4 s0 0
L0 s0 3 18e-5
VS1 18 s1 0
C1 s1 7 18e-7
VS2 5 s2 0
L2 s2 16 27e-2
VS3 12 s3 0
R3 s3 13 27e-2
VS4 0 s4 0
V4 e4 s4 DC 0 AC 47e0 -120
RI4 e4 17 10e-1
VS5 5 s5 0
R5 s5 0 56e1
VS6 5 s6 0
R6 s6 14 12e-1
VS7 1 s7 0
C7 s7 16 47e-6
VS8 2 s8 0
C8 s8 17 56e-7
VS9 7 s9 0
V9 e9 s9 DC 0 AC 15e-1 0
RI9 e9 5 33e-3
VS10 18 s10 0
R10 s10 11 33e1
VS11 0 s11 0
L11 s11 10 10e-4
VS12 18 s12 0
L12 s12 2 47e-3
VS13 14 s13 0
R13 s13 7 12e1
VS14 7 s14 0
C14 s14 15 10e-4
VS15 11 s15 0
C15 s15 10 33e-5
VS16 4 s16 0
L16 s16 11 27e-3
VS17 7 s17 0
L17 s17 4 82e-5
VS18 16 s18 0
R18 s18 0 10e-1
VS19 18 s19 0
L19 s19 5 33e-5
VS20 12 s20 0
R20 s20 16 33e-2
VS21 11 s21 0
V21 e21 s21 DC 0 AC 47e-1 120
RI21 e21 5 68e-2
VS22 7 s22 0
R22 s22 12 15e2
VS23 3 s23 0
L23 s23 2 39e-4
VS24 7 s24 0
R24 s24 18 33e-2
VS25 10 s25 0
V25 e25 s25 DC 0 AC 22e0 120
RI25 e25 9 22e-3
VS26 3 s26 0
L26 s26 11 12e-3
VS27 5 s27 0
V27 e27 s27 DC 0 AC 33e0 120
RI27 e27 6 15e-1
VS28 2 s28 0
R28 s28 4 56e-1
VS29 8 s29 0
L29 s29 5 56e-4
VS30 18 s30 0
V30 e30 s30 DC 0 AC 47e-1 0
RI30 e30 0 18e-2
.control
set numdgt=17
ac lin 1 60 60
print v(1) v(2) v(3) v(4) v(5) v(6) v(7) v(8) v(9) v(10)
print v(11) v(12) v(13) v(14) v(15) v(16) v(17) v(18)
print i(vs0) i(vs1) i(vs2) i(vs3) i(vs4) i(vs5) i(vs6) i(vs7) i(vs8) i(vs9)
print i(vs10) i(vs11) i(vs12) i(vs13) i(vs14) i(vs15) i(vs16) i(vs17) i(vs18) i(vs19)
print i(vs20) i(vs21) i(vs22) i(vs23) i(vs24) i(vs25) i(vs26) i(vs27) i(vs28) i(vs29)
print i(vs30)
.endc
.end
