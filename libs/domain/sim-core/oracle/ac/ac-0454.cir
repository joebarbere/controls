controls oracle ac-0454
* Generated (plan F2.7, ADR 0012): do not edit; regenerate with `pnpm sim oracle regen`. ac seed 20261031 index 454 nodes 19 elements 27
.options sparse gmin=1e-12 noopac
RG1 1 0 1000000000000
RG2 2 0 1000000000000
RG3 3 0 1000000000000
RG4 4 0 1000000000000
RG5 5 0 1000000000000
RG6 6 0 1000000000000
RG7 7 0 1000000000000
RG8 8 0 1000000000000
RG9 9 0 1000000000000
RG10 10 0 1000000000000
RG11 11 0 1000000000000
RG12 12 0 1000000000000
RG13 13 0 1000000000000
RG14 14 0 1000000000000
RG15 15 0 1000000000000
RG16 16 0 1000000000000
RG17 17 0 1000000000000
RG18 18 0 1000000000000
VS0 4 s0 0
L0 s0 3 82e-5
VS1 14 s1 0
L1 s1 2 18e-4
VS2 0 s2 0
V2 e2 s2 DC 0 AC 18e-1 180
RI2 e2 17 18e-2
VS3 1 s3 0
C3 s3 16 47e-6
VS4 1 s4 0
V4 e4 s4 DC 0 AC 12e1 120
RI4 e4 m4 15e-1
LI4 m4 11 39e-7
VS5 16 s5 0
R5 s5 2 10e-1
VS6 13 s6 0
L6 s6 15 27e-2
VS7 9 s7 0
V7 e7 s7 DC 0 AC 56e-1 120
RI7 e7 12 22e-3
VS8 18 s8 0
L8 s8 5 33e-5
VS9 10 s9 0
L9 s9 9 22e-2
VS10 1 s10 0
C10 s10 7 18e-7
VS11 16 s11 0
R11 s11 4 47e3
VS12 3 s12 0
C12 s12 11 18e-7
VS13 5 s13 0
V13 e13 s13 DC 0 AC 33e0 120
RI13 e13 6 15e-1
VS14 15 s14 0
L14 s14 9 12e-3
VS15 8 s15 0
L15 s15 4 27e-3
VS16 5 s16 0
R16 s16 2 56e1
VS17 18 s17 0
C17 s17 1 18e-7
VS18 7 s18 0
L18 s18 8 39e-3
VS19 12 s19 0
L19 s19 10 68e-5
VS20 5 s20 0
R20 s20 0 12e-1
VS21 2 s21 0
L21 s21 10 10e-4
VS22 17 s22 0
V22 e22 s22 DC 0 AC 56e1 120
RI22 e22 m22 22e-3
LI22 m22 8 12e-6
VS23 11 s23 0
R23 s23 13 56e2
VS24 2 s24 0
V24 e24 s24 DC 0 AC 47e0 -120
RI24 e24 m24 10e-1
LI24 m24 17 39e-6
VS25 9 s25 0
C25 s25 14 15e-7
VS26 15 s26 0
L26 s26 6 15e-5
.control
set numdgt=17
ac lin 1 60 60
print v(1) v(2) v(3) v(4) v(5) v(6) v(7) v(8) v(9) v(10)
print v(11) v(12) v(13) v(14) v(15) v(16) v(17) v(18)
print i(vs0) i(vs1) i(vs2) i(vs3) i(vs4) i(vs5) i(vs6) i(vs7) i(vs8) i(vs9)
print i(vs10) i(vs11) i(vs12) i(vs13) i(vs14) i(vs15) i(vs16) i(vs17) i(vs18) i(vs19)
print i(vs20) i(vs21) i(vs22) i(vs23) i(vs24) i(vs25) i(vs26)
.endc
.end
