controls oracle ac-0349
* Generated (plan F2.7, ADR 0012): do not edit; regenerate with `pnpm sim oracle regen`. ac seed 20261031 index 349 nodes 27 elements 39
.options sparse gmin=1e-12 noopac
RG1 1 0 1000000000000
RG2 2 0 1000000000000
RG3 3 0 1000000000000
RG4 4 0 1000000000000
RG5 5 0 1000000000000
RG6 6 0 1000000000000
RG7 7 0 1000000000000
RG8 8 0 1000000000000
RG9 9 0 1000000000000
RG10 10 0 1000000000000
RG11 11 0 1000000000000
RG12 12 0 1000000000000
RG13 13 0 1000000000000
RG14 14 0 1000000000000
RG15 15 0 1000000000000
RG16 16 0 1000000000000
RG17 17 0 1000000000000
RG18 18 0 1000000000000
RG19 19 0 1000000000000
RG20 20 0 1000000000000
RG21 21 0 1000000000000
RG22 22 0 1000000000000
RG23 23 0 1000000000000
RG24 24 0 1000000000000
RG25 25 0 1000000000000
RG26 26 0 1000000000000
VS0 11 s0 0
R0 s0 13 39e-2
VS1 0 s1 0
V1 e1 s1 DC 0 AC 33e0 180
RI1 e1 3 22e-1
VS2 14 s2 0
L2 s2 8 22e-2
VS3 15 s3 0
L3 s3 9 82e-5
VS4 11 s4 0
V4 e4 s4 DC 0 AC 47e0 0
RI4 e4 3 47e-1
VS5 9 s5 0
R5 s5 5 12e-1
VS6 21 s6 0
R6 s6 13 15e1
VS7 5 s7 0
R7 s7 23 18e3
VS8 25 s8 0
C8 s8 16 27e-6
VS9 11 s9 0
C9 s9 25 33e-4
VS10 23 s10 0
C10 s10 2 18e-7
VS11 18 s11 0
R11 s11 19 82e-1
VS12 7 s12 0
V12 e12 s12 DC 0 AC 12e1 120
RI12 e12 m12 47e-2
LI12 m12 16 10e-6
VS13 6 s13 0
C13 s13 17 18e-4
VS14 11 s14 0
L14 s14 20 82e-5
VS15 10 s15 0
C15 s15 17 18e-4
VS16 26 s16 0
R16 s16 3 22e2
VS17 24 s17 0
R17 s17 17 56e1
VS18 2 s18 0
L18 s18 11 82e-4
VS19 24 s19 0
L19 s19 18 33e-5
VS20 15 s20 0
R20 s20 6 12e2
VS21 7 s21 0
V21 e21 s21 DC 0 AC 22e-1 0
RI21 e21 m21 82e-2
LI21 m21 9 33e-5
VS22 4 s22 0
L22 s22 25 12e-4
VS23 15 s23 0
R23 s23 6 56e-1
VS24 11 s24 0
C24 s24 26 15e-7
VS25 25 s25 0
R25 s25 8 56e2
VS26 11 s26 0
C26 s26 18 18e-6
VS27 23 s27 0
C27 s27 15 12e-5
VS28 22 s28 0
R28 s28 12 68e1
VS29 12 s29 0
V29 e29 s29 DC 0 AC 39e-1 120
RI29 e29 6 22e-1
VS30 3 s30 0
C30 s30 1 18e-4
VS31 4 s31 0
R31 s31 22 33e2
VS32 10 s32 0
C32 s32 6 56e-6
VS33 19 s33 0
R33 s33 23 47e2
VS34 24 s34 0
R34 s34 20 68e-1
VS35 1 s35 0
V35 e35 s35 DC 0 AC 27e0 180
RI35 e35 22 10e-2
VS36 15 s36 0
V36 e36 s36 DC 0 AC 12e0 120
RI36 e36 m36 12e-3
LI36 m36 14 27e-5
VS37 21 s37 0
R37 s37 24 27e-2
VS38 21 s38 0
V38 e38 s38 DC 0 AC 10e1 0
RI38 e38 0 33e-3
.control
set numdgt=17
ac lin 1 60 60
print v(1) v(2) v(3) v(4) v(5) v(6) v(7) v(8) v(9) v(10)
print v(11) v(12) v(13) v(14) v(15) v(16) v(17) v(18) v(19) v(20)
print v(21) v(22) v(23) v(24) v(25) v(26)
print i(vs0) i(vs1) i(vs2) i(vs3) i(vs4) i(vs5) i(vs6) i(vs7) i(vs8) i(vs9)
print i(vs10) i(vs11) i(vs12) i(vs13) i(vs14) i(vs15) i(vs16) i(vs17) i(vs18) i(vs19)
print i(vs20) i(vs21) i(vs22) i(vs23) i(vs24) i(vs25) i(vs26) i(vs27) i(vs28) i(vs29)
print i(vs30) i(vs31) i(vs32) i(vs33) i(vs34) i(vs35) i(vs36) i(vs37) i(vs38)
.endc
.end
