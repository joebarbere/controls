controls oracle ac-0349
* Generated (plan F2.7, ADR 0012): do not edit; regenerate with `pnpm sim oracle regen`. ac seed 20261031 index 349 nodes 27 elements 40
.options sparse gmin=1e-12 noopac
RG1 1 0 1000000000000
RG2 2 0 1000000000000
RG3 3 0 1000000000000
RG4 4 0 1000000000000
RG5 5 0 1000000000000
RG6 6 0 1000000000000
RG7 7 0 1000000000000
RG8 8 0 1000000000000
RG9 9 0 1000000000000
RG10 10 0 1000000000000
RG11 11 0 1000000000000
RG12 12 0 1000000000000
RG13 13 0 1000000000000
RG14 14 0 1000000000000
RG15 15 0 1000000000000
RG16 16 0 1000000000000
RG17 17 0 1000000000000
RG18 18 0 1000000000000
RG19 19 0 1000000000000
RG20 20 0 1000000000000
RG21 21 0 1000000000000
RG22 22 0 1000000000000
RG23 23 0 1000000000000
RG24 24 0 1000000000000
RG25 25 0 1000000000000
RG26 26 0 1000000000000
VS0 15 s0 0
C0 s0 26 47e-6
VS1 0 s1 0
V1 e1 s1 DC 0 AC 82e-1 180
RI1 e1 1 18e-2
VS2 3 s2 0
R2 s2 4 12e1
VS3 10 s3 0
C3 s3 12 82e-7
VS4 7 s4 0
R4 s4 8 12e2
VS5 14 s5 0
C5 s5 2 56e-6
VS6 6 s6 0
R6 s6 16 68e3
VS7 8 s7 0
R7 s7 0 22e0
VS8 9 s8 0
L8 s8 3 82e-5
VS9 13 s9 0
L9 s9 19 15e-4
VS10 21 s10 0
R10 s10 24 68e3
VS11 24 s11 0
R11 s11 20 68e-1
VS12 14 s12 0
V12 e12 s12 DC 0 AC 15e1 120
RI12 e12 1 22e-2
VS13 11 s13 0
V13 e13 s13 DC 0 AC 47e0 0
RI13 e13 0 47e-1
VS14 7 s14 0
V14 e14 s14 DC 0 AC 22e-1 0
RI14 e14 9 82e-2
VS15 11 s15 0
C15 s15 3 18e-6
VS16 20 s16 0
L16 s16 8 10e-4
VS17 17 s17 0
L17 s17 9 27e-3
VS18 15 s18 0
V18 e18 s18 DC 0 AC 18e-1 0
RI18 e18 25 15e-1
VS19 18 s19 0
R19 s19 0 12e-2
VS20 7 s20 0
L20 s20 12 47e-4
VS21 1 s21 0
R21 s21 24 10e-1
VS22 18 s22 0
V22 e22 s22 DC 0 AC 18e1 -120
RI22 e22 23 47e-1
VS23 3 s23 0
R23 s23 19 82e-1
VS24 18 s24 0
L24 s24 16 12e-3
VS25 15 s25 0
L25 s25 1 33e-2
VS26 12 s26 0
R26 s26 17 39e-1
VS27 20 s27 0
L27 s27 1 47e-2
VS28 2 s28 0
R28 s28 21 47e0
VS29 16 s29 0
L29 s29 6 68e-4
VS30 22 s30 0
V30 e30 s30 DC 0 AC 18e-1 120
RI30 e30 8 82e-2
VS31 16 s31 0
L31 s31 2 68e-3
VS32 5 s32 0
C32 s32 22 18e-6
VS33 10 s33 0
R33 s33 13 39e2
VS34 18 s34 0
C34 s34 25 82e-6
VS35 5 s35 0
L35 s35 18 15e-5
VS36 0 s36 0
R36 s36 2 82e3
VS37 19 s37 0
C37 s37 4 12e-5
VS38 9 s38 0
V38 e38 s38 DC 0 AC 68e0 0
RI38 e38 13 39e-3
VS39 6 s39 0
L39 s39 12 10e-2
.control
set numdgt=17
ac lin 1 60 60
print v(1) v(2) v(3) v(4) v(5) v(6) v(7) v(8) v(9) v(10)
print v(11) v(12) v(13) v(14) v(15) v(16) v(17) v(18) v(19) v(20)
print v(21) v(22) v(23) v(24) v(25) v(26)
print i(vs0) i(vs1) i(vs2) i(vs3) i(vs4) i(vs5) i(vs6) i(vs7) i(vs8) i(vs9)
print i(vs10) i(vs11) i(vs12) i(vs13) i(vs14) i(vs15) i(vs16) i(vs17) i(vs18) i(vs19)
print i(vs20) i(vs21) i(vs22) i(vs23) i(vs24) i(vs25) i(vs26) i(vs27) i(vs28) i(vs29)
print i(vs30) i(vs31) i(vs32) i(vs33) i(vs34) i(vs35) i(vs36) i(vs37) i(vs38) i(vs39)
.endc
.end
