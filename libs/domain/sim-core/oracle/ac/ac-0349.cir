controls oracle ac-0349
* Generated (plan F2.7, ADR 0012): do not edit; regenerate with `pnpm sim oracle regen`. ac seed 20261031 index 349 nodes 27 elements 42
.options sparse gmin=1e-12 noopac
RG1 1 0 1000000000000
RG2 2 0 1000000000000
RG3 3 0 1000000000000
RG4 4 0 1000000000000
RG5 5 0 1000000000000
RG6 6 0 1000000000000
RG7 7 0 1000000000000
RG8 8 0 1000000000000
RG9 9 0 1000000000000
RG10 10 0 1000000000000
RG11 11 0 1000000000000
RG12 12 0 1000000000000
RG13 13 0 1000000000000
RG14 14 0 1000000000000
RG15 15 0 1000000000000
RG16 16 0 1000000000000
RG17 17 0 1000000000000
RG18 18 0 1000000000000
RG19 19 0 1000000000000
RG20 20 0 1000000000000
RG21 21 0 1000000000000
RG22 22 0 1000000000000
RG23 23 0 1000000000000
RG24 24 0 1000000000000
RG25 25 0 1000000000000
RG26 26 0 1000000000000
VS0 26 s0 0
C0 s0 14 39e-5
VS1 15 s1 0
L1 s1 1 33e-2
VS2 0 s2 0
V2 e2 s2 DC 0 AC 68e0 0
RI2 e2 n2 39e-3
H2 n2 h2 VS9 68e-4
ED2 h2 13 d2 0 33e-6
F2 0 d2 VS9 1
LD2 d2 0 1
VS3 14 s3 0
C3 s3 2 56e-6
VS4 18 s4 0
R4 s4 3 12e-2
VS5 5 s5 0
C5 s5 22 18e-6
VS6 10 s6 0
C6 s6 12 82e-7
VS7 20 s7 0
L7 s7 8 10e-4
VS8 20 s8 0
L8 s8 1 47e-2
VS9 18 s9 0
V9 e9 s9 DC 0 AC 18e1 -120
RI9 e9 n9 47e-1
H9 n9 h9 VS2 68e-4
ED9 h9 23 d9 0 33e-6
F9 0 d9 VS2 1
LD9 d9 0 1
VS10 11 s10 0
C10 s10 9 18e-6
VS11 19 s11 0
C11 s11 4 12e-5
VS12 3 s12 0
R12 s12 2 82e3
VS13 24 s13 0
R13 s13 20 68e-1
VS14 3 s14 0
V14 e14 s14 DC 0 AC 82e-1 180
RI14 e14 1 18e-2
VS15 4 s15 0
R15 s15 23 47e-2
VS16 16 s16 0
L16 s16 6 68e-4
VS17 2 s17 0
R17 s17 21 47e0
VS18 6 s18 0
R18 s18 16 68e3
VS19 0 s19 0
L19 s19 9 82e-5
VS20 7 s20 0
L20 s20 12 47e-4
VS21 10 s21 0
R21 s21 13 39e2
VS22 9 s22 0
R22 s22 19 82e-1
VS23 8 s23 0
R23 s23 3 22e0
VS24 18 s24 0
C24 s24 25 82e-6
VS25 9 s25 0
R25 s25 4 12e1
VS26 21 s26 0
R26 s26 24 68e3
VS27 13 s27 0
L27 s27 19 15e-4
VS28 15 s28 0
C28 s28 26 47e-6
VS29 12 s29 0
R29 s29 17 39e-1
VS30 7 s30 0
V30 e30 s30 DC 0 AC 22e-1 0
RI30 e30 0 82e-2
VS31 15 s31 0
V31 e31 s31 DC 0 AC 18e-1 0
RI31 e31 25 15e-1
VS32 22 s32 0
V32 e32 s32 DC 0 AC 18e-1 120
RI32 e32 m32 82e-2
LI32 m32 8 39e-6
VS33 1 s33 0
R33 s33 24 10e-1
VS34 11 s34 0
V34 e34 s34 DC 0 AC 47e0 0
RI34 e34 m34 47e-1
LI34 m34 3 27e-7
VS35 5 s35 0
L35 s35 18 15e-5
VS36 18 s36 0
L36 s36 16 12e-3
VS37 16 s37 0
L37 s37 2 68e-3
VS38 7 s38 0
R38 s38 8 12e2
VS39 14 s39 0
V39 e39 s39 DC 0 AC 15e1 120
RI39 e39 1 22e-2
VS40 6 s40 0
L40 s40 12 10e-2
VS41 17 s41 0
L41 s41 0 27e-3
.control
set numdgt=17
ac lin 1 60 60
print v(1) v(2) v(3) v(4) v(5) v(6) v(7) v(8) v(9) v(10)
print v(11) v(12) v(13) v(14) v(15) v(16) v(17) v(18) v(19) v(20)
print v(21) v(22) v(23) v(24) v(25) v(26)
print i(vs0) i(vs1) i(vs2) i(vs3) i(vs4) i(vs5) i(vs6) i(vs7) i(vs8) i(vs9)
print i(vs10) i(vs11) i(vs12) i(vs13) i(vs14) i(vs15) i(vs16) i(vs17) i(vs18) i(vs19)
print i(vs20) i(vs21) i(vs22) i(vs23) i(vs24) i(vs25) i(vs26) i(vs27) i(vs28) i(vs29)
print i(vs30) i(vs31) i(vs32) i(vs33) i(vs34) i(vs35) i(vs36) i(vs37) i(vs38) i(vs39)
print i(vs40) i(vs41)
.endc
.end
