controls oracle ac-0044
* Generated (plan F2.7, ADR 0012): do not edit; regenerate with `pnpm sim oracle regen`. ac seed 20261031 index 44 nodes 9 elements 12
.options sparse gmin=1e-12 noopac
RG1 1 0 1000000000000
RG2 2 0 1000000000000
RG3 3 0 1000000000000
RG4 4 0 1000000000000
RG5 5 0 1000000000000
RG6 6 0 1000000000000
RG7 7 0 1000000000000
RG8 8 0 1000000000000
VS0 1 s0 0
L0 s0 8 33e-2
VS1 0 s1 0
V1 e1 s1 DC 0 AC 68e1 120
RI1 e1 m1 27e-1
LI1 m1 4 10e-6
VS2 1 s2 0
L2 s2 2 18e-2
VS3 4 s3 0
V3 e3 s3 DC 0 AC 47e-1 -120
RI3 e3 m3 10e-2
LI3 m3 8 10e-7
VS4 8 s4 0
C4 s4 6 15e-7
VS5 7 s5 0
C5 s5 5 47e-6
VS6 7 s6 0
V6 e6 s6 DC 0 AC 33e-1 180
RI6 e6 m6 56e-2
LI6 m6 2 27e-7
VS7 3 s7 0
V7 e7 s7 DC 0 AC 33e0 120
RI7 e7 m7 15e-1
LI7 m7 1 12e-7
VS8 3 s8 0
V8 e8 s8 DC 0 AC 22e-1 0
RI8 e8 m8 27e-1
LI8 m8 6 39e-5
VS9 7 s9 0
R9 s9 3 18e2
VS10 0 s10 0
R10 s10 5 18e3
VS11 4 s11 0
R11 s11 7 33e-2
.control
set numdgt=17
ac lin 1 60 60
print v(1) v(2) v(3) v(4) v(5) v(6) v(7) v(8)
print i(vs0) i(vs1) i(vs2) i(vs3) i(vs4) i(vs5) i(vs6) i(vs7) i(vs8) i(vs9)
print i(vs10) i(vs11)
.endc
.end
