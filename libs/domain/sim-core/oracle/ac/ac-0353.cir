controls oracle ac-0353
* Generated (plan F2.7, ADR 0012): do not edit; regenerate with `pnpm sim oracle regen`. ac seed 20261031 index 353 nodes 4 elements 4
.options sparse gmin=1e-12 noopac
RG1 1 0 1000000000000
RG2 2 0 1000000000000
RG3 3 0 1000000000000
VS0 1 s0 0
R0 s0 2 10e-1
VS1 1 s1 0
L1 s1 0 27e-4
VS2 0 s2 0
V2 e2 s2 DC 0 AC 56e0 120
RI2 e2 1 68e-1
VS3 3 s3 0
R3 s3 2 10e0
.control
set numdgt=17
ac lin 1 60 60
print v(1) v(2) v(3)
print i(vs0) i(vs1) i(vs2) i(vs3)
.endc
.end
