controls oracle ac-0353
* Generated (plan F2.7, ADR 0012): do not edit; regenerate with `pnpm sim oracle regen`. ac seed 20261031 index 353 nodes 4 elements 5
.options sparse gmin=1e-12 noopac
RG1 1 0 1000000000000
RG2 2 0 1000000000000
RG3 3 0 1000000000000
VS0 3 s0 0
R0 s0 2 10e0
VS1 3 s1 0
C1 s1 1 82e-4
VS2 1 s2 0
R2 s2 2 10e-1
VS3 0 s3 0
V3 e3 s3 DC 0 AC 56e0 120
RI3 e3 1 68e-1
VS4 3 s4 0
V4 e4 s4 DC 0 AC 68e1 -120
RI4 e4 m4 22e-3
LI4 m4 0 39e-6
.control
set numdgt=17
ac lin 1 60 60
print v(1) v(2) v(3)
print i(vs0) i(vs1) i(vs2) i(vs3) i(vs4)
.endc
.end
