controls oracle ac-0225
* Generated (plan F2.7, ADR 0012): do not edit; regenerate with `pnpm sim oracle regen`. ac seed 20261031 index 225 nodes 8 elements 12
.options sparse gmin=1e-12 noopac
RG1 1 0 1000000000000
RG2 2 0 1000000000000
RG3 3 0 1000000000000
RG4 4 0 1000000000000
RG5 5 0 1000000000000
RG6 6 0 1000000000000
RG7 7 0 1000000000000
VS0 4 s0 0
L0 s0 5 47e-3
VS1 0 s1 0
V1 e1 s1 DC 0 AC 47e1 -120
RI1 e1 2 22e-2
VS2 0 s2 0
V2 e2 s2 DC 0 AC 10e-1 120
RI2 e2 3 10e-2
VS3 5 s3 0
R3 s3 6 82e3
VS4 1 s4 0
L4 s4 6 56e-4
VS5 7 s5 0
V5 e5 s5 DC 0 AC 68e1 0
RI5 e5 2 15e-2
VS6 0 s6 0
C6 s6 4 82e-6
VS7 0 s7 0
R7 s7 6 12e-2
VS8 3 s8 0
L8 s8 7 47e-3
VS9 3 s9 0
V9 e9 s9 DC 0 AC 39e0 0
RI9 e9 2 56e-3
VS10 5 s10 0
C10 s10 2 15e-6
VS11 5 s11 0
L11 s11 1 82e-3
.control
set numdgt=17
ac lin 1 60 60
print v(1) v(2) v(3) v(4) v(5) v(6) v(7)
print i(vs0) i(vs1) i(vs2) i(vs3) i(vs4) i(vs5) i(vs6) i(vs7) i(vs8) i(vs9)
print i(vs10) i(vs11)
.endc
.end
