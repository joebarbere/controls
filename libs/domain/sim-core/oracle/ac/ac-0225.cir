controls oracle ac-0225
* Generated (plan F2.7, ADR 0012): do not edit; regenerate with `pnpm sim oracle regen`. ac seed 20261031 index 225 nodes 8 elements 12
.options sparse gmin=1e-12 noopac
RG1 1 0 1000000000000
RG2 2 0 1000000000000
RG3 3 0 1000000000000
RG4 4 0 1000000000000
RG5 5 0 1000000000000
RG6 6 0 1000000000000
RG7 7 0 1000000000000
VS0 0 s0 0
V0 e0 s0 DC 0 AC 33e-1 0
RI0 e0 5 10e-3
VS1 7 s1 0
R1 s1 4 22e3
VS2 5 s2 0
R2 s2 1 82e3
VS3 4 s3 0
R3 s3 3 22e0
VS4 1 s4 0
C4 s4 3 12e-7
VS5 0 s5 0
L5 s5 2 10e-3
VS6 0 s6 0
L6 s6 1 56e-4
VS7 7 s7 0
V7 e7 s7 DC 0 AC 68e1 0
RI7 e7 2 15e-2
VS8 2 s8 0
R8 s8 0 22e2
VS9 7 s9 0
V9 e9 s9 DC 0 AC 10e-1 120
RI9 e9 5 10e-2
VS10 6 s10 0
C10 s10 7 82e-6
VS11 5 s11 0
C11 s11 2 15e-6
.control
set numdgt=17
ac lin 1 60 60
print v(1) v(2) v(3) v(4) v(5) v(6) v(7)
print i(vs0) i(vs1) i(vs2) i(vs3) i(vs4) i(vs5) i(vs6) i(vs7) i(vs8) i(vs9)
print i(vs10) i(vs11)
.endc
.end
