controls oracle ac-0225
* Generated (plan F2.7, ADR 0012): do not edit; regenerate with `pnpm sim oracle regen`. ac seed 20261031 index 225 nodes 8 elements 13
.options sparse gmin=1e-12 noopac
RG1 1 0 1000000000000
RG2 2 0 1000000000000
RG3 3 0 1000000000000
RG4 4 0 1000000000000
RG5 5 0 1000000000000
RG6 6 0 1000000000000
RG7 7 0 1000000000000
VS0 0 s0 0
V0 e0 s0 DC 0 AC 10e-1 120
RI0 e0 m0 10e-2
LI0 m0 n0 68e-5
H0 n0 h0 VS5 -82e-3
ED0 h0 5 d0 0 -22e-6
F0 0 d0 VS5 1
LD0 d0 0 1
VS1 4 s1 0
R1 s1 3 22e0
VS2 1 s2 0
L2 s2 2 10e-3
VS3 5 s3 0
R3 s3 7 82e3
VS4 1 s4 0
L4 s4 7 56e-4
VS5 0 s5 0
V5 e5 s5 DC 0 AC 68e1 0
RI5 e5 n5 15e-2
H5 n5 h5 VS0 -82e-3
ED5 h5 2 d5 0 -22e-6
F5 0 d5 VS0 1
LD5 d5 0 1
VS6 3 s6 0
R6 s6 6 82e0
VS7 6 s7 0
C7 s7 0 82e-6
VS8 7 s8 0
C8 s8 3 12e-7
VS9 1 s9 0
V9 e9 s9 DC 0 AC 33e-1 0
RI9 e9 m9 10e-3
LI9 m9 5 27e-6
VS10 5 s10 0
C10 s10 2 15e-6
VS11 2 s11 0
R11 s11 1 22e2
VS12 0 s12 0
R12 s12 4 22e3
.control
set numdgt=17
ac lin 1 60 60
print v(1) v(2) v(3) v(4) v(5) v(6) v(7)
print i(vs0) i(vs1) i(vs2) i(vs3) i(vs4) i(vs5) i(vs6) i(vs7) i(vs8) i(vs9)
print i(vs10) i(vs11) i(vs12)
.endc
.end
