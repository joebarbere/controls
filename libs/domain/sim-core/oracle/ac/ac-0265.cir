controls oracle ac-0265
* Generated (plan F2.7, ADR 0012): do not edit; regenerate with `pnpm sim oracle regen`. ac seed 20261031 index 265 nodes 29 elements 58
.options sparse gmin=1e-12 noopac
RG1 1 0 1000000000000
RG2 2 0 1000000000000
RG3 3 0 1000000000000
RG4 4 0 1000000000000
RG5 5 0 1000000000000
RG6 6 0 1000000000000
RG7 7 0 1000000000000
RG8 8 0 1000000000000
RG9 9 0 1000000000000
RG10 10 0 1000000000000
RG11 11 0 1000000000000
RG12 12 0 1000000000000
RG13 13 0 1000000000000
RG14 14 0 1000000000000
RG15 15 0 1000000000000
RG16 16 0 1000000000000
RG17 17 0 1000000000000
RG18 18 0 1000000000000
RG19 19 0 1000000000000
RG20 20 0 1000000000000
RG21 21 0 1000000000000
RG22 22 0 1000000000000
RG23 23 0 1000000000000
RG24 24 0 1000000000000
RG25 25 0 1000000000000
RG26 26 0 1000000000000
RG27 27 0 1000000000000
RG28 28 0 1000000000000
VS0 20 s0 0
R0 s0 23 56e0
VS1 17 s1 0
C1 s1 19 33e-7
VS2 15 s2 0
R2 s2 5 68e-1
VS3 25 s3 0
R3 s3 14 56e-1
VS4 0 s4 0
V4 e4 s4 DC 0 AC 12e-1 120
RI4 e4 m4 22e-1
LI4 m4 n4 22e-7
H4 n4 h4 VS5 68e-3
ED4 h4 15 d4 0 22e-7
F4 0 d4 VS5 1
LD4 d4 0 1
VS5 9 s5 0
V5 e5 s5 DC 0 AC 15e0 0
RI5 e5 m5 47e-2
LI5 m5 n5 27e-5
H5 n5 h5 VS4 68e-3
ED5 h5 22 d5 0 22e-7
F5 0 d5 VS4 1
LD5 d5 0 1
VS6 25 s6 0
R6 s6 11 27e2
VS7 5 s7 0
R7 s7 19 18e-1
VS8 20 s8 0
R8 s8 28 47e0
VS9 10 s9 0
V9 e9 s9 DC 0 AC 39e-1 -120
RI9 e9 m9 68e-3
LI9 m9 1 47e-6
VS10 5 s10 0
L10 s10 26 33e-5
VS11 3 s11 0
R11 s11 2 68e3
VS12 10 s12 0
C12 s12 14 82e-4
VS13 17 s13 0
V13 e13 s13 DC 0 AC 56e1 120
RI13 e13 0 15e-3
VS14 21 s14 0
L14 s14 0 56e-2
VS15 21 s15 0
V15 e15 s15 DC 0 AC 18e-1 180
RI15 e15 9 22e-1
VS16 22 s16 0
C16 s16 11 27e-5
VS17 9 s17 0
C17 s17 16 15e-7
VS18 0 s18 0
L18 s18 8 12e-4
VS19 9 s19 0
V19 e19 s19 DC 0 AC 18e0 180
RI19 e19 m19 27e-1
LI19 m19 0 27e-6
VS20 11 s20 0
R20 s20 12 56e2
VS21 15 s21 0
C21 s21 27 33e-5
VS22 28 s22 0
R22 s22 9 15e-2
VS23 8 s23 0
R23 s23 26 39e0
VS24 26 s24 0
L24 s24 3 47e-4
VS25 25 s25 0
R25 s25 13 22e3
VS26 17 s26 0
R26 s26 5 68e2
VS27 28 s27 0
C27 s27 22 12e-6
VS28 0 s28 0
C28 s28 9 47e-7
VS29 5 s29 0
R29 s29 4 10e-1
VS30 27 s30 0
V30 e30 s30 DC 0 AC 18e-1 0
RI30 e30 m30 39e-1
LI30 m30 24 47e-5
VS31 19 s31 0
R31 s31 24 33e-1
VS32 1 s32 0
C32 s32 2 27e-6
VS33 24 s33 0
L33 s33 15 15e-5
VS34 21 s34 0
R34 s34 8 39e-1
VS35 22 s35 0
R35 s35 18 18e-2
VS36 24 s36 0
L36 s36 23 39e-5
VS37 6 s37 0
C37 s37 28 39e-7
VS38 7 s38 0
V38 e38 s38 DC 0 AC 82e1 0
RI38 e38 3 33e-1
VS39 6 s39 0
L39 s39 22 12e-5
VS40 26 s40 0
L40 s40 6 82e-5
VS41 21 s41 0
V41 e41 s41 DC 0 AC 10e0 120
RI41 e41 m41 33e-2
LI41 m41 8 47e-6
VS42 13 s42 0
V42 e42 s42 DC 0 AC 15e-1 0
RI42 e42 22 82e-1
VS43 8 s43 0
R43 s43 28 15e2
VS44 4 s44 0
C44 s44 22 47e-7
VS45 5 s45 0
R45 s45 17 68e1
VS46 0 s46 0
V46 e46 s46 DC 0 AC 68e1 120
RI46 e46 26 22e-3
VS47 9 s47 0
C47 s47 18 56e-4
VS48 5 s48 0
R48 s48 14 12e-2
VS49 10 s49 0
R49 s49 22 33e0
VS50 0 s50 0
R50 s50 16 27e3
VS51 7 s51 0
C51 s51 28 68e-7
VS52 5 s52 0
R52 s52 22 10e3
VS53 18 s53 0
R53 s53 8 47e-2
VS54 13 s54 0
C54 s54 19 68e-5
VS55 12 s55 0
R55 s55 5 68e1
VS56 6 s56 0
L56 s56 11 18e-3
VS57 22 s57 0
R57 s57 9 56e3
.control
set numdgt=17
ac lin 1 60 60
print v(1) v(2) v(3) v(4) v(5) v(6) v(7) v(8) v(9) v(10)
print v(11) v(12) v(13) v(14) v(15) v(16) v(17) v(18) v(19) v(20)
print v(21) v(22) v(23) v(24) v(25) v(26) v(27) v(28)
print i(vs0) i(vs1) i(vs2) i(vs3) i(vs4) i(vs5) i(vs6) i(vs7) i(vs8) i(vs9)
print i(vs10) i(vs11) i(vs12) i(vs13) i(vs14) i(vs15) i(vs16) i(vs17) i(vs18) i(vs19)
print i(vs20) i(vs21) i(vs22) i(vs23) i(vs24) i(vs25) i(vs26) i(vs27) i(vs28) i(vs29)
print i(vs30) i(vs31) i(vs32) i(vs33) i(vs34) i(vs35) i(vs36) i(vs37) i(vs38) i(vs39)
print i(vs40) i(vs41) i(vs42) i(vs43) i(vs44) i(vs45) i(vs46) i(vs47) i(vs48) i(vs49)
print i(vs50) i(vs51) i(vs52) i(vs53) i(vs54) i(vs55) i(vs56) i(vs57)
.endc
.end
