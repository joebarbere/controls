controls oracle ac-0265
* Generated (plan F2.7, ADR 0012): do not edit; regenerate with `pnpm sim oracle regen`. ac seed 20261031 index 265 nodes 29 elements 55
.options sparse gmin=1e-12 noopac
RG1 1 0 1000000000000
RG2 2 0 1000000000000
RG3 3 0 1000000000000
RG4 4 0 1000000000000
RG5 5 0 1000000000000
RG6 6 0 1000000000000
RG7 7 0 1000000000000
RG8 8 0 1000000000000
RG9 9 0 1000000000000
RG10 10 0 1000000000000
RG11 11 0 1000000000000
RG12 12 0 1000000000000
RG13 13 0 1000000000000
RG14 14 0 1000000000000
RG15 15 0 1000000000000
RG16 16 0 1000000000000
RG17 17 0 1000000000000
RG18 18 0 1000000000000
RG19 19 0 1000000000000
RG20 20 0 1000000000000
RG21 21 0 1000000000000
RG22 22 0 1000000000000
RG23 23 0 1000000000000
RG24 24 0 1000000000000
RG25 25 0 1000000000000
RG26 26 0 1000000000000
RG27 27 0 1000000000000
RG28 28 0 1000000000000
VS0 0 s0 0
V0 e0 s0 DC 0 AC 18e-1 180
RI0 e0 9 22e-1
VS1 5 s1 0
R1 s1 21 10e3
VS2 22 s2 0
V2 e2 s2 DC 0 AC 12e-1 120
RI2 e2 15 22e-1
VS3 6 s3 0
L3 s3 11 18e-3
VS4 20 s4 0
R4 s4 28 47e0
VS5 28 s5 0
C5 s5 21 12e-6
VS6 24 s6 0
L6 s6 15 15e-5
VS7 21 s7 0
C7 s7 11 27e-5
VS8 18 s8 0
R8 s8 8 47e-2
VS9 17 s9 0
C9 s9 19 33e-7
VS10 5 s10 0
R10 s10 14 12e-2
VS11 9 s11 0
V11 e11 s11 DC 0 AC 18e0 180
RI11 e11 22 27e-1
VS12 3 s12 0
R12 s12 2 68e3
VS13 10 s13 0
R13 s13 21 33e0
VS14 13 s14 0
V14 e14 s14 DC 0 AC 15e-1 0
RI14 e14 21 82e-1
VS15 22 s15 0
C15 s15 9 47e-7
VS16 5 s16 0
R16 s16 19 18e-1
VS17 8 s17 0
R17 s17 28 15e2
VS18 17 s18 0
V18 e18 s18 DC 0 AC 56e1 120
RI18 e18 22 15e-3
VS19 0 s19 0
R19 s19 8 39e-1
VS20 22 s20 0
R20 s20 16 27e3
VS21 26 s21 0
L21 s21 3 47e-4
VS22 21 s22 0
R22 s22 18 18e-2
VS23 25 s23 0
R23 s23 14 56e-1
VS24 22 s24 0
L24 s24 8 12e-4
VS25 28 s25 0
R25 s25 9 15e-2
VS26 11 s26 0
R26 s26 12 56e2
VS27 25 s27 0
R27 s27 11 27e2
VS28 22 s28 0
V28 e28 s28 DC 0 AC 68e1 120
RI28 e28 26 22e-3
VS29 4 s29 0
C29 s29 21 47e-7
VS30 9 s30 0
V30 e30 s30 DC 0 AC 15e0 0
RI30 e30 21 47e-2
VS31 12 s31 0
R31 s31 5 68e1
VS32 6 s32 0
C32 s32 28 39e-7
VS33 10 s33 0
C33 s33 14 82e-4
VS34 25 s34 0
R34 s34 13 22e3
VS35 0 s35 0
V35 e35 s35 DC 0 AC 10e0 120
RI35 e35 8 33e-2
VS36 9 s36 0
C36 s36 18 56e-4
VS37 6 s37 0
L37 s37 21 12e-5
VS38 8 s38 0
R38 s38 26 39e0
VS39 15 s39 0
R39 s39 5 68e-1
VS40 15 s40 0
C40 s40 27 33e-5
VS41 13 s41 0
C41 s41 19 68e-5
VS42 5 s42 0
L42 s42 26 33e-5
VS43 17 s43 0
R43 s43 5 68e2
VS44 19 s44 0
R44 s44 24 33e-1
VS45 1 s45 0
C45 s45 2 27e-6
VS46 7 s46 0
V46 e46 s46 DC 0 AC 82e1 0
RI46 e46 3 33e-1
VS47 10 s47 0
V47 e47 s47 DC 0 AC 39e-1 -120
RI47 e47 1 68e-3
VS48 20 s48 0
R48 s48 23 56e0
VS49 0 s49 0
L49 s49 22 56e-2
VS50 5 s50 0
R50 s50 17 68e1
VS51 26 s51 0
L51 s51 6 82e-5
VS52 21 s52 0
R52 s52 9 56e3
VS53 24 s53 0
L53 s53 23 39e-5
VS54 9 s54 0
C54 s54 16 15e-7
.control
set numdgt=17
ac lin 1 60 60
print v(1) v(2) v(3) v(4) v(5) v(6) v(7) v(8) v(9) v(10)
print v(11) v(12) v(13) v(14) v(15) v(16) v(17) v(18) v(19) v(20)
print v(21) v(22) v(23) v(24) v(25) v(26) v(27) v(28)
print i(vs0) i(vs1) i(vs2) i(vs3) i(vs4) i(vs5) i(vs6) i(vs7) i(vs8) i(vs9)
print i(vs10) i(vs11) i(vs12) i(vs13) i(vs14) i(vs15) i(vs16) i(vs17) i(vs18) i(vs19)
print i(vs20) i(vs21) i(vs22) i(vs23) i(vs24) i(vs25) i(vs26) i(vs27) i(vs28) i(vs29)
print i(vs30) i(vs31) i(vs32) i(vs33) i(vs34) i(vs35) i(vs36) i(vs37) i(vs38) i(vs39)
print i(vs40) i(vs41) i(vs42) i(vs43) i(vs44) i(vs45) i(vs46) i(vs47) i(vs48) i(vs49)
print i(vs50) i(vs51) i(vs52) i(vs53) i(vs54)
.endc
.end
