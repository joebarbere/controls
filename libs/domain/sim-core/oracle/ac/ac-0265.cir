controls oracle ac-0265
* Generated (plan F2.7, ADR 0012): do not edit; regenerate with `pnpm sim oracle regen`. ac seed 20261031 index 265 nodes 29 elements 43
.options sparse gmin=1e-12 noopac
RG1 1 0 1000000000000
RG2 2 0 1000000000000
RG3 3 0 1000000000000
RG4 4 0 1000000000000
RG5 5 0 1000000000000
RG6 6 0 1000000000000
RG7 7 0 1000000000000
RG8 8 0 1000000000000
RG9 9 0 1000000000000
RG10 10 0 1000000000000
RG11 11 0 1000000000000
RG12 12 0 1000000000000
RG13 13 0 1000000000000
RG14 14 0 1000000000000
RG15 15 0 1000000000000
RG16 16 0 1000000000000
RG17 17 0 1000000000000
RG18 18 0 1000000000000
RG19 19 0 1000000000000
RG20 20 0 1000000000000
RG21 21 0 1000000000000
RG22 22 0 1000000000000
RG23 23 0 1000000000000
RG24 24 0 1000000000000
RG25 25 0 1000000000000
RG26 26 0 1000000000000
RG27 27 0 1000000000000
RG28 28 0 1000000000000
VS0 0 s0 0
V0 e0 s0 DC 0 AC 82e1 0
RI0 e0 21 33e-1
VS1 28 s1 0
R1 s1 12 10e2
VS2 24 s2 0
L2 s2 15 15e-5
VS3 17 s3 0
R3 s3 9 33e-1
VS4 19 s4 0
R4 s4 5 12e1
VS5 2 s5 0
C5 s5 11 22e-6
VS6 14 s6 0
V6 e6 s6 DC 0 AC 22e0 120
RI6 e6 m6 82e-3
LI6 m6 7 18e-7
VS7 19 s7 0
C7 s7 27 12e-6
VS8 12 s8 0
C8 s8 6 12e-5
VS9 3 s9 0
R9 s9 14 10e2
VS10 2 s10 0
R10 s10 4 22e-1
VS11 18 s11 0
C11 s11 22 82e-5
VS12 21 s12 0
V12 e12 s12 DC 0 AC 10e-1 0
RI12 e12 11 82e-1
VS13 23 s13 0
R13 s13 28 39e2
VS14 4 s14 0
R14 s14 27 10e-1
VS15 23 s15 0
V15 e15 s15 DC 0 AC 33e-1 -120
RI15 e15 16 18e-3
VS16 18 s16 0
C16 s16 11 27e-5
VS17 13 s17 0
V17 e17 s17 DC 0 AC 15e-1 0
RI17 e17 m17 82e-1
LI17 m17 18 82e-5
VS18 18 s18 0
R18 s18 1 47e0
VS19 16 s19 0
V19 e19 s19 DC 0 AC 27e-1 120
RI19 e19 m19 56e-3
LI19 m19 28 22e-5
VS20 28 s20 0
R20 s20 9 47e-1
VS21 25 s21 0
L21 s21 0 39e-5
VS22 18 s22 0
R22 s22 9 56e3
VS23 13 s23 0
V23 e23 s23 DC 0 AC 15e0 180
RI23 e23 25 12e-1
VS24 15 s24 0
C24 s24 27 33e-5
VS25 5 s25 0
R25 s25 18 10e3
VS26 6 s26 0
L26 s26 18 12e-5
VS27 26 s27 0
L27 s27 6 82e-5
VS28 10 s28 0
C28 s28 3 22e-4
VS29 8 s29 0
L29 s29 6 56e-2
VS30 20 s30 0
R30 s30 17 10e-1
VS31 5 s31 0
C31 s31 15 56e-6
VS32 20 s32 0
R32 s32 26 27e2
VS33 7 s33 0
L33 s33 24 22e-2
VS34 27 s34 0
R34 s34 18 82e-1
VS35 19 s35 0
C35 s35 22 82e-7
VS36 14 s36 0
V36 e36 s36 DC 0 AC 18e0 0
RI36 e36 8 18e-1
VS37 15 s37 0
R37 s37 5 68e-1
VS38 10 s38 0
R38 s38 18 33e0
VS39 9 s39 0
C39 s39 16 15e-7
VS40 15 s40 0
V40 e40 s40 DC 0 AC 18e-1 120
RI40 e40 m40 47e-2
LI40 m40 6 10e-5
VS41 6 s41 0
L41 s41 2 68e-2
VS42 17 s42 0
C42 s42 1 39e-5
.control
set numdgt=17
ac lin 1 60 60
print v(1) v(2) v(3) v(4) v(5) v(6) v(7) v(8) v(9) v(10)
print v(11) v(12) v(13) v(14) v(15) v(16) v(17) v(18) v(19) v(20)
print v(21) v(22) v(23) v(24) v(25) v(26) v(27) v(28)
print i(vs0) i(vs1) i(vs2) i(vs3) i(vs4) i(vs5) i(vs6) i(vs7) i(vs8) i(vs9)
print i(vs10) i(vs11) i(vs12) i(vs13) i(vs14) i(vs15) i(vs16) i(vs17) i(vs18) i(vs19)
print i(vs20) i(vs21) i(vs22) i(vs23) i(vs24) i(vs25) i(vs26) i(vs27) i(vs28) i(vs29)
print i(vs30) i(vs31) i(vs32) i(vs33) i(vs34) i(vs35) i(vs36) i(vs37) i(vs38) i(vs39)
print i(vs40) i(vs41) i(vs42)
.endc
.end
