controls oracle ac-0360
* Generated (plan F2.7, ADR 0012): do not edit; regenerate with `pnpm sim oracle regen`. ac seed 20261031 index 360 nodes 27 elements 31
.options sparse gmin=1e-12 noopac
RG1 1 0 1000000000000
RG2 2 0 1000000000000
RG3 3 0 1000000000000
RG4 4 0 1000000000000
RG5 5 0 1000000000000
RG6 6 0 1000000000000
RG7 7 0 1000000000000
RG8 8 0 1000000000000
RG9 9 0 1000000000000
RG10 10 0 1000000000000
RG11 11 0 1000000000000
RG12 12 0 1000000000000
RG13 13 0 1000000000000
RG14 14 0 1000000000000
RG15 15 0 1000000000000
RG16 16 0 1000000000000
RG17 17 0 1000000000000
RG18 18 0 1000000000000
RG19 19 0 1000000000000
RG20 20 0 1000000000000
RG21 21 0 1000000000000
RG22 22 0 1000000000000
RG23 23 0 1000000000000
RG24 24 0 1000000000000
RG25 25 0 1000000000000
RG26 26 0 1000000000000
VS0 12 s0 0
L0 s0 20 12e-4
VS1 20 s1 0
L1 s1 19 33e-2
VS2 0 s2 0
V2 e2 s2 DC 0 AC 22e0 -120
RI2 e2 9 27e-1
VS3 9 s3 0
R3 s3 5 12e3
VS4 7 s4 0
R4 s4 4 56e-2
VS5 14 s5 0
R5 s5 4 22e-2
VS6 2 s6 0
R6 s6 4 12e3
VS7 17 s7 0
C7 s7 11 27e-4
VS8 13 s8 0
C8 s8 5 10e-7
VS9 9 s9 0
L9 s9 15 15e-2
VS10 12 s10 0
L10 s10 16 10e-2
VS11 2 s11 0
V11 e11 s11 DC 0 AC 33e-1 -120
RI11 e11 7 12e-2
VS12 1 s12 0
C12 s12 3 47e-6
VS13 12 s13 0
L13 s13 5 12e-4
VS14 6 s14 0
R14 s14 14 22e-2
VS15 3 s15 0
R15 s15 25 82e-1
VS16 24 s16 0
V16 e16 s16 DC 0 AC 27e1 0
RI16 e16 8 18e-2
VS17 25 s17 0
C17 s17 12 56e-7
VS18 18 s18 0
L18 s18 11 15e-5
VS19 22 s19 0
C19 s19 15 47e-6
VS20 4 s20 0
V20 e20 s20 DC 0 AC 22e-1 -120
RI20 e20 15 10e-1
VS21 21 s21 0
C21 s21 14 39e-5
VS22 17 s22 0
L22 s22 23 22e-4
VS23 14 s23 0
V23 e23 s23 DC 0 AC 82e0 120
RI23 e23 16 15e-1
VS24 10 s24 0
R24 s24 21 47e-2
VS25 2 s25 0
L25 s25 11 12e-3
VS26 26 s26 0
V26 e26 s26 DC 0 AC 12e1 -120
RI26 e26 22 68e-2
VS27 3 s27 0
V27 e27 s27 DC 0 AC 82e1 180
RI27 e27 16 33e-3
VS28 17 s28 0
L28 s28 4 10e-3
VS29 24 s29 0
C29 s29 9 12e-7
VS30 26 s30 0
R30 s30 17 39e0
.control
set numdgt=17
ac lin 1 60 60
print v(1) v(2) v(3) v(4) v(5) v(6) v(7) v(8) v(9) v(10)
print v(11) v(12) v(13) v(14) v(15) v(16) v(17) v(18) v(19) v(20)
print v(21) v(22) v(23) v(24) v(25) v(26)
print i(vs0) i(vs1) i(vs2) i(vs3) i(vs4) i(vs5) i(vs6) i(vs7) i(vs8) i(vs9)
print i(vs10) i(vs11) i(vs12) i(vs13) i(vs14) i(vs15) i(vs16) i(vs17) i(vs18) i(vs19)
print i(vs20) i(vs21) i(vs22) i(vs23) i(vs24) i(vs25) i(vs26) i(vs27) i(vs28) i(vs29)
print i(vs30)
.endc
.end
