controls oracle ac-0360
* Generated (plan F2.7, ADR 0012): do not edit; regenerate with `pnpm sim oracle regen`. ac seed 20261031 index 360 nodes 27 elements 40
.options sparse gmin=1e-12 noopac
RG1 1 0 1000000000000
RG2 2 0 1000000000000
RG3 3 0 1000000000000
RG4 4 0 1000000000000
RG5 5 0 1000000000000
RG6 6 0 1000000000000
RG7 7 0 1000000000000
RG8 8 0 1000000000000
RG9 9 0 1000000000000
RG10 10 0 1000000000000
RG11 11 0 1000000000000
RG12 12 0 1000000000000
RG13 13 0 1000000000000
RG14 14 0 1000000000000
RG15 15 0 1000000000000
RG16 16 0 1000000000000
RG17 17 0 1000000000000
RG18 18 0 1000000000000
RG19 19 0 1000000000000
RG20 20 0 1000000000000
RG21 21 0 1000000000000
RG22 22 0 1000000000000
RG23 23 0 1000000000000
RG24 24 0 1000000000000
RG25 25 0 1000000000000
RG26 26 0 1000000000000
VS0 2 s0 0
L0 s0 11 12e-3
VS1 0 s1 0
V1 e1 s1 DC 0 AC 82e1 180
RI1 e1 16 33e-3
VS2 1 s2 0
C2 s2 0 47e-6
VS3 11 s3 0
R3 s3 8 12e1
VS4 2 s4 0
V4 e4 s4 DC 0 AC 33e-1 -120
RI4 e4 7 12e-2
VS5 2 s5 0
C5 s5 13 27e-6
VS6 0 s6 0
R6 s6 25 82e-1
VS7 3 s7 0
L7 s7 15 15e-2
VS8 26 s8 0
V8 e8 s8 DC 0 AC 12e1 -120
RI8 e8 22 68e-2
VS9 14 s9 0
R9 s9 4 22e-2
VS10 24 s10 0
C10 s10 3 12e-7
VS11 2 s11 0
R11 s11 4 12e3
VS12 9 s12 0
V12 e12 s12 DC 0 AC 22e0 -120
RI12 e12 3 27e-1
VS13 14 s13 0
V13 e13 s13 DC 0 AC 82e0 120
RI13 e13 16 15e-1
VS14 10 s14 0
R14 s14 21 47e-2
VS15 13 s15 0
C15 s15 5 10e-7
VS16 18 s16 0
L16 s16 11 15e-5
VS17 17 s17 0
L17 s17 4 10e-3
VS18 12 s18 0
L18 s18 16 10e-2
VS19 21 s19 0
C19 s19 14 39e-5
VS20 15 s20 0
R20 s20 23 18e1
VS21 6 s21 0
V21 e21 s21 DC 0 AC 10e1 0
RI21 e21 15 56e-2
VS22 22 s22 0
C22 s22 15 47e-6
VS23 3 s23 0
R23 s23 5 12e3
VS24 25 s24 0
L24 s24 9 10e-5
VS25 24 s25 0
V25 e25 s25 DC 0 AC 27e1 0
RI25 e25 8 18e-2
VS26 19 s26 0
R26 s26 14 27e3
VS27 4 s27 0
V27 e27 s27 DC 0 AC 22e-1 -120
RI27 e27 15 10e-1
VS28 17 s28 0
L28 s28 23 22e-4
VS29 3 s29 0
L29 s29 1 39e-2
VS30 12 s30 0
L30 s30 20 12e-4
VS31 20 s31 0
L31 s31 19 33e-2
VS32 26 s32 0
R32 s32 17 39e0
VS33 17 s33 0
C33 s33 11 27e-4
VS34 25 s34 0
C34 s34 12 56e-7
VS35 6 s35 0
R35 s35 14 22e-2
VS36 10 s36 0
R36 s36 24 56e2
VS37 7 s37 0
R37 s37 4 56e-2
VS38 12 s38 0
L38 s38 5 12e-4
VS39 26 s39 0
R39 s39 18 27e1
.control
set numdgt=17
ac lin 1 60 60
print v(1) v(2) v(3) v(4) v(5) v(6) v(7) v(8) v(9) v(10)
print v(11) v(12) v(13) v(14) v(15) v(16) v(17) v(18) v(19) v(20)
print v(21) v(22) v(23) v(24) v(25) v(26)
print i(vs0) i(vs1) i(vs2) i(vs3) i(vs4) i(vs5) i(vs6) i(vs7) i(vs8) i(vs9)
print i(vs10) i(vs11) i(vs12) i(vs13) i(vs14) i(vs15) i(vs16) i(vs17) i(vs18) i(vs19)
print i(vs20) i(vs21) i(vs22) i(vs23) i(vs24) i(vs25) i(vs26) i(vs27) i(vs28) i(vs29)
print i(vs30) i(vs31) i(vs32) i(vs33) i(vs34) i(vs35) i(vs36) i(vs37) i(vs38) i(vs39)
.endc
.end
