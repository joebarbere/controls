controls oracle ac-0360
* Generated (plan F2.7, ADR 0012): do not edit; regenerate with `pnpm sim oracle regen`. ac seed 20261031 index 360 nodes 27 elements 47
.options sparse gmin=1e-12 noopac
RG1 1 0 1000000000000
RG2 2 0 1000000000000
RG3 3 0 1000000000000
RG4 4 0 1000000000000
RG5 5 0 1000000000000
RG6 6 0 1000000000000
RG7 7 0 1000000000000
RG8 8 0 1000000000000
RG9 9 0 1000000000000
RG10 10 0 1000000000000
RG11 11 0 1000000000000
RG12 12 0 1000000000000
RG13 13 0 1000000000000
RG14 14 0 1000000000000
RG15 15 0 1000000000000
RG16 16 0 1000000000000
RG17 17 0 1000000000000
RG18 18 0 1000000000000
RG19 19 0 1000000000000
RG20 20 0 1000000000000
RG21 21 0 1000000000000
RG22 22 0 1000000000000
RG23 23 0 1000000000000
RG24 24 0 1000000000000
RG25 25 0 1000000000000
RG26 26 0 1000000000000
VS0 0 s0 0
V0 e0 s0 DC 0 AC 10e-1 0
RI0 e0 16 47e-3
VS1 1 s1 0
C1 s1 16 18e-4
VS2 1 s2 0
C2 s2 18 33e-4
VS3 22 s3 0
V3 e3 s3 DC 0 AC 56e1 -120
RI3 e3 m3 47e-2
LI3 m3 23 27e-5
VS4 14 s4 0
R4 s4 3 56e1
VS5 12 s5 0
R5 s5 13 10e3
VS6 21 s6 0
R6 s6 15 33e3
VS7 12 s7 0
V7 e7 s7 DC 0 AC 22e1 -120
RI7 e7 21 33e-1
VS8 24 s8 0
R8 s8 3 82e2
VS9 6 s9 0
L9 s9 15 15e-2
VS10 10 s10 0
V10 e10 s10 DC 0 AC 22e0 -120
RI10 e10 25 27e-1
VS11 12 s11 0
L11 s11 5 12e-4
VS12 2 s12 0
C12 s12 26 33e-4
VS13 7 s13 0
C13 s13 15 18e-6
VS14 15 s14 0
C14 s14 8 10e-6
VS15 2 s15 0
L15 s15 9 56e-2
VS16 10 s16 0
C16 s16 8 82e-5
VS17 10 s17 0
L17 s17 17 39e-3
VS18 11 s18 0
C18 s18 4 56e-7
VS19 4 s19 0
V19 e19 s19 DC 0 AC 22e-1 -120
RI19 e19 15 10e-1
VS20 20 s20 0
L20 s20 6 27e-2
VS21 21 s21 0
C21 s21 9 82e-5
VS22 12 s22 0
L22 s22 21 10e-2
VS23 6 s23 0
R23 s23 5 12e3
VS24 0 s24 0
C24 s24 9 27e-7
VS25 15 s25 0
R25 s25 0 82e-1
VS26 15 s26 0
L26 s26 24 27e-4
VS27 2 s27 0
V27 e27 s27 DC 0 AC 27e0 -120
RI27 e27 14 47e-2
VS28 9 s28 0
R28 s28 13 47e2
VS29 19 s29 0
R29 s29 6 27e-2
VS30 8 s30 0
V30 e30 s30 DC 0 AC 18e0 0
RI30 e30 20 27e-2
VS31 22 s31 0
R31 s31 3 33e2
VS32 24 s32 0
L32 s32 14 47e-3
VS33 26 s33 0
L33 s33 3 47e-5
VS34 19 s34 0
L34 s34 26 15e-5
VS35 26 s35 0
V35 e35 s35 DC 0 AC 33e0 -120
RI35 e35 23 56e-2
VS36 22 s36 0
L36 s36 25 10e-3
VS37 11 s37 0
L37 s37 21 27e-5
VS38 7 s38 0
R38 s38 6 10e1
VS39 25 s39 0
V39 e39 s39 DC 0 AC 56e0 180
RI39 e39 18 68e-1
VS40 7 s40 0
L40 s40 14 10e-5
VS41 16 s41 0
L41 s41 12 39e-3
VS42 26 s42 0
V42 e42 s42 DC 0 AC 12e1 -120
RI42 e42 m42 68e-2
LI42 m42 22 18e-6
VS43 17 s43 0
R43 s43 15 47e-2
VS44 25 s44 0
C44 s44 6 47e-6
VS45 13 s45 0
L45 s45 6 68e-3
VS46 22 s46 0
C46 s46 24 47e-7
.control
set numdgt=17
ac lin 1 60 60
print v(1) v(2) v(3) v(4) v(5) v(6) v(7) v(8) v(9) v(10)
print v(11) v(12) v(13) v(14) v(15) v(16) v(17) v(18) v(19) v(20)
print v(21) v(22) v(23) v(24) v(25) v(26)
print i(vs0) i(vs1) i(vs2) i(vs3) i(vs4) i(vs5) i(vs6) i(vs7) i(vs8) i(vs9)
print i(vs10) i(vs11) i(vs12) i(vs13) i(vs14) i(vs15) i(vs16) i(vs17) i(vs18) i(vs19)
print i(vs20) i(vs21) i(vs22) i(vs23) i(vs24) i(vs25) i(vs26) i(vs27) i(vs28) i(vs29)
print i(vs30) i(vs31) i(vs32) i(vs33) i(vs34) i(vs35) i(vs36) i(vs37) i(vs38) i(vs39)
print i(vs40) i(vs41) i(vs42) i(vs43) i(vs44) i(vs45) i(vs46)
.endc
.end
