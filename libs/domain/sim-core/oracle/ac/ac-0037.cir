controls oracle ac-0037
* Generated (plan F2.7, ADR 0012): do not edit; regenerate with `pnpm sim oracle regen`. ac seed 20261031 index 37 nodes 6 elements 8
.options sparse gmin=1e-12 noopac
RG1 1 0 1000000000000
RG2 2 0 1000000000000
RG3 3 0 1000000000000
RG4 4 0 1000000000000
RG5 5 0 1000000000000
VS0 3 s0 0
R0 s0 2 22e2
VS1 1 s1 0
C1 s1 5 68e-5
VS2 5 s2 0
C2 s2 3 47e-4
VS3 1 s3 0
R3 s3 2 47e3
VS4 0 s4 0
C4 s4 4 47e-5
VS5 0 s5 0
V5 e5 s5 DC 0 AC 68e0 -120
RI5 e5 1 15e-3
VS6 1 s6 0
V6 e6 s6 DC 0 AC 47e1 0
RI6 e6 3 82e-2
VS7 4 s7 0
C7 s7 5 56e-7
.control
set numdgt=17
ac lin 1 60 60
print v(1) v(2) v(3) v(4) v(5)
print i(vs0) i(vs1) i(vs2) i(vs3) i(vs4) i(vs5) i(vs6) i(vs7)
.endc
.end
