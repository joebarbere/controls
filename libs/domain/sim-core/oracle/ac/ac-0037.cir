controls oracle ac-0037
* Generated (plan F2.7, ADR 0012): do not edit; regenerate with `pnpm sim oracle regen`. ac seed 20261031 index 37 nodes 6 elements 11
.options sparse gmin=1e-12 noopac
RG1 1 0 1000000000000
RG2 2 0 1000000000000
RG3 3 0 1000000000000
RG4 4 0 1000000000000
RG5 5 0 1000000000000
VS0 4 s0 0
R0 s0 5 22e2
VS1 3 s1 0
C1 s1 2 82e-7
VS2 0 s2 0
V2 e2 s2 DC 0 AC 68e0 -120
RI2 e2 m2 15e-3
LI2 m2 1 47e-7
VS3 0 s3 0
C3 s3 4 39e-7
VS4 1 s4 0
C4 s4 5 82e-5
VS5 5 s5 0
L5 s5 4 39e-4
VS6 4 s6 0
R6 s6 5 47e3
VS7 5 s7 0
R7 s7 0 82e2
VS8 0 s8 0
R8 s8 2 22e1
VS9 3 s9 0
C9 s9 5 22e-5
VS10 1 s10 0
L10 s10 3 47e-2
.control
set numdgt=17
ac lin 1 60 60
print v(1) v(2) v(3) v(4) v(5)
print i(vs0) i(vs1) i(vs2) i(vs3) i(vs4) i(vs5) i(vs6) i(vs7) i(vs8) i(vs9)
print i(vs10)
.endc
.end
