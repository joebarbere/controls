controls oracle ac-0307
* Generated (plan F2.7, ADR 0012): do not edit; regenerate with `pnpm sim oracle regen`. ac seed 20261031 index 307 nodes 21 elements 42
.options sparse gmin=1e-12 noopac
RG1 1 0 1000000000000
RG2 2 0 1000000000000
RG3 3 0 1000000000000
RG4 4 0 1000000000000
RG5 5 0 1000000000000
RG6 6 0 1000000000000
RG7 7 0 1000000000000
RG8 8 0 1000000000000
RG9 9 0 1000000000000
RG10 10 0 1000000000000
RG11 11 0 1000000000000
RG12 12 0 1000000000000
RG13 13 0 1000000000000
RG14 14 0 1000000000000
RG15 15 0 1000000000000
RG16 16 0 1000000000000
RG17 17 0 1000000000000
RG18 18 0 1000000000000
RG19 19 0 1000000000000
RG20 20 0 1000000000000
VS0 11 s0 0
C0 s0 13 56e-4
VS1 15 s1 0
C1 s1 19 15e-6
VS2 4 s2 0
C2 s2 17 27e-6
VS3 11 s3 0
R3 s3 14 15e-1
VS4 3 s4 0
C4 s4 15 15e-4
VS5 0 s5 0
C5 s5 5 82e-6
VS6 0 s6 0
V6 e6 s6 DC 0 AC 39e1 -120
RI6 e6 n6 33e-3
H6 n6 h6 VS15 -33e-4
ED6 h6 11 d6 0 15e-5
F6 0 d6 VS15 1
LD6 d6 0 1
VS7 16 s7 0
C7 s7 13 10e-4
VS8 17 s8 0
R8 s8 12 56e-1
VS9 14 s9 0
L9 s9 2 56e-3
VS10 16 s10 0
R10 s10 12 18e2
VS11 5 s11 0
C11 s11 18 33e-6
VS12 3 s12 0
C12 s12 5 39e-5
VS13 12 s13 0
L13 s13 1 27e-5
VS14 4 s14 0
L14 s14 12 15e-3
VS15 15 s15 0
V15 e15 s15 DC 0 AC 18e1 120
RI15 e15 n15 10e-2
H15 n15 h15 VS6 -33e-4
ED15 h15 5 d15 0 15e-5
F15 0 d15 VS6 1
LD15 d15 0 1
VS16 7 s16 0
C16 s16 6 82e-4
VS17 7 s17 0
R17 s17 11 39e-2
VS18 3 s18 0
R18 s18 12 12e-2
VS19 18 s19 0
V19 e19 s19 DC 0 AC 22e1 0
RI19 e19 m19 22e-1
LI19 m19 1 15e-7
VS20 7 s20 0
L20 s20 11 68e-3
VS21 9 s21 0
L21 s21 2 12e-3
VS22 17 s22 0
R22 s22 3 56e1
VS23 0 s23 0
R23 s23 8 68e2
VS24 0 s24 0
C24 s24 20 39e-5
VS25 13 s25 0
L25 s25 3 18e-3
VS26 10 s26 0
R26 s26 9 39e-2
VS27 6 s27 0
V27 e27 s27 DC 0 AC 27e1 180
RI27 e27 m27 56e-2
LI27 m27 10 47e-6
VS28 7 s28 0
R28 s28 9 15e2
VS29 19 s29 0
R29 s29 8 47e2
VS30 6 s30 0
R30 s30 5 15e3
VS31 2 s31 0
L31 s31 12 12e-4
VS32 5 s32 0
R32 s32 18 12e-1
VS33 20 s33 0
L33 s33 8 27e-2
VS34 20 s34 0
L34 s34 11 56e-5
VS35 11 s35 0
L35 s35 19 12e-4
VS36 11 s36 0
V36 e36 s36 DC 0 AC 82e0 120
RI36 e36 0 39e-1
VS37 16 s37 0
R37 s37 12 39e-2
VS38 19 s38 0
R38 s38 14 27e2
VS39 1 s39 0
R39 s39 14 22e1
VS40 3 s40 0
L40 s40 6 18e-5
VS41 7 s41 0
V41 e41 s41 DC 0 AC 68e1 180
RI41 e41 4 22e-2
.control
set numdgt=17
ac lin 1 60 60
print v(1) v(2) v(3) v(4) v(5) v(6) v(7) v(8) v(9) v(10)
print v(11) v(12) v(13) v(14) v(15) v(16) v(17) v(18) v(19) v(20)
print i(vs0) i(vs1) i(vs2) i(vs3) i(vs4) i(vs5) i(vs6) i(vs7) i(vs8) i(vs9)
print i(vs10) i(vs11) i(vs12) i(vs13) i(vs14) i(vs15) i(vs16) i(vs17) i(vs18) i(vs19)
print i(vs20) i(vs21) i(vs22) i(vs23) i(vs24) i(vs25) i(vs26) i(vs27) i(vs28) i(vs29)
print i(vs30) i(vs31) i(vs32) i(vs33) i(vs34) i(vs35) i(vs36) i(vs37) i(vs38) i(vs39)
print i(vs40) i(vs41)
.endc
.end
