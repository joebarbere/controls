controls oracle ac-0307
* Generated (plan F2.7, ADR 0012): do not edit; regenerate with `pnpm sim oracle regen`. ac seed 20261031 index 307 nodes 21 elements 41
.options sparse gmin=1e-12 noopac
RG1 1 0 1000000000000
RG2 2 0 1000000000000
RG3 3 0 1000000000000
RG4 4 0 1000000000000
RG5 5 0 1000000000000
RG6 6 0 1000000000000
RG7 7 0 1000000000000
RG8 8 0 1000000000000
RG9 9 0 1000000000000
RG10 10 0 1000000000000
RG11 11 0 1000000000000
RG12 12 0 1000000000000
RG13 13 0 1000000000000
RG14 14 0 1000000000000
RG15 15 0 1000000000000
RG16 16 0 1000000000000
RG17 17 0 1000000000000
RG18 18 0 1000000000000
RG19 19 0 1000000000000
RG20 20 0 1000000000000
VS0 0 s0 0
C0 s0 19 15e-6
VS1 5 s1 0
R1 s1 18 12e-1
VS2 7 s2 0
C2 s2 20 39e-5
VS3 0 s3 0
V3 e3 s3 DC 0 AC 18e1 120
RI3 e3 5 10e-2
VS4 3 s4 0
L4 s4 6 18e-5
VS5 2 s5 0
L5 s5 12 12e-4
VS6 19 s6 0
R6 s6 8 47e2
VS7 4 s7 0
L7 s7 12 15e-3
VS8 15 s8 0
C8 s8 6 82e-4
VS9 15 s9 0
V9 e9 s9 DC 0 AC 68e1 180
RI9 e9 4 22e-2
VS10 16 s10 0
C10 s10 13 10e-4
VS11 13 s11 0
L11 s11 3 18e-3
VS12 19 s12 0
R12 s12 14 27e2
VS13 7 s13 0
V13 e13 s13 DC 0 AC 39e1 -120
RI13 e13 11 33e-3
VS14 4 s14 0
C14 s14 17 27e-6
VS15 14 s15 0
L15 s15 2 56e-3
VS16 3 s16 0
C16 s16 0 15e-4
VS17 17 s17 0
R17 s17 3 56e1
VS18 15 s18 0
R18 s18 9 15e2
VS19 5 s19 0
C19 s19 18 33e-6
VS20 3 s20 0
C20 s20 5 39e-5
VS21 11 s21 0
R21 s21 14 15e-1
VS22 12 s22 0
L22 s22 1 27e-5
VS23 3 s23 0
R23 s23 12 12e-2
VS24 10 s24 0
R24 s24 9 39e-2
VS25 9 s25 0
L25 s25 2 12e-3
VS26 11 s26 0
L26 s26 19 12e-4
VS27 20 s27 0
L27 s27 8 27e-2
VS28 15 s28 0
R28 s28 11 39e-2
VS29 16 s29 0
R29 s29 12 39e-2
VS30 6 s30 0
R30 s30 5 15e3
VS31 17 s31 0
R31 s31 12 56e-1
VS32 7 s32 0
C32 s32 5 82e-6
VS33 11 s33 0
C33 s33 13 56e-4
VS34 7 s34 0
R34 s34 8 68e2
VS35 15 s35 0
L35 s35 11 68e-3
VS36 1 s36 0
R36 s36 14 22e1
VS37 6 s37 0
V37 e37 s37 DC 0 AC 27e1 180
RI37 e37 10 56e-2
VS38 16 s38 0
R38 s38 12 18e2
VS39 20 s39 0
L39 s39 11 56e-5
VS40 11 s40 0
V40 e40 s40 DC 0 AC 82e0 120
RI40 e40 7 39e-1
.control
set numdgt=17
ac lin 1 60 60
print v(1) v(2) v(3) v(4) v(5) v(6) v(7) v(8) v(9) v(10)
print v(11) v(12) v(13) v(14) v(15) v(16) v(17) v(18) v(19) v(20)
print i(vs0) i(vs1) i(vs2) i(vs3) i(vs4) i(vs5) i(vs6) i(vs7) i(vs8) i(vs9)
print i(vs10) i(vs11) i(vs12) i(vs13) i(vs14) i(vs15) i(vs16) i(vs17) i(vs18) i(vs19)
print i(vs20) i(vs21) i(vs22) i(vs23) i(vs24) i(vs25) i(vs26) i(vs27) i(vs28) i(vs29)
print i(vs30) i(vs31) i(vs32) i(vs33) i(vs34) i(vs35) i(vs36) i(vs37) i(vs38) i(vs39)
print i(vs40)
.endc
.end
