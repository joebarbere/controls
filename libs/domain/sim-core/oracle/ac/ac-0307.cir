controls oracle ac-0307
* Generated (plan F2.7, ADR 0012): do not edit; regenerate with `pnpm sim oracle regen`. ac seed 20261031 index 307 nodes 21 elements 38
.options sparse gmin=1e-12 noopac
RG1 1 0 1000000000000
RG2 2 0 1000000000000
RG3 3 0 1000000000000
RG4 4 0 1000000000000
RG5 5 0 1000000000000
RG6 6 0 1000000000000
RG7 7 0 1000000000000
RG8 8 0 1000000000000
RG9 9 0 1000000000000
RG10 10 0 1000000000000
RG11 11 0 1000000000000
RG12 12 0 1000000000000
RG13 13 0 1000000000000
RG14 14 0 1000000000000
RG15 15 0 1000000000000
RG16 16 0 1000000000000
RG17 17 0 1000000000000
RG18 18 0 1000000000000
RG19 19 0 1000000000000
RG20 20 0 1000000000000
VS0 0 s0 0
V0 e0 s0 DC 0 AC 27e1 180
RI0 e0 m0 56e-2
LI0 m0 10 15e-5
VS1 14 s1 0
R1 s1 18 27e1
VS2 5 s2 0
R2 s2 7 15e-1
VS3 13 s3 0
L3 s3 15 56e-5
VS4 3 s4 0
C4 s4 12 39e-6
VS5 2 s5 0
L5 s5 9 68e-4
VS6 8 s6 0
C6 s6 5 47e-6
VS7 14 s7 0
C7 s7 12 10e-7
VS8 0 s8 0
V8 e8 s8 DC 0 AC 39e-1 -120
RI8 e8 m8 47e-1
LI8 m8 6 18e-7
VS9 6 s9 0
V9 e9 s9 DC 0 AC 68e1 180
RI9 e9 m9 22e-2
LI9 m9 4 39e-5
VS10 13 s10 0
C10 s10 17 12e-5
VS11 9 s11 0
L11 s11 2 12e-3
VS12 19 s12 0
R12 s12 14 27e2
VS13 12 s13 0
L13 s13 1 27e-5
VS14 7 s14 0
V14 e14 s14 DC 0 AC 39e1 -120
RI14 e14 m14 33e-3
LI14 m14 11 22e-7
VS15 11 s15 0
C15 s15 13 56e-4
VS16 5 s16 0
C16 s16 18 33e-6
VS17 7 s17 0
C17 s17 5 82e-6
VS18 4 s18 0
R18 s18 9 82e0
VS19 17 s19 0
R19 s19 3 56e1
VS20 5 s20 0
V20 e20 s20 DC 0 AC 18e0 180
RI20 e20 m20 22e-3
LI20 m20 19 18e-5
VS21 11 s21 0
R21 s21 14 15e-1
VS22 3 s22 0
R22 s22 12 12e-2
VS23 13 s23 0
L23 s23 3 18e-3
VS24 17 s24 0
L24 s24 10 68e-3
VS25 15 s25 0
C25 s25 19 15e-6
VS26 20 s26 0
L26 s26 9 12e-2
VS27 20 s27 0
R27 s27 16 22e-2
VS28 6 s28 0
R28 s28 11 39e-2
VS29 2 s29 0
V29 e29 s29 DC 0 AC 10e0 180
RI29 e29 m29 12e-3
LI29 m29 6 27e-5
VS30 3 s30 0
R30 s30 0 39e3
VS31 4 s31 0
L31 s31 17 68e-2
VS32 3 s32 0
L32 s32 10 27e-2
VS33 3 s33 0
C33 s33 15 15e-4
VS34 16 s34 0
L34 s34 13 47e-5
VS35 0 s35 0
R35 s35 5 15e3
VS36 1 s36 0
L36 s36 13 47e-5
VS37 8 s37 0
R37 s37 20 56e3
.control
set numdgt=17
ac lin 1 60 60
print v(1) v(2) v(3) v(4) v(5) v(6) v(7) v(8) v(9) v(10)
print v(11) v(12) v(13) v(14) v(15) v(16) v(17) v(18) v(19) v(20)
print i(vs0) i(vs1) i(vs2) i(vs3) i(vs4) i(vs5) i(vs6) i(vs7) i(vs8) i(vs9)
print i(vs10) i(vs11) i(vs12) i(vs13) i(vs14) i(vs15) i(vs16) i(vs17) i(vs18) i(vs19)
print i(vs20) i(vs21) i(vs22) i(vs23) i(vs24) i(vs25) i(vs26) i(vs27) i(vs28) i(vs29)
print i(vs30) i(vs31) i(vs32) i(vs33) i(vs34) i(vs35) i(vs36) i(vs37)
.endc
.end
