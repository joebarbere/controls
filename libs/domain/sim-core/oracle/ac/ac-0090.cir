controls oracle ac-0090
* Generated (plan F2.7, ADR 0012): do not edit; regenerate with `pnpm sim oracle regen`. ac seed 20261031 index 90 nodes 15 elements 26
.options sparse gmin=1e-12 noopac
RG1 1 0 1000000000000
RG2 2 0 1000000000000
RG3 3 0 1000000000000
RG4 4 0 1000000000000
RG5 5 0 1000000000000
RG6 6 0 1000000000000
RG7 7 0 1000000000000
RG8 8 0 1000000000000
RG9 9 0 1000000000000
RG10 10 0 1000000000000
RG11 11 0 1000000000000
RG12 12 0 1000000000000
RG13 13 0 1000000000000
RG14 14 0 1000000000000
VS0 6 s0 0
R0 s0 8 22e3
VS1 0 s1 0
V1 e1 s1 DC 0 AC 12e0 120
RI1 e1 n1 22e-2
H1 n1 h1 VS2 22e-4
ED1 h1 1 d1 0 33e-5
F1 0 d1 VS2 1
LD1 d1 0 1
VS2 11 s2 0
V2 e2 s2 DC 0 AC 68e-1 -120
RI2 e2 n2 33e-3
H2 n2 h2 VS1 22e-4
ED2 h2 13 d2 0 33e-5
F2 0 d2 VS1 1
LD2 d2 0 1
VS3 8 s3 0
R3 s3 12 68e2
VS4 0 s4 0
R4 s4 11 12e-2
VS5 13 s5 0
C5 s5 7 56e-7
VS6 14 s6 0
V6 e6 s6 DC 0 AC 22e1 -120
RI6 e6 m6 68e-1
LI6 m6 8 18e-6
VS7 2 s7 0
C7 s7 14 22e-7
VS8 4 s8 0
C8 s8 6 10e-6
VS9 12 s9 0
C9 s9 5 82e-6
VS10 0 s10 0
C10 s10 11 15e-6
VS11 13 s11 0
V11 e11 s11 DC 0 AC 33e-1 0
RI11 e11 3 56e-3
VS12 6 s12 0
C12 s12 7 27e-5
VS13 3 s13 0
R13 s13 0 56e2
VS14 2 s14 0
V14 e14 s14 DC 0 AC 12e1 180
RI14 e14 10 27e-1
VS15 13 s15 0
L15 s15 14 39e-2
VS16 10 s16 0
V16 e16 s16 DC 0 AC 82e-1 0
RI16 e16 m16 39e-3
LI16 m16 12 10e-7
VS17 1 s17 0
L17 s17 9 47e-5
VS18 4 s18 0
C18 s18 12 68e-6
VS19 5 s19 0
R19 s19 6 39e1
VS20 6 s20 0
L20 s20 11 39e-3
VS21 10 s21 0
V21 e21 s21 DC 0 AC 56e1 0
RI21 e21 m21 47e-2
LI21 m21 11 27e-7
VS22 10 s22 0
C22 s22 4 12e-6
VS23 6 s23 0
V23 e23 s23 DC 0 AC 27e0 180
RI23 e23 9 22e-1
VS24 9 s24 0
C24 s24 12 39e-6
VS25 2 s25 0
V25 e25 s25 DC 0 AC 33e1 -120
RI25 e25 12 15e-2
.control
set numdgt=17
ac lin 1 60 60
print v(1) v(2) v(3) v(4) v(5) v(6) v(7) v(8) v(9) v(10)
print v(11) v(12) v(13) v(14)
print i(vs0) i(vs1) i(vs2) i(vs3) i(vs4) i(vs5) i(vs6) i(vs7) i(vs8) i(vs9)
print i(vs10) i(vs11) i(vs12) i(vs13) i(vs14) i(vs15) i(vs16) i(vs17) i(vs18) i(vs19)
print i(vs20) i(vs21) i(vs22) i(vs23) i(vs24) i(vs25)
.endc
.end
