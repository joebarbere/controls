controls oracle ac-0090
* Generated (plan F2.7, ADR 0012): do not edit; regenerate with `pnpm sim oracle regen`. ac seed 20261031 index 90 nodes 15 elements 23
.options sparse gmin=1e-12 noopac
RG1 1 0 1000000000000
RG2 2 0 1000000000000
RG3 3 0 1000000000000
RG4 4 0 1000000000000
RG5 5 0 1000000000000
RG6 6 0 1000000000000
RG7 7 0 1000000000000
RG8 8 0 1000000000000
RG9 9 0 1000000000000
RG10 10 0 1000000000000
RG11 11 0 1000000000000
RG12 12 0 1000000000000
RG13 13 0 1000000000000
RG14 14 0 1000000000000
VS0 0 s0 0
V0 e0 s0 DC 0 AC 68e-1 -120
RI0 e0 13 33e-3
VS1 6 s1 0
V1 e1 s1 DC 0 AC 27e0 180
RI1 e1 9 22e-1
VS2 2 s2 0
V2 e2 s2 DC 0 AC 12e1 180
RI2 e2 10 27e-1
VS3 13 s3 0
V3 e3 s3 DC 0 AC 33e-1 0
RI3 e3 3 56e-3
VS4 10 s4 0
V4 e4 s4 DC 0 AC 56e1 0
RI4 e4 0 47e-2
VS5 10 s5 0
C5 s5 4 12e-6
VS6 11 s6 0
C6 s6 0 15e-6
VS7 13 s7 0
C7 s7 7 56e-7
VS8 11 s8 0
R8 s8 0 12e-2
VS9 8 s9 0
R9 s9 12 68e2
VS10 11 s10 0
V10 e10 s10 DC 0 AC 12e0 120
RI10 e10 1 22e-2
VS11 6 s11 0
C11 s11 7 27e-5
VS12 6 s12 0
L12 s12 0 39e-3
VS13 14 s13 0
V13 e13 s13 DC 0 AC 22e1 -120
RI13 e13 8 68e-1
VS14 4 s14 0
C14 s14 12 68e-6
VS15 2 s15 0
C15 s15 14 22e-7
VS16 9 s16 0
C16 s16 12 39e-6
VS17 12 s17 0
C17 s17 5 82e-6
VS18 4 s18 0
C18 s18 6 10e-6
VS19 10 s19 0
V19 e19 s19 DC 0 AC 82e-1 0
RI19 e19 12 39e-3
VS20 13 s20 0
L20 s20 14 39e-2
VS21 2 s21 0
V21 e21 s21 DC 0 AC 33e1 -120
RI21 e21 12 15e-2
VS22 6 s22 0
R22 s22 8 22e3
.control
set numdgt=17
ac lin 1 60 60
print v(1) v(2) v(3) v(4) v(5) v(6) v(7) v(8) v(9) v(10)
print v(11) v(12) v(13) v(14)
print i(vs0) i(vs1) i(vs2) i(vs3) i(vs4) i(vs5) i(vs6) i(vs7) i(vs8) i(vs9)
print i(vs10) i(vs11) i(vs12) i(vs13) i(vs14) i(vs15) i(vs16) i(vs17) i(vs18) i(vs19)
print i(vs20) i(vs21) i(vs22)
.endc
.end
