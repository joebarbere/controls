controls oracle ac-0090
* Generated (plan F2.7, ADR 0012): do not edit; regenerate with `pnpm sim oracle regen`. ac seed 20261031 index 90 nodes 15 elements 27
.options sparse gmin=1e-12 noopac
RG1 1 0 1000000000000
RG2 2 0 1000000000000
RG3 3 0 1000000000000
RG4 4 0 1000000000000
RG5 5 0 1000000000000
RG6 6 0 1000000000000
RG7 7 0 1000000000000
RG8 8 0 1000000000000
RG9 9 0 1000000000000
RG10 10 0 1000000000000
RG11 11 0 1000000000000
RG12 12 0 1000000000000
RG13 13 0 1000000000000
RG14 14 0 1000000000000
VS0 0 s0 0
V0 e0 s0 DC 0 AC 68e-1 -120
RI0 e0 m0 33e-3
LI0 m0 13 10e-7
VS1 11 s1 0
C1 s1 2 22e-5
VS2 12 s2 0
C2 s2 13 27e-6
VS3 12 s3 0
C3 s3 9 18e-6
VS4 11 s4 0
R4 s4 8 33e-1
VS5 5 s5 0
R5 s5 13 27e3
VS6 7 s6 0
V6 e6 s6 DC 0 AC 18e1 0
RI6 e6 1 56e-1
VS7 8 s7 0
V7 e7 s7 DC 0 AC 39e-1 -120
RI7 e7 m7 82e-1
LI7 m7 10 39e-5
VS8 3 s8 0
V8 e8 s8 DC 0 AC 18e-1 180
RI8 e8 2 10e-1
VS9 5 s9 0
C9 s9 6 22e-7
VS10 12 s10 0
C10 s10 13 39e-7
VS11 14 s11 0
C11 s11 0 22e-5
VS12 14 s12 0
V12 e12 s12 DC 0 AC 39e-1 0
RI12 e12 10 12e-1
VS13 2 s13 0
L13 s13 10 33e-2
VS14 5 s14 0
C14 s14 2 18e-5
VS15 7 s15 0
R15 s15 12 10e-2
VS16 6 s16 0
L16 s16 11 82e-3
VS17 4 s17 0
V17 e17 s17 DC 0 AC 47e-1 120
RI17 e17 m17 68e-1
LI17 m17 8 56e-5
VS18 7 s18 0
L18 s18 14 47e-5
VS19 9 s19 0
V19 e19 s19 DC 0 AC 22e1 -120
RI19 e19 m19 12e-3
LI19 m19 13 18e-6
VS20 3 s20 0
L20 s20 7 33e-2
VS21 12 s21 0
L21 s21 5 47e-5
VS22 4 s22 0
C22 s22 0 22e-7
VS23 2 s23 0
L23 s23 13 15e-2
VS24 11 s24 0
R24 s24 1 39e-2
VS25 11 s25 0
C25 s25 0 15e-6
VS26 12 s26 0
R26 s26 14 33e-1
.control
set numdgt=17
ac lin 1 60 60
print v(1) v(2) v(3) v(4) v(5) v(6) v(7) v(8) v(9) v(10)
print v(11) v(12) v(13) v(14)
print i(vs0) i(vs1) i(vs2) i(vs3) i(vs4) i(vs5) i(vs6) i(vs7) i(vs8) i(vs9)
print i(vs10) i(vs11) i(vs12) i(vs13) i(vs14) i(vs15) i(vs16) i(vs17) i(vs18) i(vs19)
print i(vs20) i(vs21) i(vs22) i(vs23) i(vs24) i(vs25) i(vs26)
.endc
.end
