controls oracle ac-0006
* Generated (plan F2.7, ADR 0012): do not edit; regenerate with `pnpm sim oracle regen`. ac seed 20261031 index 6 nodes 17 elements 35
.options sparse gmin=1e-12 noopac
RG1 1 0 1000000000000
RG2 2 0 1000000000000
RG3 3 0 1000000000000
RG4 4 0 1000000000000
RG5 5 0 1000000000000
RG6 6 0 1000000000000
RG7 7 0 1000000000000
RG8 8 0 1000000000000
RG9 9 0 1000000000000
RG10 10 0 1000000000000
RG11 11 0 1000000000000
RG12 12 0 1000000000000
RG13 13 0 1000000000000
RG14 14 0 1000000000000
RG15 15 0 1000000000000
RG16 16 0 1000000000000
VS0 11 s0 0
L0 s0 12 33e-5
VS1 15 s1 0
L1 s1 8 15e-4
VS2 6 s2 0
C2 s2 7 22e-4
VS3 0 s3 0
V3 e3 s3 DC 0 AC 56e-1 180
RI3 e3 15 10e-3
VS4 13 s4 0
L4 s4 14 68e-2
VS5 5 s5 0
L5 s5 0 27e-3
VS6 3 s6 0
V6 e6 s6 DC 0 AC 56e1 0
RI6 e6 12 22e-1
VS7 3 s7 0
V7 e7 s7 DC 0 AC 22e1 120
RI7 e7 m7 10e-2
LI7 m7 10 12e-5
VS8 7 s8 0
L8 s8 14 15e-2
VS9 16 s9 0
C9 s9 3 15e-6
VS10 7 s10 0
C10 s10 2 22e-4
VS11 2 s11 0
R11 s11 15 33e-1
VS12 7 s12 0
C12 s12 11 33e-7
VS13 11 s13 0
L13 s13 10 39e-3
VS14 13 s14 0
V14 e14 s14 DC 0 AC 15e1 0
RI14 e14 8 27e-2
VS15 0 s15 0
R15 s15 6 10e0
VS16 9 s16 0
R16 s16 5 56e1
VS17 11 s17 0
C17 s17 16 39e-6
VS18 7 s18 0
R18 s18 0 12e3
VS19 1 s19 0
V19 e19 s19 DC 0 AC 27e-1 180
RI19 e19 m19 68e-3
LI19 m19 4 10e-7
VS20 14 s20 0
C20 s20 8 22e-7
VS21 9 s21 0
V21 e21 s21 DC 0 AC 47e0 -120
RI21 e21 6 27e-1
VS22 3 s22 0
V22 e22 s22 DC 0 AC 39e-1 -120
RI22 e22 m22 22e-2
LI22 m22 16 27e-5
VS23 7 s23 0
C23 s23 0 33e-4
VS24 0 s24 0
L24 s24 13 18e-4
VS25 6 s25 0
C25 s25 1 15e-6
VS26 3 s26 0
L26 s26 6 10e-4
VS27 12 s27 0
R27 s27 14 56e1
VS28 15 s28 0
V28 e28 s28 DC 0 AC 33e1 0
RI28 e28 m28 68e-3
LI28 m28 7 18e-6
VS29 3 s29 0
L29 s29 4 47e-5
VS30 8 s30 0
R30 s30 0 15e-2
VS31 9 s31 0
L31 s31 6 10e-3
VS32 5 s32 0
R32 s32 15 12e0
VS33 10 s33 0
V33 e33 s33 DC 0 AC 39e1 120
RI33 e33 m33 47e-1
LI33 m33 11 33e-6
VS34 9 s34 0
V34 e34 s34 DC 0 AC 47e-1 -120
RI34 e34 15 27e-2
.control
set numdgt=17
ac lin 1 60 60
print v(1) v(2) v(3) v(4) v(5) v(6) v(7) v(8) v(9) v(10)
print v(11) v(12) v(13) v(14) v(15) v(16)
print i(vs0) i(vs1) i(vs2) i(vs3) i(vs4) i(vs5) i(vs6) i(vs7) i(vs8) i(vs9)
print i(vs10) i(vs11) i(vs12) i(vs13) i(vs14) i(vs15) i(vs16) i(vs17) i(vs18) i(vs19)
print i(vs20) i(vs21) i(vs22) i(vs23) i(vs24) i(vs25) i(vs26) i(vs27) i(vs28) i(vs29)
print i(vs30) i(vs31) i(vs32) i(vs33) i(vs34)
.endc
.end
