controls oracle ac-0006
* Generated (plan F2.7, ADR 0012): do not edit; regenerate with `pnpm sim oracle regen`. ac seed 20261031 index 6 nodes 17 elements 17
.options sparse gmin=1e-12 noopac
RG1 1 0 1000000000000
RG2 2 0 1000000000000
RG3 3 0 1000000000000
RG4 4 0 1000000000000
RG5 5 0 1000000000000
RG6 6 0 1000000000000
RG7 7 0 1000000000000
RG8 8 0 1000000000000
RG9 9 0 1000000000000
RG10 10 0 1000000000000
RG11 11 0 1000000000000
RG12 12 0 1000000000000
RG13 13 0 1000000000000
RG14 14 0 1000000000000
RG15 15 0 1000000000000
RG16 16 0 1000000000000
VS0 0 s0 0
V0 e0 s0 DC 0 AC 39e1 120
RI0 e0 15 47e-1
VS1 4 s1 0
L1 s1 9 68e-4
VS2 15 s2 0
C2 s2 12 33e-4
VS3 14 s3 0
L3 s3 12 47e-4
VS4 4 s4 0
C4 s4 8 22e-4
VS5 9 s5 0
L5 s5 13 10e-3
VS6 3 s6 0
L6 s6 13 10e-4
VS7 16 s7 0
C7 s7 12 56e-4
VS8 14 s8 0
V8 e8 s8 DC 0 AC 10e-1 0
RI8 e8 11 56e-3
VS9 12 s9 0
R9 s9 10 12e0
VS10 13 s10 0
C10 s10 1 15e-6
VS11 7 s11 0
C11 s11 9 12e-5
VS12 3 s12 0
L12 s12 6 47e-2
VS13 2 s13 0
L13 s13 12 27e-4
VS14 8 s14 0
L14 s14 0 47e-5
VS15 13 s15 0
R15 s15 5 39e0
VS16 3 s16 0
V16 e16 s16 DC 0 AC 56e1 0
RI16 e16 12 22e-1
.control
set numdgt=17
ac lin 1 60 60
print v(1) v(2) v(3) v(4) v(5) v(6) v(7) v(8) v(9) v(10)
print v(11) v(12) v(13) v(14) v(15) v(16)
print i(vs0) i(vs1) i(vs2) i(vs3) i(vs4) i(vs5) i(vs6) i(vs7) i(vs8) i(vs9)
print i(vs10) i(vs11) i(vs12) i(vs13) i(vs14) i(vs15) i(vs16)
.endc
.end
