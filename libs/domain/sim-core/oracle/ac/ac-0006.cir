controls oracle ac-0006
* Generated (plan F2.7, ADR 0012): do not edit; regenerate with `pnpm sim oracle regen`. ac seed 20261031 index 6 nodes 17 elements 24
.options sparse gmin=1e-12 noopac
RG1 1 0 1000000000000
RG2 2 0 1000000000000
RG3 3 0 1000000000000
RG4 4 0 1000000000000
RG5 5 0 1000000000000
RG6 6 0 1000000000000
RG7 7 0 1000000000000
RG8 8 0 1000000000000
RG9 9 0 1000000000000
RG10 10 0 1000000000000
RG11 11 0 1000000000000
RG12 12 0 1000000000000
RG13 13 0 1000000000000
RG14 14 0 1000000000000
RG15 15 0 1000000000000
RG16 16 0 1000000000000
VS0 11 s0 0
R0 s0 6 47e-1
VS1 3 s1 0
L1 s1 6 47e-2
VS2 15 s2 0
C2 s2 12 33e-4
VS3 16 s3 0
C3 s3 12 56e-4
VS4 15 s4 0
L4 s4 7 10e-5
VS5 7 s5 0
C5 s5 9 12e-5
VS6 2 s6 0
L6 s6 10 12e-4
VS7 16 s7 0
R7 s7 1 10e2
VS8 0 s8 0
V8 e8 s8 DC 0 AC 39e1 120
RI8 e8 15 47e-1
VS9 3 s9 0
V9 e9 s9 DC 0 AC 56e1 0
RI9 e9 12 22e-1
VS10 9 s10 0
L10 s10 13 10e-3
VS11 14 s11 0
V11 e11 s11 DC 0 AC 18e0 180
RI11 e11 2 15e-2
VS12 4 s12 0
L12 s12 9 68e-4
VS13 14 s13 0
V13 e13 s13 DC 0 AC 10e-1 0
RI13 e13 11 56e-3
VS14 3 s14 0
L14 s14 13 10e-4
VS15 13 s15 0
C15 s15 1 15e-6
VS16 14 s16 0
L16 s16 12 47e-4
VS17 12 s17 0
R17 s17 10 12e0
VS18 2 s18 0
L18 s18 12 27e-4
VS19 8 s19 0
L19 s19 0 47e-5
VS20 9 s20 0
C20 s20 11 18e-6
VS21 13 s21 0
R21 s21 5 39e0
VS22 8 s22 0
R22 s22 5 33e3
VS23 4 s23 0
C23 s23 8 22e-4
.control
set numdgt=17
ac lin 1 60 60
print v(1) v(2) v(3) v(4) v(5) v(6) v(7) v(8) v(9) v(10)
print v(11) v(12) v(13) v(14) v(15) v(16)
print i(vs0) i(vs1) i(vs2) i(vs3) i(vs4) i(vs5) i(vs6) i(vs7) i(vs8) i(vs9)
print i(vs10) i(vs11) i(vs12) i(vs13) i(vs14) i(vs15) i(vs16) i(vs17) i(vs18) i(vs19)
print i(vs20) i(vs21) i(vs22) i(vs23)
.endc
.end
