controls oracle ac-0309
* Generated (plan F2.7, ADR 0012): do not edit; regenerate with `pnpm sim oracle regen`. ac seed 20261031 index 309 nodes 14 elements 23
.options sparse gmin=1e-12 noopac
RG1 1 0 1000000000000
RG2 2 0 1000000000000
RG3 3 0 1000000000000
RG4 4 0 1000000000000
RG5 5 0 1000000000000
RG6 6 0 1000000000000
RG7 7 0 1000000000000
RG8 8 0 1000000000000
RG9 9 0 1000000000000
RG10 10 0 1000000000000
RG11 11 0 1000000000000
RG12 12 0 1000000000000
RG13 13 0 1000000000000
VS0 0 s0 0
V0 e0 s0 DC 0 AC 33e-1 120
RI0 e0 7 39e-1
VS1 12 s1 0
L1 s1 5 56e-5
VS2 6 s2 0
L2 s2 13 47e-3
VS3 4 s3 0
R3 s3 0 82e0
VS4 0 s4 0
L4 s4 9 68e-2
VS5 2 s5 0
L5 s5 13 18e-3
VS6 8 s6 0
R6 s6 10 18e2
VS7 5 s7 0
V7 e7 s7 DC 0 AC 68e1 120
RI7 e7 9 12e-1
VS8 4 s8 0
R8 s8 8 56e1
VS9 3 s9 0
C9 s9 1 33e-5
VS10 10 s10 0
R10 s10 2 27e2
VS11 0 s11 0
R11 s11 1 22e3
VS12 10 s12 0
V12 e12 s12 DC 0 AC 39e1 0
RI12 e12 m12 39e-1
LI12 m12 8 68e-5
VS13 11 s13 0
R13 s13 3 12e1
VS14 13 s14 0
C14 s14 10 82e-5
VS15 13 s15 0
C15 s15 0 22e-7
VS16 1 s16 0
R16 s16 5 27e1
VS17 11 s17 0
R17 s17 10 68e0
VS18 8 s18 0
V18 e18 s18 DC 0 AC 33e1 120
RI18 e18 m18 33e-2
LI18 m18 11 33e-6
VS19 5 s19 0
C19 s19 1 15e-6
VS20 12 s20 0
L20 s20 11 12e-3
VS21 13 s21 0
C21 s21 10 27e-4
VS22 6 s22 0
R22 s22 7 33e0
.control
set numdgt=17
ac lin 1 60 60
print v(1) v(2) v(3) v(4) v(5) v(6) v(7) v(8) v(9) v(10)
print v(11) v(12) v(13)
print i(vs0) i(vs1) i(vs2) i(vs3) i(vs4) i(vs5) i(vs6) i(vs7) i(vs8) i(vs9)
print i(vs10) i(vs11) i(vs12) i(vs13) i(vs14) i(vs15) i(vs16) i(vs17) i(vs18) i(vs19)
print i(vs20) i(vs21) i(vs22)
.endc
.end
