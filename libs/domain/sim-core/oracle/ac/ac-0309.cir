controls oracle ac-0309
* Generated (plan F2.7, ADR 0012): do not edit; regenerate with `pnpm sim oracle regen`. ac seed 20261031 index 309 nodes 14 elements 21
.options sparse gmin=1e-12 noopac
RG1 1 0 1000000000000
RG2 2 0 1000000000000
RG3 3 0 1000000000000
RG4 4 0 1000000000000
RG5 5 0 1000000000000
RG6 6 0 1000000000000
RG7 7 0 1000000000000
RG8 8 0 1000000000000
RG9 9 0 1000000000000
RG10 10 0 1000000000000
RG11 11 0 1000000000000
RG12 12 0 1000000000000
RG13 13 0 1000000000000
VS0 3 s0 0
C0 s0 1 33e-5
VS1 0 s1 0
R1 s1 1 22e3
VS2 10 s2 0
C2 s2 0 15e-5
VS3 8 s3 0
R3 s3 10 18e2
VS4 11 s4 0
R4 s4 10 68e0
VS5 6 s5 0
R5 s5 7 33e0
VS6 12 s6 0
L6 s6 5 56e-5
VS7 4 s7 0
R7 s7 0 82e0
VS8 11 s8 0
R8 s8 3 12e1
VS9 4 s9 0
L9 s9 10 10e-3
VS10 6 s10 0
L10 s10 13 47e-3
VS11 5 s11 0
C11 s11 1 15e-6
VS12 0 s12 0
V12 e12 s12 DC 0 AC 47e0 0
RI12 e12 12 56e-2
VS13 13 s13 0
C13 s13 0 22e-7
VS14 8 s14 0
V14 e14 s14 DC 0 AC 33e1 120
RI14 e14 11 33e-2
VS15 1 s15 0
R15 s15 5 27e1
VS16 0 s16 0
L16 s16 9 68e-2
VS17 13 s17 0
L17 s17 2 22e-5
VS18 13 s18 0
C18 s18 10 27e-4
VS19 13 s19 0
C19 s19 10 82e-5
VS20 10 s20 0
R20 s20 2 27e2
.control
set numdgt=17
ac lin 1 60 60
print v(1) v(2) v(3) v(4) v(5) v(6) v(7) v(8) v(9) v(10)
print v(11) v(12) v(13)
print i(vs0) i(vs1) i(vs2) i(vs3) i(vs4) i(vs5) i(vs6) i(vs7) i(vs8) i(vs9)
print i(vs10) i(vs11) i(vs12) i(vs13) i(vs14) i(vs15) i(vs16) i(vs17) i(vs18) i(vs19)
print i(vs20)
.endc
.end
