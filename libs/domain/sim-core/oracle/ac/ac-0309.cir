controls oracle ac-0309
* Generated (plan F2.7, ADR 0012): do not edit; regenerate with `pnpm sim oracle regen`. ac seed 20261031 index 309 nodes 14 elements 23
.options sparse gmin=1e-12 noopac
RG1 1 0 1000000000000
RG2 2 0 1000000000000
RG3 3 0 1000000000000
RG4 4 0 1000000000000
RG5 5 0 1000000000000
RG6 6 0 1000000000000
RG7 7 0 1000000000000
RG8 8 0 1000000000000
RG9 9 0 1000000000000
RG10 10 0 1000000000000
RG11 11 0 1000000000000
RG12 12 0 1000000000000
RG13 13 0 1000000000000
VS0 13 s0 0
C0 s0 10 27e-4
VS1 5 s1 0
C1 s1 1 15e-6
VS2 4 s2 0
R2 s2 0 82e0
VS3 0 s3 0
R3 s3 1 22e3
VS4 0 s4 0
V4 e4 s4 DC 0 AC 47e0 0
RI4 e4 n4 56e-2
H4 n4 h4 VS5 -18e-3
ED4 h4 12 d4 0 -10e-7
F4 0 d4 VS5 1
LD4 d4 0 1
VS5 0 s5 0
V5 e5 s5 DC 0 AC 33e-1 120
RI5 e5 n5 39e-1
H5 n5 h5 VS4 -18e-3
ED5 h5 7 d5 0 -10e-7
F5 0 d5 VS4 1
LD5 d5 0 1
VS6 8 s6 0
V6 e6 s6 DC 0 AC 33e1 120
RI6 e6 m6 33e-2
LI6 m6 11 10e-6
VS7 4 s7 0
L7 s7 10 10e-3
VS8 8 s8 0
R8 s8 10 18e2
VS9 0 s9 0
L9 s9 9 68e-2
VS10 13 s10 0
C10 s10 0 22e-7
VS11 12 s11 0
L11 s11 5 56e-5
VS12 1 s12 0
R12 s12 5 27e1
VS13 13 s13 0
L13 s13 2 22e-5
VS14 6 s14 0
R14 s14 7 33e0
VS15 3 s15 0
C15 s15 1 33e-5
VS16 11 s16 0
R16 s16 3 12e1
VS17 10 s17 0
R17 s17 2 27e2
VS18 10 s18 0
C18 s18 0 15e-5
VS19 6 s19 0
L19 s19 13 47e-3
VS20 11 s20 0
R20 s20 10 68e0
VS21 13 s21 0
C21 s21 10 82e-5
VS22 9 s22 0
V22 e22 s22 DC 0 AC 68e0 0
RI22 e22 10 68e-2
.control
set numdgt=17
ac lin 1 60 60
print v(1) v(2) v(3) v(4) v(5) v(6) v(7) v(8) v(9) v(10)
print v(11) v(12) v(13)
print i(vs0) i(vs1) i(vs2) i(vs3) i(vs4) i(vs5) i(vs6) i(vs7) i(vs8) i(vs9)
print i(vs10) i(vs11) i(vs12) i(vs13) i(vs14) i(vs15) i(vs16) i(vs17) i(vs18) i(vs19)
print i(vs20) i(vs21) i(vs22)
.endc
.end
