controls oracle ac-0338
* Generated (plan F2.7, ADR 0012): do not edit; regenerate with `pnpm sim oracle regen`. ac seed 20261031 index 338 nodes 11 elements 18
.options sparse gmin=1e-12 noopac
RG1 1 0 1000000000000
RG2 2 0 1000000000000
RG3 3 0 1000000000000
RG4 4 0 1000000000000
RG5 5 0 1000000000000
RG6 6 0 1000000000000
RG7 7 0 1000000000000
RG8 8 0 1000000000000
RG9 9 0 1000000000000
RG10 10 0 1000000000000
VS0 3 s0 0
R0 s0 1 68e3
VS1 4 s1 0
L1 s1 8 22e-3
VS2 8 s2 0
L2 s2 0 47e-5
VS3 7 s3 0
L3 s3 9 22e-3
VS4 0 s4 0
V4 e4 s4 DC 0 AC 56e0 0
RI4 e4 10 33e-1
VS5 4 s5 0
V5 e5 s5 DC 0 AC 33e0 120
RI5 e5 m5 39e-1
LI5 m5 6 33e-6
VS6 9 s6 0
V6 e6 s6 DC 0 AC 33e0 180
RI6 e6 5 56e-1
VS7 3 s7 0
C7 s7 9 39e-5
VS8 6 s8 0
V8 e8 s8 DC 0 AC 39e1 -120
RI8 e8 m8 33e-2
LI8 m8 3 27e-6
VS9 1 s9 0
C9 s9 4 15e-6
VS10 0 s10 0
V10 e10 s10 DC 0 AC 10e0 120
RI10 e10 m10 12e-3
LI10 m10 6 68e-7
VS11 10 s11 0
L11 s11 7 15e-4
VS12 5 s12 0
R12 s12 0 68e0
VS13 3 s13 0
L13 s13 0 12e-2
VS14 4 s14 0
V14 e14 s14 DC 0 AC 12e-1 -120
RI14 e14 2 82e-1
VS15 4 s15 0
R15 s15 10 56e2
VS16 5 s16 0
L16 s16 4 82e-2
VS17 8 s17 0
V17 e17 s17 DC 0 AC 12e1 0
RI17 e17 2 27e-2
.control
set numdgt=17
ac lin 1 60 60
print v(1) v(2) v(3) v(4) v(5) v(6) v(7) v(8) v(9) v(10)
print i(vs0) i(vs1) i(vs2) i(vs3) i(vs4) i(vs5) i(vs6) i(vs7) i(vs8) i(vs9)
print i(vs10) i(vs11) i(vs12) i(vs13) i(vs14) i(vs15) i(vs16) i(vs17)
.endc
.end
