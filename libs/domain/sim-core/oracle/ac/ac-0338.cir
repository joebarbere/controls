controls oracle ac-0338
* Generated (plan F2.7, ADR 0012): do not edit; regenerate with `pnpm sim oracle regen`. ac seed 20261031 index 338 nodes 11 elements 20
.options sparse gmin=1e-12 noopac
RG1 1 0 1000000000000
RG2 2 0 1000000000000
RG3 3 0 1000000000000
RG4 4 0 1000000000000
RG5 5 0 1000000000000
RG6 6 0 1000000000000
RG7 7 0 1000000000000
RG8 8 0 1000000000000
RG9 9 0 1000000000000
RG10 10 0 1000000000000
VS0 0 s0 0
R0 s0 8 68e1
VS1 0 s1 0
V1 e1 s1 DC 0 AC 68e1 180
RI1 e1 10 82e-3
VS2 1 s2 0
L2 s2 0 12e-2
VS3 3 s3 0
V3 e3 s3 DC 0 AC 10e0 120
RI3 e3 9 12e-3
VS4 1 s4 0
R4 s4 8 33e3
VS5 2 s5 0
R5 s5 4 27e1
VS6 3 s6 0
L6 s6 10 22e-5
VS7 6 s7 0
V7 e7 s7 DC 0 AC 39e1 -120
RI7 e7 3 33e-2
VS8 6 s8 0
V8 e8 s8 DC 0 AC 68e1 180
RI8 e8 1 12e-1
VS9 7 s9 0
L9 s9 9 22e-3
VS10 6 s10 0
C10 s10 2 15e-6
VS11 0 s11 0
R11 s11 3 47e-2
VS12 8 s12 0
L12 s12 4 47e-5
VS13 5 s13 0
R13 s13 2 68e0
VS14 1 s14 0
R14 s14 2 39e3
VS15 4 s15 0
R15 s15 5 18e3
VS16 4 s16 0
V16 e16 s16 DC 0 AC 12e-1 -120
RI16 e16 0 82e-1
VS17 0 s17 0
V17 e17 s17 DC 0 AC 47e1 180
RI17 e17 4 33e-3
VS18 10 s18 0
C18 s18 0 47e-6
VS19 10 s19 0
L19 s19 7 22e-4
.control
set numdgt=17
ac lin 1 60 60
print v(1) v(2) v(3) v(4) v(5) v(6) v(7) v(8) v(9) v(10)
print i(vs0) i(vs1) i(vs2) i(vs3) i(vs4) i(vs5) i(vs6) i(vs7) i(vs8) i(vs9)
print i(vs10) i(vs11) i(vs12) i(vs13) i(vs14) i(vs15) i(vs16) i(vs17) i(vs18) i(vs19)
.endc
.end
