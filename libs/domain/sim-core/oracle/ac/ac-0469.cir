controls oracle ac-0469
* Generated (plan F2.7, ADR 0012): do not edit; regenerate with `pnpm sim oracle regen`. ac seed 20261031 index 469 nodes 5 elements 9
.options sparse gmin=1e-12 noopac
RG1 1 0 1000000000000
RG2 2 0 1000000000000
RG3 3 0 1000000000000
RG4 4 0 1000000000000
VS0 0 s0 0
V0 e0 s0 DC 0 AC 39e-1 180
RI0 e0 3 27e-3
VS1 4 s1 0
C1 s1 2 33e-7
VS2 2 s2 0
R2 s2 4 33e3
VS3 3 s3 0
R3 s3 1 82e-1
VS4 2 s4 0
L4 s4 4 22e-5
VS5 4 s5 0
R5 s5 1 39e-1
VS6 4 s6 0
L6 s6 0 27e-4
VS7 4 s7 0
L7 s7 3 12e-4
VS8 3 s8 0
R8 s8 1 33e-1
.control
set numdgt=17
ac lin 1 60 60
print v(1) v(2) v(3) v(4)
print i(vs0) i(vs1) i(vs2) i(vs3) i(vs4) i(vs5) i(vs6) i(vs7) i(vs8)
.endc
.end
