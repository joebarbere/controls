controls oracle ac-0469
* Generated (plan F2.7, ADR 0012): do not edit; regenerate with `pnpm sim oracle regen`. ac seed 20261031 index 469 nodes 5 elements 10
.options sparse gmin=1e-12 noopac
RG1 1 0 1000000000000
RG2 2 0 1000000000000
RG3 3 0 1000000000000
RG4 4 0 1000000000000
VS0 3 s0 0
R0 s0 1 33e-1
VS1 2 s1 0
R1 s1 0 56e-1
VS2 4 s2 0
R2 s2 1 39e-1
VS3 0 s3 0
V3 e3 s3 DC 0 AC 39e-1 180
RI3 e3 3 27e-3
VS4 2 s4 0
R4 s4 4 33e3
VS5 2 s5 0
L5 s5 4 22e-5
VS6 4 s6 0
C6 s6 2 33e-7
VS7 3 s7 0
R7 s7 1 82e-1
VS8 4 s8 0
L8 s8 3 12e-4
VS9 4 s9 0
L9 s9 0 27e-4
.control
set numdgt=17
ac lin 1 60 60
print v(1) v(2) v(3) v(4)
print i(vs0) i(vs1) i(vs2) i(vs3) i(vs4) i(vs5) i(vs6) i(vs7) i(vs8) i(vs9)
.endc
.end
