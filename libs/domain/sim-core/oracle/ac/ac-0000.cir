controls oracle ac-0000
* Generated (plan F2.7, ADR 0012): do not edit; regenerate with `pnpm sim oracle regen`. ac seed 20261031 index 0 nodes 27 elements 39
.options sparse gmin=1e-12 noopac
RG1 1 0 1000000000000
RG2 2 0 1000000000000
RG3 3 0 1000000000000
RG4 4 0 1000000000000
RG5 5 0 1000000000000
RG6 6 0 1000000000000
RG7 7 0 1000000000000
RG8 8 0 1000000000000
RG9 9 0 1000000000000
RG10 10 0 1000000000000
RG11 11 0 1000000000000
RG12 12 0 1000000000000
RG13 13 0 1000000000000
RG14 14 0 1000000000000
RG15 15 0 1000000000000
RG16 16 0 1000000000000
RG17 17 0 1000000000000
RG18 18 0 1000000000000
RG19 19 0 1000000000000
RG20 20 0 1000000000000
RG21 21 0 1000000000000
RG22 22 0 1000000000000
RG23 23 0 1000000000000
RG24 24 0 1000000000000
RG25 25 0 1000000000000
RG26 26 0 1000000000000
VS0 15 s0 0
L0 s0 14 82e-2
VS1 8 s1 0
R1 s1 6 12e2
VS2 12 s2 0
L2 s2 8 39e-2
VS3 0 s3 0
V3 e3 s3 DC 0 AC 22e1 -120
RI3 e3 m3 12e-2
LI3 m3 20 56e-5
VS4 20 s4 0
V4 e4 s4 DC 0 AC 27e0 0
RI4 e4 21 22e-1
VS5 15 s5 0
C5 s5 22 39e-7
VS6 12 s6 0
L6 s6 0 68e-4
VS7 18 s7 0
V7 e7 s7 DC 0 AC 39e-1 120
RI7 e7 20 82e-1
VS8 2 s8 0
C8 s8 24 15e-5
VS9 22 s9 0
R9 s9 10 68e0
VS10 23 s10 0
V10 e10 s10 DC 0 AC 15e-1 180
RI10 e10 14 68e-1
VS11 17 s11 0
C11 s11 14 39e-5
VS12 16 s12 0
L12 s12 17 33e-5
VS13 14 s13 0
C13 s13 21 47e-7
VS14 19 s14 0
C14 s14 26 56e-7
VS15 3 s15 0
C15 s15 24 82e-6
VS16 22 s16 0
L16 s16 5 18e-3
VS17 25 s17 0
C17 s17 4 33e-7
VS18 1 s18 0
R18 s18 12 10e-1
VS19 26 s19 0
C19 s19 4 22e-5
VS20 3 s20 0
R20 s20 1 12e-1
VS21 14 s21 0
R21 s21 24 12e2
VS22 23 s22 0
L22 s22 6 82e-3
VS23 22 s23 0
R23 s23 24 12e-2
VS24 2 s24 0
V24 e24 s24 DC 0 AC 15e0 120
RI24 e24 4 68e-1
VS25 25 s25 0
L25 s25 13 47e-3
VS26 5 s26 0
R26 s26 3 33e1
VS27 26 s27 0
C27 s27 7 47e-5
VS28 16 s28 0
L28 s28 9 27e-4
VS29 10 s29 0
L29 s29 11 56e-2
VS30 0 s30 0
R30 s30 7 22e1
VS31 6 s31 0
C31 s31 26 56e-5
VS32 13 s32 0
C32 s32 18 27e-6
VS33 6 s33 0
V33 e33 s33 DC 0 AC 68e1 0
RI33 e33 14 33e-2
VS34 9 s34 0
L34 s34 7 82e-4
VS35 10 s35 0
V35 e35 s35 DC 0 AC 12e1 0
RI35 e35 9 22e-3
VS36 9 s36 0
L36 s36 19 56e-3
VS37 26 s37 0
C37 s37 11 39e-6
VS38 7 s38 0
L38 s38 6 27e-4
.control
set numdgt=17
ac lin 1 60 60
print v(1) v(2) v(3) v(4) v(5) v(6) v(7) v(8) v(9) v(10)
print v(11) v(12) v(13) v(14) v(15) v(16) v(17) v(18) v(19) v(20)
print v(21) v(22) v(23) v(24) v(25) v(26)
print i(vs0) i(vs1) i(vs2) i(vs3) i(vs4) i(vs5) i(vs6) i(vs7) i(vs8) i(vs9)
print i(vs10) i(vs11) i(vs12) i(vs13) i(vs14) i(vs15) i(vs16) i(vs17) i(vs18) i(vs19)
print i(vs20) i(vs21) i(vs22) i(vs23) i(vs24) i(vs25) i(vs26) i(vs27) i(vs28) i(vs29)
print i(vs30) i(vs31) i(vs32) i(vs33) i(vs34) i(vs35) i(vs36) i(vs37) i(vs38)
.endc
.end
