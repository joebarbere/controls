controls oracle ac-0000
* Generated (plan F2.7, ADR 0012): do not edit; regenerate with `pnpm sim oracle regen`. ac seed 20261031 index 0 nodes 27 elements 39
.options sparse gmin=1e-12 noopac
RG1 1 0 1000000000000
RG2 2 0 1000000000000
RG3 3 0 1000000000000
RG4 4 0 1000000000000
RG5 5 0 1000000000000
RG6 6 0 1000000000000
RG7 7 0 1000000000000
RG8 8 0 1000000000000
RG9 9 0 1000000000000
RG10 10 0 1000000000000
RG11 11 0 1000000000000
RG12 12 0 1000000000000
RG13 13 0 1000000000000
RG14 14 0 1000000000000
RG15 15 0 1000000000000
RG16 16 0 1000000000000
RG17 17 0 1000000000000
RG18 18 0 1000000000000
RG19 19 0 1000000000000
RG20 20 0 1000000000000
RG21 21 0 1000000000000
RG22 22 0 1000000000000
RG23 23 0 1000000000000
RG24 24 0 1000000000000
RG25 25 0 1000000000000
RG26 26 0 1000000000000
VS0 25 s0 0
R0 s0 9 18e3
VS1 18 s1 0
C1 s1 10 10e-7
VS2 24 s2 0
C2 s2 20 39e-7
VS3 0 s3 0
V3 e3 s3 DC 0 AC 68e1 0
RI3 e3 6 33e-2
VS4 15 s4 0
L4 s4 17 15e-4
VS5 7 s5 0
R5 s5 0 82e2
VS6 6 s6 0
R6 s6 3 39e2
VS7 15 s7 0
R7 s7 6 27e3
VS8 9 s8 0
L8 s8 19 56e-3
VS9 24 s9 0
C9 s9 6 47e-5
VS10 12 s10 0
L10 s10 21 15e-5
VS11 4 s11 0
L11 s11 17 39e-3
VS12 15 s12 0
V12 e12 s12 DC 0 AC 27e-1 180
RI12 e12 19 10e-3
VS13 14 s13 0
V13 e13 s13 DC 0 AC 15e-1 0
RI13 e13 6 12e-2
VS14 3 s14 0
C14 s14 24 82e-6
VS15 13 s15 0
V15 e15 s15 DC 0 AC 12e-1 180
RI15 e15 15 18e-3
VS16 7 s16 0
R16 s16 25 47e2
VS17 0 s17 0
R17 s17 23 15e3
VS18 4 s18 0
R18 s18 8 47e-2
VS19 2 s19 0
V19 e19 s19 DC 0 AC 10e-1 180
RI19 e19 22 33e-2
VS20 7 s20 0
R20 s20 1 10e2
VS21 0 s21 0
C21 s21 26 56e-5
VS22 10 s22 0
R22 s22 7 56e3
VS23 11 s23 0
C23 s23 24 33e-5
VS24 25 s24 0
C24 s24 4 56e-5
VS25 18 s25 0
C25 s25 8 33e-4
VS26 26 s26 0
R26 s26 14 39e0
VS27 20 s27 0
V27 e27 s27 DC 0 AC 33e0 -120
RI27 e27 16 33e-1
VS28 23 s28 0
V28 e28 s28 DC 0 AC 15e-1 180
RI28 e28 6 68e-1
VS29 6 s29 0
V29 e29 s29 DC 0 AC 18e0 0
RI29 e29 8 82e-1
VS30 12 s30 0
R30 s30 23 47e-1
VS31 23 s31 0
V31 e31 s31 DC 0 AC 22e1 -120
RI31 e31 4 12e-2
VS32 25 s32 0
C32 s32 4 33e-7
VS33 2 s33 0
C33 s33 8 27e-4
VS34 18 s34 0
L34 s34 22 33e-4
VS35 11 s35 0
L35 s35 3 18e-3
VS36 0 s36 0
R36 s36 5 33e-1
VS37 6 s37 0
R37 s37 11 39e1
VS38 8 s38 0
C38 s38 26 22e-5
.control
set numdgt=17
ac lin 1 60 60
print v(1) v(2) v(3) v(4) v(5) v(6) v(7) v(8) v(9) v(10)
print v(11) v(12) v(13) v(14) v(15) v(16) v(17) v(18) v(19) v(20)
print v(21) v(22) v(23) v(24) v(25) v(26)
print i(vs0) i(vs1) i(vs2) i(vs3) i(vs4) i(vs5) i(vs6) i(vs7) i(vs8) i(vs9)
print i(vs10) i(vs11) i(vs12) i(vs13) i(vs14) i(vs15) i(vs16) i(vs17) i(vs18) i(vs19)
print i(vs20) i(vs21) i(vs22) i(vs23) i(vs24) i(vs25) i(vs26) i(vs27) i(vs28) i(vs29)
print i(vs30) i(vs31) i(vs32) i(vs33) i(vs34) i(vs35) i(vs36) i(vs37) i(vs38)
.endc
.end
