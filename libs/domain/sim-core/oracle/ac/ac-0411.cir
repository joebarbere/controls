controls oracle ac-0411
* Generated (plan F2.7, ADR 0012): do not edit; regenerate with `pnpm sim oracle regen`. ac seed 20261031 index 411 nodes 22 elements 36
.options sparse gmin=1e-12 noopac
RG1 1 0 1000000000000
RG2 2 0 1000000000000
RG3 3 0 1000000000000
RG4 4 0 1000000000000
RG5 5 0 1000000000000
RG6 6 0 1000000000000
RG7 7 0 1000000000000
RG8 8 0 1000000000000
RG9 9 0 1000000000000
RG10 10 0 1000000000000
RG11 11 0 1000000000000
RG12 12 0 1000000000000
RG13 13 0 1000000000000
RG14 14 0 1000000000000
RG15 15 0 1000000000000
RG16 16 0 1000000000000
RG17 17 0 1000000000000
RG18 18 0 1000000000000
RG19 19 0 1000000000000
RG20 20 0 1000000000000
RG21 21 0 1000000000000
VS0 9 s0 0
L0 s0 11 56e-3
VS1 4 s1 0
C1 s1 17 12e-5
VS2 0 s2 0
V2 e2 s2 DC 0 AC 39e1 -120
RI2 e2 m2 39e-2
LI2 m2 19 47e-7
VS3 13 s3 0
L3 s3 12 12e-2
VS4 13 s4 0
R4 s4 20 22e-2
VS5 16 s5 0
R5 s5 21 47e0
VS6 18 s6 0
C6 s6 7 22e-6
VS7 8 s7 0
R7 s7 5 15e-1
VS8 19 s8 0
R8 s8 6 82e-2
VS9 0 s9 0
L9 s9 13 56e-5
VS10 21 s10 0
L10 s10 5 10e-3
VS11 5 s11 0
L11 s11 14 39e-2
VS12 13 s12 0
C12 s12 6 22e-7
VS13 1 s13 0
L13 s13 7 10e-3
VS14 16 s14 0
L14 s14 8 15e-5
VS15 7 s15 0
R15 s15 10 68e0
VS16 18 s16 0
V16 e16 s16 DC 0 AC 15e0 120
RI16 e16 12 56e-3
VS17 20 s17 0
C17 s17 4 47e-5
VS18 16 s18 0
R18 s18 15 15e-1
VS19 9 s19 0
R19 s19 2 12e1
VS20 9 s20 0
L20 s20 20 27e-4
VS21 21 s21 0
C21 s21 1 82e-6
VS22 4 s22 0
C22 s22 11 22e-6
VS23 3 s23 0
C23 s23 4 12e-7
VS24 11 s24 0
L24 s24 3 22e-2
VS25 18 s25 0
V25 e25 s25 DC 0 AC 15e1 180
RI25 e25 11 68e-2
VS26 11 s26 0
L26 s26 5 82e-4
VS27 16 s27 0
L27 s27 11 27e-4
VS28 9 s28 0
C28 s28 5 33e-7
VS29 11 s29 0
V29 e29 s29 DC 0 AC 10e0 0
RI29 e29 m29 18e-1
LI29 m29 0 39e-5
VS30 17 s30 0
C30 s30 18 47e-7
VS31 3 s31 0
V31 e31 s31 DC 0 AC 18e1 120
RI31 e31 15 15e-1
VS32 16 s32 0
V32 e32 s32 DC 0 AC 39e1 120
RI32 e32 m32 68e-1
LI32 m32 2 33e-6
VS33 12 s33 0
R33 s33 14 56e2
VS34 9 s34 0
C34 s34 1 47e-4
VS35 10 s35 0
R35 s35 20 39e2
.control
set numdgt=17
ac lin 1 60 60
print v(1) v(2) v(3) v(4) v(5) v(6) v(7) v(8) v(9) v(10)
print v(11) v(12) v(13) v(14) v(15) v(16) v(17) v(18) v(19) v(20)
print v(21)
print i(vs0) i(vs1) i(vs2) i(vs3) i(vs4) i(vs5) i(vs6) i(vs7) i(vs8) i(vs9)
print i(vs10) i(vs11) i(vs12) i(vs13) i(vs14) i(vs15) i(vs16) i(vs17) i(vs18) i(vs19)
print i(vs20) i(vs21) i(vs22) i(vs23) i(vs24) i(vs25) i(vs26) i(vs27) i(vs28) i(vs29)
print i(vs30) i(vs31) i(vs32) i(vs33) i(vs34) i(vs35)
.endc
.end
