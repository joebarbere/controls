controls oracle ac-0411
* Generated (plan F2.7, ADR 0012): do not edit; regenerate with `pnpm sim oracle regen`. ac seed 20261031 index 411 nodes 22 elements 37
.options sparse gmin=1e-12 noopac
RG1 1 0 1000000000000
RG2 2 0 1000000000000
RG3 3 0 1000000000000
RG4 4 0 1000000000000
RG5 5 0 1000000000000
RG6 6 0 1000000000000
RG7 7 0 1000000000000
RG8 8 0 1000000000000
RG9 9 0 1000000000000
RG10 10 0 1000000000000
RG11 11 0 1000000000000
RG12 12 0 1000000000000
RG13 13 0 1000000000000
RG14 14 0 1000000000000
RG15 15 0 1000000000000
RG16 16 0 1000000000000
RG17 17 0 1000000000000
RG18 18 0 1000000000000
RG19 19 0 1000000000000
RG20 20 0 1000000000000
RG21 21 0 1000000000000
VS0 21 s0 0
C0 s0 14 27e-5
VS1 11 s1 0
L1 s1 20 27e-4
VS2 6 s2 0
R2 s2 20 39e2
VS3 0 s3 0
V3 e3 s3 DC 0 AC 27e0 -120
RI3 e3 m3 47e-2
LI3 m3 n3 33e-7
H3 n3 h3 VS15 82e-3
ED3 h3 9 d3 0 -39e-6
F3 0 d3 VS15 1
LD3 d3 0 1
VS4 19 s4 0
L4 s4 20 10e-5
VS5 5 s5 0
C5 s5 10 12e-5
VS6 16 s6 0
R6 s6 21 47e0
VS7 10 s7 0
R7 s7 4 22e2
VS8 18 s8 0
R8 s8 9 68e-1
VS9 16 s9 0
R9 s9 3 15e-1
VS10 9 s10 0
R10 s10 15 47e2
VS11 17 s11 0
R11 s11 19 82e-2
VS12 11 s12 0
L12 s12 0 56e-3
VS13 11 s13 0
C13 s13 1 47e-4
VS14 7 s14 0
R14 s14 1 56e-1
VS15 21 s15 0
V15 e15 s15 DC 0 AC 56e1 180
RI15 e15 m15 68e-1
LI15 m15 n15 12e-7
H15 n15 h15 VS3 82e-3
ED15 h15 17 d15 0 -39e-6
F15 0 d15 VS3 1
LD15 d15 0 1
VS16 13 s16 0
R16 s16 2 56e2
VS17 8 s17 0
C17 s17 6 47e-6
VS18 11 s18 0
C18 s18 5 33e-7
VS19 11 s19 0
R19 s19 2 12e1
VS20 0 s20 0
L20 s20 5 82e-4
VS21 13 s21 0
L21 s21 12 12e-2
VS22 14 s22 0
C22 s22 13 33e-6
VS23 21 s23 0
R23 s23 16 47e2
VS24 9 s24 0
R24 s24 12 15e3
VS25 4 s25 0
R25 s25 21 10e-2
VS26 0 s26 0
R26 s26 11 22e0
VS27 4 s27 0
C27 s27 0 22e-6
VS28 21 s28 0
C28 s28 1 82e-6
VS29 13 s29 0
V29 e29 s29 DC 0 AC 15e1 -120
RI29 e29 m29 22e-3
LI29 m29 18 47e-6
VS30 16 s30 0
L30 s30 8 15e-5
VS31 15 s31 0
C31 s31 8 12e-4
VS32 3 s32 0
R32 s32 9 82e2
VS33 0 s33 0
V33 e33 s33 DC 0 AC 10e0 0
RI33 e33 m33 18e-1
LI33 m33 9 68e-7
VS34 21 s34 0
L34 s34 5 10e-3
VS35 9 s35 0
L35 s35 13 56e-5
VS36 18 s36 0
C36 s36 7 22e-6
.control
set numdgt=17
ac lin 1 60 60
print v(1) v(2) v(3) v(4) v(5) v(6) v(7) v(8) v(9) v(10)
print v(11) v(12) v(13) v(14) v(15) v(16) v(17) v(18) v(19) v(20)
print v(21)
print i(vs0) i(vs1) i(vs2) i(vs3) i(vs4) i(vs5) i(vs6) i(vs7) i(vs8) i(vs9)
print i(vs10) i(vs11) i(vs12) i(vs13) i(vs14) i(vs15) i(vs16) i(vs17) i(vs18) i(vs19)
print i(vs20) i(vs21) i(vs22) i(vs23) i(vs24) i(vs25) i(vs26) i(vs27) i(vs28) i(vs29)
print i(vs30) i(vs31) i(vs32) i(vs33) i(vs34) i(vs35) i(vs36)
.endc
.end
