controls oracle ac-0411
* Generated (plan F2.7, ADR 0012): do not edit; regenerate with `pnpm sim oracle regen`. ac seed 20261031 index 411 nodes 22 elements 32
.options sparse gmin=1e-12 noopac
RG1 1 0 1000000000000
RG2 2 0 1000000000000
RG3 3 0 1000000000000
RG4 4 0 1000000000000
RG5 5 0 1000000000000
RG6 6 0 1000000000000
RG7 7 0 1000000000000
RG8 8 0 1000000000000
RG9 9 0 1000000000000
RG10 10 0 1000000000000
RG11 11 0 1000000000000
RG12 12 0 1000000000000
RG13 13 0 1000000000000
RG14 14 0 1000000000000
RG15 15 0 1000000000000
RG16 16 0 1000000000000
RG17 17 0 1000000000000
RG18 18 0 1000000000000
RG19 19 0 1000000000000
RG20 20 0 1000000000000
RG21 21 0 1000000000000
VS0 18 s0 0
R0 s0 9 68e-1
VS1 4 s1 0
C1 s1 11 22e-6
VS2 13 s2 0
L2 s2 11 56e-3
VS3 21 s3 0
R3 s3 16 47e2
VS4 11 s4 0
L4 s4 5 82e-4
VS5 8 s5 0
C5 s5 6 47e-6
VS6 21 s6 0
L6 s6 5 10e-3
VS7 10 s7 0
R7 s7 4 22e2
VS8 21 s8 0
C8 s8 1 82e-6
VS9 3 s9 0
R9 s9 9 82e2
VS10 13 s10 0
C10 s10 5 33e-7
VS11 21 s11 0
C11 s11 14 27e-5
VS12 16 s12 0
R12 s12 21 47e0
VS13 18 s13 0
C13 s13 7 22e-6
VS14 19 s14 0
L14 s14 20 10e-5
VS15 7 s15 0
R15 s15 1 56e-1
VS16 0 s16 0
L16 s16 12 12e-2
VS17 14 s17 0
C17 s17 0 33e-6
VS18 9 s18 0
L18 s18 0 56e-5
VS19 0 s19 0
V19 e19 s19 DC 0 AC 15e1 -120
RI19 e19 18 22e-3
VS20 11 s20 0
R20 s20 13 22e0
VS21 4 s21 0
R21 s21 21 10e-2
VS22 13 s22 0
C22 s22 1 47e-4
VS23 9 s23 0
R23 s23 12 15e3
VS24 13 s24 0
R24 s24 2 12e1
VS25 11 s25 0
V25 e25 s25 DC 0 AC 10e0 0
RI25 e25 9 18e-1
VS26 13 s26 0
L26 s26 20 27e-4
VS27 9 s27 0
R27 s27 15 47e2
VS28 16 s28 0
L28 s28 8 15e-5
VS29 15 s29 0
C29 s29 8 12e-4
VS30 11 s30 0
V30 e30 s30 DC 0 AC 27e0 -120
RI30 e30 9 47e-2
VS31 21 s31 0
V31 e31 s31 DC 0 AC 56e1 180
RI31 e31 17 68e-1
.control
set numdgt=17
ac lin 1 60 60
print v(1) v(2) v(3) v(4) v(5) v(6) v(7) v(8) v(9) v(10)
print v(11) v(12) v(13) v(14) v(15) v(16) v(17) v(18) v(19) v(20)
print v(21)
print i(vs0) i(vs1) i(vs2) i(vs3) i(vs4) i(vs5) i(vs6) i(vs7) i(vs8) i(vs9)
print i(vs10) i(vs11) i(vs12) i(vs13) i(vs14) i(vs15) i(vs16) i(vs17) i(vs18) i(vs19)
print i(vs20) i(vs21) i(vs22) i(vs23) i(vs24) i(vs25) i(vs26) i(vs27) i(vs28) i(vs29)
print i(vs30) i(vs31)
.endc
.end
