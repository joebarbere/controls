controls oracle ac-0317
* Generated (plan F2.7, ADR 0012): do not edit; regenerate with `pnpm sim oracle regen`. ac seed 20261031 index 317 nodes 16 elements 31
.options sparse gmin=1e-12 noopac
RG1 1 0 1000000000000
RG2 2 0 1000000000000
RG3 3 0 1000000000000
RG4 4 0 1000000000000
RG5 5 0 1000000000000
RG6 6 0 1000000000000
RG7 7 0 1000000000000
RG8 8 0 1000000000000
RG9 9 0 1000000000000
RG10 10 0 1000000000000
RG11 11 0 1000000000000
RG12 12 0 1000000000000
RG13 13 0 1000000000000
RG14 14 0 1000000000000
RG15 15 0 1000000000000
VS0 6 s0 0
C0 s0 12 22e-6
VS1 5 s1 0
C1 s1 3 47e-6
VS2 14 s2 0
C2 s2 6 33e-6
VS3 2 s3 0
R3 s3 12 12e1
VS4 7 s4 0
R4 s4 5 68e0
VS5 11 s5 0
R5 s5 6 22e3
VS6 15 s6 0
R6 s6 14 18e-1
VS7 4 s7 0
R7 s7 0 33e3
VS8 13 s8 0
C8 s8 4 22e-6
VS9 6 s9 0
R9 s9 5 39e0
VS10 3 s10 0
C10 s10 10 68e-6
VS11 2 s11 0
R11 s11 9 12e2
VS12 9 s12 0
L12 s12 4 39e-5
VS13 3 s13 0
R13 s13 7 18e3
VS14 6 s14 0
C14 s14 15 10e-6
VS15 1 s15 0
R15 s15 2 33e0
VS16 0 s16 0
V16 e16 s16 DC 0 AC 12e0 -120
RI16 e16 m16 15e-3
LI16 m16 n16 47e-6
H16 n16 h16 VS23 33e-4
ED16 h16 2 d16 0 47e-7
F16 0 d16 VS23 1
LD16 d16 0 1
VS17 12 s17 0
R17 s17 2 82e0
VS18 10 s18 0
R18 s18 4 82e3
VS19 11 s19 0
L19 s19 0 68e-5
VS20 2 s20 0
R20 s20 7 82e0
VS21 1 s21 0
C21 s21 9 82e-6
VS22 3 s22 0
C22 s22 8 18e-7
VS23 7 s23 0
V23 e23 s23 DC 0 AC 82e1 120
RI23 e23 m23 47e-3
LI23 m23 n23 12e-5
H23 n23 h23 VS16 33e-4
ED23 h23 12 d23 0 47e-7
F23 0 d23 VS16 1
LD23 d23 0 1
VS24 15 s24 0
L24 s24 3 18e-3
VS25 6 s25 0
R25 s25 3 82e0
VS26 1 s26 0
R26 s26 7 22e-2
VS27 12 s27 0
L27 s27 13 39e-5
VS28 2 s28 0
R28 s28 11 82e-2
VS29 14 s29 0
V29 e29 s29 DC 0 AC 18e1 -120
RI29 e29 1 18e-1
VS30 11 s30 0
R30 s30 8 33e-2
.control
set numdgt=17
ac lin 1 60 60
print v(1) v(2) v(3) v(4) v(5) v(6) v(7) v(8) v(9) v(10)
print v(11) v(12) v(13) v(14) v(15)
print i(vs0) i(vs1) i(vs2) i(vs3) i(vs4) i(vs5) i(vs6) i(vs7) i(vs8) i(vs9)
print i(vs10) i(vs11) i(vs12) i(vs13) i(vs14) i(vs15) i(vs16) i(vs17) i(vs18) i(vs19)
print i(vs20) i(vs21) i(vs22) i(vs23) i(vs24) i(vs25) i(vs26) i(vs27) i(vs28) i(vs29)
print i(vs30)
.endc
.end
