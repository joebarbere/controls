controls oracle ac-0317
* Generated (plan F2.7, ADR 0012): do not edit; regenerate with `pnpm sim oracle regen`. ac seed 20261031 index 317 nodes 16 elements 31
.options sparse gmin=1e-12 noopac
RG1 1 0 1000000000000
RG2 2 0 1000000000000
RG3 3 0 1000000000000
RG4 4 0 1000000000000
RG5 5 0 1000000000000
RG6 6 0 1000000000000
RG7 7 0 1000000000000
RG8 8 0 1000000000000
RG9 9 0 1000000000000
RG10 10 0 1000000000000
RG11 11 0 1000000000000
RG12 12 0 1000000000000
RG13 13 0 1000000000000
RG14 14 0 1000000000000
RG15 15 0 1000000000000
VS0 3 s0 0
L0 s0 9 22e-4
VS1 0 s1 0
V1 e1 s1 DC 0 AC 15e0 -120
RI1 e1 14 82e-1
VS2 3 s2 0
L2 s2 7 82e-3
VS3 5 s3 0
C3 s3 15 10e-6
VS4 4 s4 0
R4 s4 10 56e1
VS5 8 s5 0
R5 s5 3 18e0
VS6 8 s6 0
V6 e6 s6 DC 0 AC 39e1 0
RI6 e6 10 18e-3
VS7 0 s7 0
R7 s7 2 82e0
VS8 11 s8 0
C8 s8 15 10e-5
VS9 3 s9 0
R9 s9 0 56e-1
VS10 7 s10 0
R10 s10 1 47e0
VS11 6 s11 0
C11 s11 15 10e-6
VS12 12 s12 0
L12 s12 6 22e-4
VS13 9 s13 0
C13 s13 5 27e-6
VS14 11 s14 0
C14 s14 13 15e-4
VS15 0 s15 0
R15 s15 15 33e1
VS16 6 s16 0
C16 s16 7 22e-5
VS17 15 s17 0
V17 e17 s17 DC 0 AC 10e1 -120
RI17 e17 3 12e-2
VS18 12 s18 0
R18 s18 10 18e-2
VS19 7 s19 0
R19 s19 13 12e0
VS20 8 s20 0
V20 e20 s20 DC 0 AC 18e-1 120
RI20 e20 m20 47e-1
LI20 m20 3 82e-6
VS21 2 s21 0
R21 s21 11 82e-2
VS22 10 s22 0
L22 s22 6 27e-2
VS23 2 s23 0
R23 s23 12 12e2
VS24 11 s24 0
R24 s24 6 22e3
VS25 6 s25 0
V25 e25 s25 DC 0 AC 47e0 -120
RI25 e25 m25 68e-2
LI25 m25 1 15e-6
VS26 10 s26 0
C26 s26 5 47e-5
VS27 14 s27 0
V27 e27 s27 DC 0 AC 82e0 180
RI27 e27 4 82e-2
VS28 9 s28 0
V28 e28 s28 DC 0 AC 12e0 -120
RI28 e28 m28 15e-3
LI28 m28 2 68e-6
VS29 12 s29 0
L29 s29 4 39e-5
VS30 1 s30 0
L30 s30 5 82e-2
.control
set numdgt=17
ac lin 1 60 60
print v(1) v(2) v(3) v(4) v(5) v(6) v(7) v(8) v(9) v(10)
print v(11) v(12) v(13) v(14) v(15)
print i(vs0) i(vs1) i(vs2) i(vs3) i(vs4) i(vs5) i(vs6) i(vs7) i(vs8) i(vs9)
print i(vs10) i(vs11) i(vs12) i(vs13) i(vs14) i(vs15) i(vs16) i(vs17) i(vs18) i(vs19)
print i(vs20) i(vs21) i(vs22) i(vs23) i(vs24) i(vs25) i(vs26) i(vs27) i(vs28) i(vs29)
print i(vs30)
.endc
.end
