controls oracle ac-0317
* Generated (plan F2.7, ADR 0012): do not edit; regenerate with `pnpm sim oracle regen`. ac seed 20261031 index 317 nodes 16 elements 29
.options sparse gmin=1e-12 noopac
RG1 1 0 1000000000000
RG2 2 0 1000000000000
RG3 3 0 1000000000000
RG4 4 0 1000000000000
RG5 5 0 1000000000000
RG6 6 0 1000000000000
RG7 7 0 1000000000000
RG8 8 0 1000000000000
RG9 9 0 1000000000000
RG10 10 0 1000000000000
RG11 11 0 1000000000000
RG12 12 0 1000000000000
RG13 13 0 1000000000000
RG14 14 0 1000000000000
RG15 15 0 1000000000000
VS0 1 s0 0
R0 s0 2 33e0
VS1 3 s1 0
R1 s1 0 18e3
VS2 6 s2 0
C2 s2 12 22e-6
VS3 2 s3 0
R3 s3 12 12e1
VS4 5 s4 0
C4 s4 3 47e-6
VS5 6 s5 0
R5 s5 5 39e0
VS6 11 s6 0
L6 s6 9 68e-5
VS7 6 s7 0
C7 s7 15 10e-6
VS8 0 s8 0
V8 e8 s8 DC 0 AC 82e1 120
RI8 e8 12 47e-3
VS9 12 s9 0
R9 s9 2 82e0
VS10 4 s10 0
R10 s10 9 33e3
VS11 1 s11 0
C11 s11 7 82e-6
VS12 6 s12 0
R12 s12 3 82e0
VS13 13 s13 0
C13 s13 4 22e-6
VS14 14 s14 0
C14 s14 6 33e-6
VS15 2 s15 0
R15 s15 0 82e0
VS16 15 s16 0
L16 s16 3 18e-3
VS17 9 s17 0
V17 e17 s17 DC 0 AC 12e0 -120
RI17 e17 2 15e-3
VS18 2 s18 0
R18 s18 7 12e2
VS19 11 s19 0
R19 s19 6 22e3
VS20 1 s20 0
R20 s20 0 22e-2
VS21 11 s21 0
R21 s21 8 33e-2
VS22 12 s22 0
L22 s22 13 39e-5
VS23 10 s23 0
R23 s23 4 82e3
VS24 7 s24 0
L24 s24 4 39e-5
VS25 15 s25 0
R25 s25 14 18e-1
VS26 0 s26 0
R26 s26 5 68e0
VS27 14 s27 0
V27 e27 s27 DC 0 AC 18e1 -120
RI27 e27 1 18e-1
VS28 2 s28 0
R28 s28 11 82e-2
.control
set numdgt=17
ac lin 1 60 60
print v(1) v(2) v(3) v(4) v(5) v(6) v(7) v(8) v(9) v(10)
print v(11) v(12) v(13) v(14) v(15)
print i(vs0) i(vs1) i(vs2) i(vs3) i(vs4) i(vs5) i(vs6) i(vs7) i(vs8) i(vs9)
print i(vs10) i(vs11) i(vs12) i(vs13) i(vs14) i(vs15) i(vs16) i(vs17) i(vs18) i(vs19)
print i(vs20) i(vs21) i(vs22) i(vs23) i(vs24) i(vs25) i(vs26) i(vs27) i(vs28)
.endc
.end
