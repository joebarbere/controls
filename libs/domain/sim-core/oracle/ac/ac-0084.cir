controls oracle ac-0084
* Generated (plan F2.7, ADR 0012): do not edit; regenerate with `pnpm sim oracle regen`. ac seed 20261031 index 84 nodes 22 elements 23
.options sparse gmin=1e-12 noopac
RG1 1 0 1000000000000
RG2 2 0 1000000000000
RG3 3 0 1000000000000
RG4 4 0 1000000000000
RG5 5 0 1000000000000
RG6 6 0 1000000000000
RG7 7 0 1000000000000
RG8 8 0 1000000000000
RG9 9 0 1000000000000
RG10 10 0 1000000000000
RG11 11 0 1000000000000
RG12 12 0 1000000000000
RG13 13 0 1000000000000
RG14 14 0 1000000000000
RG15 15 0 1000000000000
RG16 16 0 1000000000000
RG17 17 0 1000000000000
RG18 18 0 1000000000000
RG19 19 0 1000000000000
RG20 20 0 1000000000000
RG21 21 0 1000000000000
VS0 14 s0 0
R0 s0 0 82e3
VS1 17 s1 0
R1 s1 7 18e3
VS2 5 s2 0
L2 s2 15 47e-3
VS3 10 s3 0
R3 s3 20 27e1
VS4 13 s4 0
L4 s4 5 12e-4
VS5 1 s5 0
C5 s5 13 15e-4
VS6 3 s6 0
C6 s6 17 33e-4
VS7 18 s7 0
C7 s7 9 56e-6
VS8 6 s8 0
R8 s8 5 56e-2
VS9 13 s9 0
R9 s9 1 47e-1
VS10 4 s10 0
R10 s10 7 15e-2
VS11 20 s11 0
R11 s11 5 12e-1
VS12 1 s12 0
C12 s12 11 27e-4
VS13 0 s13 0
V13 e13 s13 DC 0 AC 82e1 -120
RI13 e13 3 18e-2
VS14 17 s14 0
V14 e14 s14 DC 0 AC 22e1 180
RI14 e14 2 18e-1
VS15 19 s15 0
V15 e15 s15 DC 0 AC 33e0 120
RI15 e15 15 27e-3
VS16 17 s16 0
C16 s16 18 47e-7
VS17 1 s17 0
R17 s17 12 33e-1
VS18 17 s18 0
L18 s18 16 47e-3
VS19 1 s19 0
R19 s19 18 47e-1
VS20 8 s20 0
L20 s20 17 15e-3
VS21 5 s21 0
V21 e21 s21 DC 0 AC 56e1 120
RI21 e21 13 39e-3
VS22 21 s22 0
R22 s22 13 47e0
.control
set numdgt=17
ac lin 1 60 60
print v(1) v(2) v(3) v(4) v(5) v(6) v(7) v(8) v(9) v(10)
print v(11) v(12) v(13) v(14) v(15) v(16) v(17) v(18) v(19) v(20)
print v(21)
print i(vs0) i(vs1) i(vs2) i(vs3) i(vs4) i(vs5) i(vs6) i(vs7) i(vs8) i(vs9)
print i(vs10) i(vs11) i(vs12) i(vs13) i(vs14) i(vs15) i(vs16) i(vs17) i(vs18) i(vs19)
print i(vs20) i(vs21) i(vs22)
.endc
.end
