controls oracle ac-0084
* Generated (plan F2.7, ADR 0012): do not edit; regenerate with `pnpm sim oracle regen`. ac seed 20261031 index 84 nodes 22 elements 32
.options sparse gmin=1e-12 noopac
RG1 1 0 1000000000000
RG2 2 0 1000000000000
RG3 3 0 1000000000000
RG4 4 0 1000000000000
RG5 5 0 1000000000000
RG6 6 0 1000000000000
RG7 7 0 1000000000000
RG8 8 0 1000000000000
RG9 9 0 1000000000000
RG10 10 0 1000000000000
RG11 11 0 1000000000000
RG12 12 0 1000000000000
RG13 13 0 1000000000000
RG14 14 0 1000000000000
RG15 15 0 1000000000000
RG16 16 0 1000000000000
RG17 17 0 1000000000000
RG18 18 0 1000000000000
RG19 19 0 1000000000000
RG20 20 0 1000000000000
RG21 21 0 1000000000000
VS0 1 s0 0
C0 s0 13 15e-4
VS1 15 s1 0
C1 s1 4 33e-5
VS2 21 s2 0
L2 s2 19 10e-4
VS3 18 s3 0
C3 s3 9 56e-6
VS4 1 s4 0
R4 s4 12 33e-1
VS5 0 s5 0
V5 e5 s5 DC 0 AC 82e1 -120
RI5 e5 n5 18e-2
H5 n5 h5 VS14 39e-4
ED5 h5 3 d5 0 -47e-6
F5 0 d5 VS14 1
LD5 d5 0 1
VS6 10 s6 0
C6 s6 12 68e-4
VS7 8 s7 0
L7 s7 17 15e-3
VS8 17 s8 0
R8 s8 10 47e1
VS9 3 s9 0
C9 s9 17 33e-4
VS10 1 s10 0
R10 s10 18 47e-1
VS11 1 s11 0
C11 s11 16 47e-4
VS12 14 s12 0
R12 s12 5 18e2
VS13 20 s13 0
R13 s13 5 12e-1
VS14 19 s14 0
V14 e14 s14 DC 0 AC 33e0 120
RI14 e14 m14 27e-3
LI14 m14 n14 27e-5
H14 n14 h14 VS5 39e-4
ED14 h14 15 d14 0 -47e-6
F14 0 d14 VS5 1
LD14 d14 0 1
VS15 13 s15 0
R15 s15 1 47e-1
VS16 17 s16 0
R16 s16 7 18e3
VS17 14 s17 0
R17 s17 0 82e3
VS18 17 s18 0
C18 s18 18 47e-7
VS19 17 s19 0
V19 e19 s19 DC 0 AC 22e1 180
RI19 e19 2 18e-1
VS20 10 s20 0
R20 s20 20 27e1
VS21 11 s21 0
V21 e21 s21 DC 0 AC 47e-1 120
RI21 e21 9 47e-2
VS22 5 s22 0
V22 e22 s22 DC 0 AC 56e1 120
RI22 e22 m22 39e-3
LI22 m22 13 56e-6
VS23 4 s23 0
R23 s23 7 15e-2
VS24 21 s24 0
R24 s24 13 47e0
VS25 1 s25 0
C25 s25 11 27e-4
VS26 5 s26 0
L26 s26 15 47e-3
VS27 1 s27 0
R27 s27 2 39e2
VS28 17 s28 0
L28 s28 16 47e-3
VS29 6 s29 0
R29 s29 7 15e0
VS30 20 s30 0
C30 s30 8 82e-6
VS31 6 s31 0
R31 s31 5 56e-2
.control
set numdgt=17
ac lin 1 60 60
print v(1) v(2) v(3) v(4) v(5) v(6) v(7) v(8) v(9) v(10)
print v(11) v(12) v(13) v(14) v(15) v(16) v(17) v(18) v(19) v(20)
print v(21)
print i(vs0) i(vs1) i(vs2) i(vs3) i(vs4) i(vs5) i(vs6) i(vs7) i(vs8) i(vs9)
print i(vs10) i(vs11) i(vs12) i(vs13) i(vs14) i(vs15) i(vs16) i(vs17) i(vs18) i(vs19)
print i(vs20) i(vs21) i(vs22) i(vs23) i(vs24) i(vs25) i(vs26) i(vs27) i(vs28) i(vs29)
print i(vs30) i(vs31)
.endc
.end
