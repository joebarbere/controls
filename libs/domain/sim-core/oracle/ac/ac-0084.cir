controls oracle ac-0084
* Generated (plan F2.7, ADR 0012): do not edit; regenerate with `pnpm sim oracle regen`. ac seed 20261031 index 84 nodes 22 elements 30
.options sparse gmin=1e-12 noopac
RG1 1 0 1000000000000
RG2 2 0 1000000000000
RG3 3 0 1000000000000
RG4 4 0 1000000000000
RG5 5 0 1000000000000
RG6 6 0 1000000000000
RG7 7 0 1000000000000
RG8 8 0 1000000000000
RG9 9 0 1000000000000
RG10 10 0 1000000000000
RG11 11 0 1000000000000
RG12 12 0 1000000000000
RG13 13 0 1000000000000
RG14 14 0 1000000000000
RG15 15 0 1000000000000
RG16 16 0 1000000000000
RG17 17 0 1000000000000
RG18 18 0 1000000000000
RG19 19 0 1000000000000
RG20 20 0 1000000000000
RG21 21 0 1000000000000
VS0 1 s0 0
C0 s0 3 39e-5
VS1 5 s1 0
R1 s1 1 47e-1
VS2 0 s2 0
V2 e2 s2 DC 0 AC 56e1 120
RI2 e2 5 39e-3
VS3 1 s3 0
C3 s3 5 15e-4
VS4 11 s4 0
V4 e4 s4 DC 0 AC 39e1 180
RI4 e4 2 39e-2
VS5 16 s5 0
C5 s5 8 47e-4
VS6 10 s6 0
C6 s6 3 18e-6
VS7 6 s7 0
L7 s7 1 10e-5
VS8 4 s8 0
L8 s8 7 18e-3
VS9 16 s9 0
R9 s9 14 39e3
VS10 21 s10 0
R10 s10 1 15e0
VS11 16 s11 0
C11 s11 6 68e-7
VS12 3 s12 0
C12 s12 2 27e-6
VS13 1 s13 0
R13 s13 18 47e-1
VS14 21 s14 0
L14 s14 4 10e-4
VS15 13 s15 0
L15 s15 9 10e-4
VS16 18 s16 0
R16 s16 12 12e0
VS17 20 s17 0
C17 s17 14 82e-6
VS18 20 s18 0
R18 s18 0 18e2
VS19 18 s19 0
R19 s19 9 47e1
VS20 13 s20 0
R20 s20 11 39e1
VS21 7 s21 0
C21 s21 3 27e-6
VS22 13 s22 0
C22 s22 19 33e-5
VS23 19 s23 0
L23 s23 17 82e-3
VS24 7 s24 0
R24 s24 10 39e2
VS25 21 s25 0
L25 s25 0 12e-5
VS26 15 s26 0
C26 s26 17 27e-7
VS27 8 s27 0
V27 e27 s27 DC 0 AC 56e1 -120
RI27 e27 3 18e-1
VS28 12 s28 0
L28 s28 17 47e-4
VS29 15 s29 0
L29 s29 20 12e-4
.control
set numdgt=17
ac lin 1 60 60
print v(1) v(2) v(3) v(4) v(5) v(6) v(7) v(8) v(9) v(10)
print v(11) v(12) v(13) v(14) v(15) v(16) v(17) v(18) v(19) v(20)
print v(21)
print i(vs0) i(vs1) i(vs2) i(vs3) i(vs4) i(vs5) i(vs6) i(vs7) i(vs8) i(vs9)
print i(vs10) i(vs11) i(vs12) i(vs13) i(vs14) i(vs15) i(vs16) i(vs17) i(vs18) i(vs19)
print i(vs20) i(vs21) i(vs22) i(vs23) i(vs24) i(vs25) i(vs26) i(vs27) i(vs28) i(vs29)
.endc
.end
