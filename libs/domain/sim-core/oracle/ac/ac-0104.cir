controls oracle ac-0104
* Generated (plan F2.7, ADR 0012): do not edit; regenerate with `pnpm sim oracle regen`. ac seed 20261031 index 104 nodes 13 elements 14
.options sparse gmin=1e-12 noopac
RG1 1 0 1000000000000
RG2 2 0 1000000000000
RG3 3 0 1000000000000
RG4 4 0 1000000000000
RG5 5 0 1000000000000
RG6 6 0 1000000000000
RG7 7 0 1000000000000
RG8 8 0 1000000000000
RG9 9 0 1000000000000
RG10 10 0 1000000000000
RG11 11 0 1000000000000
RG12 12 0 1000000000000
VS0 8 s0 0
L0 s0 4 18e-5
VS1 0 s1 0
V1 e1 s1 DC 0 AC 12e-1 0
RI1 e1 7 33e-2
VS2 10 s2 0
L2 s2 3 82e-5
VS3 12 s3 0
C3 s3 5 27e-7
VS4 6 s4 0
R4 s4 0 15e2
VS5 11 s5 0
V5 e5 s5 DC 0 AC 12e1 -120
RI5 e5 0 39e-2
VS6 3 s6 0
V6 e6 s6 DC 0 AC 12e-1 0
RI6 e6 8 18e-2
VS7 6 s7 0
V7 e7 s7 DC 0 AC 15e1 180
RI7 e7 9 12e-3
VS8 6 s8 0
V8 e8 s8 DC 0 AC 12e-1 120
RI8 e8 3 22e-3
VS9 5 s9 0
L9 s9 2 56e-4
VS10 6 s10 0
R10 s10 7 56e3
VS11 1 s11 0
R11 s11 2 15e-2
VS12 8 s12 0
R12 s12 1 15e-2
VS13 3 s13 0
C13 s13 12 27e-5
.control
set numdgt=17
ac lin 1 60 60
print v(1) v(2) v(3) v(4) v(5) v(6) v(7) v(8) v(9) v(10)
print v(11) v(12)
print i(vs0) i(vs1) i(vs2) i(vs3) i(vs4) i(vs5) i(vs6) i(vs7) i(vs8) i(vs9)
print i(vs10) i(vs11) i(vs12) i(vs13)
.endc
.end
