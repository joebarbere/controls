controls oracle ac-0104
* Generated (plan F2.7, ADR 0012): do not edit; regenerate with `pnpm sim oracle regen`. ac seed 20261031 index 104 nodes 13 elements 18
.options sparse gmin=1e-12 noopac
RG1 1 0 1000000000000
RG2 2 0 1000000000000
RG3 3 0 1000000000000
RG4 4 0 1000000000000
RG5 5 0 1000000000000
RG6 6 0 1000000000000
RG7 7 0 1000000000000
RG8 8 0 1000000000000
RG9 9 0 1000000000000
RG10 10 0 1000000000000
RG11 11 0 1000000000000
RG12 12 0 1000000000000
VS0 8 s0 0
R0 s0 3 15e-2
VS1 12 s1 0
C1 s1 5 27e-7
VS2 9 s2 0
R2 s2 11 47e0
VS3 0 s3 0
V3 e3 s3 DC 0 AC 12e-1 0
RI3 e3 8 18e-2
VS4 6 s4 0
R4 s4 7 56e3
VS5 6 s5 0
V5 e5 s5 DC 0 AC 15e1 180
RI5 e5 9 12e-3
VS6 11 s6 0
V6 e6 s6 DC 0 AC 12e1 -120
RI6 e6 1 39e-2
VS7 10 s7 0
L7 s7 0 82e-5
VS8 6 s8 0
R8 s8 1 15e2
VS9 2 s9 0
L9 s9 4 33e-2
VS10 1 s10 0
V10 e10 s10 DC 0 AC 12e-1 0
RI10 e10 7 33e-2
VS11 7 s11 0
R11 s11 2 27e1
VS12 5 s12 0
L12 s12 2 56e-4
VS13 10 s13 0
V13 e13 s13 DC 0 AC 12e-1 -120
RI13 e13 5 68e-2
VS14 6 s14 0
V14 e14 s14 DC 0 AC 12e-1 120
RI14 e14 0 22e-3
VS15 3 s15 0
R15 s15 2 15e-2
VS16 0 s16 0
C16 s16 12 27e-5
VS17 8 s17 0
L17 s17 4 18e-5
.control
set numdgt=17
ac lin 1 60 60
print v(1) v(2) v(3) v(4) v(5) v(6) v(7) v(8) v(9) v(10)
print v(11) v(12)
print i(vs0) i(vs1) i(vs2) i(vs3) i(vs4) i(vs5) i(vs6) i(vs7) i(vs8) i(vs9)
print i(vs10) i(vs11) i(vs12) i(vs13) i(vs14) i(vs15) i(vs16) i(vs17)
.endc
.end
