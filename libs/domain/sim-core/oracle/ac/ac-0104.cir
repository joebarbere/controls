controls oracle ac-0104
* Generated (plan F2.7, ADR 0012): do not edit; regenerate with `pnpm sim oracle regen`. ac seed 20261031 index 104 nodes 13 elements 24
.options sparse gmin=1e-12 noopac
RG1 1 0 1000000000000
RG2 2 0 1000000000000
RG3 3 0 1000000000000
RG4 4 0 1000000000000
RG5 5 0 1000000000000
RG6 6 0 1000000000000
RG7 7 0 1000000000000
RG8 8 0 1000000000000
RG9 9 0 1000000000000
RG10 10 0 1000000000000
RG11 11 0 1000000000000
RG12 12 0 1000000000000
VS0 7 s0 0
C0 s0 10 56e-4
VS1 8 s1 0
R1 s1 12 18e2
VS2 11 s2 0
R2 s2 2 18e0
VS3 5 s3 0
C3 s3 11 27e-6
VS4 0 s4 0
V4 e4 s4 DC 0 AC 18e0 120
RI4 e4 8 10e-1
VS5 3 s5 0
C5 s5 12 47e-4
VS6 4 s6 0
C6 s6 11 15e-4
VS7 12 s7 0
C7 s7 5 15e-7
VS8 8 s8 0
R8 s8 0 33e-2
VS9 1 s9 0
C9 s9 8 22e-5
VS10 1 s10 0
R10 s10 10 33e-2
VS11 7 s11 0
L11 s11 2 39e-3
VS12 4 s12 0
V12 e12 s12 DC 0 AC 27e0 -120
RI12 e12 6 82e-3
VS13 8 s13 0
V13 e13 s13 DC 0 AC 27e1 120
RI13 e13 m13 18e-1
LI13 m13 0 39e-5
VS14 9 s14 0
L14 s14 10 10e-3
VS15 3 s15 0
V15 e15 s15 DC 0 AC 12e-1 0
RI15 e15 8 18e-2
VS16 7 s16 0
L16 s16 10 68e-2
VS17 10 s17 0
L17 s17 2 15e-5
VS18 6 s18 0
V18 e18 s18 DC 0 AC 56e-1 0
RI18 e18 3 56e-2
VS19 1 s19 0
R19 s19 9 18e-2
VS20 7 s20 0
V20 e20 s20 DC 0 AC 10e-1 -120
RI20 e20 9 15e-2
VS21 3 s21 0
R21 s21 0 18e-1
VS22 8 s22 0
R22 s22 2 15e-2
VS23 6 s23 0
C23 s23 10 39e-5
.control
set numdgt=17
ac lin 1 60 60
print v(1) v(2) v(3) v(4) v(5) v(6) v(7) v(8) v(9) v(10)
print v(11) v(12)
print i(vs0) i(vs1) i(vs2) i(vs3) i(vs4) i(vs5) i(vs6) i(vs7) i(vs8) i(vs9)
print i(vs10) i(vs11) i(vs12) i(vs13) i(vs14) i(vs15) i(vs16) i(vs17) i(vs18) i(vs19)
print i(vs20) i(vs21) i(vs22) i(vs23)
.endc
.end
