controls oracle ac-0238
* Generated (plan F2.7, ADR 0012): do not edit; regenerate with `pnpm sim oracle regen`. ac seed 20261031 index 238 nodes 14 elements 22
.options sparse gmin=1e-12 noopac
RG1 1 0 1000000000000
RG2 2 0 1000000000000
RG3 3 0 1000000000000
RG4 4 0 1000000000000
RG5 5 0 1000000000000
RG6 6 0 1000000000000
RG7 7 0 1000000000000
RG8 8 0 1000000000000
RG9 9 0 1000000000000
RG10 10 0 1000000000000
RG11 11 0 1000000000000
RG12 12 0 1000000000000
RG13 13 0 1000000000000
VS0 13 s0 0
R0 s0 8 33e0
VS1 2 s1 0
R1 s1 8 22e1
VS2 1 s2 0
R2 s2 3 18e0
VS3 4 s3 0
C3 s3 3 82e-4
VS4 1 s4 0
C4 s4 0 27e-4
VS5 0 s5 0
V5 e5 s5 DC 0 AC 39e0 180
RI5 e5 m5 22e-1
LI5 m5 9 56e-6
VS6 7 s6 0
V6 e6 s6 DC 0 AC 22e-1 0
RI6 e6 m6 68e-2
LI6 m6 1 33e-6
VS7 11 s7 0
C7 s7 5 27e-6
VS8 13 s8 0
R8 s8 12 22e-2
VS9 0 s9 0
R9 s9 10 47e0
VS10 6 s10 0
V10 e10 s10 DC 0 AC 39e1 -120
RI10 e10 m10 18e-2
LI10 m10 5 15e-5
VS11 11 s11 0
L11 s11 1 15e-5
VS12 8 s12 0
R12 s12 6 33e3
VS13 9 s13 0
L13 s13 0 33e-3
VS14 8 s14 0
R14 s14 3 12e3
VS15 6 s15 0
R15 s15 9 68e0
VS16 7 s16 0
R16 s16 5 18e1
VS17 5 s17 0
C17 s17 10 82e-7
VS18 12 s18 0
R18 s18 10 10e-1
VS19 2 s19 0
C19 s19 12 33e-6
VS20 7 s20 0
L20 s20 4 27e-2
VS21 3 s21 0
C21 s21 4 82e-6
.control
set numdgt=17
ac lin 1 60 60
print v(1) v(2) v(3) v(4) v(5) v(6) v(7) v(8) v(9) v(10)
print v(11) v(12) v(13)
print i(vs0) i(vs1) i(vs2) i(vs3) i(vs4) i(vs5) i(vs6) i(vs7) i(vs8) i(vs9)
print i(vs10) i(vs11) i(vs12) i(vs13) i(vs14) i(vs15) i(vs16) i(vs17) i(vs18) i(vs19)
print i(vs20) i(vs21)
.endc
.end
