controls oracle ac-0238
* Generated (plan F2.7, ADR 0012): do not edit; regenerate with `pnpm sim oracle regen`. ac seed 20261031 index 238 nodes 14 elements 23
.options sparse gmin=1e-12 noopac
RG1 1 0 1000000000000
RG2 2 0 1000000000000
RG3 3 0 1000000000000
RG4 4 0 1000000000000
RG5 5 0 1000000000000
RG6 6 0 1000000000000
RG7 7 0 1000000000000
RG8 8 0 1000000000000
RG9 9 0 1000000000000
RG10 10 0 1000000000000
RG11 11 0 1000000000000
RG12 12 0 1000000000000
RG13 13 0 1000000000000
VS0 10 s0 0
R0 s0 5 12e0
VS1 0 s1 0
V1 e1 s1 DC 0 AC 39e0 180
RI1 e1 n1 22e-1
H1 n1 h1 VS12 -39e-4
ED1 h1 9 d1 0 -82e-7
F1 0 d1 VS12 1
LD1 d1 0 1
VS2 11 s2 0
C2 s2 5 27e-6
VS3 7 s3 0
C3 s3 5 15e-5
VS4 12 s4 0
R4 s4 10 10e-1
VS5 13 s5 0
R5 s5 8 33e0
VS6 3 s6 0
C6 s6 11 47e-5
VS7 11 s7 0
L7 s7 1 15e-5
VS8 2 s8 0
C8 s8 12 33e-6
VS9 8 s9 0
R9 s9 3 12e3
VS10 7 s10 0
L10 s10 4 27e-2
VS11 5 s11 0
L11 s11 11 68e-5
VS12 12 s12 0
V12 e12 s12 DC 0 AC 10e1 120
RI12 e12 n12 82e-3
H12 n12 h12 VS1 -39e-4
ED12 h12 13 d12 0 -82e-7
F12 0 d12 VS1 1
LD12 d12 0 1
VS13 6 s13 0
R13 s13 4 18e0
VS14 7 s14 0
C14 s14 2 10e-6
VS15 13 s15 0
R15 s15 12 22e-2
VS16 8 s16 0
R16 s16 6 33e3
VS17 10 s17 0
V17 e17 s17 DC 0 AC 82e-1 120
RI17 e17 0 33e-1
VS18 7 s18 0
V18 e18 s18 DC 0 AC 22e-1 0
RI18 e18 m18 68e-2
LI18 m18 1 27e-7
VS19 9 s19 0
C19 s19 7 10e-4
VS20 6 s20 0
V20 e20 s20 DC 0 AC 39e1 -120
RI20 e20 5 18e-2
VS21 1 s21 0
R21 s21 3 18e0
VS22 2 s22 0
R22 s22 8 22e1
.control
set numdgt=17
ac lin 1 60 60
print v(1) v(2) v(3) v(4) v(5) v(6) v(7) v(8) v(9) v(10)
print v(11) v(12) v(13)
print i(vs0) i(vs1) i(vs2) i(vs3) i(vs4) i(vs5) i(vs6) i(vs7) i(vs8) i(vs9)
print i(vs10) i(vs11) i(vs12) i(vs13) i(vs14) i(vs15) i(vs16) i(vs17) i(vs18) i(vs19)
print i(vs20) i(vs21) i(vs22)
.endc
.end
