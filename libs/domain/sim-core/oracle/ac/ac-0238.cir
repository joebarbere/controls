controls oracle ac-0238
* Generated (plan F2.7, ADR 0012): do not edit; regenerate with `pnpm sim oracle regen`. ac seed 20261031 index 238 nodes 14 elements 22
.options sparse gmin=1e-12 noopac
RG1 1 0 1000000000000
RG2 2 0 1000000000000
RG3 3 0 1000000000000
RG4 4 0 1000000000000
RG5 5 0 1000000000000
RG6 6 0 1000000000000
RG7 7 0 1000000000000
RG8 8 0 1000000000000
RG9 9 0 1000000000000
RG10 10 0 1000000000000
RG11 11 0 1000000000000
RG12 12 0 1000000000000
RG13 13 0 1000000000000
VS0 0 s0 0
V0 e0 s0 DC 0 AC 82e-1 120
RI0 e0 8 33e-1
VS1 5 s1 0
L1 s1 11 68e-5
VS2 8 s2 0
V2 e2 s2 DC 0 AC 39e0 180
RI2 e2 9 22e-1
VS3 12 s3 0
R3 s3 0 10e-1
VS4 7 s4 0
C4 s4 5 15e-5
VS5 11 s5 0
C5 s5 5 27e-6
VS6 13 s6 0
R6 s6 10 33e0
VS7 6 s7 0
V7 e7 s7 DC 0 AC 39e1 -120
RI7 e7 5 18e-2
VS8 2 s8 0
R8 s8 10 22e1
VS9 2 s9 0
C9 s9 12 33e-6
VS10 3 s10 0
C10 s10 11 47e-5
VS11 7 s11 0
L11 s11 4 27e-2
VS12 10 s12 0
R12 s12 3 12e3
VS13 9 s13 0
C13 s13 7 10e-4
VS14 13 s14 0
R14 s14 12 22e-2
VS15 10 s15 0
R15 s15 6 33e3
VS16 11 s16 0
L16 s16 1 15e-5
VS17 7 s17 0
V17 e17 s17 DC 0 AC 22e-1 0
RI17 e17 1 68e-2
VS18 0 s18 0
R18 s18 5 12e0
VS19 12 s19 0
V19 e19 s19 DC 0 AC 10e1 120
RI19 e19 13 82e-3
VS20 1 s20 0
R20 s20 3 18e0
VS21 7 s21 0
C21 s21 2 10e-6
.control
set numdgt=17
ac lin 1 60 60
print v(1) v(2) v(3) v(4) v(5) v(6) v(7) v(8) v(9) v(10)
print v(11) v(12) v(13)
print i(vs0) i(vs1) i(vs2) i(vs3) i(vs4) i(vs5) i(vs6) i(vs7) i(vs8) i(vs9)
print i(vs10) i(vs11) i(vs12) i(vs13) i(vs14) i(vs15) i(vs16) i(vs17) i(vs18) i(vs19)
print i(vs20) i(vs21)
.endc
.end
