controls oracle ac-0335
* Generated (plan F2.7, ADR 0012): do not edit; regenerate with `pnpm sim oracle regen`. ac seed 20261031 index 335 nodes 22 elements 40
.options sparse gmin=1e-12 noopac
RG1 1 0 1000000000000
RG2 2 0 1000000000000
RG3 3 0 1000000000000
RG4 4 0 1000000000000
RG5 5 0 1000000000000
RG6 6 0 1000000000000
RG7 7 0 1000000000000
RG8 8 0 1000000000000
RG9 9 0 1000000000000
RG10 10 0 1000000000000
RG11 11 0 1000000000000
RG12 12 0 1000000000000
RG13 13 0 1000000000000
RG14 14 0 1000000000000
RG15 15 0 1000000000000
RG16 16 0 1000000000000
RG17 17 0 1000000000000
RG18 18 0 1000000000000
RG19 19 0 1000000000000
RG20 20 0 1000000000000
RG21 21 0 1000000000000
VS0 0 s0 0
V0 e0 s0 DC 0 AC 10e0 -120
RI0 e0 m0 15e-1
LI0 m0 n0 68e-5
H0 n0 h0 VS3 -39e-3
ED0 h0 4 d0 0 39e-6
F0 0 d0 VS3 1
LD0 d0 0 1
VS1 17 s1 0
R1 s1 14 12e1
VS2 2 s2 0
R2 s2 8 33e0
VS3 20 s3 0
V3 e3 s3 DC 0 AC 12e-1 120
RI3 e3 n3 18e-2
H3 n3 h3 VS0 -39e-3
ED3 h3 3 d3 0 39e-6
F3 0 d3 VS0 1
LD3 d3 0 1
VS4 6 s4 0
L4 s4 21 18e-4
VS5 18 s5 0
L5 s5 5 33e-5
VS6 10 s6 0
R6 s6 4 56e2
VS7 15 s7 0
R7 s7 12 82e-1
VS8 16 s8 0
C8 s8 6 47e-5
VS9 20 s9 0
C9 s9 9 82e-5
VS10 12 s10 0
R10 s10 3 56e2
VS11 21 s11 0
C11 s11 1 47e-4
VS12 12 s12 0
V12 e12 s12 DC 0 AC 27e0 180
RI12 e12 18 12e-2
VS13 4 s13 0
L13 s13 19 68e-2
VS14 9 s14 0
R14 s14 14 18e-2
VS15 6 s15 0
L15 s15 0 22e-4
VS16 14 s16 0
V16 e16 s16 DC 0 AC 56e0 120
RI16 e16 21 15e-1
VS17 19 s17 0
L17 s17 5 27e-2
VS18 5 s18 0
L18 s18 18 56e-2
VS19 13 s19 0
R19 s19 4 18e3
VS20 7 s20 0
R20 s20 14 33e-1
VS21 6 s21 0
R21 s21 20 10e2
VS22 19 s22 0
R22 s22 21 68e-2
VS23 14 s23 0
V23 e23 s23 DC 0 AC 27e1 120
RI23 e23 13 15e-1
VS24 20 s24 0
C24 s24 12 47e-4
VS25 14 s25 0
V25 e25 s25 DC 0 AC 68e-1 120
RI25 e25 m25 47e-2
LI25 m25 13 82e-5
VS26 17 s26 0
R26 s26 21 82e0
VS27 7 s27 0
L27 s27 16 15e-3
VS28 8 s28 0
R28 s28 6 15e-1
VS29 2 s29 0
C29 s29 14 18e-6
VS30 3 s30 0
C30 s30 14 82e-4
VS31 4 s31 0
C31 s31 7 68e-4
VS32 15 s32 0
R32 s32 16 82e3
VS33 21 s33 0
L33 s33 11 39e-4
VS34 5 s34 0
R34 s34 9 56e0
VS35 20 s35 0
L35 s35 11 68e-5
VS36 10 s36 0
R36 s36 20 12e1
VS37 21 s37 0
V37 e37 s37 DC 0 AC 10e1 0
RI37 e37 m37 12e-2
LI37 m37 4 22e-6
VS38 1 s38 0
R38 s38 11 22e-2
VS39 11 s39 0
R39 s39 15 39e2
.control
set numdgt=17
ac lin 1 60 60
print v(1) v(2) v(3) v(4) v(5) v(6) v(7) v(8) v(9) v(10)
print v(11) v(12) v(13) v(14) v(15) v(16) v(17) v(18) v(19) v(20)
print v(21)
print i(vs0) i(vs1) i(vs2) i(vs3) i(vs4) i(vs5) i(vs6) i(vs7) i(vs8) i(vs9)
print i(vs10) i(vs11) i(vs12) i(vs13) i(vs14) i(vs15) i(vs16) i(vs17) i(vs18) i(vs19)
print i(vs20) i(vs21) i(vs22) i(vs23) i(vs24) i(vs25) i(vs26) i(vs27) i(vs28) i(vs29)
print i(vs30) i(vs31) i(vs32) i(vs33) i(vs34) i(vs35) i(vs36) i(vs37) i(vs38) i(vs39)
.endc
.end
