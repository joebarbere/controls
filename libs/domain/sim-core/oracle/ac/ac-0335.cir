controls oracle ac-0335
* Generated (plan F2.7, ADR 0012): do not edit; regenerate with `pnpm sim oracle regen`. ac seed 20261031 index 335 nodes 22 elements 31
.options sparse gmin=1e-12 noopac
RG1 1 0 1000000000000
RG2 2 0 1000000000000
RG3 3 0 1000000000000
RG4 4 0 1000000000000
RG5 5 0 1000000000000
RG6 6 0 1000000000000
RG7 7 0 1000000000000
RG8 8 0 1000000000000
RG9 9 0 1000000000000
RG10 10 0 1000000000000
RG11 11 0 1000000000000
RG12 12 0 1000000000000
RG13 13 0 1000000000000
RG14 14 0 1000000000000
RG15 15 0 1000000000000
RG16 16 0 1000000000000
RG17 17 0 1000000000000
RG18 18 0 1000000000000
RG19 19 0 1000000000000
RG20 20 0 1000000000000
RG21 21 0 1000000000000
VS0 2 s0 0
R0 s0 17 12e3
VS1 11 s1 0
R1 s1 6 56e2
VS2 19 s2 0
R2 s2 15 39e2
VS3 1 s3 0
L3 s3 9 10e-2
VS4 4 s4 0
C4 s4 5 10e-4
VS5 6 s5 0
L5 s5 0 18e-4
VS6 0 s6 0
V6 e6 s6 DC 0 AC 15e-1 0
RI6 e6 15 33e-2
VS7 0 s7 0
V7 e7 s7 DC 0 AC 27e0 -120
RI7 e7 3 12e-3
VS8 19 s8 0
R8 s8 0 68e-2
VS9 3 s9 0
V9 e9 s9 DC 0 AC 68e1 180
RI9 e9 2 18e-3
VS10 13 s10 0
V10 e10 s10 DC 0 AC 39e0 180
RI10 e10 m10 82e-1
LI10 m10 8 82e-7
VS11 14 s11 0
L11 s11 20 39e-2
VS12 18 s12 0
C12 s12 2 68e-4
VS13 13 s13 0
L13 s13 7 56e-2
VS14 9 s14 0
L14 s14 12 18e-3
VS15 18 s15 0
C15 s15 8 82e-7
VS16 10 s16 0
R16 s16 21 39e0
VS17 0 s17 0
R17 s17 4 12e-1
VS18 5 s18 0
C18 s18 20 68e-7
VS19 21 s19 0
V19 e19 s19 DC 0 AC 27e1 120
RI19 e19 13 15e-1
VS20 13 s20 0
R20 s20 12 82e-2
VS21 21 s21 0
V21 e21 s21 DC 0 AC 56e0 120
RI21 e21 m21 15e-1
LI21 m21 0 39e-5
VS22 11 s22 0
C22 s22 3 39e-6
VS23 15 s23 0
L23 s23 11 10e-2
VS24 13 s24 0
V24 e24 s24 DC 0 AC 33e1 120
RI24 e24 20 47e-3
VS25 10 s25 0
R25 s25 14 47e-1
VS26 16 s26 0
V26 e26 s26 DC 0 AC 22e1 180
RI26 e26 17 18e-1
VS27 4 s27 0
C27 s27 16 27e-4
VS28 1 s28 0
R28 s28 18 33e0
VS29 8 s29 0
R29 s29 18 47e3
VS30 0 s30 0
C30 s30 7 22e-7
.control
set numdgt=17
ac lin 1 60 60
print v(1) v(2) v(3) v(4) v(5) v(6) v(7) v(8) v(9) v(10)
print v(11) v(12) v(13) v(14) v(15) v(16) v(17) v(18) v(19) v(20)
print v(21)
print i(vs0) i(vs1) i(vs2) i(vs3) i(vs4) i(vs5) i(vs6) i(vs7) i(vs8) i(vs9)
print i(vs10) i(vs11) i(vs12) i(vs13) i(vs14) i(vs15) i(vs16) i(vs17) i(vs18) i(vs19)
print i(vs20) i(vs21) i(vs22) i(vs23) i(vs24) i(vs25) i(vs26) i(vs27) i(vs28) i(vs29)
print i(vs30)
.endc
.end
