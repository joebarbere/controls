controls oracle ac-0335
* Generated (plan F2.7, ADR 0012): do not edit; regenerate with `pnpm sim oracle regen`. ac seed 20261031 index 335 nodes 22 elements 36
.options sparse gmin=1e-12 noopac
RG1 1 0 1000000000000
RG2 2 0 1000000000000
RG3 3 0 1000000000000
RG4 4 0 1000000000000
RG5 5 0 1000000000000
RG6 6 0 1000000000000
RG7 7 0 1000000000000
RG8 8 0 1000000000000
RG9 9 0 1000000000000
RG10 10 0 1000000000000
RG11 11 0 1000000000000
RG12 12 0 1000000000000
RG13 13 0 1000000000000
RG14 14 0 1000000000000
RG15 15 0 1000000000000
RG16 16 0 1000000000000
RG17 17 0 1000000000000
RG18 18 0 1000000000000
RG19 19 0 1000000000000
RG20 20 0 1000000000000
RG21 21 0 1000000000000
VS0 19 s0 0
L0 s0 5 27e-2
VS1 9 s1 0
R1 s1 0 18e-2
VS2 10 s2 0
R2 s2 4 56e2
VS3 3 s3 0
C3 s3 0 82e-4
VS4 2 s4 0
C4 s4 0 18e-6
VS5 20 s5 0
C5 s5 9 82e-5
VS6 0 s6 0
V6 e6 s6 DC 0 AC 27e1 120
RI6 e6 13 15e-1
VS7 20 s7 0
L7 s7 11 68e-5
VS8 20 s8 0
C8 s8 12 47e-4
VS9 15 s9 0
R9 s9 12 82e-1
VS10 0 s10 0
V10 e10 s10 DC 0 AC 68e-1 120
RI10 e10 13 47e-2
VS11 7 s11 0
L11 s11 16 15e-3
VS12 4 s12 0
C12 s12 7 68e-4
VS13 21 s13 0
V13 e13 s13 DC 0 AC 10e1 0
RI13 e13 4 12e-2
VS14 7 s14 0
R14 s14 0 33e-1
VS15 12 s15 0
V15 e15 s15 DC 0 AC 27e0 180
RI15 e15 18 12e-2
VS16 20 s16 0
V16 e16 s16 DC 0 AC 12e-1 120
RI16 e16 3 18e-2
VS17 4 s17 0
L17 s17 19 68e-2
VS18 16 s18 0
C18 s18 6 47e-5
VS19 0 s19 0
V19 e19 s19 DC 0 AC 56e0 120
RI19 e19 21 15e-1
VS20 19 s20 0
R20 s20 21 68e-2
VS21 6 s21 0
L21 s21 21 18e-4
VS22 12 s22 0
R22 s22 3 56e2
VS23 11 s23 0
R23 s23 15 39e2
VS24 5 s24 0
R24 s24 9 56e0
VS25 1 s25 0
R25 s25 11 22e-2
VS26 8 s26 0
R26 s26 6 15e-1
VS27 21 s27 0
L27 s27 11 39e-4
VS28 15 s28 0
R28 s28 16 82e3
VS29 6 s29 0
R29 s29 20 10e2
VS30 2 s30 0
R30 s30 8 33e0
VS31 10 s31 0
R31 s31 20 12e1
VS32 6 s32 0
L32 s32 14 22e-4
VS33 5 s33 0
L33 s33 18 56e-2
VS34 18 s34 0
L34 s34 5 33e-5
VS35 17 s35 0
R35 s35 21 82e0
.control
set numdgt=17
ac lin 1 60 60
print v(1) v(2) v(3) v(4) v(5) v(6) v(7) v(8) v(9) v(10)
print v(11) v(12) v(13) v(14) v(15) v(16) v(17) v(18) v(19) v(20)
print v(21)
print i(vs0) i(vs1) i(vs2) i(vs3) i(vs4) i(vs5) i(vs6) i(vs7) i(vs8) i(vs9)
print i(vs10) i(vs11) i(vs12) i(vs13) i(vs14) i(vs15) i(vs16) i(vs17) i(vs18) i(vs19)
print i(vs20) i(vs21) i(vs22) i(vs23) i(vs24) i(vs25) i(vs26) i(vs27) i(vs28) i(vs29)
print i(vs30) i(vs31) i(vs32) i(vs33) i(vs34) i(vs35)
.endc
.end
