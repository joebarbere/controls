controls oracle ac-0397
* Generated (plan F2.7, ADR 0012): do not edit; regenerate with `pnpm sim oracle regen`. ac seed 20261031 index 397 nodes 4 elements 6
.options sparse gmin=1e-12 noopac
RG1 1 0 1000000000000
RG2 2 0 1000000000000
RG3 3 0 1000000000000
VS0 2 s0 0
C0 s0 3 18e-7
VS1 0 s1 0
C1 s1 1 33e-4
VS2 0 s2 0
V2 e2 s2 DC 0 AC 18e1 -120
RI2 e2 3 68e-2
VS3 0 s3 0
V3 e3 s3 DC 0 AC 27e1 120
RI3 e3 m3 10e-2
LI3 m3 2 18e-7
VS4 2 s4 0
V4 e4 s4 DC 0 AC 15e-1 120
RI4 e4 m4 82e-3
LI4 m4 1 18e-5
VS5 1 s5 0
C5 s5 2 39e-7
.control
set numdgt=17
ac lin 1 60 60
print v(1) v(2) v(3)
print i(vs0) i(vs1) i(vs2) i(vs3) i(vs4) i(vs5)
.endc
.end
