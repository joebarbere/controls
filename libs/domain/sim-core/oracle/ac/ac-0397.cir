controls oracle ac-0397
* Generated (plan F2.7, ADR 0012): do not edit; regenerate with `pnpm sim oracle regen`. ac seed 20261031 index 397 nodes 4 elements 7
.options sparse gmin=1e-12 noopac
RG1 1 0 1000000000000
RG2 2 0 1000000000000
RG3 3 0 1000000000000
VS0 0 s0 0
V0 e0 s0 DC 0 AC 33e1 120
RI0 e0 m0 18e-3
LI0 m0 3 33e-7
VS1 0 s1 0
C1 s1 1 39e-7
VS2 1 s2 0
C2 s2 3 33e-4
VS3 2 s3 0
V3 e3 s3 DC 0 AC 27e1 120
RI3 e3 1 10e-2
VS4 2 s4 0
L4 s4 0 68e-3
VS5 3 s5 0
C5 s5 0 10e-5
VS6 3 s6 0
V6 e6 s6 DC 0 AC 18e1 -120
RI6 e6 0 68e-2
.control
set numdgt=17
ac lin 1 60 60
print v(1) v(2) v(3)
print i(vs0) i(vs1) i(vs2) i(vs3) i(vs4) i(vs5) i(vs6)
.endc
.end
