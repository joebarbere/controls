controls oracle ac-0056
* Generated (plan F2.7, ADR 0012): do not edit; regenerate with `pnpm sim oracle regen`. ac seed 20261031 index 56 nodes 12 elements 20
.options sparse gmin=1e-12 noopac
RG1 1 0 1000000000000
RG2 2 0 1000000000000
RG3 3 0 1000000000000
RG4 4 0 1000000000000
RG5 5 0 1000000000000
RG6 6 0 1000000000000
RG7 7 0 1000000000000
RG8 8 0 1000000000000
RG9 9 0 1000000000000
RG10 10 0 1000000000000
RG11 11 0 1000000000000
VS0 10 s0 0
L0 s0 3 82e-2
VS1 5 s1 0
R1 s1 1 12e-1
VS2 3 s2 0
L2 s2 0 56e-2
VS3 11 s3 0
C3 s3 2 27e-6
VS4 1 s4 0
R4 s4 5 82e-2
VS5 0 s5 0
V5 e5 s5 DC 0 AC 15e1 180
RI5 e5 n5 33e-3
H5 n5 h5 VS7 -10e-4
ED5 h5 3 d5 0 15e-7
F5 0 d5 VS7 1
LD5 d5 0 1
VS6 5 s6 0
C6 s6 9 39e-7
VS7 2 s7 0
V7 e7 s7 DC 0 AC 82e1 0
RI7 e7 m7 68e-2
LI7 m7 n7 56e-5
H7 n7 h7 VS5 -10e-4
ED7 h7 7 d7 0 15e-7
F7 0 d7 VS5 1
LD7 d7 0 1
VS8 0 s8 0
V8 e8 s8 DC 0 AC 22e-1 0
RI8 e8 m8 27e-3
LI8 m8 7 18e-7
VS9 3 s9 0
V9 e9 s9 DC 0 AC 82e-1 0
RI9 e9 8 22e-2
VS10 5 s10 0
C10 s10 11 82e-6
VS11 6 s11 0
R11 s11 1 82e3
VS12 11 s12 0
C12 s12 5 12e-7
VS13 6 s13 0
C13 s13 3 27e-4
VS14 4 s14 0
L14 s14 10 47e-3
VS15 2 s15 0
L15 s15 6 47e-3
VS16 9 s16 0
V16 e16 s16 DC 0 AC 12e0 180
RI16 e16 m16 56e-2
LI16 m16 10 56e-7
VS17 8 s17 0
V17 e17 s17 DC 0 AC 10e-1 120
RI17 e17 0 22e-2
VS18 10 s18 0
L18 s18 8 33e-2
VS19 4 s19 0
R19 s19 5 47e2
.control
set numdgt=17
ac lin 1 60 60
print v(1) v(2) v(3) v(4) v(5) v(6) v(7) v(8) v(9) v(10)
print v(11)
print i(vs0) i(vs1) i(vs2) i(vs3) i(vs4) i(vs5) i(vs6) i(vs7) i(vs8) i(vs9)
print i(vs10) i(vs11) i(vs12) i(vs13) i(vs14) i(vs15) i(vs16) i(vs17) i(vs18) i(vs19)
.endc
.end
