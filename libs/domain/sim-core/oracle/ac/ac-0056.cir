controls oracle ac-0056
* Generated (plan F2.7, ADR 0012): do not edit; regenerate with `pnpm sim oracle regen`. ac seed 20261031 index 56 nodes 12 elements 22
.options sparse gmin=1e-12 noopac
RG1 1 0 1000000000000
RG2 2 0 1000000000000
RG3 3 0 1000000000000
RG4 4 0 1000000000000
RG5 5 0 1000000000000
RG6 6 0 1000000000000
RG7 7 0 1000000000000
RG8 8 0 1000000000000
RG9 9 0 1000000000000
RG10 10 0 1000000000000
RG11 11 0 1000000000000
VS0 11 s0 0
R0 s0 7 56e1
VS1 0 s1 0
V1 e1 s1 DC 0 AC 12e0 180
RI1 e1 m1 56e-2
LI1 m1 10 82e-5
VS2 9 s2 0
C2 s2 0 33e-6
VS3 6 s3 0
V3 e3 s3 DC 0 AC 39e1 0
RI3 e3 m3 22e-2
LI3 m3 3 27e-7
VS4 3 s4 0
L4 s4 7 15e-4
VS5 8 s5 0
R5 s5 9 15e3
VS6 4 s6 0
V6 e6 s6 DC 0 AC 47e0 0
RI6 e6 3 27e-2
VS7 8 s7 0
C7 s7 0 47e-7
VS8 4 s8 0
V8 e8 s8 DC 0 AC 33e0 180
RI8 e8 m8 56e-1
LI8 m8 0 82e-5
VS9 0 s9 0
R9 s9 9 39e-1
VS10 4 s10 0
V10 e10 s10 DC 0 AC 22e-1 0
RI10 e10 11 27e-3
VS11 7 s11 0
C11 s11 1 18e-4
VS12 9 s12 0
R12 s12 1 33e2
VS13 9 s13 0
C13 s13 7 56e-4
VS14 5 s14 0
R14 s14 9 12e-2
VS15 6 s15 0
V15 e15 s15 DC 0 AC 68e1 180
RI15 e15 m15 47e-2
LI15 m15 1 15e-5
VS16 10 s16 0
C16 s16 2 22e-4
VS17 8 s17 0
L17 s17 2 82e-4
VS18 10 s18 0
L18 s18 3 33e-2
VS19 10 s19 0
L19 s19 5 56e-5
VS20 5 s20 0
V20 e20 s20 DC 0 AC 15e0 180
RI20 e20 m20 39e-1
LI20 m20 8 39e-5
VS21 4 s21 0
R21 s21 5 39e-2
.control
set numdgt=17
ac lin 1 60 60
print v(1) v(2) v(3) v(4) v(5) v(6) v(7) v(8) v(9) v(10)
print v(11)
print i(vs0) i(vs1) i(vs2) i(vs3) i(vs4) i(vs5) i(vs6) i(vs7) i(vs8) i(vs9)
print i(vs10) i(vs11) i(vs12) i(vs13) i(vs14) i(vs15) i(vs16) i(vs17) i(vs18) i(vs19)
print i(vs20) i(vs21)
.endc
.end
