controls oracle ac-0354
* Generated (plan F2.7, ADR 0012): do not edit; regenerate with `pnpm sim oracle regen`. ac seed 20261031 index 354 nodes 19 elements 30
.options sparse gmin=1e-12 noopac
RG1 1 0 1000000000000
RG2 2 0 1000000000000
RG3 3 0 1000000000000
RG4 4 0 1000000000000
RG5 5 0 1000000000000
RG6 6 0 1000000000000
RG7 7 0 1000000000000
RG8 8 0 1000000000000
RG9 9 0 1000000000000
RG10 10 0 1000000000000
RG11 11 0 1000000000000
RG12 12 0 1000000000000
RG13 13 0 1000000000000
RG14 14 0 1000000000000
RG15 15 0 1000000000000
RG16 16 0 1000000000000
RG17 17 0 1000000000000
RG18 18 0 1000000000000
VS0 0 s0 0
R0 s0 15 10e-1
VS1 11 s1 0
L1 s1 3 12e-3
VS2 12 s2 0
R2 s2 7 22e1
VS3 0 s3 0
V3 e3 s3 DC 0 AC 10e1 120
RI3 e3 5 10e-2
VS4 5 s4 0
R4 s4 2 18e0
VS5 6 s5 0
L5 s5 9 27e-5
VS6 13 s6 0
C6 s6 14 15e-4
VS7 13 s7 0
V7 e7 s7 DC 0 AC 47e-1 120
RI7 e7 m7 68e-1
LI7 m7 9 22e-6
VS8 6 s8 0
R8 s8 12 27e-1
VS9 7 s9 0
C9 s9 18 33e-6
VS10 9 s10 0
V10 e10 s10 DC 0 AC 47e-1 0
RI10 e10 7 33e-2
VS11 11 s11 0
R11 s11 8 27e-2
VS12 12 s12 0
C12 s12 7 18e-4
VS13 13 s13 0
V13 e13 s13 DC 0 AC 27e0 120
RI13 e13 2 12e-2
VS14 17 s14 0
L14 s14 16 22e-4
VS15 4 s15 0
C15 s15 10 33e-5
VS16 10 s16 0
V16 e16 s16 DC 0 AC 10e-1 -120
RI16 e16 13 15e-1
VS17 9 s17 0
R17 s17 0 15e-1
VS18 8 s18 0
V18 e18 s18 DC 0 AC 10e-1 180
RI18 e18 m18 33e-2
LI18 m18 2 33e-6
VS19 1 s19 0
R19 s19 6 12e1
VS20 6 s20 0
C20 s20 16 22e-6
VS21 17 s21 0
R21 s21 3 15e-1
VS22 18 s22 0
C22 s22 8 39e-5
VS23 13 s23 0
R23 s23 15 12e2
VS24 1 s24 0
R24 s24 14 56e2
VS25 12 s25 0
V25 e25 s25 DC 0 AC 56e0 120
RI25 e25 m25 47e-3
LI25 m25 10 27e-6
VS26 2 s26 0
L26 s26 5 82e-3
VS27 3 s27 0
V27 e27 s27 DC 0 AC 33e0 180
RI27 e27 13 68e-1
VS28 17 s28 0
C28 s28 4 27e-7
VS29 4 s29 0
V29 e29 s29 DC 0 AC 68e1 0
RI29 e29 m29 27e-3
LI29 m29 3 68e-7
.control
set numdgt=17
ac lin 1 60 60
print v(1) v(2) v(3) v(4) v(5) v(6) v(7) v(8) v(9) v(10)
print v(11) v(12) v(13) v(14) v(15) v(16) v(17) v(18)
print i(vs0) i(vs1) i(vs2) i(vs3) i(vs4) i(vs5) i(vs6) i(vs7) i(vs8) i(vs9)
print i(vs10) i(vs11) i(vs12) i(vs13) i(vs14) i(vs15) i(vs16) i(vs17) i(vs18) i(vs19)
print i(vs20) i(vs21) i(vs22) i(vs23) i(vs24) i(vs25) i(vs26) i(vs27) i(vs28) i(vs29)
.endc
.end
