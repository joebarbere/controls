controls oracle ac-0354
* Generated (plan F2.7, ADR 0012): do not edit; regenerate with `pnpm sim oracle regen`. ac seed 20261031 index 354 nodes 19 elements 24
.options sparse gmin=1e-12 noopac
RG1 1 0 1000000000000
RG2 2 0 1000000000000
RG3 3 0 1000000000000
RG4 4 0 1000000000000
RG5 5 0 1000000000000
RG6 6 0 1000000000000
RG7 7 0 1000000000000
RG8 8 0 1000000000000
RG9 9 0 1000000000000
RG10 10 0 1000000000000
RG11 11 0 1000000000000
RG12 12 0 1000000000000
RG13 13 0 1000000000000
RG14 14 0 1000000000000
RG15 15 0 1000000000000
RG16 16 0 1000000000000
RG17 17 0 1000000000000
RG18 18 0 1000000000000
VS0 3 s0 0
C0 s0 13 39e-7
VS1 0 s1 0
V1 e1 s1 DC 0 AC 56e0 120
RI1 e1 3 47e-3
VS2 3 s2 0
V2 e2 s2 DC 0 AC 27e0 120
RI2 e2 8 12e-2
VS3 9 s3 0
L3 s3 0 82e-2
VS4 10 s4 0
C4 s4 15 18e-7
VS5 2 s5 0
C5 s5 11 68e-6
VS6 6 s6 0
R6 s6 8 39e1
VS7 14 s7 0
R7 s7 15 12e2
VS8 0 s8 0
V8 e8 s8 DC 0 AC 12e-1 0
RI8 e8 2 15e-2
VS9 16 s9 0
V9 e9 s9 DC 0 AC 18e0 0
RI9 e9 6 22e-1
VS10 9 s10 0
R10 s10 6 10e-2
VS11 12 s11 0
R11 s11 7 18e3
VS12 15 s12 0
C12 s12 17 22e-4
VS13 9 s13 0
V13 e13 s13 DC 0 AC 47e-1 0
RI13 e13 5 33e-2
VS14 4 s14 0
V14 e14 s14 DC 0 AC 12e1 -120
RI14 e14 9 12e-1
VS15 3 s15 0
C15 s15 1 56e-6
VS16 15 s16 0
C16 s16 18 12e-7
VS17 10 s17 0
R17 s17 12 82e0
VS18 7 s18 0
C18 s18 1 47e-6
VS19 16 s19 0
R19 s19 2 15e1
VS20 3 s20 0
V20 e20 s20 DC 0 AC 33e0 180
RI20 e20 14 68e-1
VS21 16 s21 0
R21 s21 17 22e2
VS22 17 s22 0
L22 s22 12 56e-5
VS23 5 s23 0
C23 s23 18 12e-7
.control
set numdgt=17
ac lin 1 60 60
print v(1) v(2) v(3) v(4) v(5) v(6) v(7) v(8) v(9) v(10)
print v(11) v(12) v(13) v(14) v(15) v(16) v(17) v(18)
print i(vs0) i(vs1) i(vs2) i(vs3) i(vs4) i(vs5) i(vs6) i(vs7) i(vs8) i(vs9)
print i(vs10) i(vs11) i(vs12) i(vs13) i(vs14) i(vs15) i(vs16) i(vs17) i(vs18) i(vs19)
print i(vs20) i(vs21) i(vs22) i(vs23)
.endc
.end
