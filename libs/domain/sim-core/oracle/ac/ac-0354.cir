controls oracle ac-0354
* Generated (plan F2.7, ADR 0012): do not edit; regenerate with `pnpm sim oracle regen`. ac seed 20261031 index 354 nodes 19 elements 27
.options sparse gmin=1e-12 noopac
RG1 1 0 1000000000000
RG2 2 0 1000000000000
RG3 3 0 1000000000000
RG4 4 0 1000000000000
RG5 5 0 1000000000000
RG6 6 0 1000000000000
RG7 7 0 1000000000000
RG8 8 0 1000000000000
RG9 9 0 1000000000000
RG10 10 0 1000000000000
RG11 11 0 1000000000000
RG12 12 0 1000000000000
RG13 13 0 1000000000000
RG14 14 0 1000000000000
RG15 15 0 1000000000000
RG16 16 0 1000000000000
RG17 17 0 1000000000000
RG18 18 0 1000000000000
VS0 0 s0 0
V0 e0 s0 DC 0 AC 18e0 0
RI0 e0 m0 22e-1
LI0 m0 n0 56e-5
H0 n0 h0 VS2 68e-3
ED0 h0 6 d0 0 -15e-7
F0 0 d0 VS2 1
LD0 d0 0 1
VS1 8 s1 0
C1 s1 11 27e-6
VS2 3 s2 0
V2 e2 s2 DC 0 AC 27e0 120
RI2 e2 m2 12e-2
LI2 m2 n2 12e-6
H2 n2 h2 VS0 68e-3
ED2 h2 8 d2 0 -15e-7
F2 0 d2 VS0 1
LD2 d2 0 1
VS3 0 s3 0
R3 s3 17 22e2
VS4 9 s4 0
L4 s4 14 82e-2
VS5 16 s5 0
R5 s5 15 12e2
VS6 14 s6 0
V6 e6 s6 DC 0 AC 12e-1 0
RI6 e6 m6 15e-2
LI6 m6 2 33e-5
VS7 3 s7 0
C7 s7 13 39e-7
VS8 13 s8 0
L8 s8 9 33e-4
VS9 4 s9 0
V9 e9 s9 DC 0 AC 12e1 -120
RI9 e9 m9 12e-1
LI9 m9 9 27e-6
VS10 14 s10 0
V10 e10 s10 DC 0 AC 56e0 120
RI10 e10 3 47e-3
VS11 15 s11 0
C11 s11 18 12e-7
VS12 9 s12 0
R12 s12 6 10e-2
VS13 3 s13 0
C13 s13 1 56e-6
VS14 9 s14 0
V14 e14 s14 DC 0 AC 47e-1 0
RI14 e14 m14 33e-2
LI14 m14 5 27e-6
VS15 10 s15 0
R15 s15 12 82e0
VS16 10 s16 0
C16 s16 15 18e-7
VS17 5 s17 0
C17 s17 18 12e-7
VS18 2 s18 0
C18 s18 11 68e-6
VS19 6 s19 0
R19 s19 8 39e1
VS20 17 s20 0
L20 s20 12 56e-5
VS21 15 s21 0
C21 s21 17 22e-4
VS22 12 s22 0
R22 s22 7 18e3
VS23 7 s23 0
C23 s23 1 47e-6
VS24 0 s24 0
R24 s24 2 15e1
VS25 4 s25 0
V25 e25 s25 DC 0 AC 18e0 180
RI25 e25 m25 12e-2
LI25 m25 17 39e-7
VS26 3 s26 0
V26 e26 s26 DC 0 AC 33e0 180
RI26 e26 16 68e-1
.control
set numdgt=17
ac lin 1 60 60
print v(1) v(2) v(3) v(4) v(5) v(6) v(7) v(8) v(9) v(10)
print v(11) v(12) v(13) v(14) v(15) v(16) v(17) v(18)
print i(vs0) i(vs1) i(vs2) i(vs3) i(vs4) i(vs5) i(vs6) i(vs7) i(vs8) i(vs9)
print i(vs10) i(vs11) i(vs12) i(vs13) i(vs14) i(vs15) i(vs16) i(vs17) i(vs18) i(vs19)
print i(vs20) i(vs21) i(vs22) i(vs23) i(vs24) i(vs25) i(vs26)
.endc
.end
