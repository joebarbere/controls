controls oracle ac-0182
* Generated (plan F2.7, ADR 0012): do not edit; regenerate with `pnpm sim oracle regen`. ac seed 20261031 index 182 nodes 12 elements 18
.options sparse gmin=1e-12 noopac
RG1 1 0 1000000000000
RG2 2 0 1000000000000
RG3 3 0 1000000000000
RG4 4 0 1000000000000
RG5 5 0 1000000000000
RG6 6 0 1000000000000
RG7 7 0 1000000000000
RG8 8 0 1000000000000
RG9 9 0 1000000000000
RG10 10 0 1000000000000
RG11 11 0 1000000000000
VS0 10 s0 0
R0 s0 6 39e-1
VS1 7 s1 0
L1 s1 6 12e-5
VS2 9 s2 0
L2 s2 0 39e-3
VS3 0 s3 0
V3 e3 s3 DC 0 AC 47e0 -120
RI3 e3 6 56e-1
VS4 9 s4 0
L4 s4 1 10e-2
VS5 3 s5 0
L5 s5 9 12e-2
VS6 5 s6 0
R6 s6 11 68e0
VS7 5 s7 0
L7 s7 0 12e-4
VS8 1 s8 0
R8 s8 10 22e1
VS9 4 s9 0
L9 s9 8 82e-5
VS10 7 s10 0
V10 e10 s10 DC 0 AC 27e1 180
RI10 e10 5 22e-2
VS11 7 s11 0
R11 s11 10 10e-1
VS12 10 s12 0
V12 e12 s12 DC 0 AC 15e1 180
RI12 e12 9 18e-1
VS13 0 s13 0
R13 s13 11 33e1
VS14 9 s14 0
R14 s14 5 82e-2
VS15 11 s15 0
C15 s15 5 33e-5
VS16 4 s16 0
R16 s16 0 22e0
VS17 10 s17 0
C17 s17 2 33e-4
.control
set numdgt=17
ac lin 1 60 60
print v(1) v(2) v(3) v(4) v(5) v(6) v(7) v(8) v(9) v(10)
print v(11)
print i(vs0) i(vs1) i(vs2) i(vs3) i(vs4) i(vs5) i(vs6) i(vs7) i(vs8) i(vs9)
print i(vs10) i(vs11) i(vs12) i(vs13) i(vs14) i(vs15) i(vs16) i(vs17)
.endc
.end
