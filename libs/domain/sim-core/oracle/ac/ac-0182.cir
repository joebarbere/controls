controls oracle ac-0182
* Generated (plan F2.7, ADR 0012): do not edit; regenerate with `pnpm sim oracle regen`. ac seed 20261031 index 182 nodes 12 elements 22
.options sparse gmin=1e-12 noopac
RG1 1 0 1000000000000
RG2 2 0 1000000000000
RG3 3 0 1000000000000
RG4 4 0 1000000000000
RG5 5 0 1000000000000
RG6 6 0 1000000000000
RG7 7 0 1000000000000
RG8 8 0 1000000000000
RG9 9 0 1000000000000
RG10 10 0 1000000000000
RG11 11 0 1000000000000
VS0 9 s0 0
L0 s0 6 56e-3
VS1 6 s1 0
R1 s1 0 56e0
VS2 5 s2 0
L2 s2 11 33e-2
VS3 3 s3 0
R3 s3 0 18e2
VS4 10 s4 0
R4 s4 6 39e-1
VS5 7 s5 0
C5 s5 8 33e-4
VS6 10 s6 0
L6 s6 1 47e-5
VS7 9 s7 0
C7 s7 1 33e-5
VS8 5 s8 0
C8 s8 3 47e-5
VS9 0 s9 0
L9 s9 2 18e-3
VS10 9 s10 0
L10 s10 7 39e-4
VS11 7 s11 0
R11 s11 10 22e1
VS12 2 s12 0
L12 s12 11 15e-4
VS13 3 s13 0
R13 s13 8 18e3
VS14 0 s14 0
V14 e14 s14 DC 0 AC 33e1 0
RI14 e14 1 47e-2
VS15 1 s15 0
V15 e15 s15 DC 0 AC 47e0 -120
RI15 e15 m15 56e-1
LI15 m15 6 56e-6
VS16 6 s16 0
L16 s16 11 68e-2
VS17 4 s17 0
V17 e17 s17 DC 0 AC 47e1 0
RI17 e17 m17 27e-1
LI17 m17 10 22e-6
VS18 1 s18 0
L18 s18 5 82e-5
VS19 9 s19 0
C19 s19 2 27e-5
VS20 4 s20 0
L20 s20 8 56e-5
VS21 11 s21 0
L21 s21 7 12e-2
.control
set numdgt=17
ac lin 1 60 60
print v(1) v(2) v(3) v(4) v(5) v(6) v(7) v(8) v(9) v(10)
print v(11)
print i(vs0) i(vs1) i(vs2) i(vs3) i(vs4) i(vs5) i(vs6) i(vs7) i(vs8) i(vs9)
print i(vs10) i(vs11) i(vs12) i(vs13) i(vs14) i(vs15) i(vs16) i(vs17) i(vs18) i(vs19)
print i(vs20) i(vs21)
.endc
.end
