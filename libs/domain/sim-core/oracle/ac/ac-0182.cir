controls oracle ac-0182
* Generated (plan F2.7, ADR 0012): do not edit; regenerate with `pnpm sim oracle regen`. ac seed 20261031 index 182 nodes 12 elements 21
.options sparse gmin=1e-12 noopac
RG1 1 0 1000000000000
RG2 2 0 1000000000000
RG3 3 0 1000000000000
RG4 4 0 1000000000000
RG5 5 0 1000000000000
RG6 6 0 1000000000000
RG7 7 0 1000000000000
RG8 8 0 1000000000000
RG9 9 0 1000000000000
RG10 10 0 1000000000000
RG11 11 0 1000000000000
VS0 5 s0 0
R0 s0 11 68e0
VS1 0 s1 0
V1 e1 s1 DC 0 AC 15e1 180
RI1 e1 m1 18e-1
LI1 m1 9 10e-7
VS2 4 s2 0
L2 s2 8 82e-5
VS3 1 s3 0
R3 s3 11 33e1
VS4 5 s4 0
L4 s4 1 12e-4
VS5 9 s5 0
L5 s5 1 39e-3
VS6 9 s6 0
R6 s6 5 82e-2
VS7 0 s7 0
C7 s7 2 33e-4
VS8 7 s8 0
L8 s8 6 12e-5
VS9 0 s9 0
R9 s9 6 39e-1
VS10 11 s10 0
C10 s10 5 33e-5
VS11 11 s11 0
C11 s11 3 22e-6
VS12 1 s12 0
V12 e12 s12 DC 0 AC 47e0 -120
RI12 e12 6 56e-1
VS13 10 s13 0
R13 s13 0 22e1
VS14 9 s14 0
L14 s14 10 10e-2
VS15 7 s15 0
V15 e15 s15 DC 0 AC 27e1 180
RI15 e15 5 22e-2
VS16 7 s16 0
R16 s16 8 15e-2
VS17 7 s17 0
R17 s17 0 10e-1
VS18 4 s18 0
R18 s18 1 22e0
VS19 3 s19 0
L19 s19 9 12e-2
VS20 2 s20 0
L20 s20 10 10e-4
.control
set numdgt=17
ac lin 1 60 60
print v(1) v(2) v(3) v(4) v(5) v(6) v(7) v(8) v(9) v(10)
print v(11)
print i(vs0) i(vs1) i(vs2) i(vs3) i(vs4) i(vs5) i(vs6) i(vs7) i(vs8) i(vs9)
print i(vs10) i(vs11) i(vs12) i(vs13) i(vs14) i(vs15) i(vs16) i(vs17) i(vs18) i(vs19)
print i(vs20)
.endc
.end
