controls oracle ac-0124
* Generated (plan F2.7, ADR 0012): do not edit; regenerate with `pnpm sim oracle regen`. ac seed 20261031 index 124 nodes 14 elements 26
.options sparse gmin=1e-12 noopac
RG1 1 0 1000000000000
RG2 2 0 1000000000000
RG3 3 0 1000000000000
RG4 4 0 1000000000000
RG5 5 0 1000000000000
RG6 6 0 1000000000000
RG7 7 0 1000000000000
RG8 8 0 1000000000000
RG9 9 0 1000000000000
RG10 10 0 1000000000000
RG11 11 0 1000000000000
RG12 12 0 1000000000000
RG13 13 0 1000000000000
VS0 0 s0 0
V0 e0 s0 DC 0 AC 82e1 120
RI0 e0 m0 39e-1
LI0 m0 11 56e-5
VS1 1 s1 0
L1 s1 7 27e-2
VS2 11 s2 0
R2 s2 2 82e3
VS3 11 s3 0
C3 s3 10 56e-4
VS4 8 s4 0
R4 s4 4 39e1
VS5 2 s5 0
C5 s5 12 15e-4
VS6 13 s6 0
R6 s6 1 56e2
VS7 3 s7 0
R7 s7 0 18e3
VS8 11 s8 0
R8 s8 5 15e3
VS9 10 s9 0
L9 s9 6 15e-3
VS10 4 s10 0
R10 s10 12 15e2
VS11 1 s11 0
L11 s11 12 22e-3
VS12 6 s12 0
L12 s12 8 33e-3
VS13 7 s13 0
V13 e13 s13 DC 0 AC 18e1 120
RI13 e13 8 33e-2
VS14 7 s14 0
V14 e14 s14 DC 0 AC 39e1 120
RI14 e14 m14 27e-3
LI14 m14 4 33e-5
VS15 6 s15 0
C15 s15 9 22e-6
VS16 11 s16 0
V16 e16 s16 DC 0 AC 68e0 -120
RI16 e16 1 82e-3
VS17 1 s17 0
L17 s17 13 56e-4
VS18 5 s18 0
C18 s18 9 56e-4
VS19 2 s19 0
R19 s19 4 47e1
VS20 6 s20 0
L20 s20 12 10e-3
VS21 2 s21 0
R21 s21 0 22e0
VS22 11 s22 0
C22 s22 9 82e-7
VS23 10 s23 0
C23 s23 13 10e-4
VS24 2 s24 0
C24 s24 7 15e-4
VS25 3 s25 0
C25 s25 7 15e-4
.control
set numdgt=17
ac lin 1 60 60
print v(1) v(2) v(3) v(4) v(5) v(6) v(7) v(8) v(9) v(10)
print v(11) v(12) v(13)
print i(vs0) i(vs1) i(vs2) i(vs3) i(vs4) i(vs5) i(vs6) i(vs7) i(vs8) i(vs9)
print i(vs10) i(vs11) i(vs12) i(vs13) i(vs14) i(vs15) i(vs16) i(vs17) i(vs18) i(vs19)
print i(vs20) i(vs21) i(vs22) i(vs23) i(vs24) i(vs25)
.endc
.end
