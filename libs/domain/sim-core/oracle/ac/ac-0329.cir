controls oracle ac-0329
* Generated (plan F2.7, ADR 0012): do not edit; regenerate with `pnpm sim oracle regen`. ac seed 20261031 index 329 nodes 23 elements 33
.options sparse gmin=1e-12 noopac
RG1 1 0 1000000000000
RG2 2 0 1000000000000
RG3 3 0 1000000000000
RG4 4 0 1000000000000
RG5 5 0 1000000000000
RG6 6 0 1000000000000
RG7 7 0 1000000000000
RG8 8 0 1000000000000
RG9 9 0 1000000000000
RG10 10 0 1000000000000
RG11 11 0 1000000000000
RG12 12 0 1000000000000
RG13 13 0 1000000000000
RG14 14 0 1000000000000
RG15 15 0 1000000000000
RG16 16 0 1000000000000
RG17 17 0 1000000000000
RG18 18 0 1000000000000
RG19 19 0 1000000000000
RG20 20 0 1000000000000
RG21 21 0 1000000000000
RG22 22 0 1000000000000
VS0 0 s0 0
V0 e0 s0 DC 0 AC 15e-1 -120
RI0 e0 n0 22e-2
H0 n0 h0 VS7 56e-3
ED0 h0 13 d0 0 15e-7
F0 0 d0 VS7 1
LD0 d0 0 1
VS1 11 s1 0
L1 s1 5 27e-4
VS2 22 s2 0
L2 s2 7 10e-3
VS3 17 s3 0
C3 s3 22 15e-7
VS4 0 s4 0
C4 s4 3 56e-7
VS5 13 s5 0
L5 s5 18 18e-2
VS6 16 s6 0
L6 s6 18 82e-2
VS7 14 s7 0
V7 e7 s7 DC 0 AC 12e1 180
RI7 e7 m7 33e-2
LI7 m7 n7 33e-7
H7 n7 h7 VS0 56e-3
ED7 h7 22 d7 0 15e-7
F7 0 d7 VS0 1
LD7 d7 0 1
VS8 13 s8 0
V8 e8 s8 DC 0 AC 15e1 0
RI8 e8 9 39e-2
VS9 17 s9 0
L9 s9 6 10e-4
VS10 10 s10 0
R10 s10 7 47e0
VS11 19 s11 0
R11 s11 0 18e2
VS12 15 s12 0
L12 s12 5 22e-4
VS13 7 s13 0
R13 s13 12 15e-2
VS14 22 s14 0
R14 s14 1 15e-1
VS15 6 s15 0
V15 e15 s15 DC 0 AC 12e-1 -120
RI15 e15 m15 15e-1
LI15 m15 7 18e-5
VS16 1 s16 0
R16 s16 7 82e1
VS17 9 s17 0
R17 s17 14 18e2
VS18 16 s18 0
V18 e18 s18 DC 0 AC 18e1 -120
RI18 e18 m18 33e-3
LI18 m18 0 47e-6
VS19 4 s19 0
R19 s19 8 56e3
VS20 20 s20 0
L20 s20 19 68e-3
VS21 21 s21 0
L21 s21 0 12e-4
VS22 13 s22 0
L22 s22 2 39e-5
VS23 20 s23 0
R23 s23 15 82e-2
VS24 0 s24 0
R24 s24 12 39e-2
VS25 3 s25 0
R25 s25 20 68e-2
VS26 8 s26 0
V26 e26 s26 DC 0 AC 39e-1 120
RI26 e26 20 56e-3
VS27 20 s27 0
L27 s27 7 82e-2
VS28 8 s28 0
C28 s28 2 22e-7
VS29 22 s29 0
L29 s29 11 27e-3
VS30 18 s30 0
C30 s30 4 33e-7
VS31 10 s31 0
L31 s31 21 47e-5
VS32 7 s32 0
R32 s32 0 56e-1
.control
set numdgt=17
ac lin 1 60 60
print v(1) v(2) v(3) v(4) v(5) v(6) v(7) v(8) v(9) v(10)
print v(11) v(12) v(13) v(14) v(15) v(16) v(17) v(18) v(19) v(20)
print v(21) v(22)
print i(vs0) i(vs1) i(vs2) i(vs3) i(vs4) i(vs5) i(vs6) i(vs7) i(vs8) i(vs9)
print i(vs10) i(vs11) i(vs12) i(vs13) i(vs14) i(vs15) i(vs16) i(vs17) i(vs18) i(vs19)
print i(vs20) i(vs21) i(vs22) i(vs23) i(vs24) i(vs25) i(vs26) i(vs27) i(vs28) i(vs29)
print i(vs30) i(vs31) i(vs32)
.endc
.end
