controls oracle ac-0329
* Generated (plan F2.7, ADR 0012): do not edit; regenerate with `pnpm sim oracle regen`. ac seed 20261031 index 329 nodes 23 elements 36
.options sparse gmin=1e-12 noopac
RG1 1 0 1000000000000
RG2 2 0 1000000000000
RG3 3 0 1000000000000
RG4 4 0 1000000000000
RG5 5 0 1000000000000
RG6 6 0 1000000000000
RG7 7 0 1000000000000
RG8 8 0 1000000000000
RG9 9 0 1000000000000
RG10 10 0 1000000000000
RG11 11 0 1000000000000
RG12 12 0 1000000000000
RG13 13 0 1000000000000
RG14 14 0 1000000000000
RG15 15 0 1000000000000
RG16 16 0 1000000000000
RG17 17 0 1000000000000
RG18 18 0 1000000000000
RG19 19 0 1000000000000
RG20 20 0 1000000000000
RG21 21 0 1000000000000
RG22 22 0 1000000000000
VS0 12 s0 0
L0 s0 18 10e-5
VS1 11 s1 0
R1 s1 8 39e-2
VS2 19 s2 0
L2 s2 6 39e-5
VS3 0 s3 0
V3 e3 s3 DC 0 AC 82e0 180
RI3 e3 m3 10e-2
LI3 m3 6 39e-6
VS4 20 s4 0
L4 s4 9 82e-2
VS5 15 s5 0
R5 s5 21 15e0
VS6 6 s6 0
C6 s6 2 15e-4
VS7 17 s7 0
V7 e7 s7 DC 0 AC 22e0 180
RI7 e7 22 27e-3
VS8 16 s8 0
R8 s8 2 82e-1
VS9 16 s9 0
C9 s9 22 33e-5
VS10 22 s10 0
V10 e10 s10 DC 0 AC 56e1 0
RI10 e10 m10 39e-2
LI10 m10 6 82e-6
VS11 20 s11 0
C11 s11 15 27e-5
VS12 8 s12 0
R12 s12 0 47e1
VS13 7 s13 0
R13 s13 4 47e0
VS14 11 s14 0
V14 e14 s14 DC 0 AC 22e1 120
RI14 e14 3 68e-1
VS15 3 s15 0
R15 s15 7 56e-1
VS16 17 s16 0
R16 s16 14 68e-1
VS17 15 s17 0
C17 s17 10 68e-6
VS18 1 s18 0
V18 e18 s18 DC 0 AC 68e0 0
RI18 e18 12 39e-1
VS19 18 s19 0
V19 e19 s19 DC 0 AC 68e0 0
RI19 e19 m19 27e-2
LI19 m19 15 10e-5
VS20 3 s20 0
R20 s20 9 27e1
VS21 3 s21 0
L21 s21 13 68e-2
VS22 5 s22 0
L22 s22 20 68e-3
VS23 5 s23 0
R23 s23 21 33e0
VS24 7 s24 0
C24 s24 4 10e-4
VS25 7 s25 0
R25 s25 1 12e2
VS26 10 s26 0
C26 s26 19 15e-6
VS27 8 s27 0
V27 e27 s27 DC 0 AC 39e-1 120
RI27 e27 m27 56e-3
LI27 m27 20 10e-6
VS28 6 s28 0
R28 s28 14 15e1
VS29 4 s29 0
R29 s29 13 47e3
VS30 8 s30 0
V30 e30 s30 DC 0 AC 82e-1 180
RI30 e30 m30 47e-3
LI30 m30 7 47e-5
VS31 0 s31 0
V31 e31 s31 DC 0 AC 33e0 180
RI31 e31 4 12e-1
VS32 19 s32 0
V32 e32 s32 DC 0 AC 18e1 -120
RI32 e32 m32 56e-3
LI32 m32 15 15e-7
VS33 2 s33 0
R33 s33 6 39e0
VS34 22 s34 0
L34 s34 9 10e-3
VS35 14 s35 0
L35 s35 15 47e-2
.control
set numdgt=17
ac lin 1 60 60
print v(1) v(2) v(3) v(4) v(5) v(6) v(7) v(8) v(9) v(10)
print v(11) v(12) v(13) v(14) v(15) v(16) v(17) v(18) v(19) v(20)
print v(21) v(22)
print i(vs0) i(vs1) i(vs2) i(vs3) i(vs4) i(vs5) i(vs6) i(vs7) i(vs8) i(vs9)
print i(vs10) i(vs11) i(vs12) i(vs13) i(vs14) i(vs15) i(vs16) i(vs17) i(vs18) i(vs19)
print i(vs20) i(vs21) i(vs22) i(vs23) i(vs24) i(vs25) i(vs26) i(vs27) i(vs28) i(vs29)
print i(vs30) i(vs31) i(vs32) i(vs33) i(vs34) i(vs35)
.endc
.end
