controls oracle ac-0329
* Generated (plan F2.7, ADR 0012): do not edit; regenerate with `pnpm sim oracle regen`. ac seed 20261031 index 329 nodes 23 elements 25
.options sparse gmin=1e-12 noopac
RG1 1 0 1000000000000
RG2 2 0 1000000000000
RG3 3 0 1000000000000
RG4 4 0 1000000000000
RG5 5 0 1000000000000
RG6 6 0 1000000000000
RG7 7 0 1000000000000
RG8 8 0 1000000000000
RG9 9 0 1000000000000
RG10 10 0 1000000000000
RG11 11 0 1000000000000
RG12 12 0 1000000000000
RG13 13 0 1000000000000
RG14 14 0 1000000000000
RG15 15 0 1000000000000
RG16 16 0 1000000000000
RG17 17 0 1000000000000
RG18 18 0 1000000000000
RG19 19 0 1000000000000
RG20 20 0 1000000000000
RG21 21 0 1000000000000
RG22 22 0 1000000000000
VS0 8 s0 0
C0 s0 20 12e-7
VS1 13 s1 0
L1 s1 18 18e-2
VS2 17 s2 0
L2 s2 6 10e-4
VS3 22 s3 0
R3 s3 1 15e-1
VS4 8 s4 0
C4 s4 2 22e-7
VS5 22 s5 0
L5 s5 11 27e-3
VS6 7 s6 0
R6 s6 0 56e-1
VS7 0 s7 0
V7 e7 s7 DC 0 AC 15e-1 -120
RI7 e7 13 22e-2
VS8 10 s8 0
R8 s8 7 47e0
VS9 20 s9 0
R9 s9 15 82e-2
VS10 8 s10 0
V10 e10 s10 DC 0 AC 39e-1 120
RI10 e10 20 56e-3
VS11 11 s11 0
L11 s11 5 27e-4
VS12 22 s12 0
L12 s12 7 10e-3
VS13 21 s13 0
L13 s13 0 12e-4
VS14 20 s14 0
L14 s14 19 68e-3
VS15 6 s15 0
V15 e15 s15 DC 0 AC 12e-1 -120
RI15 e15 7 15e-1
VS16 16 s16 0
V16 e16 s16 DC 0 AC 18e1 -120
RI16 e16 0 33e-3
VS17 0 s17 0
R17 s17 12 39e-2
VS18 4 s18 0
R18 s18 8 56e3
VS19 19 s19 0
R19 s19 0 18e2
VS20 20 s20 0
L20 s20 7 82e-2
VS21 1 s21 0
R21 s21 7 82e1
VS22 13 s22 0
V22 e22 s22 DC 0 AC 15e1 0
RI22 e22 9 39e-2
VS23 14 s23 0
V23 e23 s23 DC 0 AC 12e1 180
RI23 e23 22 33e-2
VS24 0 s24 0
C24 s24 3 56e-7
.control
set numdgt=17
ac lin 1 60 60
print v(1) v(2) v(3) v(4) v(5) v(6) v(7) v(8) v(9) v(10)
print v(11) v(12) v(13) v(14) v(15) v(16) v(17) v(18) v(19) v(20)
print v(21) v(22)
print i(vs0) i(vs1) i(vs2) i(vs3) i(vs4) i(vs5) i(vs6) i(vs7) i(vs8) i(vs9)
print i(vs10) i(vs11) i(vs12) i(vs13) i(vs14) i(vs15) i(vs16) i(vs17) i(vs18) i(vs19)
print i(vs20) i(vs21) i(vs22) i(vs23) i(vs24)
.endc
.end
