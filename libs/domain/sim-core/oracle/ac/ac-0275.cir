controls oracle ac-0275
* Generated (plan F2.7, ADR 0012): do not edit; regenerate with `pnpm sim oracle regen`. ac seed 20261031 index 275 nodes 15 elements 31
.options sparse gmin=1e-12 noopac
RG1 1 0 1000000000000
RG2 2 0 1000000000000
RG3 3 0 1000000000000
RG4 4 0 1000000000000
RG5 5 0 1000000000000
RG6 6 0 1000000000000
RG7 7 0 1000000000000
RG8 8 0 1000000000000
RG9 9 0 1000000000000
RG10 10 0 1000000000000
RG11 11 0 1000000000000
RG12 12 0 1000000000000
RG13 13 0 1000000000000
RG14 14 0 1000000000000
VS0 8 s0 0
C0 s0 1 15e-7
VS1 11 s1 0
L1 s1 4 47e-2
VS2 0 s2 0
L2 s2 14 12e-5
VS3 14 s3 0
R3 s3 10 68e1
VS4 0 s4 0
V4 e4 s4 DC 0 AC 33e-1 0
RI4 e4 5 39e-2
VS5 2 s5 0
L5 s5 3 10e-3
VS6 12 s6 0
L6 s6 10 15e-3
VS7 2 s7 0
C7 s7 11 12e-7
VS8 3 s8 0
R8 s8 12 56e2
VS9 14 s9 0
R9 s9 6 47e3
VS10 8 s10 0
L10 s10 4 47e-2
VS11 8 s11 0
L11 s11 12 12e-2
VS12 7 s12 0
L12 s12 9 22e-3
VS13 3 s13 0
V13 e13 s13 DC 0 AC 27e0 180
RI13 e13 m13 56e-1
LI13 m13 5 15e-6
VS14 6 s14 0
R14 s14 3 10e-2
VS15 1 s15 0
L15 s15 12 22e-3
VS16 12 s16 0
R16 s16 1 10e-1
VS17 7 s17 0
V17 e17 s17 DC 0 AC 33e-1 0
RI17 e17 m17 12e-1
LI17 m17 8 15e-7
VS18 4 s18 0
L18 s18 2 39e-5
VS19 4 s19 0
L19 s19 1 15e-3
VS20 13 s20 0
R20 s20 3 15e-2
VS21 0 s21 0
L21 s21 14 56e-3
VS22 12 s22 0
C22 s22 11 18e-5
VS23 9 s23 0
R23 s23 13 33e-1
VS24 3 s24 0
R24 s24 12 22e-1
VS25 3 s25 0
L25 s25 0 18e-4
VS26 1 s26 0
V26 e26 s26 DC 0 AC 82e1 0
RI26 e26 m26 56e-2
LI26 m26 8 10e-6
VS27 13 s27 0
R27 s27 14 27e2
VS28 14 s28 0
C28 s28 2 56e-7
VS29 3 s29 0
R29 s29 1 33e3
VS30 7 s30 0
R30 s30 0 10e-1
.control
set numdgt=17
ac lin 1 60 60
print v(1) v(2) v(3) v(4) v(5) v(6) v(7) v(8) v(9) v(10)
print v(11) v(12) v(13) v(14)
print i(vs0) i(vs1) i(vs2) i(vs3) i(vs4) i(vs5) i(vs6) i(vs7) i(vs8) i(vs9)
print i(vs10) i(vs11) i(vs12) i(vs13) i(vs14) i(vs15) i(vs16) i(vs17) i(vs18) i(vs19)
print i(vs20) i(vs21) i(vs22) i(vs23) i(vs24) i(vs25) i(vs26) i(vs27) i(vs28) i(vs29)
print i(vs30)
.endc
.end
