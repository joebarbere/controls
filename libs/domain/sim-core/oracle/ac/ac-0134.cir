controls oracle ac-0134
* Generated (plan F2.7, ADR 0012): do not edit; regenerate with `pnpm sim oracle regen`. ac seed 20261031 index 134 nodes 4 elements 6
.options sparse gmin=1e-12 noopac
RG1 1 0 1000000000000
RG2 2 0 1000000000000
RG3 3 0 1000000000000
VS0 2 s0 0
L0 s0 0 68e-3
VS1 0 s1 0
V1 e1 s1 DC 0 AC 27e1 120
RI1 e1 2 39e-1
VS2 0 s2 0
L2 s2 1 47e-3
VS3 3 s3 0
V3 e3 s3 DC 0 AC 27e1 120
RI3 e3 0 12e-1
VS4 3 s4 0
R4 s4 2 39e-1
VS5 1 s5 0
R5 s5 2 56e-2
.control
set numdgt=17
ac lin 1 60 60
print v(1) v(2) v(3)
print i(vs0) i(vs1) i(vs2) i(vs3) i(vs4) i(vs5)
.endc
.end
