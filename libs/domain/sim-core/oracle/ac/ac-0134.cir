controls oracle ac-0134
* Generated (plan F2.7, ADR 0012): do not edit; regenerate with `pnpm sim oracle regen`. ac seed 20261031 index 134 nodes 4 elements 5
.options sparse gmin=1e-12 noopac
RG1 1 0 1000000000000
RG2 2 0 1000000000000
RG3 3 0 1000000000000
VS0 0 s0 0
V0 e0 s0 DC 0 AC 27e1 120
RI0 e0 2 12e-1
VS1 3 s1 0
L1 s1 2 68e-3
VS2 0 s2 0
R2 s2 3 39e-1
VS3 2 s3 0
V3 e3 s3 DC 0 AC 27e1 120
RI3 e3 3 39e-1
VS4 1 s4 0
R4 s4 3 56e-2
.control
set numdgt=17
ac lin 1 60 60
print v(1) v(2) v(3)
print i(vs0) i(vs1) i(vs2) i(vs3) i(vs4)
.endc
.end
