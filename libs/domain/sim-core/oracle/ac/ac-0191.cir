controls oracle ac-0191
* Generated (plan F2.7, ADR 0012): do not edit; regenerate with `pnpm sim oracle regen`. ac seed 20261031 index 191 nodes 9 elements 12
.options sparse gmin=1e-12 noopac
RG1 1 0 1000000000000
RG2 2 0 1000000000000
RG3 3 0 1000000000000
RG4 4 0 1000000000000
RG5 5 0 1000000000000
RG6 6 0 1000000000000
RG7 7 0 1000000000000
RG8 8 0 1000000000000
VS0 6 s0 0
C0 s0 8 22e-6
VS1 1 s1 0
L1 s1 4 33e-2
VS2 5 s2 0
L2 s2 2 18e-5
VS3 2 s3 0
R3 s3 3 27e-2
VS4 0 s4 0
V4 e4 s4 DC 0 AC 82e-1 -120
RI4 e4 m4 68e-2
LI4 m4 n4 22e-7
H4 n4 h4 VS7 68e-4
ED4 h4 6 d4 0 -27e-5
F4 0 d4 VS7 1
LD4 d4 0 1
VS5 2 s5 0
C5 s5 8 10e-5
VS6 4 s6 0
R6 s6 7 10e2
VS7 4 s7 0
V7 e7 s7 DC 0 AC 56e1 0
RI7 e7 m7 27e-3
LI7 m7 n7 15e-5
H7 n7 h7 VS4 68e-4
ED7 h7 2 d7 0 -27e-5
F7 0 d7 VS4 1
LD7 d7 0 1
VS8 1 s8 0
R8 s8 3 15e2
VS9 6 s9 0
R9 s9 5 10e-1
VS10 3 s10 0
L10 s10 7 56e-3
VS11 3 s11 0
V11 e11 s11 DC 0 AC 68e-1 120
RI11 e11 0 47e-3
.control
set numdgt=17
ac lin 1 60 60
print v(1) v(2) v(3) v(4) v(5) v(6) v(7) v(8)
print i(vs0) i(vs1) i(vs2) i(vs3) i(vs4) i(vs5) i(vs6) i(vs7) i(vs8) i(vs9)
print i(vs10) i(vs11)
.endc
.end
