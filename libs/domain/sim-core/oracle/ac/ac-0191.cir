controls oracle ac-0191
* Generated (plan F2.7, ADR 0012): do not edit; regenerate with `pnpm sim oracle regen`. ac seed 20261031 index 191 nodes 9 elements 14
.options sparse gmin=1e-12 noopac
RG1 1 0 1000000000000
RG2 2 0 1000000000000
RG3 3 0 1000000000000
RG4 4 0 1000000000000
RG5 5 0 1000000000000
RG6 6 0 1000000000000
RG7 7 0 1000000000000
RG8 8 0 1000000000000
VS0 4 s0 0
R0 s0 5 27e3
VS1 2 s1 0
L1 s1 8 56e-2
VS2 8 s2 0
C2 s2 0 82e-4
VS3 0 s3 0
V3 e3 s3 DC 0 AC 68e-1 120
RI3 e3 2 47e-3
VS4 3 s4 0
V4 e4 s4 DC 0 AC 56e-1 180
RI4 e4 8 68e-3
VS5 4 s5 0
V5 e5 s5 DC 0 AC 56e0 120
RI5 e5 m5 12e-3
LI5 m5 7 12e-7
VS6 1 s6 0
R6 s6 0 15e2
VS7 6 s7 0
C7 s7 2 56e-6
VS8 3 s8 0
R8 s8 0 27e-2
VS9 5 s9 0
L9 s9 3 18e-5
VS10 5 s10 0
L10 s10 6 39e-5
VS11 1 s11 0
L11 s11 4 12e-3
VS12 4 s12 0
R12 s12 7 10e2
VS13 0 s13 0
L13 s13 7 56e-3
.control
set numdgt=17
ac lin 1 60 60
print v(1) v(2) v(3) v(4) v(5) v(6) v(7) v(8)
print i(vs0) i(vs1) i(vs2) i(vs3) i(vs4) i(vs5) i(vs6) i(vs7) i(vs8) i(vs9)
print i(vs10) i(vs11) i(vs12) i(vs13)
.endc
.end
