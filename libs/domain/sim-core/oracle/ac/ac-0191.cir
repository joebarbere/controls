controls oracle ac-0191
* Generated (plan F2.7, ADR 0012): do not edit; regenerate with `pnpm sim oracle regen`. ac seed 20261031 index 191 nodes 9 elements 9
.options sparse gmin=1e-12 noopac
RG1 1 0 1000000000000
RG2 2 0 1000000000000
RG3 3 0 1000000000000
RG4 4 0 1000000000000
RG5 5 0 1000000000000
RG6 6 0 1000000000000
RG7 7 0 1000000000000
RG8 8 0 1000000000000
VS0 0 s0 0
V0 e0 s0 DC 0 AC 82e-1 -120
RI0 e0 6 68e-2
VS1 6 s1 0
R1 s1 5 10e-1
VS2 6 s2 0
C2 s2 8 22e-6
VS3 1 s3 0
R3 s3 3 15e2
VS4 3 s4 0
L4 s4 7 56e-3
VS5 5 s5 0
L5 s5 2 18e-5
VS6 2 s6 0
R6 s6 3 27e-2
VS7 3 s7 0
V7 e7 s7 DC 0 AC 68e-1 120
RI7 e7 0 47e-3
VS8 4 s8 0
R8 s8 7 10e2
.control
set numdgt=17
ac lin 1 60 60
print v(1) v(2) v(3) v(4) v(5) v(6) v(7) v(8)
print i(vs0) i(vs1) i(vs2) i(vs3) i(vs4) i(vs5) i(vs6) i(vs7) i(vs8)
.endc
.end
