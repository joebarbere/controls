controls oracle ac-0273
* Generated (plan F2.7, ADR 0012): do not edit; regenerate with `pnpm sim oracle regen`. ac seed 20261031 index 273 nodes 16 elements 25
.options sparse gmin=1e-12 noopac
RG1 1 0 1000000000000
RG2 2 0 1000000000000
RG3 3 0 1000000000000
RG4 4 0 1000000000000
RG5 5 0 1000000000000
RG6 6 0 1000000000000
RG7 7 0 1000000000000
RG8 8 0 1000000000000
RG9 9 0 1000000000000
RG10 10 0 1000000000000
RG11 11 0 1000000000000
RG12 12 0 1000000000000
RG13 13 0 1000000000000
RG14 14 0 1000000000000
RG15 15 0 1000000000000
VS0 1 s0 0
R0 s0 5 33e3
VS1 8 s1 0
R1 s1 9 33e2
VS2 5 s2 0
R2 s2 6 56e-2
VS3 11 s3 0
L3 s3 15 18e-3
VS4 7 s4 0
R4 s4 8 68e-1
VS5 3 s5 0
R5 s5 5 68e2
VS6 2 s6 0
L6 s6 0 22e-2
VS7 0 s7 0
V7 e7 s7 DC 0 AC 68e1 180
RI7 e7 m7 10e-1
LI7 m7 14 47e-6
VS8 3 s8 0
C8 s8 4 82e-5
VS9 8 s9 0
R9 s9 3 68e-1
VS10 10 s10 0
R10 s10 0 27e3
VS11 8 s11 0
R11 s11 10 68e-1
VS12 9 s12 0
R12 s12 6 15e-1
VS13 13 s13 0
R13 s13 10 27e0
VS14 5 s14 0
C14 s14 4 27e-4
VS15 3 s15 0
C15 s15 12 82e-6
VS16 9 s16 0
R16 s16 7 33e-2
VS17 12 s17 0
C17 s17 0 33e-7
VS18 15 s18 0
V18 e18 s18 DC 0 AC 12e1 -120
RI18 e18 14 56e-1
VS19 8 s19 0
L19 s19 14 39e-3
VS20 11 s20 0
C20 s20 1 15e-6
VS21 13 s21 0
L21 s21 0 12e-3
VS22 3 s22 0
R22 s22 2 27e-2
VS23 5 s23 0
C23 s23 15 12e-4
VS24 3 s24 0
L24 s24 0 82e-5
.control
set numdgt=17
ac lin 1 60 60
print v(1) v(2) v(3) v(4) v(5) v(6) v(7) v(8) v(9) v(10)
print v(11) v(12) v(13) v(14) v(15)
print i(vs0) i(vs1) i(vs2) i(vs3) i(vs4) i(vs5) i(vs6) i(vs7) i(vs8) i(vs9)
print i(vs10) i(vs11) i(vs12) i(vs13) i(vs14) i(vs15) i(vs16) i(vs17) i(vs18) i(vs19)
print i(vs20) i(vs21) i(vs22) i(vs23) i(vs24)
.endc
.end
