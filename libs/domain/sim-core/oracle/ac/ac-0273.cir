controls oracle ac-0273
* Generated (plan F2.7, ADR 0012): do not edit; regenerate with `pnpm sim oracle regen`. ac seed 20261031 index 273 nodes 16 elements 18
.options sparse gmin=1e-12 noopac
RG1 1 0 1000000000000
RG2 2 0 1000000000000
RG3 3 0 1000000000000
RG4 4 0 1000000000000
RG5 5 0 1000000000000
RG6 6 0 1000000000000
RG7 7 0 1000000000000
RG8 8 0 1000000000000
RG9 9 0 1000000000000
RG10 10 0 1000000000000
RG11 11 0 1000000000000
RG12 12 0 1000000000000
RG13 13 0 1000000000000
RG14 14 0 1000000000000
RG15 15 0 1000000000000
VS0 13 s0 0
L0 s0 0 12e-3
VS1 3 s1 0
C1 s1 12 82e-6
VS2 11 s2 0
L2 s2 15 18e-3
VS3 8 s3 0
L3 s3 14 39e-3
VS4 8 s4 0
R4 s4 9 33e2
VS5 2 s5 0
L5 s5 0 22e-2
VS6 9 s6 0
R6 s6 7 33e-2
VS7 3 s7 0
L7 s7 0 82e-5
VS8 9 s8 0
R8 s8 6 15e-1
VS9 3 s9 0
R9 s9 5 68e2
VS10 10 s10 0
R10 s10 0 27e3
VS11 5 s11 0
C11 s11 4 27e-4
VS12 1 s12 0
R12 s12 5 33e3
VS13 5 s13 0
C13 s13 15 12e-4
VS14 8 s14 0
R14 s14 3 68e-1
VS15 5 s15 0
R15 s15 6 56e-2
VS16 0 s16 0
V16 e16 s16 DC 0 AC 68e1 180
RI16 e16 14 10e-1
VS17 8 s17 0
R17 s17 10 68e-1
.control
set numdgt=17
ac lin 1 60 60
print v(1) v(2) v(3) v(4) v(5) v(6) v(7) v(8) v(9) v(10)
print v(11) v(12) v(13) v(14) v(15)
print i(vs0) i(vs1) i(vs2) i(vs3) i(vs4) i(vs5) i(vs6) i(vs7) i(vs8) i(vs9)
print i(vs10) i(vs11) i(vs12) i(vs13) i(vs14) i(vs15) i(vs16) i(vs17)
.endc
.end
