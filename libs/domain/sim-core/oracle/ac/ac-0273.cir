controls oracle ac-0273
* Generated (plan F2.7, ADR 0012): do not edit; regenerate with `pnpm sim oracle regen`. ac seed 20261031 index 273 nodes 16 elements 24
.options sparse gmin=1e-12 noopac
RG1 1 0 1000000000000
RG2 2 0 1000000000000
RG3 3 0 1000000000000
RG4 4 0 1000000000000
RG5 5 0 1000000000000
RG6 6 0 1000000000000
RG7 7 0 1000000000000
RG8 8 0 1000000000000
RG9 9 0 1000000000000
RG10 10 0 1000000000000
RG11 11 0 1000000000000
RG12 12 0 1000000000000
RG13 13 0 1000000000000
RG14 14 0 1000000000000
RG15 15 0 1000000000000
VS0 3 s0 0
C0 s0 12 82e-6
VS1 5 s1 0
C1 s1 15 12e-4
VS2 2 s2 0
L2 s2 0 22e-2
VS3 5 s3 0
R3 s3 6 56e-2
VS4 13 s4 0
L4 s4 0 12e-3
VS5 10 s5 0
R5 s5 0 27e3
VS6 5 s6 0
C6 s6 4 27e-4
VS7 8 s7 0
R7 s7 9 33e2
VS8 0 s8 0
V8 e8 s8 DC 0 AC 68e1 180
RI8 e8 m8 10e-1
LI8 m8 14 27e-7
VS9 7 s9 0
R9 s9 11 27e0
VS10 9 s10 0
R10 s10 7 33e-2
VS11 4 s11 0
R11 s11 13 27e-2
VS12 4 s12 0
R12 s12 2 68e-1
VS13 1 s13 0
R13 s13 5 33e3
VS14 3 s14 0
R14 s14 5 68e2
VS15 12 s15 0
C15 s15 0 33e-7
VS16 3 s16 0
L16 s16 0 82e-5
VS17 8 s17 0
R17 s17 3 68e-1
VS18 9 s18 0
R18 s18 6 15e-1
VS19 4 s19 0
V19 e19 s19 DC 0 AC 56e1 180
RI19 e19 m19 12e-1
LI19 m19 11 56e-5
VS20 11 s20 0
L20 s20 15 18e-3
VS21 8 s21 0
R21 s21 10 68e-1
VS22 8 s22 0
L22 s22 14 39e-3
VS23 3 s23 0
C23 s23 1 82e-5
.control
set numdgt=17
ac lin 1 60 60
print v(1) v(2) v(3) v(4) v(5) v(6) v(7) v(8) v(9) v(10)
print v(11) v(12) v(13) v(14) v(15)
print i(vs0) i(vs1) i(vs2) i(vs3) i(vs4) i(vs5) i(vs6) i(vs7) i(vs8) i(vs9)
print i(vs10) i(vs11) i(vs12) i(vs13) i(vs14) i(vs15) i(vs16) i(vs17) i(vs18) i(vs19)
print i(vs20) i(vs21) i(vs22) i(vs23)
.endc
.end
