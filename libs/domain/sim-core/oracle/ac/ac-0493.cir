controls oracle ac-0493
* Generated (plan F2.7, ADR 0012): do not edit; regenerate with `pnpm sim oracle regen`. ac seed 20261031 index 493 nodes 14 elements 24
.options sparse gmin=1e-12 noopac
RG1 1 0 1000000000000
RG2 2 0 1000000000000
RG3 3 0 1000000000000
RG4 4 0 1000000000000
RG5 5 0 1000000000000
RG6 6 0 1000000000000
RG7 7 0 1000000000000
RG8 8 0 1000000000000
RG9 9 0 1000000000000
RG10 10 0 1000000000000
RG11 11 0 1000000000000
RG12 12 0 1000000000000
RG13 13 0 1000000000000
VS0 0 s0 0
L0 s0 13 47e-2
VS1 9 s1 0
R1 s1 0 27e3
VS2 0 s2 0
C2 s2 6 18e-7
VS3 2 s3 0
R3 s3 4 82e2
VS4 6 s4 0
R4 s4 4 27e1
VS5 0 s5 0
V5 e5 s5 DC 0 AC 56e0 0
RI5 e5 m5 10e-2
LI5 m5 n5 18e-5
H5 n5 h5 VS6 33e-3
ED5 h5 11 d5 0 18e-5
F5 0 d5 VS6 1
LD5 d5 0 1
VS6 6 s6 0
V6 e6 s6 DC 0 AC 18e0 120
RI6 e6 n6 68e-1
H6 n6 h6 VS5 33e-3
ED6 h6 3 d6 0 18e-5
F6 0 d6 VS5 1
LD6 d6 0 1
VS7 5 s7 0
L7 s7 8 27e-2
VS8 8 s8 0
V8 e8 s8 DC 0 AC 12e1 -120
RI8 e8 13 68e-1
VS9 12 s9 0
L9 s9 4 56e-5
VS10 7 s10 0
L10 s10 9 27e-4
VS11 7 s11 0
C11 s11 1 33e-4
VS12 0 s12 0
C12 s12 12 10e-4
VS13 11 s13 0
C13 s13 4 47e-6
VS14 3 s14 0
C14 s14 10 15e-6
VS15 9 s15 0
R15 s15 1 12e0
VS16 2 s16 0
R16 s16 10 56e-2
VS17 11 s17 0
R17 s17 2 82e2
VS18 10 s18 0
R18 s18 9 47e2
VS19 10 s19 0
R19 s19 13 47e-2
VS20 5 s20 0
V20 e20 s20 DC 0 AC 10e-1 120
RI20 e20 6 39e-2
VS21 4 s21 0
R21 s21 3 39e-1
VS22 11 s22 0
R22 s22 6 47e1
VS23 0 s23 0
L23 s23 1 39e-5
.control
set numdgt=17
ac lin 1 60 60
print v(1) v(2) v(3) v(4) v(5) v(6) v(7) v(8) v(9) v(10)
print v(11) v(12) v(13)
print i(vs0) i(vs1) i(vs2) i(vs3) i(vs4) i(vs5) i(vs6) i(vs7) i(vs8) i(vs9)
print i(vs10) i(vs11) i(vs12) i(vs13) i(vs14) i(vs15) i(vs16) i(vs17) i(vs18) i(vs19)
print i(vs20) i(vs21) i(vs22) i(vs23)
.endc
.end
