controls oracle ac-0493
* Generated (plan F2.7, ADR 0012): do not edit; regenerate with `pnpm sim oracle regen`. ac seed 20261031 index 493 nodes 14 elements 23
.options sparse gmin=1e-12 noopac
RG1 1 0 1000000000000
RG2 2 0 1000000000000
RG3 3 0 1000000000000
RG4 4 0 1000000000000
RG5 5 0 1000000000000
RG6 6 0 1000000000000
RG7 7 0 1000000000000
RG8 8 0 1000000000000
RG9 9 0 1000000000000
RG10 10 0 1000000000000
RG11 11 0 1000000000000
RG12 12 0 1000000000000
RG13 13 0 1000000000000
VS0 1 s0 0
C0 s0 12 10e-4
VS1 4 s1 0
R1 s1 3 39e-1
VS2 11 s2 0
C2 s2 4 47e-6
VS3 7 s3 0
C3 s3 5 33e-4
VS4 1 s4 0
L4 s4 5 39e-5
VS5 3 s5 0
C5 s5 10 15e-6
VS6 9 s6 0
R6 s6 5 12e0
VS7 11 s7 0
R7 s7 6 47e1
VS8 7 s8 0
L8 s8 9 27e-4
VS9 6 s9 0
R9 s9 4 27e1
VS10 2 s10 0
R10 s10 10 56e-2
VS11 0 s11 0
L11 s11 8 27e-2
VS12 0 s12 0
V12 e12 s12 DC 0 AC 10e-1 120
RI12 e12 6 39e-2
VS13 1 s13 0
C13 s13 6 18e-7
VS14 1 s14 0
V14 e14 s14 DC 0 AC 56e0 0
RI14 e14 11 10e-2
VS15 6 s15 0
V15 e15 s15 DC 0 AC 18e0 120
RI15 e15 3 68e-1
VS16 11 s16 0
R16 s16 2 82e2
VS17 8 s17 0
V17 e17 s17 DC 0 AC 12e1 -120
RI17 e17 13 68e-1
VS18 2 s18 0
R18 s18 4 82e2
VS19 10 s19 0
R19 s19 9 47e2
VS20 1 s20 0
L20 s20 13 47e-2
VS21 10 s21 0
R21 s21 13 47e-2
VS22 9 s22 0
R22 s22 1 27e3
.control
set numdgt=17
ac lin 1 60 60
print v(1) v(2) v(3) v(4) v(5) v(6) v(7) v(8) v(9) v(10)
print v(11) v(12) v(13)
print i(vs0) i(vs1) i(vs2) i(vs3) i(vs4) i(vs5) i(vs6) i(vs7) i(vs8) i(vs9)
print i(vs10) i(vs11) i(vs12) i(vs13) i(vs14) i(vs15) i(vs16) i(vs17) i(vs18) i(vs19)
print i(vs20) i(vs21) i(vs22)
.endc
.end
