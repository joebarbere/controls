controls oracle ac-0493
* Generated (plan F2.7, ADR 0012): do not edit; regenerate with `pnpm sim oracle regen`. ac seed 20261031 index 493 nodes 14 elements 20
.options sparse gmin=1e-12 noopac
RG1 1 0 1000000000000
RG2 2 0 1000000000000
RG3 3 0 1000000000000
RG4 4 0 1000000000000
RG5 5 0 1000000000000
RG6 6 0 1000000000000
RG7 7 0 1000000000000
RG8 8 0 1000000000000
RG9 9 0 1000000000000
RG10 10 0 1000000000000
RG11 11 0 1000000000000
RG12 12 0 1000000000000
RG13 13 0 1000000000000
VS0 7 s0 0
L0 s0 3 68e-4
VS1 0 s1 0
V1 e1 s1 DC 0 AC 22e1 180
RI1 e1 m1 10e-3
LI1 m1 2 47e-7
VS2 3 s2 0
L2 s2 4 33e-4
VS3 2 s3 0
L3 s3 3 22e-2
VS4 13 s4 0
R4 s4 10 82e1
VS5 1 s5 0
L5 s5 13 47e-2
VS6 2 s6 0
L6 s6 10 39e-2
VS7 7 s7 0
R7 s7 5 39e1
VS8 9 s8 0
R8 s8 13 33e-1
VS9 6 s9 0
V9 e9 s9 DC 0 AC 18e0 120
RI9 e9 m9 68e-1
LI9 m9 3 82e-5
VS10 2 s10 0
V10 e10 s10 DC 0 AC 18e-1 180
RI10 e10 m10 82e-2
LI10 m10 9 39e-5
VS11 11 s11 0
L11 s11 3 18e-4
VS12 4 s12 0
L12 s12 12 82e-5
VS13 6 s13 0
V13 e13 s13 DC 0 AC 39e-1 -120
RI13 e13 m13 27e-1
LI13 m13 12 27e-5
VS14 1 s14 0
C14 s14 6 18e-7
VS15 7 s15 0
R15 s15 11 68e3
VS16 8 s16 0
V16 e16 s16 DC 0 AC 12e0 120
RI16 e16 11 82e-1
VS17 0 s17 0
V17 e17 s17 DC 0 AC 10e-1 120
RI17 e17 6 39e-2
VS18 1 s18 0
L18 s18 5 39e-5
VS19 8 s19 0
C19 s19 4 68e-4
.control
set numdgt=17
ac lin 1 60 60
print v(1) v(2) v(3) v(4) v(5) v(6) v(7) v(8) v(9) v(10)
print v(11) v(12) v(13)
print i(vs0) i(vs1) i(vs2) i(vs3) i(vs4) i(vs5) i(vs6) i(vs7) i(vs8) i(vs9)
print i(vs10) i(vs11) i(vs12) i(vs13) i(vs14) i(vs15) i(vs16) i(vs17) i(vs18) i(vs19)
.endc
.end
