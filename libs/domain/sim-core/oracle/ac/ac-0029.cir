controls oracle ac-0029
* Generated (plan F2.7, ADR 0012): do not edit; regenerate with `pnpm sim oracle regen`. ac seed 20261031 index 29 nodes 7 elements 8
.options sparse gmin=1e-12 noopac
RG1 1 0 1000000000000
RG2 2 0 1000000000000
RG3 3 0 1000000000000
RG4 4 0 1000000000000
RG5 5 0 1000000000000
RG6 6 0 1000000000000
VS0 0 s0 0
V0 e0 s0 DC 0 AC 10e-1 120
RI0 e0 5 12e-2
VS1 1 s1 0
C1 s1 0 68e-7
VS2 5 s2 0
L2 s2 6 33e-4
VS3 0 s3 0
R3 s3 2 33e2
VS4 4 s4 0
R4 s4 2 22e-1
VS5 3 s5 0
R5 s5 6 47e1
VS6 5 s6 0
L6 s6 4 22e-5
VS7 0 s7 0
L7 s7 3 18e-4
.control
set numdgt=17
ac lin 1 60 60
print v(1) v(2) v(3) v(4) v(5) v(6)
print i(vs0) i(vs1) i(vs2) i(vs3) i(vs4) i(vs5) i(vs6) i(vs7)
.endc
.end
