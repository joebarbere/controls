controls oracle ac-0029
* Generated (plan F2.7, ADR 0012): do not edit; regenerate with `pnpm sim oracle regen`. ac seed 20261031 index 29 nodes 7 elements 9
.options sparse gmin=1e-12 noopac
RG1 1 0 1000000000000
RG2 2 0 1000000000000
RG3 3 0 1000000000000
RG4 4 0 1000000000000
RG5 5 0 1000000000000
RG6 6 0 1000000000000
VS0 3 s0 0
R0 s0 6 47e1
VS1 0 s1 0
V1 e1 s1 DC 0 AC 12e0 -120
RI1 e1 3 22e-1
VS2 5 s2 0
V2 e2 s2 DC 0 AC 10e-1 120
RI2 e2 m2 12e-2
LI2 m2 2 10e-5
VS3 2 s3 0
V3 e3 s3 DC 0 AC 82e-1 120
RI3 e3 m3 10e-1
LI3 m3 4 47e-7
VS4 2 s4 0
L4 s4 6 33e-4
VS5 6 s5 0
L5 s5 1 10e-3
VS6 5 s6 0
V6 e6 s6 DC 0 AC 56e0 120
RI6 e6 m6 56e-3
LI6 m6 4 56e-5
VS7 0 s7 0
R7 s7 4 33e1
VS8 1 s8 0
C8 s8 2 39e-6
.control
set numdgt=17
ac lin 1 60 60
print v(1) v(2) v(3) v(4) v(5) v(6)
print i(vs0) i(vs1) i(vs2) i(vs3) i(vs4) i(vs5) i(vs6) i(vs7) i(vs8)
.endc
.end
