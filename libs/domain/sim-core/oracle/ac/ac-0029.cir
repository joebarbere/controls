controls oracle ac-0029
* Generated (plan F2.7, ADR 0012): do not edit; regenerate with `pnpm sim oracle regen`. ac seed 20261031 index 29 nodes 7 elements 9
.options sparse gmin=1e-12 noopac
RG1 1 0 1000000000000
RG2 2 0 1000000000000
RG3 3 0 1000000000000
RG4 4 0 1000000000000
RG5 5 0 1000000000000
RG6 6 0 1000000000000
VS0 5 s0 0
L0 s0 4 22e-5
VS1 0 s1 0
V1 e1 s1 DC 0 AC 10e-1 120
RI1 e1 5 12e-2
VS2 1 s2 0
C2 s2 0 68e-7
VS3 5 s3 0
L3 s3 6 33e-4
VS4 3 s4 0
R4 s4 6 47e1
VS5 5 s5 0
R5 s5 1 56e-2
VS6 4 s6 0
R6 s6 2 22e-1
VS7 0 s7 0
R7 s7 2 33e2
VS8 0 s8 0
L8 s8 3 18e-4
.control
set numdgt=17
ac lin 1 60 60
print v(1) v(2) v(3) v(4) v(5) v(6)
print i(vs0) i(vs1) i(vs2) i(vs3) i(vs4) i(vs5) i(vs6) i(vs7) i(vs8)
.endc
.end
