controls oracle ac-0209
* Generated (plan F2.7, ADR 0012): do not edit; regenerate with `pnpm sim oracle regen`. ac seed 20261031 index 209 nodes 11 elements 13
.options sparse gmin=1e-12 noopac
RG1 1 0 1000000000000
RG2 2 0 1000000000000
RG3 3 0 1000000000000
RG4 4 0 1000000000000
RG5 5 0 1000000000000
RG6 6 0 1000000000000
RG7 7 0 1000000000000
RG8 8 0 1000000000000
RG9 9 0 1000000000000
RG10 10 0 1000000000000
VS0 0 s0 0
V0 e0 s0 DC 0 AC 27e-1 0
RI0 e0 4 18e-3
VS1 9 s1 0
V1 e1 s1 DC 0 AC 10e-1 120
RI1 e1 2 22e-1
VS2 7 s2 0
R2 s2 10 18e-2
VS3 10 s3 0
R3 s3 6 12e1
VS4 6 s4 0
R4 s4 3 56e2
VS5 5 s5 0
L5 s5 1 18e-4
VS6 10 s6 0
R6 s6 4 56e3
VS7 5 s7 0
C7 s7 10 33e-4
VS8 9 s8 0
R8 s8 4 56e3
VS9 8 s9 0
L9 s9 9 33e-5
VS10 0 s10 0
C10 s10 1 82e-7
VS11 4 s11 0
C11 s11 8 56e-5
VS12 6 s12 0
V12 e12 s12 DC 0 AC 22e-1 120
RI12 e12 8 82e-3
.control
set numdgt=17
ac lin 1 60 60
print v(1) v(2) v(3) v(4) v(5) v(6) v(7) v(8) v(9) v(10)
print i(vs0) i(vs1) i(vs2) i(vs3) i(vs4) i(vs5) i(vs6) i(vs7) i(vs8) i(vs9)
print i(vs10) i(vs11) i(vs12)
.endc
.end
