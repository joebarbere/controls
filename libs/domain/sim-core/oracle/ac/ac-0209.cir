controls oracle ac-0209
* Generated (plan F2.7, ADR 0012): do not edit; regenerate with `pnpm sim oracle regen`. ac seed 20261031 index 209 nodes 11 elements 16
.options sparse gmin=1e-12 noopac
RG1 1 0 1000000000000
RG2 2 0 1000000000000
RG3 3 0 1000000000000
RG4 4 0 1000000000000
RG5 5 0 1000000000000
RG6 6 0 1000000000000
RG7 7 0 1000000000000
RG8 8 0 1000000000000
RG9 9 0 1000000000000
RG10 10 0 1000000000000
VS0 6 s0 0
R0 s0 3 56e2
VS1 0 s1 0
V1 e1 s1 DC 0 AC 39e0 0
RI1 e1 m1 22e-3
LI1 m1 n1 12e-5
H1 n1 h1 VS4 -39e-4
ED1 h1 2 d1 0 68e-6
F1 0 d1 VS4 1
LD1 d1 0 1
VS2 7 s2 0
R2 s2 10 18e-2
VS3 5 s3 0
L3 s3 1 18e-4
VS4 6 s4 0
V4 e4 s4 DC 0 AC 22e-1 120
RI4 e4 n4 82e-3
H4 n4 h4 VS1 -39e-4
ED4 h4 8 d4 0 68e-6
F4 0 d4 VS1 1
LD4 d4 0 1
VS5 10 s5 0
R5 s5 4 56e3
VS6 0 s6 0
V6 e6 s6 DC 0 AC 27e-1 0
RI6 e6 m6 18e-3
LI6 m6 4 33e-7
VS7 7 s7 0
C7 s7 6 82e-5
VS8 5 s8 0
C8 s8 10 33e-4
VS9 4 s9 0
C9 s9 8 56e-5
VS10 9 s10 0
V10 e10 s10 DC 0 AC 10e-1 120
RI10 e10 2 22e-1
VS11 0 s11 0
C11 s11 1 82e-7
VS12 9 s12 0
R12 s12 4 56e3
VS13 10 s13 0
R13 s13 6 12e1
VS14 3 s14 0
V14 e14 s14 DC 0 AC 56e-1 0
RI14 e14 m14 39e-1
LI14 m14 8 68e-7
VS15 8 s15 0
L15 s15 9 33e-5
.control
set numdgt=17
ac lin 1 60 60
print v(1) v(2) v(3) v(4) v(5) v(6) v(7) v(8) v(9) v(10)
print i(vs0) i(vs1) i(vs2) i(vs3) i(vs4) i(vs5) i(vs6) i(vs7) i(vs8) i(vs9)
print i(vs10) i(vs11) i(vs12) i(vs13) i(vs14) i(vs15)
.endc
.end
