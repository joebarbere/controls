controls oracle ac-0066
* Generated (plan F2.7, ADR 0012): do not edit; regenerate with `pnpm sim oracle regen`. ac seed 20261031 index 66 nodes 13 elements 23
.options sparse gmin=1e-12 noopac
RG1 1 0 1000000000000
RG2 2 0 1000000000000
RG3 3 0 1000000000000
RG4 4 0 1000000000000
RG5 5 0 1000000000000
RG6 6 0 1000000000000
RG7 7 0 1000000000000
RG8 8 0 1000000000000
RG9 9 0 1000000000000
RG10 10 0 1000000000000
RG11 11 0 1000000000000
RG12 12 0 1000000000000
VS0 2 s0 0
L0 s0 11 10e-2
VS1 10 s1 0
R1 s1 2 27e3
VS2 7 s2 0
L2 s2 12 47e-2
VS3 0 s3 0
V3 e3 s3 DC 0 AC 68e-1 180
RI3 e3 m3 18e-1
LI3 m3 n3 47e-7
H3 n3 h3 VS7 22e-3
ED3 h3 1 d3 0 47e-7
F3 0 d3 VS7 1
LD3 d3 0 1
VS4 6 s4 0
R4 s4 3 82e0
VS5 4 s5 0
R5 s5 7 15e3
VS6 7 s6 0
L6 s6 5 82e-5
VS7 11 s7 0
V7 e7 s7 DC 0 AC 22e-1 180
RI7 e7 n7 56e-2
H7 n7 h7 VS3 22e-3
ED7 h7 4 d7 0 47e-7
F7 0 d7 VS3 1
LD7 d7 0 1
VS8 11 s8 0
R8 s8 1 39e3
VS9 7 s9 0
L9 s9 12 27e-5
VS10 5 s10 0
C10 s10 3 47e-4
VS11 9 s11 0
C11 s11 0 47e-6
VS12 11 s12 0
L12 s12 3 33e-3
VS13 8 s13 0
V13 e13 s13 DC 0 AC 10e1 -120
RI13 e13 10 12e-3
VS14 1 s14 0
R14 s14 12 22e3
VS15 12 s15 0
C15 s15 5 18e-4
VS16 10 s16 0
R16 s16 2 10e-2
VS17 11 s17 0
L17 s17 6 18e-5
VS18 8 s18 0
V18 e18 s18 DC 0 AC 22e1 120
RI18 e18 m18 15e-1
LI18 m18 11 33e-5
VS19 10 s19 0
C19 s19 4 39e-7
VS20 9 s20 0
V20 e20 s20 DC 0 AC 68e0 0
RI20 e20 5 22e-3
VS21 9 s21 0
R21 s21 1 82e-2
VS22 7 s22 0
C22 s22 0 82e-5
.control
set numdgt=17
ac lin 1 60 60
print v(1) v(2) v(3) v(4) v(5) v(6) v(7) v(8) v(9) v(10)
print v(11) v(12)
print i(vs0) i(vs1) i(vs2) i(vs3) i(vs4) i(vs5) i(vs6) i(vs7) i(vs8) i(vs9)
print i(vs10) i(vs11) i(vs12) i(vs13) i(vs14) i(vs15) i(vs16) i(vs17) i(vs18) i(vs19)
print i(vs20) i(vs21) i(vs22)
.endc
.end
