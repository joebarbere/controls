controls oracle ac-0066
* Generated (plan F2.7, ADR 0012): do not edit; regenerate with `pnpm sim oracle regen`. ac seed 20261031 index 66 nodes 13 elements 19
.options sparse gmin=1e-12 noopac
RG1 1 0 1000000000000
RG2 2 0 1000000000000
RG3 3 0 1000000000000
RG4 4 0 1000000000000
RG5 5 0 1000000000000
RG6 6 0 1000000000000
RG7 7 0 1000000000000
RG8 8 0 1000000000000
RG9 9 0 1000000000000
RG10 10 0 1000000000000
RG11 11 0 1000000000000
RG12 12 0 1000000000000
VS0 5 s0 0
L0 s0 0 15e-4
VS1 3 s1 0
L1 s1 11 22e-3
VS2 6 s2 0
L2 s2 1 82e-3
VS3 12 s3 0
L3 s3 7 12e-4
VS4 6 s4 0
L4 s4 10 56e-3
VS5 0 s5 0
R5 s5 12 27e1
VS6 8 s6 0
C6 s6 2 27e-6
VS7 0 s7 0
V7 e7 s7 DC 0 AC 47e-1 0
RI7 e7 2 82e-1
VS8 9 s8 0
C8 s8 11 22e-7
VS9 2 s9 0
C9 s9 3 47e-4
VS10 12 s10 0
C10 s10 5 15e-4
VS11 11 s11 0
L11 s11 6 22e-5
VS12 9 s12 0
V12 e12 s12 DC 0 AC 68e0 0
RI12 e12 m12 22e-3
LI12 m12 2 15e-6
VS13 4 s13 0
L13 s13 6 68e-2
VS14 1 s14 0
C14 s14 8 33e-6
VS15 7 s15 0
L15 s15 2 82e-5
VS16 11 s16 0
R16 s16 4 82e2
VS17 4 s17 0
C17 s17 10 22e-4
VS18 3 s18 0
C18 s18 7 33e-7
.control
set numdgt=17
ac lin 1 60 60
print v(1) v(2) v(3) v(4) v(5) v(6) v(7) v(8) v(9) v(10)
print v(11) v(12)
print i(vs0) i(vs1) i(vs2) i(vs3) i(vs4) i(vs5) i(vs6) i(vs7) i(vs8) i(vs9)
print i(vs10) i(vs11) i(vs12) i(vs13) i(vs14) i(vs15) i(vs16) i(vs17) i(vs18)
.endc
.end
