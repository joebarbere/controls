controls oracle ac-0164
* Generated (plan F2.7, ADR 0012): do not edit; regenerate with `pnpm sim oracle regen`. ac seed 20261031 index 164 nodes 19 elements 33
.options sparse gmin=1e-12 noopac
RG1 1 0 1000000000000
RG2 2 0 1000000000000
RG3 3 0 1000000000000
RG4 4 0 1000000000000
RG5 5 0 1000000000000
RG6 6 0 1000000000000
RG7 7 0 1000000000000
RG8 8 0 1000000000000
RG9 9 0 1000000000000
RG10 10 0 1000000000000
RG11 11 0 1000000000000
RG12 12 0 1000000000000
RG13 13 0 1000000000000
RG14 14 0 1000000000000
RG15 15 0 1000000000000
RG16 16 0 1000000000000
RG17 17 0 1000000000000
RG18 18 0 1000000000000
VS0 5 s0 0
R0 s0 17 47e-1
VS1 12 s1 0
L1 s1 6 47e-3
VS2 15 s2 0
R2 s2 1 15e-1
VS3 7 s3 0
L3 s3 3 47e-4
VS4 5 s4 0
L4 s4 10 27e-5
VS5 0 s5 0
V5 e5 s5 DC 0 AC 22e-1 0
RI5 e5 11 56e-2
VS6 6 s6 0
C6 s6 5 22e-6
VS7 18 s7 0
L7 s7 3 39e-4
VS8 11 s8 0
R8 s8 9 18e2
VS9 15 s9 0
V9 e9 s9 DC 0 AC 27e0 120
RI9 e9 2 15e-1
VS10 4 s10 0
R10 s10 0 82e2
VS11 12 s11 0
R11 s11 13 33e1
VS12 13 s12 0
R12 s12 7 68e-2
VS13 2 s13 0
L13 s13 13 22e-3
VS14 16 s14 0
V14 e14 s14 DC 0 AC 27e0 180
RI14 e14 9 15e-3
VS15 5 s15 0
R15 s15 0 27e-2
VS16 9 s16 0
L16 s16 5 27e-4
VS17 18 s17 0
R17 s17 7 82e2
VS18 9 s18 0
L18 s18 14 82e-5
VS19 15 s19 0
R19 s19 16 22e1
VS20 9 s20 0
R20 s20 13 39e-2
VS21 9 s21 0
V21 e21 s21 DC 0 AC 56e1 0
RI21 e21 15 10e-3
VS22 3 s22 0
V22 e22 s22 DC 0 AC 33e-1 180
RI22 e22 5 18e-1
VS23 10 s23 0
R23 s23 15 12e-2
VS24 2 s24 0
R24 s24 7 12e3
VS25 11 s25 0
L25 s25 9 68e-4
VS26 8 s26 0
L26 s26 0 68e-4
VS27 0 s27 0
C27 s27 5 47e-7
VS28 0 s28 0
C28 s28 13 27e-5
VS29 14 s29 0
R29 s29 1 33e1
VS30 8 s30 0
V30 e30 s30 DC 0 AC 15e1 180
RI30 e30 m30 10e-3
LI30 m30 2 22e-5
VS31 4 s31 0
L31 s31 5 27e-2
VS32 16 s32 0
C32 s32 17 56e-6
.control
set numdgt=17
ac lin 1 60 60
print v(1) v(2) v(3) v(4) v(5) v(6) v(7) v(8) v(9) v(10)
print v(11) v(12) v(13) v(14) v(15) v(16) v(17) v(18)
print i(vs0) i(vs1) i(vs2) i(vs3) i(vs4) i(vs5) i(vs6) i(vs7) i(vs8) i(vs9)
print i(vs10) i(vs11) i(vs12) i(vs13) i(vs14) i(vs15) i(vs16) i(vs17) i(vs18) i(vs19)
print i(vs20) i(vs21) i(vs22) i(vs23) i(vs24) i(vs25) i(vs26) i(vs27) i(vs28) i(vs29)
print i(vs30) i(vs31) i(vs32)
.endc
.end
