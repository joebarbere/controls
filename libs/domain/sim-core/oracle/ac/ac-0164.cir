controls oracle ac-0164
* Generated (plan F2.7, ADR 0012): do not edit; regenerate with `pnpm sim oracle regen`. ac seed 20261031 index 164 nodes 19 elements 32
.options sparse gmin=1e-12 noopac
RG1 1 0 1000000000000
RG2 2 0 1000000000000
RG3 3 0 1000000000000
RG4 4 0 1000000000000
RG5 5 0 1000000000000
RG6 6 0 1000000000000
RG7 7 0 1000000000000
RG8 8 0 1000000000000
RG9 9 0 1000000000000
RG10 10 0 1000000000000
RG11 11 0 1000000000000
RG12 12 0 1000000000000
RG13 13 0 1000000000000
RG14 14 0 1000000000000
RG15 15 0 1000000000000
RG16 16 0 1000000000000
RG17 17 0 1000000000000
RG18 18 0 1000000000000
VS0 3 s0 0
R0 s0 17 47e-1
VS1 17 s1 0
R1 s1 1 47e-2
VS2 15 s2 0
C2 s2 13 10e-7
VS3 0 s3 0
V3 e3 s3 DC 0 AC 33e-1 180
RI3 e3 m3 18e-1
LI3 m3 3 33e-5
VS4 18 s4 0
C4 s4 0 27e-4
VS5 3 s5 0
L5 s5 0 15e-5
VS6 18 s6 0
C6 s6 8 82e-6
VS7 9 s7 0
L7 s7 3 27e-4
VS8 9 s8 0
L8 s8 14 82e-5
VS9 3 s9 0
V9 e9 s9 DC 0 AC 12e0 180
RI9 e9 m9 47e-1
LI9 m9 11 33e-7
VS10 13 s10 0
V10 e10 s10 DC 0 AC 68e-1 0
RI10 e10 8 15e-1
VS11 5 s11 0
V11 e11 s11 DC 0 AC 22e-1 180
RI11 e11 m11 10e-2
LI11 m11 11 68e-5
VS12 14 s12 0
C12 s12 3 18e-5
VS13 2 s13 0
V13 e13 s13 DC 0 AC 10e1 120
RI13 e13 m13 47e-2
LI13 m13 17 47e-7
VS14 14 s14 0
V14 e14 s14 DC 0 AC 22e1 0
RI14 e14 5 12e-2
VS15 4 s15 0
V15 e15 s15 DC 0 AC 82e1 -120
RI15 e15 m15 47e-2
LI15 m15 11 68e-6
VS16 2 s16 0
V16 e16 s16 DC 0 AC 27e0 120
RI16 e16 9 15e-1
VS17 3 s17 0
C17 s17 13 15e-4
VS18 10 s18 0
V18 e18 s18 DC 0 AC 33e1 -120
RI18 e18 7 22e-3
VS19 17 s19 0
V19 e19 s19 DC 0 AC 68e1 120
RI19 e19 2 18e-3
VS20 6 s20 0
R20 s20 15 39e1
VS21 12 s21 0
V21 e21 s21 DC 0 AC 33e1 0
RI21 e21 11 33e-3
VS22 10 s22 0
C22 s22 14 33e-4
VS23 0 s23 0
R23 s23 4 82e-1
VS24 17 s24 0
L24 s24 7 56e-2
VS25 3 s25 0
V25 e25 s25 DC 0 AC 27e1 0
RI25 e25 m25 68e-3
LI25 m25 16 39e-7
VS26 0 s26 0
V26 e26 s26 DC 0 AC 68e1 0
RI26 e26 m26 18e-1
LI26 m26 12 15e-7
VS27 11 s27 0
R27 s27 7 27e-2
VS28 0 s28 0
C28 s28 6 18e-5
VS29 0 s29 0
L29 s29 7 12e-4
VS30 14 s30 0
C30 s30 1 27e-4
VS31 14 s31 0
L31 s31 16 33e-5
.control
set numdgt=17
ac lin 1 60 60
print v(1) v(2) v(3) v(4) v(5) v(6) v(7) v(8) v(9) v(10)
print v(11) v(12) v(13) v(14) v(15) v(16) v(17) v(18)
print i(vs0) i(vs1) i(vs2) i(vs3) i(vs4) i(vs5) i(vs6) i(vs7) i(vs8) i(vs9)
print i(vs10) i(vs11) i(vs12) i(vs13) i(vs14) i(vs15) i(vs16) i(vs17) i(vs18) i(vs19)
print i(vs20) i(vs21) i(vs22) i(vs23) i(vs24) i(vs25) i(vs26) i(vs27) i(vs28) i(vs29)
print i(vs30) i(vs31)
.endc
.end
