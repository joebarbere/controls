controls oracle ac-0498
* Generated (plan F2.7, ADR 0012): do not edit; regenerate with `pnpm sim oracle regen`. ac seed 20261031 index 498 nodes 18 elements 28
.options sparse gmin=1e-12 noopac
RG1 1 0 1000000000000
RG2 2 0 1000000000000
RG3 3 0 1000000000000
RG4 4 0 1000000000000
RG5 5 0 1000000000000
RG6 6 0 1000000000000
RG7 7 0 1000000000000
RG8 8 0 1000000000000
RG9 9 0 1000000000000
RG10 10 0 1000000000000
RG11 11 0 1000000000000
RG12 12 0 1000000000000
RG13 13 0 1000000000000
RG14 14 0 1000000000000
RG15 15 0 1000000000000
RG16 16 0 1000000000000
RG17 17 0 1000000000000
VS0 17 s0 0
R0 s0 2 27e2
VS1 17 s1 0
C1 s1 11 15e-7
VS2 3 s2 0
R2 s2 7 39e-2
VS3 9 s3 0
L3 s3 2 47e-5
VS4 0 s4 0
R4 s4 10 15e0
VS5 0 s5 0
V5 e5 s5 DC 0 AC 15e1 -120
RI5 e5 m5 12e-2
LI5 m5 7 82e-5
VS6 6 s6 0
R6 s6 16 39e0
VS7 6 s7 0
V7 e7 s7 DC 0 AC 56e-1 -120
RI7 e7 m7 27e-1
LI7 m7 12 82e-6
VS8 3 s8 0
R8 s8 1 15e-1
VS9 10 s9 0
L9 s9 7 39e-4
VS10 8 s10 0
R10 s10 12 47e0
VS11 7 s11 0
L11 s11 14 18e-3
VS12 16 s12 0
C12 s12 13 22e-6
VS13 16 s13 0
V13 e13 s13 DC 0 AC 10e-1 -120
RI13 e13 11 33e-3
VS14 15 s14 0
V14 e14 s14 DC 0 AC 56e0 -120
RI14 e14 11 56e-3
VS15 17 s15 0
V15 e15 s15 DC 0 AC 12e-1 -120
RI15 e15 m15 10e-3
LI15 m15 16 22e-5
VS16 3 s16 0
R16 s16 5 33e-1
VS17 10 s17 0
R17 s17 8 39e0
VS18 16 s18 0
R18 s18 7 10e-2
VS19 12 s19 0
L19 s19 5 15e-5
VS20 17 s20 0
L20 s20 5 68e-2
VS21 1 s21 0
R21 s21 17 22e2
VS22 14 s22 0
R22 s22 5 82e-2
VS23 4 s23 0
L23 s23 10 15e-2
VS24 3 s24 0
R24 s24 16 39e2
VS25 4 s25 0
R25 s25 13 33e1
VS26 9 s26 0
R26 s26 3 33e-2
VS27 15 s27 0
L27 s27 8 22e-5
.control
set numdgt=17
ac lin 1 60 60
print v(1) v(2) v(3) v(4) v(5) v(6) v(7) v(8) v(9) v(10)
print v(11) v(12) v(13) v(14) v(15) v(16) v(17)
print i(vs0) i(vs1) i(vs2) i(vs3) i(vs4) i(vs5) i(vs6) i(vs7) i(vs8) i(vs9)
print i(vs10) i(vs11) i(vs12) i(vs13) i(vs14) i(vs15) i(vs16) i(vs17) i(vs18) i(vs19)
print i(vs20) i(vs21) i(vs22) i(vs23) i(vs24) i(vs25) i(vs26) i(vs27)
.endc
.end
