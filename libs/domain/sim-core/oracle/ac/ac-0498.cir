controls oracle ac-0498
* Generated (plan F2.7, ADR 0012): do not edit; regenerate with `pnpm sim oracle regen`. ac seed 20261031 index 498 nodes 18 elements 35
.options sparse gmin=1e-12 noopac
RG1 1 0 1000000000000
RG2 2 0 1000000000000
RG3 3 0 1000000000000
RG4 4 0 1000000000000
RG5 5 0 1000000000000
RG6 6 0 1000000000000
RG7 7 0 1000000000000
RG8 8 0 1000000000000
RG9 9 0 1000000000000
RG10 10 0 1000000000000
RG11 11 0 1000000000000
RG12 12 0 1000000000000
RG13 13 0 1000000000000
RG14 14 0 1000000000000
RG15 15 0 1000000000000
RG16 16 0 1000000000000
RG17 17 0 1000000000000
VS0 13 s0 0
R0 s0 16 22e2
VS1 4 s1 0
L1 s1 13 15e-5
VS2 12 s2 0
R2 s2 7 10e1
VS3 2 s3 0
C3 s3 17 47e-6
VS4 14 s4 0
R4 s4 16 33e1
VS5 1 s5 0
R5 s5 3 10e0
VS6 0 s6 0
V6 e6 s6 DC 0 AC 33e0 -120
RI6 e6 16 39e-3
VS7 11 s7 0
V7 e7 s7 DC 0 AC 47e0 0
RI7 e7 m7 68e-2
LI7 m7 2 18e-7
VS8 15 s8 0
V8 e8 s8 DC 0 AC 39e-1 120
RI8 e8 m8 10e-2
LI8 m8 17 27e-6
VS9 8 s9 0
R9 s9 9 56e3
VS10 3 s10 0
L10 s10 5 39e-4
VS11 12 s11 0
L11 s11 10 33e-2
VS12 8 s12 0
R12 s12 16 15e0
VS13 14 s13 0
V13 e13 s13 DC 0 AC 47e-1 120
RI13 e13 m13 18e-2
LI13 m13 11 12e-5
VS14 11 s14 0
C14 s14 0 15e-6
VS15 15 s15 0
L15 s15 2 47e-2
VS16 0 s16 0
V16 e16 s16 DC 0 AC 10e-1 -120
RI16 e16 m16 33e-3
LI16 m16 11 39e-6
VS17 14 s17 0
R17 s17 11 22e-2
VS18 16 s18 0
V18 e18 s18 DC 0 AC 56e-1 180
RI18 e18 m18 10e-1
LI18 m18 17 33e-5
VS19 4 s19 0
C19 s19 11 39e-7
VS20 0 s20 0
R20 s20 7 10e-2
VS21 17 s21 0
C21 s21 16 10e-5
VS22 6 s22 0
V22 e22 s22 DC 0 AC 39e-1 0
RI22 e22 m22 18e-2
LI22 m22 17 22e-7
VS23 3 s23 0
R23 s23 0 39e2
VS24 4 s24 0
L24 s24 17 39e-4
VS25 9 s25 0
R25 s25 3 82e2
VS26 5 s26 0
L26 s26 12 15e-2
VS27 11 s27 0
C27 s27 1 12e-6
VS28 4 s28 0
R28 s28 9 33e-2
VS29 0 s29 0
R29 s29 9 12e3
VS30 6 s30 0
R30 s30 0 39e0
VS31 6 s31 0
L31 s31 0 22e-4
VS32 10 s32 0
V32 e32 s32 DC 0 AC 39e0 180
RI32 e32 11 39e-1
VS33 4 s33 0
R33 s33 8 22e-2
VS34 13 s34 0
R34 s34 7 18e2
.control
set numdgt=17
ac lin 1 60 60
print v(1) v(2) v(3) v(4) v(5) v(6) v(7) v(8) v(9) v(10)
print v(11) v(12) v(13) v(14) v(15) v(16) v(17)
print i(vs0) i(vs1) i(vs2) i(vs3) i(vs4) i(vs5) i(vs6) i(vs7) i(vs8) i(vs9)
print i(vs10) i(vs11) i(vs12) i(vs13) i(vs14) i(vs15) i(vs16) i(vs17) i(vs18) i(vs19)
print i(vs20) i(vs21) i(vs22) i(vs23) i(vs24) i(vs25) i(vs26) i(vs27) i(vs28) i(vs29)
print i(vs30) i(vs31) i(vs32) i(vs33) i(vs34)
.endc
.end
