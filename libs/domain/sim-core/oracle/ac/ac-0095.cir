controls oracle ac-0095
* Generated (plan F2.7, ADR 0012): do not edit; regenerate with `pnpm sim oracle regen`. ac seed 20261031 index 95 nodes 26 elements 44
.options sparse gmin=1e-12 noopac
RG1 1 0 1000000000000
RG2 2 0 1000000000000
RG3 3 0 1000000000000
RG4 4 0 1000000000000
RG5 5 0 1000000000000
RG6 6 0 1000000000000
RG7 7 0 1000000000000
RG8 8 0 1000000000000
RG9 9 0 1000000000000
RG10 10 0 1000000000000
RG11 11 0 1000000000000
RG12 12 0 1000000000000
RG13 13 0 1000000000000
RG14 14 0 1000000000000
RG15 15 0 1000000000000
RG16 16 0 1000000000000
RG17 17 0 1000000000000
RG18 18 0 1000000000000
RG19 19 0 1000000000000
RG20 20 0 1000000000000
RG21 21 0 1000000000000
RG22 22 0 1000000000000
RG23 23 0 1000000000000
RG24 24 0 1000000000000
RG25 25 0 1000000000000
VS0 12 s0 0
L0 s0 0 82e-4
VS1 15 s1 0
R1 s1 9 39e1
VS2 14 s2 0
L2 s2 19 47e-2
VS3 21 s3 0
L3 s3 20 56e-5
VS4 20 s4 0
R4 s4 15 27e-2
VS5 9 s5 0
R5 s5 1 47e0
VS6 20 s6 0
R6 s6 9 18e0
VS7 9 s7 0
C7 s7 8 12e-4
VS8 0 s8 0
V8 e8 s8 DC 0 AC 33e0 180
RI8 e8 n8 15e-1
H8 n8 h8 VS9 -56e-3
ED8 h8 7 d8 0 -33e-6
F8 0 d8 VS9 1
LD8 d8 0 1
VS9 20 s9 0
V9 e9 s9 DC 0 AC 15e-1 0
RI9 e9 n9 10e-2
H9 n9 h9 VS8 -56e-3
ED9 h9 17 d9 0 -33e-6
F9 0 d9 VS8 1
LD9 d9 0 1
VS10 3 s10 0
L10 s10 7 22e-5
VS11 12 s11 0
R11 s11 22 22e2
VS12 10 s12 0
C12 s12 15 82e-4
VS13 12 s13 0
L13 s13 11 68e-4
VS14 4 s14 0
L14 s14 18 39e-4
VS15 25 s15 0
V15 e15 s15 DC 0 AC 39e1 0
RI15 e15 9 18e-2
VS16 6 s16 0
R16 s16 24 10e0
VS17 0 s17 0
R17 s17 20 82e1
VS18 19 s18 0
V18 e18 s18 DC 0 AC 12e-1 0
RI18 e18 m18 47e-1
LI18 m18 6 18e-5
VS19 10 s19 0
L19 s19 24 18e-2
VS20 4 s20 0
R20 s20 16 12e3
VS21 5 s21 0
C21 s21 2 33e-7
VS22 4 s22 0
V22 e22 s22 DC 0 AC 12e1 0
RI22 e22 7 12e-1
VS23 13 s23 0
C23 s23 2 47e-7
VS24 7 s24 0
V24 e24 s24 DC 0 AC 18e-1 -120
RI24 e24 0 10e-3
VS25 3 s25 0
C25 s25 23 18e-6
VS26 21 s26 0
C26 s26 8 47e-5
VS27 6 s27 0
C27 s27 25 82e-4
VS28 12 s28 0
V28 e28 s28 DC 0 AC 33e0 120
RI28 e28 m28 12e-1
LI28 m28 18 68e-5
VS29 1 s29 0
L29 s29 22 18e-5
VS30 1 s30 0
R30 s30 18 39e2
VS31 3 s31 0
V31 e31 s31 DC 0 AC 56e1 180
RI31 e31 m31 56e-3
LI31 m31 20 56e-6
VS32 10 s32 0
C32 s32 2 10e-5
VS33 12 s33 0
L33 s33 14 68e-2
VS34 17 s34 0
V34 e34 s34 DC 0 AC 82e1 120
RI34 e34 11 47e-3
VS35 2 s35 0
R35 s35 4 15e-1
VS36 11 s36 0
V36 e36 s36 DC 0 AC 47e0 -120
RI36 e36 m36 39e-3
LI36 m36 2 33e-5
VS37 16 s37 0
L37 s37 20 27e-2
VS38 13 s38 0
R38 s38 12 39e-2
VS39 6 s39 0
C39 s39 1 27e-6
VS40 15 s40 0
C40 s40 24 10e-6
VS41 7 s41 0
L41 s41 23 47e-3
VS42 2 s42 0
R42 s42 22 15e3
VS43 24 s43 0
L43 s43 5 47e-3
.control
set numdgt=17
ac lin 1 60 60
print v(1) v(2) v(3) v(4) v(5) v(6) v(7) v(8) v(9) v(10)
print v(11) v(12) v(13) v(14) v(15) v(16) v(17) v(18) v(19) v(20)
print v(21) v(22) v(23) v(24) v(25)
print i(vs0) i(vs1) i(vs2) i(vs3) i(vs4) i(vs5) i(vs6) i(vs7) i(vs8) i(vs9)
print i(vs10) i(vs11) i(vs12) i(vs13) i(vs14) i(vs15) i(vs16) i(vs17) i(vs18) i(vs19)
print i(vs20) i(vs21) i(vs22) i(vs23) i(vs24) i(vs25) i(vs26) i(vs27) i(vs28) i(vs29)
print i(vs30) i(vs31) i(vs32) i(vs33) i(vs34) i(vs35) i(vs36) i(vs37) i(vs38) i(vs39)
print i(vs40) i(vs41) i(vs42) i(vs43)
.endc
.end
