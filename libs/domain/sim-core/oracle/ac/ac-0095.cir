controls oracle ac-0095
* Generated (plan F2.7, ADR 0012): do not edit; regenerate with `pnpm sim oracle regen`. ac seed 20261031 index 95 nodes 26 elements 53
.options sparse gmin=1e-12 noopac
RG1 1 0 1000000000000
RG2 2 0 1000000000000
RG3 3 0 1000000000000
RG4 4 0 1000000000000
RG5 5 0 1000000000000
RG6 6 0 1000000000000
RG7 7 0 1000000000000
RG8 8 0 1000000000000
RG9 9 0 1000000000000
RG10 10 0 1000000000000
RG11 11 0 1000000000000
RG12 12 0 1000000000000
RG13 13 0 1000000000000
RG14 14 0 1000000000000
RG15 15 0 1000000000000
RG16 16 0 1000000000000
RG17 17 0 1000000000000
RG18 18 0 1000000000000
RG19 19 0 1000000000000
RG20 20 0 1000000000000
RG21 21 0 1000000000000
RG22 22 0 1000000000000
RG23 23 0 1000000000000
RG24 24 0 1000000000000
RG25 25 0 1000000000000
VS0 19 s0 0
C0 s0 20 39e-4
VS1 16 s1 0
C1 s1 3 15e-6
VS2 0 s2 0
V2 e2 s2 DC 0 AC 22e0 180
RI2 e2 8 82e-1
VS3 16 s3 0
C3 s3 13 10e-6
VS4 15 s4 0
V4 e4 s4 DC 0 AC 33e0 180
RI4 e4 7 15e-1
VS5 18 s5 0
L5 s5 6 47e-5
VS6 3 s6 0
L6 s6 17 27e-5
VS7 0 s7 0
R7 s7 3 15e1
VS8 3 s8 0
L8 s8 7 10e-4
VS9 20 s9 0
R9 s9 16 27e-2
VS10 11 s10 0
V10 e10 s10 DC 0 AC 10e1 0
RI10 e10 20 22e-3
VS11 20 s11 0
L11 s11 22 39e-4
VS12 7 s12 0
R12 s12 4 47e0
VS13 19 s13 0
L13 s13 20 56e-5
VS14 24 s14 0
L14 s14 10 82e-2
VS15 0 s15 0
V15 e15 s15 DC 0 AC 27e-1 0
RI15 e15 m15 27e-1
LI15 m15 15 39e-7
VS16 5 s16 0
V16 e16 s16 DC 0 AC 39e1 180
RI16 e16 12 33e-2
VS17 15 s17 0
V17 e17 s17 DC 0 AC 15e0 120
RI17 e17 9 56e-3
VS18 5 s18 0
C18 s18 23 12e-5
VS19 23 s19 0
C19 s19 10 56e-7
VS20 23 s20 0
R20 s20 3 22e2
VS21 23 s21 0
C21 s21 2 18e-5
VS22 6 s22 0
C22 s22 1 27e-6
VS23 10 s23 0
C23 s23 16 82e-4
VS24 14 s24 0
R24 s24 15 68e0
VS25 15 s25 0
R25 s25 18 47e3
VS26 16 s26 0
R26 s26 2 18e-2
VS27 15 s27 0
V27 e27 s27 DC 0 AC 82e1 0
RI27 e27 25 47e-2
VS28 8 s28 0
C28 s28 11 82e-4
VS29 23 s29 0
L29 s29 25 47e-2
VS30 8 s30 0
R30 s30 21 12e-2
VS31 10 s31 0
L31 s31 8 33e-3
VS32 22 s32 0
V32 e32 s32 DC 0 AC 15e-1 180
RI32 e32 m32 18e-2
LI32 m32 13 82e-5
VS33 19 s33 0
C33 s33 1 56e-5
VS34 6 s34 0
R34 s34 24 10e0
VS35 13 s35 0
R35 s35 21 10e-1
VS36 18 s36 0
R36 s36 1 15e-1
VS37 7 s37 0
L37 s37 17 68e-4
VS38 14 s38 0
L38 s38 3 18e-3
VS39 1 s39 0
R39 s39 18 39e2
VS40 20 s40 0
R40 s40 9 18e0
VS41 23 s41 0
L41 s41 10 22e-3
VS42 23 s42 0
L42 s42 16 10e-4
VS43 17 s43 0
C43 s43 4 33e-6
VS44 16 s44 0
C44 s44 24 10e-6
VS45 5 s45 0
R45 s45 21 22e3
VS46 6 s46 0
V46 e46 s46 DC 0 AC 15e-1 180
RI46 e46 m46 18e-2
LI46 m46 5 47e-5
VS47 12 s47 0
C47 s47 20 12e-4
VS48 25 s48 0
R48 s48 7 18e-1
VS49 3 s49 0
V49 e49 s49 DC 0 AC 18e0 0
RI49 e49 15 68e-3
VS50 2 s50 0
L50 s50 13 68e-5
VS51 15 s51 0
R51 s51 20 82e1
VS52 15 s52 0
L52 s52 12 47e-4
.control
set numdgt=17
ac lin 1 60 60
print v(1) v(2) v(3) v(4) v(5) v(6) v(7) v(8) v(9) v(10)
print v(11) v(12) v(13) v(14) v(15) v(16) v(17) v(18) v(19) v(20)
print v(21) v(22) v(23) v(24) v(25)
print i(vs0) i(vs1) i(vs2) i(vs3) i(vs4) i(vs5) i(vs6) i(vs7) i(vs8) i(vs9)
print i(vs10) i(vs11) i(vs12) i(vs13) i(vs14) i(vs15) i(vs16) i(vs17) i(vs18) i(vs19)
print i(vs20) i(vs21) i(vs22) i(vs23) i(vs24) i(vs25) i(vs26) i(vs27) i(vs28) i(vs29)
print i(vs30) i(vs31) i(vs32) i(vs33) i(vs34) i(vs35) i(vs36) i(vs37) i(vs38) i(vs39)
print i(vs40) i(vs41) i(vs42) i(vs43) i(vs44) i(vs45) i(vs46) i(vs47) i(vs48) i(vs49)
print i(vs50) i(vs51) i(vs52)
.endc
.end
