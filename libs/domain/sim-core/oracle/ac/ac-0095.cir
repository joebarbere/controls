controls oracle ac-0095
* Generated (plan F2.7, ADR 0012): do not edit; regenerate with `pnpm sim oracle regen`. ac seed 20261031 index 95 nodes 26 elements 40
.options sparse gmin=1e-12 noopac
RG1 1 0 1000000000000
RG2 2 0 1000000000000
RG3 3 0 1000000000000
RG4 4 0 1000000000000
RG5 5 0 1000000000000
RG6 6 0 1000000000000
RG7 7 0 1000000000000
RG8 8 0 1000000000000
RG9 9 0 1000000000000
RG10 10 0 1000000000000
RG11 11 0 1000000000000
RG12 12 0 1000000000000
RG13 13 0 1000000000000
RG14 14 0 1000000000000
RG15 15 0 1000000000000
RG16 16 0 1000000000000
RG17 17 0 1000000000000
RG18 18 0 1000000000000
RG19 19 0 1000000000000
RG20 20 0 1000000000000
RG21 21 0 1000000000000
RG22 22 0 1000000000000
RG23 23 0 1000000000000
RG24 24 0 1000000000000
RG25 25 0 1000000000000
VS0 0 s0 0
V0 e0 s0 DC 0 AC 33e0 120
RI0 e0 18 12e-1
VS1 6 s1 0
R1 s1 24 10e0
VS2 15 s2 0
R2 s2 20 82e1
VS3 7 s3 0
V3 e3 s3 DC 0 AC 18e-1 -120
RI3 e3 15 10e-3
VS4 4 s4 0
V4 e4 s4 DC 0 AC 12e1 0
RI4 e4 7 12e-1
VS5 19 s5 0
V5 e5 s5 DC 0 AC 12e-1 0
RI5 e5 6 47e-1
VS6 20 s6 0
V6 e6 s6 DC 0 AC 15e-1 0
RI6 e6 17 10e-2
VS7 10 s7 0
C7 s7 12 82e-4
VS8 12 s8 0
R8 s8 9 39e1
VS9 1 s9 0
R9 s9 18 39e2
VS10 3 s10 0
L10 s10 7 22e-5
VS11 16 s11 0
L11 s11 20 27e-2
VS12 24 s12 0
L12 s12 5 47e-3
VS13 4 s13 0
R13 s13 16 12e3
VS14 2 s14 0
R14 s14 22 15e3
VS15 11 s15 0
V15 e15 s15 DC 0 AC 47e0 -120
RI15 e15 2 39e-3
VS16 0 s16 0
R16 s16 22 22e2
VS17 7 s17 0
L17 s17 23 47e-3
VS18 25 s18 0
V18 e18 s18 DC 0 AC 39e1 0
RI18 e18 9 18e-2
VS19 2 s19 0
R19 s19 4 15e-1
VS20 15 s20 0
V20 e20 s20 DC 0 AC 33e0 180
RI20 e20 7 15e-1
VS21 0 s21 0
L21 s21 14 68e-2
VS22 0 s22 0
L22 s22 15 82e-4
VS23 12 s23 0
C23 s23 24 10e-6
VS24 1 s24 0
L24 s24 22 18e-5
VS25 3 s25 0
C25 s25 23 18e-6
VS26 4 s26 0
L26 s26 18 39e-4
VS27 10 s27 0
L27 s27 24 18e-2
VS28 20 s28 0
R28 s28 12 27e-2
VS29 20 s29 0
R29 s29 9 18e0
VS30 0 s30 0
L30 s30 11 68e-4
VS31 10 s31 0
C31 s31 2 10e-5
VS32 6 s32 0
C32 s32 25 82e-4
VS33 6 s33 0
C33 s33 1 27e-6
VS34 5 s34 0
C34 s34 2 33e-7
VS35 21 s35 0
L35 s35 20 56e-5
VS36 9 s36 0
C36 s36 8 12e-4
VS37 21 s37 0
C37 s37 8 47e-5
VS38 9 s38 0
R38 s38 1 47e0
VS39 13 s39 0
R39 s39 0 39e-2
.control
set numdgt=17
ac lin 1 60 60
print v(1) v(2) v(3) v(4) v(5) v(6) v(7) v(8) v(9) v(10)
print v(11) v(12) v(13) v(14) v(15) v(16) v(17) v(18) v(19) v(20)
print v(21) v(22) v(23) v(24) v(25)
print i(vs0) i(vs1) i(vs2) i(vs3) i(vs4) i(vs5) i(vs6) i(vs7) i(vs8) i(vs9)
print i(vs10) i(vs11) i(vs12) i(vs13) i(vs14) i(vs15) i(vs16) i(vs17) i(vs18) i(vs19)
print i(vs20) i(vs21) i(vs22) i(vs23) i(vs24) i(vs25) i(vs26) i(vs27) i(vs28) i(vs29)
print i(vs30) i(vs31) i(vs32) i(vs33) i(vs34) i(vs35) i(vs36) i(vs37) i(vs38) i(vs39)
.endc
.end
