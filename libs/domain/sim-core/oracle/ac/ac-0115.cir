controls oracle ac-0115
* Generated (plan F2.7, ADR 0012): do not edit; regenerate with `pnpm sim oracle regen`. ac seed 20261031 index 115 nodes 27 elements 43
.options sparse gmin=1e-12 noopac
RG1 1 0 1000000000000
RG2 2 0 1000000000000
RG3 3 0 1000000000000
RG4 4 0 1000000000000
RG5 5 0 1000000000000
RG6 6 0 1000000000000
RG7 7 0 1000000000000
RG8 8 0 1000000000000
RG9 9 0 1000000000000
RG10 10 0 1000000000000
RG11 11 0 1000000000000
RG12 12 0 1000000000000
RG13 13 0 1000000000000
RG14 14 0 1000000000000
RG15 15 0 1000000000000
RG16 16 0 1000000000000
RG17 17 0 1000000000000
RG18 18 0 1000000000000
RG19 19 0 1000000000000
RG20 20 0 1000000000000
RG21 21 0 1000000000000
RG22 22 0 1000000000000
RG23 23 0 1000000000000
RG24 24 0 1000000000000
RG25 25 0 1000000000000
RG26 26 0 1000000000000
VS0 11 s0 0
L0 s0 21 12e-4
VS1 4 s1 0
R1 s1 26 18e-1
VS2 0 s2 0
V2 e2 s2 DC 0 AC 47e1 120
RI2 e2 10 15e-1
VS3 12 s3 0
C3 s3 22 56e-4
VS4 18 s4 0
R4 s4 1 56e-2
VS5 16 s5 0
L5 s5 23 47e-2
VS6 8 s6 0
C6 s6 12 56e-5
VS7 23 s7 0
R7 s7 24 68e-2
VS8 4 s8 0
C8 s8 1 33e-7
VS9 5 s9 0
R9 s9 9 33e1
VS10 10 s10 0
R10 s10 21 15e-1
VS11 1 s11 0
C11 s11 14 15e-5
VS12 24 s12 0
L12 s12 12 18e-2
VS13 23 s13 0
R13 s13 7 22e3
VS14 4 s14 0
L14 s14 0 68e-2
VS15 0 s15 0
V15 e15 s15 DC 0 AC 27e1 -120
RI15 e15 4 39e-1
VS16 2 s16 0
L16 s16 19 47e-2
VS17 0 s17 0
R17 s17 6 12e2
VS18 23 s18 0
V18 e18 s18 DC 0 AC 27e1 120
RI18 e18 22 15e-2
VS19 16 s19 0
C19 s19 10 68e-5
VS20 1 s20 0
V20 e20 s20 DC 0 AC 15e0 -120
RI20 e20 12 33e-1
VS21 14 s21 0
L21 s21 9 18e-3
VS22 18 s22 0
C22 s22 1 47e-4
VS23 1 s23 0
R23 s23 7 10e-1
VS24 10 s24 0
L24 s24 22 10e-3
VS25 0 s25 0
L25 s25 10 22e-3
VS26 21 s26 0
R26 s26 19 22e1
VS27 16 s27 0
L27 s27 1 22e-2
VS28 1 s28 0
V28 e28 s28 DC 0 AC 47e1 120
RI28 e28 23 33e-2
VS29 7 s29 0
R29 s29 9 15e1
VS30 3 s30 0
R30 s30 19 68e0
VS31 13 s31 0
L31 s31 5 15e-4
VS32 20 s32 0
V32 e32 s32 DC 0 AC 82e-1 120
RI32 e32 9 33e-1
VS33 26 s33 0
L33 s33 20 47e-3
VS34 9 s34 0
C34 s34 14 56e-4
VS35 15 s35 0
V35 e35 s35 DC 0 AC 22e0 -120
RI35 e35 18 56e-1
VS36 7 s36 0
V36 e36 s36 DC 0 AC 27e1 -120
RI36 e36 17 33e-1
VS37 10 s37 0
V37 e37 s37 DC 0 AC 68e0 180
RI37 e37 25 18e-2
VS38 21 s38 0
R38 s38 13 82e-1
VS39 21 s39 0
R39 s39 17 56e-1
VS40 25 s40 0
L40 s40 5 82e-4
VS41 15 s41 0
C41 s41 0 56e-6
VS42 9 s42 0
L42 s42 8 82e-3
.control
set numdgt=17
ac lin 1 60 60
print v(1) v(2) v(3) v(4) v(5) v(6) v(7) v(8) v(9) v(10)
print v(11) v(12) v(13) v(14) v(15) v(16) v(17) v(18) v(19) v(20)
print v(21) v(22) v(23) v(24) v(25) v(26)
print i(vs0) i(vs1) i(vs2) i(vs3) i(vs4) i(vs5) i(vs6) i(vs7) i(vs8) i(vs9)
print i(vs10) i(vs11) i(vs12) i(vs13) i(vs14) i(vs15) i(vs16) i(vs17) i(vs18) i(vs19)
print i(vs20) i(vs21) i(vs22) i(vs23) i(vs24) i(vs25) i(vs26) i(vs27) i(vs28) i(vs29)
print i(vs30) i(vs31) i(vs32) i(vs33) i(vs34) i(vs35) i(vs36) i(vs37) i(vs38) i(vs39)
print i(vs40) i(vs41) i(vs42)
.endc
.end
