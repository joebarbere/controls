controls oracle ac-0115
* Generated (plan F2.7, ADR 0012): do not edit; regenerate with `pnpm sim oracle regen`. ac seed 20261031 index 115 nodes 27 elements 40
.options sparse gmin=1e-12 noopac
RG1 1 0 1000000000000
RG2 2 0 1000000000000
RG3 3 0 1000000000000
RG4 4 0 1000000000000
RG5 5 0 1000000000000
RG6 6 0 1000000000000
RG7 7 0 1000000000000
RG8 8 0 1000000000000
RG9 9 0 1000000000000
RG10 10 0 1000000000000
RG11 11 0 1000000000000
RG12 12 0 1000000000000
RG13 13 0 1000000000000
RG14 14 0 1000000000000
RG15 15 0 1000000000000
RG16 16 0 1000000000000
RG17 17 0 1000000000000
RG18 18 0 1000000000000
RG19 19 0 1000000000000
RG20 20 0 1000000000000
RG21 21 0 1000000000000
RG22 22 0 1000000000000
RG23 23 0 1000000000000
RG24 24 0 1000000000000
RG25 25 0 1000000000000
RG26 26 0 1000000000000
VS0 5 s0 0
R0 s0 1 12e1
VS1 0 s1 0
V1 e1 s1 DC 0 AC 56e1 0
RI1 e1 m1 82e-2
LI1 m1 4 15e-5
VS2 4 s2 0
L2 s2 13 12e-4
VS3 17 s3 0
C3 s3 4 56e-5
VS4 2 s4 0
R4 s4 19 18e0
VS5 0 s5 0
C5 s5 8 33e-5
VS6 6 s6 0
R6 s6 19 56e2
VS7 9 s7 0
C7 s7 10 39e-5
VS8 15 s8 0
R8 s8 4 15e0
VS9 7 s9 0
C9 s9 2 47e-6
VS10 10 s10 0
L10 s10 22 10e-3
VS11 3 s11 0
R11 s11 26 27e0
VS12 17 s12 0
C12 s12 14 47e-4
VS13 3 s13 0
C13 s13 8 47e-5
VS14 20 s14 0
R14 s14 24 12e-1
VS15 26 s15 0
R15 s15 25 47e3
VS16 6 s16 0
R16 s16 10 18e0
VS17 18 s17 0
L17 s17 4 68e-2
VS18 10 s18 0
V18 e18 s18 DC 0 AC 68e0 180
RI18 e18 m18 18e-2
LI18 m18 25 82e-7
VS19 11 s19 0
L19 s19 22 15e-3
VS20 17 s20 0
L20 s20 12 27e-2
VS21 20 s21 0
C21 s21 18 56e-6
VS22 1 s22 0
R22 s22 7 10e-1
VS23 13 s23 0
R23 s23 12 15e-1
VS24 15 s24 0
R24 s24 19 18e-1
VS25 12 s25 0
C25 s25 15 15e-5
VS26 18 s26 0
C26 s26 1 33e-7
VS27 4 s27 0
R27 s27 23 12e-2
VS28 9 s28 0
L28 s28 21 82e-5
VS29 8 s29 0
C29 s29 10 47e-5
VS30 3 s30 0
L30 s30 25 39e-4
VS31 11 s31 0
C31 s31 4 22e-6
VS32 16 s32 0
V32 e32 s32 DC 0 AC 68e1 120
RI32 e32 m32 56e-3
LI32 m32 21 27e-5
VS33 24 s33 0
L33 s33 26 12e-4
VS34 26 s34 0
V34 e34 s34 DC 0 AC 27e1 120
RI34 e34 m34 33e-3
LI34 m34 22 56e-5
VS35 14 s35 0
C35 s35 1 68e-4
VS36 4 s36 0
L36 s36 10 22e-3
VS37 12 s37 0
L37 s37 24 10e-5
VS38 5 s38 0
V38 e38 s38 DC 0 AC 18e1 -120
RI38 e38 16 18e-2
VS39 23 s39 0
V39 e39 s39 DC 0 AC 82e-1 0
RI39 e39 m39 22e-2
LI39 m39 26 27e-6
.control
set numdgt=17
ac lin 1 60 60
print v(1) v(2) v(3) v(4) v(5) v(6) v(7) v(8) v(9) v(10)
print v(11) v(12) v(13) v(14) v(15) v(16) v(17) v(18) v(19) v(20)
print v(21) v(22) v(23) v(24) v(25) v(26)
print i(vs0) i(vs1) i(vs2) i(vs3) i(vs4) i(vs5) i(vs6) i(vs7) i(vs8) i(vs9)
print i(vs10) i(vs11) i(vs12) i(vs13) i(vs14) i(vs15) i(vs16) i(vs17) i(vs18) i(vs19)
print i(vs20) i(vs21) i(vs22) i(vs23) i(vs24) i(vs25) i(vs26) i(vs27) i(vs28) i(vs29)
print i(vs30) i(vs31) i(vs32) i(vs33) i(vs34) i(vs35) i(vs36) i(vs37) i(vs38) i(vs39)
.endc
.end
