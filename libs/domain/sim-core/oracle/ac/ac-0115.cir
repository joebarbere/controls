controls oracle ac-0115
* Generated (plan F2.7, ADR 0012): do not edit; regenerate with `pnpm sim oracle regen`. ac seed 20261031 index 115 nodes 27 elements 47
.options sparse gmin=1e-12 noopac
RG1 1 0 1000000000000
RG2 2 0 1000000000000
RG3 3 0 1000000000000
RG4 4 0 1000000000000
RG5 5 0 1000000000000
RG6 6 0 1000000000000
RG7 7 0 1000000000000
RG8 8 0 1000000000000
RG9 9 0 1000000000000
RG10 10 0 1000000000000
RG11 11 0 1000000000000
RG12 12 0 1000000000000
RG13 13 0 1000000000000
RG14 14 0 1000000000000
RG15 15 0 1000000000000
RG16 16 0 1000000000000
RG17 17 0 1000000000000
RG18 18 0 1000000000000
RG19 19 0 1000000000000
RG20 20 0 1000000000000
RG21 21 0 1000000000000
RG22 22 0 1000000000000
RG23 23 0 1000000000000
RG24 24 0 1000000000000
RG25 25 0 1000000000000
RG26 26 0 1000000000000
VS0 10 s0 0
L0 s0 22 10e-3
VS1 0 s1 0
V1 e1 s1 DC 0 AC 27e1 -120
RI1 e1 17 33e-1
VS2 7 s2 0
L2 s2 4 68e-2
VS3 9 s3 0
L3 s3 8 82e-3
VS4 25 s4 0
L4 s4 5 82e-4
VS5 2 s5 0
L5 s5 9 10e-3
VS6 15 s6 0
C6 s6 4 56e-6
VS7 16 s7 0
L7 s7 1 22e-2
VS8 3 s8 0
R8 s8 20 10e-1
VS9 12 s9 0
C9 s9 22 56e-4
VS10 5 s10 0
R10 s10 6 10e-1
VS11 10 s11 0
V11 e11 s11 DC 0 AC 68e0 180
RI11 e11 25 18e-2
VS12 0 s12 0
R12 s12 9 15e1
VS13 24 s13 0
L13 s13 12 18e-2
VS14 13 s14 0
L14 s14 5 15e-4
VS15 7 s15 0
R15 s15 26 18e-1
VS16 26 s16 0
L16 s16 20 47e-3
VS17 8 s17 0
C17 s17 12 56e-5
VS18 1 s18 0
C18 s18 14 15e-5
VS19 21 s19 0
R19 s19 17 56e-1
VS20 11 s20 0
R20 s20 1 15e3
VS21 4 s21 0
V21 e21 s21 DC 0 AC 27e1 -120
RI21 e21 7 39e-1
VS22 2 s22 0
L22 s22 19 47e-2
VS23 10 s23 0
R23 s23 21 15e-1
VS24 18 s24 0
C24 s24 1 47e-4
VS25 21 s25 0
R25 s25 19 22e1
VS26 11 s26 0
L26 s26 21 12e-4
VS27 1 s27 0
V27 e27 s27 DC 0 AC 47e1 120
RI27 e27 23 33e-2
VS28 9 s28 0
C28 s28 14 56e-4
VS29 5 s29 0
R29 s29 9 33e1
VS30 18 s30 0
R30 s30 1 56e-2
VS31 15 s31 0
V31 e31 s31 DC 0 AC 22e0 -120
RI31 e31 18 56e-1
VS32 16 s32 0
L32 s32 23 47e-2
VS33 23 s33 0
V33 e33 s33 DC 0 AC 27e1 120
RI33 e33 22 15e-2
VS34 20 s34 0
V34 e34 s34 DC 0 AC 82e-1 120
RI34 e34 9 33e-1
VS35 4 s35 0
V35 e35 s35 DC 0 AC 47e1 120
RI35 e35 10 15e-1
VS36 21 s36 0
R36 s36 13 82e-1
VS37 4 s37 0
R37 s37 6 12e2
VS38 16 s38 0
C38 s38 10 68e-5
VS39 3 s39 0
R39 s39 19 68e0
VS40 1 s40 0
R40 s40 0 10e-1
VS41 23 s41 0
R41 s41 24 68e-2
VS42 14 s42 0
L42 s42 9 18e-3
VS43 7 s43 0
C43 s43 1 33e-7
VS44 1 s44 0
V44 e44 s44 DC 0 AC 15e0 -120
RI44 e44 12 33e-1
VS45 4 s45 0
L45 s45 10 22e-3
VS46 23 s46 0
R46 s46 0 22e3
.control
set numdgt=17
ac lin 1 60 60
print v(1) v(2) v(3) v(4) v(5) v(6) v(7) v(8) v(9) v(10)
print v(11) v(12) v(13) v(14) v(15) v(16) v(17) v(18) v(19) v(20)
print v(21) v(22) v(23) v(24) v(25) v(26)
print i(vs0) i(vs1) i(vs2) i(vs3) i(vs4) i(vs5) i(vs6) i(vs7) i(vs8) i(vs9)
print i(vs10) i(vs11) i(vs12) i(vs13) i(vs14) i(vs15) i(vs16) i(vs17) i(vs18) i(vs19)
print i(vs20) i(vs21) i(vs22) i(vs23) i(vs24) i(vs25) i(vs26) i(vs27) i(vs28) i(vs29)
print i(vs30) i(vs31) i(vs32) i(vs33) i(vs34) i(vs35) i(vs36) i(vs37) i(vs38) i(vs39)
print i(vs40) i(vs41) i(vs42) i(vs43) i(vs44) i(vs45) i(vs46)
.endc
.end
