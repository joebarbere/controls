controls oracle ac-0413
* Generated (plan F2.7, ADR 0012): do not edit; regenerate with `pnpm sim oracle regen`. ac seed 20261031 index 413 nodes 6 elements 12
.options sparse gmin=1e-12 noopac
RG1 1 0 1000000000000
RG2 2 0 1000000000000
RG3 3 0 1000000000000
RG4 4 0 1000000000000
RG5 5 0 1000000000000
VS0 1 s0 0
C0 s0 0 10e-5
VS1 0 s1 0
V1 e1 s1 DC 0 AC 15e0 180
RI1 e1 m1 68e-3
LI1 m1 3 33e-6
VS2 1 s2 0
L2 s2 0 10e-4
VS3 1 s3 0
L3 s3 0 39e-4
VS4 2 s4 0
L4 s4 4 47e-3
VS5 1 s5 0
R5 s5 0 10e-1
VS6 0 s6 0
R6 s6 1 68e-2
VS7 2 s7 0
L7 s7 0 82e-2
VS8 1 s8 0
V8 e8 s8 DC 0 AC 18e1 0
RI8 e8 m8 47e-2
LI8 m8 3 47e-6
VS9 4 s9 0
C9 s9 1 68e-5
VS10 5 s10 0
V10 e10 s10 DC 0 AC 47e1 -120
RI10 e10 3 22e-1
VS11 4 s11 0
R11 s11 5 39e2
.control
set numdgt=17
ac lin 1 60 60
print v(1) v(2) v(3) v(4) v(5)
print i(vs0) i(vs1) i(vs2) i(vs3) i(vs4) i(vs5) i(vs6) i(vs7) i(vs8) i(vs9)
print i(vs10) i(vs11)
.endc
.end
