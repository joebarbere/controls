controls oracle ac-0413
* Generated (plan F2.7, ADR 0012): do not edit; regenerate with `pnpm sim oracle regen`. ac seed 20261031 index 413 nodes 6 elements 8
.options sparse gmin=1e-12 noopac
RG1 1 0 1000000000000
RG2 2 0 1000000000000
RG3 3 0 1000000000000
RG4 4 0 1000000000000
RG5 5 0 1000000000000
VS0 3 s0 0
L0 s0 5 39e-5
VS1 3 s1 0
L1 s1 2 12e-4
VS2 1 s2 0
R2 s2 2 68e-2
VS3 0 s3 0
L3 s3 1 82e-2
VS4 5 s4 0
L4 s4 3 12e-3
VS5 4 s5 0
C5 s5 2 68e-5
VS6 0 s6 0
V6 e6 s6 DC 0 AC 27e1 120
RI6 e6 2 47e-1
VS7 1 s7 0
V7 e7 s7 DC 0 AC 15e0 180
RI7 e7 3 68e-3
.control
set numdgt=17
ac lin 1 60 60
print v(1) v(2) v(3) v(4) v(5)
print i(vs0) i(vs1) i(vs2) i(vs3) i(vs4) i(vs5) i(vs6) i(vs7)
.endc
.end
