controls oracle ac-0235
* Generated (plan F2.7, ADR 0012): do not edit; regenerate with `pnpm sim oracle regen`. ac seed 20261031 index 235 nodes 6 elements 12
.options sparse gmin=1e-12 noopac
RG1 1 0 1000000000000
RG2 2 0 1000000000000
RG3 3 0 1000000000000
RG4 4 0 1000000000000
RG5 5 0 1000000000000
VS0 2 s0 0
R0 s0 0 33e-2
VS1 0 s1 0
V1 e1 s1 DC 0 AC 39e0 120
RI1 e1 m1 39e-1
LI1 m1 5 15e-5
VS2 4 s2 0
R2 s2 2 56e-1
VS3 3 s3 0
V3 e3 s3 DC 0 AC 82e-1 180
RI3 e3 m3 22e-2
LI3 m3 0 82e-6
VS4 2 s4 0
L4 s4 1 82e-2
VS5 3 s5 0
L5 s5 0 10e-4
VS6 4 s6 0
R6 s6 0 22e-1
VS7 5 s7 0
R7 s7 1 68e-2
VS8 0 s8 0
L8 s8 4 15e-3
VS9 1 s9 0
V9 e9 s9 DC 0 AC 10e-1 120
RI9 e9 3 12e-3
VS10 2 s10 0
R10 s10 1 39e-1
VS11 1 s11 0
C11 s11 2 18e-5
.control
set numdgt=17
ac lin 1 60 60
print v(1) v(2) v(3) v(4) v(5)
print i(vs0) i(vs1) i(vs2) i(vs3) i(vs4) i(vs5) i(vs6) i(vs7) i(vs8) i(vs9)
print i(vs10) i(vs11)
.endc
.end
