controls oracle ac-0235
* Generated (plan F2.7, ADR 0012): do not edit; regenerate with `pnpm sim oracle regen`. ac seed 20261031 index 235 nodes 6 elements 9
.options sparse gmin=1e-12 noopac
RG1 1 0 1000000000000
RG2 2 0 1000000000000
RG3 3 0 1000000000000
RG4 4 0 1000000000000
RG5 5 0 1000000000000
VS0 0 s0 0
R0 s0 5 47e3
VS1 5 s1 0
L1 s1 2 33e-2
VS2 0 s2 0
L2 s2 1 47e-2
VS3 0 s3 0
V3 e3 s3 DC 0 AC 15e-1 120
RI3 e3 m3 22e-3
LI3 m3 n3 82e-5
H3 n3 h3 VS7 -10e-4
ED3 h3 2 d3 0 -39e-6
F3 0 d3 VS7 1
LD3 d3 0 1
VS4 0 s4 0
C4 s4 4 33e-6
VS5 2 s5 0
L5 s5 3 10e-4
VS6 4 s6 0
L6 s6 3 27e-5
VS7 1 s7 0
V7 e7 s7 DC 0 AC 10e-1 120
RI7 e7 n7 12e-3
H7 n7 h7 VS3 -10e-4
ED7 h7 2 d7 0 -39e-6
F7 0 d7 VS3 1
LD7 d7 0 1
VS8 4 s8 0
C8 s8 1 22e-6
.control
set numdgt=17
ac lin 1 60 60
print v(1) v(2) v(3) v(4) v(5)
print i(vs0) i(vs1) i(vs2) i(vs3) i(vs4) i(vs5) i(vs6) i(vs7) i(vs8)
.endc
.end
