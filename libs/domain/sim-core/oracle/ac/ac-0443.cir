controls oracle ac-0443
* Generated (plan F2.7, ADR 0012): do not edit; regenerate with `pnpm sim oracle regen`. ac seed 20261031 index 443 nodes 2 elements 2
.options sparse gmin=1e-12 noopac
RG1 1 0 1000000000000
VS0 0 s0 0
V0 e0 s0 DC 0 AC 27e-1 120
RI0 e0 1 15e-1
VS1 1 s1 0
V1 e1 s1 DC 0 AC 39e1 180
RI1 e1 0 39e-3
.control
set numdgt=17
ac lin 1 60 60
print v(1)
print i(vs0) i(vs1)
.endc
.end
