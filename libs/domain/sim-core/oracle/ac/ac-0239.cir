controls oracle ac-0239
* Generated (plan F2.7, ADR 0012): do not edit; regenerate with `pnpm sim oracle regen`. ac seed 20261031 index 239 nodes 3 elements 5
.options sparse gmin=1e-12 noopac
RG1 1 0 1000000000000
RG2 2 0 1000000000000
VS0 2 s0 0
C0 s0 1 18e-6
VS1 1 s1 0
R1 s1 0 15e0
VS2 0 s2 0
L2 s2 2 12e-4
VS3 2 s3 0
R3 s3 1 82e3
VS4 0 s4 0
V4 e4 s4 DC 0 AC 39e1 0
RI4 e4 m4 10e-2
LI4 m4 1 27e-6
.control
set numdgt=17
ac lin 1 60 60
print v(1) v(2)
print i(vs0) i(vs1) i(vs2) i(vs3) i(vs4)
.endc
.end
