controls oracle ac-0387
* Generated (plan F2.7, ADR 0012): do not edit; regenerate with `pnpm sim oracle regen`. ac seed 20261031 index 387 nodes 5 elements 6
.options sparse gmin=1e-12 noopac
RG1 1 0 1000000000000
RG2 2 0 1000000000000
RG3 3 0 1000000000000
RG4 4 0 1000000000000
VS0 0 s0 0
V0 e0 s0 DC 0 AC 22e-1 120
RI0 e0 m0 56e-2
LI0 m0 1 82e-7
VS1 4 s1 0
V1 e1 s1 DC 0 AC 27e1 180
RI1 e1 m1 33e-3
LI1 m1 1 33e-7
VS2 2 s2 0
C2 s2 3 68e-7
VS3 2 s3 0
C3 s3 0 10e-6
VS4 0 s4 0
R4 s4 4 18e-1
VS5 3 s5 0
L5 s5 1 82e-4
.control
set numdgt=17
ac lin 1 60 60
print v(1) v(2) v(3) v(4)
print i(vs0) i(vs1) i(vs2) i(vs3) i(vs4) i(vs5)
.endc
.end
