controls oracle ac-0387
* Generated (plan F2.7, ADR 0012): do not edit; regenerate with `pnpm sim oracle regen`. ac seed 20261031 index 387 nodes 5 elements 6
.options sparse gmin=1e-12 noopac
RG1 1 0 1000000000000
RG2 2 0 1000000000000
RG3 3 0 1000000000000
RG4 4 0 1000000000000
VS0 0 s0 0
V0 e0 s0 DC 0 AC 12e-1 0
RI0 e0 3 56e-3
VS1 1 s1 0
R1 s1 0 39e2
VS2 1 s2 0
R2 s2 2 18e3
VS3 1 s3 0
V3 e3 s3 DC 0 AC 22e-1 120
RI3 e3 4 56e-2
VS4 1 s4 0
L4 s4 4 47e-4
VS5 0 s5 0
C5 s5 1 12e-5
.control
set numdgt=17
ac lin 1 60 60
print v(1) v(2) v(3) v(4)
print i(vs0) i(vs1) i(vs2) i(vs3) i(vs4) i(vs5)
.endc
.end
