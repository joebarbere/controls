controls oracle ac-0387
* Generated (plan F2.7, ADR 0012): do not edit; regenerate with `pnpm sim oracle regen`. ac seed 20261031 index 387 nodes 5 elements 8
.options sparse gmin=1e-12 noopac
RG1 1 0 1000000000000
RG2 2 0 1000000000000
RG3 3 0 1000000000000
RG4 4 0 1000000000000
VS0 0 s0 0
C0 s0 1 12e-5
VS1 4 s1 0
R1 s1 0 18e-1
VS2 1 s2 0
R2 s2 2 18e3
VS3 2 s3 0
R3 s3 4 27e-2
VS4 0 s4 0
V4 e4 s4 DC 0 AC 12e-1 0
RI4 e4 3 56e-3
VS5 1 s5 0
R5 s5 0 39e2
VS6 1 s6 0
V6 e6 s6 DC 0 AC 22e-1 120
RI6 e6 4 56e-2
VS7 3 s7 0
C7 s7 1 68e-7
.control
set numdgt=17
ac lin 1 60 60
print v(1) v(2) v(3) v(4)
print i(vs0) i(vs1) i(vs2) i(vs3) i(vs4) i(vs5) i(vs6) i(vs7)
.endc
.end
