controls oracle ac-0237
* Generated (plan F2.7, ADR 0012): do not edit; regenerate with `pnpm sim oracle regen`. ac seed 20261031 index 237 nodes 16 elements 21
.options sparse gmin=1e-12 noopac
RG1 1 0 1000000000000
RG2 2 0 1000000000000
RG3 3 0 1000000000000
RG4 4 0 1000000000000
RG5 5 0 1000000000000
RG6 6 0 1000000000000
RG7 7 0 1000000000000
RG8 8 0 1000000000000
RG9 9 0 1000000000000
RG10 10 0 1000000000000
RG11 11 0 1000000000000
RG12 12 0 1000000000000
RG13 13 0 1000000000000
RG14 14 0 1000000000000
RG15 15 0 1000000000000
VS0 9 s0 0
L0 s0 13 10e-5
VS1 12 s1 0
L1 s1 4 18e-2
VS2 3 s2 0
L2 s2 5 82e-2
VS3 1 s3 0
R3 s3 7 82e0
VS4 13 s4 0
L4 s4 11 56e-5
VS5 0 s5 0
V5 e5 s5 DC 0 AC 15e-1 -120
RI5 e5 11 56e-1
VS6 12 s6 0
V6 e6 s6 DC 0 AC 68e-1 -120
RI6 e6 10 10e-2
VS7 0 s7 0
L7 s7 2 47e-4
VS8 15 s8 0
R8 s8 0 68e2
VS9 10 s9 0
R9 s9 1 12e3
VS10 7 s10 0
V10 e10 s10 DC 0 AC 68e0 -120
RI10 e10 13 68e-1
VS11 15 s11 0
C11 s11 14 27e-7
VS12 4 s12 0
V12 e12 s12 DC 0 AC 82e-1 180
RI12 e12 13 10e-3
VS13 9 s13 0
V13 e13 s13 DC 0 AC 39e0 -120
RI13 e13 6 82e-3
VS14 1 s14 0
V14 e14 s14 DC 0 AC 33e0 0
RI14 e14 m14 18e-2
LI14 m14 0 15e-7
VS15 11 s15 0
C15 s15 8 22e-7
VS16 12 s16 0
C16 s16 11 12e-6
VS17 11 s17 0
L17 s17 3 33e-3
VS18 11 s18 0
V18 e18 s18 DC 0 AC 27e-1 120
RI18 e18 6 47e-3
VS19 5 s19 0
L19 s19 2 39e-5
VS20 14 s20 0
C20 s20 8 56e-6
.control
set numdgt=17
ac lin 1 60 60
print v(1) v(2) v(3) v(4) v(5) v(6) v(7) v(8) v(9) v(10)
print v(11) v(12) v(13) v(14) v(15)
print i(vs0) i(vs1) i(vs2) i(vs3) i(vs4) i(vs5) i(vs6) i(vs7) i(vs8) i(vs9)
print i(vs10) i(vs11) i(vs12) i(vs13) i(vs14) i(vs15) i(vs16) i(vs17) i(vs18) i(vs19)
print i(vs20)
.endc
.end
