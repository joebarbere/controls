controls oracle ac-0237
* Generated (plan F2.7, ADR 0012): do not edit; regenerate with `pnpm sim oracle regen`. ac seed 20261031 index 237 nodes 16 elements 16
.options sparse gmin=1e-12 noopac
RG1 1 0 1000000000000
RG2 2 0 1000000000000
RG3 3 0 1000000000000
RG4 4 0 1000000000000
RG5 5 0 1000000000000
RG6 6 0 1000000000000
RG7 7 0 1000000000000
RG8 8 0 1000000000000
RG9 9 0 1000000000000
RG10 10 0 1000000000000
RG11 11 0 1000000000000
RG12 12 0 1000000000000
RG13 13 0 1000000000000
RG14 14 0 1000000000000
RG15 15 0 1000000000000
VS0 0 s0 0
V0 e0 s0 DC 0 AC 68e-1 -120
RI0 e0 11 82e-2
VS1 11 s1 0
R1 s1 8 22e0
VS2 6 s2 0
V2 e2 s2 DC 0 AC 10e1 -120
RI2 e2 5 33e-1
VS3 10 s3 0
L3 s3 3 82e-3
VS4 12 s4 0
V4 e4 s4 DC 0 AC 10e-1 120
RI4 e4 4 27e-2
VS5 5 s5 0
C5 s5 11 12e-6
VS6 5 s6 0
R6 s6 1 10e0
VS7 9 s7 0
C7 s7 8 22e-4
VS8 14 s8 0
R8 s8 13 27e2
VS9 13 s9 0
R9 s9 0 18e-2
VS10 3 s10 0
R10 s10 2 68e-1
VS11 0 s11 0
C11 s11 7 27e-6
VS12 11 s12 0
L12 s12 15 56e-3
VS13 6 s13 0
V13 e13 s13 DC 0 AC 12e-1 -120
RI13 e13 9 22e-2
VS14 12 s14 0
V14 e14 s14 DC 0 AC 15e-1 -120
RI14 e14 11 56e-1
VS15 11 s15 0
L15 s15 3 33e-3
.control
set numdgt=17
ac lin 1 60 60
print v(1) v(2) v(3) v(4) v(5) v(6) v(7) v(8) v(9) v(10)
print v(11) v(12) v(13) v(14) v(15)
print i(vs0) i(vs1) i(vs2) i(vs3) i(vs4) i(vs5) i(vs6) i(vs7) i(vs8) i(vs9)
print i(vs10) i(vs11) i(vs12) i(vs13) i(vs14) i(vs15)
.endc
.end
