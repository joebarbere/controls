controls oracle ac-0016
* Generated (plan F2.7, ADR 0012): do not edit; regenerate with `pnpm sim oracle regen`. ac seed 20261031 index 16 nodes 3 elements 3
.options sparse gmin=1e-12 noopac
RG1 1 0 1000000000000
RG2 2 0 1000000000000
VS0 0 s0 0
L0 s0 1 12e-4
VS1 1 s1 0
C1 s1 2 10e-5
VS2 0 s2 0
V2 e2 s2 DC 0 AC 47e-1 0
RI2 e2 2 56e-1
.control
set numdgt=17
ac lin 1 60 60
print v(1) v(2)
print i(vs0) i(vs1) i(vs2)
.endc
.end
