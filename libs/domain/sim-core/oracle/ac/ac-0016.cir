controls oracle ac-0016
* Generated (plan F2.7, ADR 0012): do not edit; regenerate with `pnpm sim oracle regen`. ac seed 20261031 index 16 nodes 3 elements 3
.options sparse gmin=1e-12 noopac
RG1 1 0 1000000000000
RG2 2 0 1000000000000
VS0 0 s0 0
V0 e0 s0 DC 0 AC 47e-1 0
RI0 e0 m0 56e-1
LI0 m0 2 68e-6
VS1 0 s1 0
L1 s1 1 12e-4
VS2 1 s2 0
C2 s2 2 10e-5
.control
set numdgt=17
ac lin 1 60 60
print v(1) v(2)
print i(vs0) i(vs1) i(vs2)
.endc
.end
