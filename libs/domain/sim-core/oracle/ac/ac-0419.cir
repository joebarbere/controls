controls oracle ac-0419
* Generated (plan F2.7, ADR 0012): do not edit; regenerate with `pnpm sim oracle regen`. ac seed 20261031 index 419 nodes 3 elements 3
.options sparse gmin=1e-12 noopac
RG1 1 0 1000000000000
RG2 2 0 1000000000000
VS0 0 s0 0
V0 e0 s0 DC 0 AC 47e1 -120
RI0 e0 2 68e-2
VS1 1 s1 0
R1 s1 2 27e0
VS2 1 s2 0
R2 s2 0 68e1
.control
set numdgt=17
ac lin 1 60 60
print v(1) v(2)
print i(vs0) i(vs1) i(vs2)
.endc
.end
