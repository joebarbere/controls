controls oracle ac-0146
* Generated (plan F2.7, ADR 0012): do not edit; regenerate with `pnpm sim oracle regen`. ac seed 20261031 index 146 nodes 10 elements 14
.options sparse gmin=1e-12 noopac
RG1 1 0 1000000000000
RG2 2 0 1000000000000
RG3 3 0 1000000000000
RG4 4 0 1000000000000
RG5 5 0 1000000000000
RG6 6 0 1000000000000
RG7 7 0 1000000000000
RG8 8 0 1000000000000
RG9 9 0 1000000000000
VS0 0 s0 0
V0 e0 s0 DC 0 AC 27e1 180
RI0 e0 m0 10e-2
LI0 m0 n0 12e-5
H0 n0 h0 VS3 15e-4
ED0 h0 4 d0 0 -47e-5
F0 0 d0 VS3 1
LD0 d0 0 1
VS1 4 s1 0
C1 s1 9 18e-7
VS2 1 s2 0
L2 s2 0 39e-4
VS3 6 s3 0
V3 e3 s3 DC 0 AC 15e-1 120
RI3 e3 n3 15e-3
H3 n3 h3 VS0 15e-4
ED3 h3 5 d3 0 -47e-5
F3 0 d3 VS0 1
LD3 d3 0 1
VS4 9 s4 0
C4 s4 4 15e-4
VS5 2 s5 0
R5 s5 4 18e3
VS6 4 s6 0
R6 s6 7 33e2
VS7 5 s7 0
V7 e7 s7 DC 0 AC 10e-1 120
RI7 e7 2 27e-1
VS8 7 s8 0
V8 e8 s8 DC 0 AC 33e0 0
RI8 e8 3 56e-3
VS9 6 s9 0
L9 s9 3 10e-3
VS10 6 s10 0
R10 s10 1 47e1
VS11 1 s11 0
R11 s11 8 47e2
VS12 6 s12 0
R12 s12 8 56e3
VS13 9 s13 0
L13 s13 0 47e-5
.control
set numdgt=17
ac lin 1 60 60
print v(1) v(2) v(3) v(4) v(5) v(6) v(7) v(8) v(9)
print i(vs0) i(vs1) i(vs2) i(vs3) i(vs4) i(vs5) i(vs6) i(vs7) i(vs8) i(vs9)
print i(vs10) i(vs11) i(vs12) i(vs13)
.endc
.end
