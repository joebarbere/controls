controls oracle ac-0268
* Generated (plan F2.7, ADR 0012): do not edit; regenerate with `pnpm sim oracle regen`. ac seed 20261031 index 268 nodes 11 elements 19
.options sparse gmin=1e-12 noopac
RG1 1 0 1000000000000
RG2 2 0 1000000000000
RG3 3 0 1000000000000
RG4 4 0 1000000000000
RG5 5 0 1000000000000
RG6 6 0 1000000000000
RG7 7 0 1000000000000
RG8 8 0 1000000000000
RG9 9 0 1000000000000
RG10 10 0 1000000000000
VS0 0 s0 0
V0 e0 s0 DC 0 AC 47e0 120
RI0 e0 10 39e-2
VS1 6 s1 0
V1 e1 s1 DC 0 AC 33e-1 180
RI1 e1 1 39e-2
VS2 1 s2 0
V2 e2 s2 DC 0 AC 18e1 0
RI2 e2 8 22e-1
VS3 2 s3 0
C3 s3 9 10e-6
VS4 8 s4 0
L4 s4 10 47e-3
VS5 4 s5 0
L5 s5 3 56e-2
VS6 6 s6 0
R6 s6 9 68e3
VS7 3 s7 0
R7 s7 8 18e0
VS8 4 s8 0
R8 s8 0 39e-1
VS9 6 s9 0
C9 s9 4 22e-6
VS10 9 s10 0
C10 s10 1 15e-6
VS11 4 s11 0
V11 e11 s11 DC 0 AC 27e-1 180
RI11 e11 5 39e-2
VS12 7 s12 0
R12 s12 2 39e-2
VS13 2 s13 0
R13 s13 6 82e1
VS14 4 s14 0
C14 s14 7 56e-7
VS15 1 s15 0
R15 s15 0 82e1
VS16 3 s16 0
L16 s16 9 18e-5
VS17 7 s17 0
R17 s17 5 56e1
VS18 5 s18 0
L18 s18 9 27e-5
.control
set numdgt=17
ac lin 1 60 60
print v(1) v(2) v(3) v(4) v(5) v(6) v(7) v(8) v(9) v(10)
print i(vs0) i(vs1) i(vs2) i(vs3) i(vs4) i(vs5) i(vs6) i(vs7) i(vs8) i(vs9)
print i(vs10) i(vs11) i(vs12) i(vs13) i(vs14) i(vs15) i(vs16) i(vs17) i(vs18)
.endc
.end
