controls oracle ac-0268
* Generated (plan F2.7, ADR 0012): do not edit; regenerate with `pnpm sim oracle regen`. ac seed 20261031 index 268 nodes 11 elements 20
.options sparse gmin=1e-12 noopac
RG1 1 0 1000000000000
RG2 2 0 1000000000000
RG3 3 0 1000000000000
RG4 4 0 1000000000000
RG5 5 0 1000000000000
RG6 6 0 1000000000000
RG7 7 0 1000000000000
RG8 8 0 1000000000000
RG9 9 0 1000000000000
RG10 10 0 1000000000000
VS0 1 s0 0
L0 s0 4 18e-4
VS1 0 s1 0
V1 e1 s1 DC 0 AC 22e1 -120
RI1 e1 4 15e-3
VS2 3 s2 0
C2 s2 2 39e-5
VS3 4 s3 0
V3 e3 s3 DC 0 AC 27e-1 180
RI3 e3 5 39e-2
VS4 3 s4 0
C4 s4 7 15e-7
VS5 5 s5 0
V5 e5 s5 DC 0 AC 18e-1 -120
RI5 e5 6 56e-3
VS6 5 s6 0
V6 e6 s6 DC 0 AC 56e1 0
RI6 e6 m6 68e-1
LI6 m6 9 68e-5
VS7 8 s7 0
V7 e7 s7 DC 0 AC 15e1 0
RI7 e7 5 15e-2
VS8 2 s8 0
C8 s8 1 15e-6
VS9 8 s9 0
R9 s9 1 15e1
VS10 6 s10 0
R10 s10 2 68e3
VS11 9 s11 0
R11 s11 0 12e-1
VS12 7 s12 0
R12 s12 4 10e3
VS13 0 s13 0
C13 s13 2 10e-6
VS14 6 s14 0
R14 s14 2 18e2
VS15 5 s15 0
L15 s15 2 27e-5
VS16 10 s16 0
V16 e16 s16 DC 0 AC 33e0 -120
RI16 e16 m16 56e-3
LI16 m16 3 39e-6
VS17 10 s17 0
R17 s17 6 33e2
VS18 2 s18 0
C18 s18 7 56e-5
VS19 3 s19 0
R19 s19 8 18e0
.control
set numdgt=17
ac lin 1 60 60
print v(1) v(2) v(3) v(4) v(5) v(6) v(7) v(8) v(9) v(10)
print i(vs0) i(vs1) i(vs2) i(vs3) i(vs4) i(vs5) i(vs6) i(vs7) i(vs8) i(vs9)
print i(vs10) i(vs11) i(vs12) i(vs13) i(vs14) i(vs15) i(vs16) i(vs17) i(vs18) i(vs19)
.endc
.end
