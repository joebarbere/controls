controls oracle ac-0444
* Generated (plan F2.7, ADR 0012): do not edit; regenerate with `pnpm sim oracle regen`. ac seed 20261031 index 444 nodes 10 elements 14
.options sparse gmin=1e-12 noopac
RG1 1 0 1000000000000
RG2 2 0 1000000000000
RG3 3 0 1000000000000
RG4 4 0 1000000000000
RG5 5 0 1000000000000
RG6 6 0 1000000000000
RG7 7 0 1000000000000
RG8 8 0 1000000000000
RG9 9 0 1000000000000
VS0 0 s0 0
L0 s0 9 18e-2
VS1 0 s1 0
R1 s1 6 15e-1
VS2 0 s2 0
V2 e2 s2 DC 0 AC 12e1 -120
RI2 e2 m2 18e-1
LI2 m2 8 10e-5
VS3 2 s3 0
L3 s3 6 22e-2
VS4 5 s4 0
V4 e4 s4 DC 0 AC 82e-1 0
RI4 e4 m4 12e-2
LI4 m4 9 12e-7
VS5 8 s5 0
L5 s5 6 18e-4
VS6 4 s6 0
L6 s6 2 33e-4
VS7 5 s7 0
L7 s7 1 56e-2
VS8 1 s8 0
L8 s8 8 12e-2
VS9 4 s9 0
V9 e9 s9 DC 0 AC 18e0 180
RI9 e9 3 33e-3
VS10 7 s10 0
C10 s10 9 82e-4
VS11 3 s11 0
R11 s11 7 33e2
VS12 9 s12 0
R12 s12 1 47e-1
VS13 3 s13 0
C13 s13 6 22e-4
.control
set numdgt=17
ac lin 1 60 60
print v(1) v(2) v(3) v(4) v(5) v(6) v(7) v(8) v(9)
print i(vs0) i(vs1) i(vs2) i(vs3) i(vs4) i(vs5) i(vs6) i(vs7) i(vs8) i(vs9)
print i(vs10) i(vs11) i(vs12) i(vs13)
.endc
.end
