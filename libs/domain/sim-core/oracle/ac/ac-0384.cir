controls oracle ac-0384
* Generated (plan F2.7, ADR 0012): do not edit; regenerate with `pnpm sim oracle regen`. ac seed 20261031 index 384 nodes 21 elements 29
.options sparse gmin=1e-12 noopac
RG1 1 0 1000000000000
RG2 2 0 1000000000000
RG3 3 0 1000000000000
RG4 4 0 1000000000000
RG5 5 0 1000000000000
RG6 6 0 1000000000000
RG7 7 0 1000000000000
RG8 8 0 1000000000000
RG9 9 0 1000000000000
RG10 10 0 1000000000000
RG11 11 0 1000000000000
RG12 12 0 1000000000000
RG13 13 0 1000000000000
RG14 14 0 1000000000000
RG15 15 0 1000000000000
RG16 16 0 1000000000000
RG17 17 0 1000000000000
RG18 18 0 1000000000000
RG19 19 0 1000000000000
RG20 20 0 1000000000000
VS0 4 s0 0
R0 s0 12 39e2
VS1 0 s1 0
V1 e1 s1 DC 0 AC 39e1 0
RI1 e1 10 22e-2
VS2 0 s2 0
C2 s2 4 22e-7
VS3 7 s3 0
V3 e3 s3 DC 0 AC 12e-1 180
RI3 e3 12 22e-3
VS4 14 s4 0
R4 s4 15 22e1
VS5 8 s5 0
R5 s5 2 33e3
VS6 15 s6 0
R6 s6 19 56e1
VS7 11 s7 0
V7 e7 s7 DC 0 AC 82e-1 180
RI7 e7 18 18e-2
VS8 8 s8 0
C8 s8 6 12e-7
VS9 5 s9 0
V9 e9 s9 DC 0 AC 10e0 120
RI9 e9 2 15e-3
VS10 2 s10 0
L10 s10 13 22e-2
VS11 9 s11 0
L11 s11 6 82e-2
VS12 18 s12 0
R12 s12 20 82e-2
VS13 10 s13 0
V13 e13 s13 DC 0 AC 47e-1 -120
RI13 e13 17 39e-3
VS14 20 s14 0
L14 s14 2 15e-4
VS15 1 s15 0
L15 s15 11 18e-5
VS16 6 s16 0
L16 s16 14 82e-4
VS17 14 s17 0
C17 s17 20 27e-6
VS18 12 s18 0
R18 s18 2 10e0
VS19 18 s19 0
C19 s19 3 82e-5
VS20 9 s20 0
L20 s20 1 56e-3
VS21 5 s21 0
L21 s21 11 27e-3
VS22 11 s22 0
V22 e22 s22 DC 0 AC 10e1 0
RI22 e22 9 82e-1
VS23 14 s23 0
L23 s23 1 18e-2
VS24 15 s24 0
R24 s24 16 68e3
VS25 12 s25 0
R25 s25 0 82e3
VS26 4 s26 0
R26 s26 3 68e2
VS27 17 s27 0
C27 s27 19 33e-6
VS28 17 s28 0
L28 s28 18 82e-4
.control
set numdgt=17
ac lin 1 60 60
print v(1) v(2) v(3) v(4) v(5) v(6) v(7) v(8) v(9) v(10)
print v(11) v(12) v(13) v(14) v(15) v(16) v(17) v(18) v(19) v(20)
print i(vs0) i(vs1) i(vs2) i(vs3) i(vs4) i(vs5) i(vs6) i(vs7) i(vs8) i(vs9)
print i(vs10) i(vs11) i(vs12) i(vs13) i(vs14) i(vs15) i(vs16) i(vs17) i(vs18) i(vs19)
print i(vs20) i(vs21) i(vs22) i(vs23) i(vs24) i(vs25) i(vs26) i(vs27) i(vs28)
.endc
.end
