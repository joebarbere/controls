controls oracle ac-0384
* Generated (plan F2.7, ADR 0012): do not edit; regenerate with `pnpm sim oracle regen`. ac seed 20261031 index 384 nodes 21 elements 40
.options sparse gmin=1e-12 noopac
RG1 1 0 1000000000000
RG2 2 0 1000000000000
RG3 3 0 1000000000000
RG4 4 0 1000000000000
RG5 5 0 1000000000000
RG6 6 0 1000000000000
RG7 7 0 1000000000000
RG8 8 0 1000000000000
RG9 9 0 1000000000000
RG10 10 0 1000000000000
RG11 11 0 1000000000000
RG12 12 0 1000000000000
RG13 13 0 1000000000000
RG14 14 0 1000000000000
RG15 15 0 1000000000000
RG16 16 0 1000000000000
RG17 17 0 1000000000000
RG18 18 0 1000000000000
RG19 19 0 1000000000000
RG20 20 0 1000000000000
VS0 0 s0 0
V0 e0 s0 DC 0 AC 22e1 -120
RI0 e0 m0 82e-3
LI0 m0 12 82e-7
VS1 11 s1 0
V1 e1 s1 DC 0 AC 39e-1 180
RI1 e1 m1 15e-1
LI1 m1 13 12e-7
VS2 12 s2 0
C2 s2 15 82e-5
VS3 4 s3 0
L3 s3 3 27e-5
VS4 16 s4 0
C4 s4 2 18e-6
VS5 19 s5 0
R5 s5 10 10e1
VS6 7 s6 0
L6 s6 8 33e-2
VS7 4 s7 0
R7 s7 3 68e2
VS8 9 s8 0
R8 s8 20 39e-1
VS9 1 s9 0
L9 s9 4 27e-5
VS10 10 s10 0
R10 s10 1 68e-1
VS11 6 s11 0
C11 s11 1 56e-6
VS12 8 s12 0
L12 s12 9 82e-2
VS13 19 s13 0
R13 s13 20 18e3
VS14 18 s14 0
V14 e14 s14 DC 0 AC 10e0 -120
RI14 e14 m14 39e-2
LI14 m14 17 15e-6
VS15 16 s15 0
C15 s15 20 18e-5
VS16 12 s16 0
R16 s16 2 10e0
VS17 5 s17 0
C17 s17 7 10e-4
VS18 5 s18 0
V18 e18 s18 DC 0 AC 10e0 120
RI18 e18 2 15e-3
VS19 9 s19 0
C19 s19 16 12e-6
VS20 20 s20 0
L20 s20 2 15e-4
VS21 18 s21 0
C21 s21 3 82e-5
VS22 8 s22 0
C22 s22 0 82e-6
VS23 11 s23 0
V23 e23 s23 DC 0 AC 82e1 120
RI23 e23 m23 39e-1
LI23 m23 3 22e-6
VS24 11 s24 0
R24 s24 3 68e1
VS25 11 s25 0
R25 s25 6 27e-1
VS26 12 s26 0
R26 s26 14 18e3
VS27 4 s27 0
R27 s27 7 82e0
VS28 13 s28 0
R28 s28 3 39e-2
VS29 10 s29 0
R29 s29 1 47e3
VS30 12 s30 0
V30 e30 s30 DC 0 AC 56e1 -120
RI30 e30 0 56e-2
VS31 2 s31 0
C31 s31 3 27e-5
VS32 19 s32 0
R32 s32 17 27e0
VS33 1 s33 0
C33 s33 19 33e-6
VS34 7 s34 0
R34 s34 16 56e1
VS35 15 s35 0
R35 s35 19 56e1
VS36 0 s36 0
R36 s36 14 56e-2
VS37 1 s37 0
L37 s37 18 82e-4
VS38 10 s38 0
V38 e38 s38 DC 0 AC 82e0 -120
RI38 e38 9 56e-3
VS39 18 s39 0
R39 s39 20 82e-2
.control
set numdgt=17
ac lin 1 60 60
print v(1) v(2) v(3) v(4) v(5) v(6) v(7) v(8) v(9) v(10)
print v(11) v(12) v(13) v(14) v(15) v(16) v(17) v(18) v(19) v(20)
print i(vs0) i(vs1) i(vs2) i(vs3) i(vs4) i(vs5) i(vs6) i(vs7) i(vs8) i(vs9)
print i(vs10) i(vs11) i(vs12) i(vs13) i(vs14) i(vs15) i(vs16) i(vs17) i(vs18) i(vs19)
print i(vs20) i(vs21) i(vs22) i(vs23) i(vs24) i(vs25) i(vs26) i(vs27) i(vs28) i(vs29)
print i(vs30) i(vs31) i(vs32) i(vs33) i(vs34) i(vs35) i(vs36) i(vs37) i(vs38) i(vs39)
.endc
.end
