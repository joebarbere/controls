controls oracle ac-0384
* Generated (plan F2.7, ADR 0012): do not edit; regenerate with `pnpm sim oracle regen`. ac seed 20261031 index 384 nodes 21 elements 32
.options sparse gmin=1e-12 noopac
RG1 1 0 1000000000000
RG2 2 0 1000000000000
RG3 3 0 1000000000000
RG4 4 0 1000000000000
RG5 5 0 1000000000000
RG6 6 0 1000000000000
RG7 7 0 1000000000000
RG8 8 0 1000000000000
RG9 9 0 1000000000000
RG10 10 0 1000000000000
RG11 11 0 1000000000000
RG12 12 0 1000000000000
RG13 13 0 1000000000000
RG14 14 0 1000000000000
RG15 15 0 1000000000000
RG16 16 0 1000000000000
RG17 17 0 1000000000000
RG18 18 0 1000000000000
RG19 19 0 1000000000000
RG20 20 0 1000000000000
VS0 12 s0 0
R0 s0 2 10e0
VS1 10 s1 0
C1 s1 19 33e-6
VS2 15 s2 0
R2 s2 16 68e3
VS3 8 s3 0
R3 s3 2 33e3
VS4 0 s4 0
V4 e4 s4 DC 0 AC 47e-1 -120
RI4 e4 10 39e-3
VS5 1 s5 0
L5 s5 11 18e-5
VS6 14 s6 0
L6 s6 1 18e-2
VS7 2 s7 0
L7 s7 13 22e-2
VS8 6 s8 0
L8 s8 14 82e-4
VS9 18 s9 0
C9 s9 3 82e-5
VS10 7 s10 0
V10 e10 s10 DC 0 AC 12e-1 180
RI10 e10 12 22e-3
VS11 9 s11 0
L11 s11 6 82e-2
VS12 17 s12 0
V12 e12 s12 DC 0 AC 39e1 0
RI12 e12 0 22e-2
VS13 20 s13 0
L13 s13 2 15e-4
VS14 14 s14 0
C14 s14 20 27e-6
VS15 18 s15 0
R15 s15 20 82e-2
VS16 5 s16 0
L16 s16 11 27e-3
VS17 11 s17 0
V17 e17 s17 DC 0 AC 10e1 0
RI17 e17 9 82e-1
VS18 13 s18 0
L18 s18 6 27e-2
VS19 11 s19 0
V19 e19 s19 DC 0 AC 82e-1 180
RI19 e19 18 18e-2
VS20 15 s20 0
R20 s20 19 56e1
VS21 7 s21 0
C21 s21 4 39e-6
VS22 5 s22 0
V22 e22 s22 DC 0 AC 10e0 120
RI22 e22 2 15e-3
VS23 12 s23 0
R23 s23 17 82e3
VS24 8 s24 0
C24 s24 6 12e-7
VS25 14 s25 0
R25 s25 15 22e1
VS26 10 s26 0
L26 s26 18 82e-4
VS27 17 s27 0
C27 s27 4 22e-7
VS28 4 s28 0
R28 s28 12 39e2
VS29 12 s29 0
R29 s29 16 10e-2
VS30 9 s30 0
L30 s30 1 56e-3
VS31 4 s31 0
R31 s31 3 68e2
.control
set numdgt=17
ac lin 1 60 60
print v(1) v(2) v(3) v(4) v(5) v(6) v(7) v(8) v(9) v(10)
print v(11) v(12) v(13) v(14) v(15) v(16) v(17) v(18) v(19) v(20)
print i(vs0) i(vs1) i(vs2) i(vs3) i(vs4) i(vs5) i(vs6) i(vs7) i(vs8) i(vs9)
print i(vs10) i(vs11) i(vs12) i(vs13) i(vs14) i(vs15) i(vs16) i(vs17) i(vs18) i(vs19)
print i(vs20) i(vs21) i(vs22) i(vs23) i(vs24) i(vs25) i(vs26) i(vs27) i(vs28) i(vs29)
print i(vs30) i(vs31)
.endc
.end
