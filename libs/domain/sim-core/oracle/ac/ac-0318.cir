controls oracle ac-0318
* Generated (plan F2.7, ADR 0012): do not edit; regenerate with `pnpm sim oracle regen`. ac seed 20261031 index 318 nodes 26 elements 48
.options sparse gmin=1e-12 noopac
RG1 1 0 1000000000000
RG2 2 0 1000000000000
RG3 3 0 1000000000000
RG4 4 0 1000000000000
RG5 5 0 1000000000000
RG6 6 0 1000000000000
RG7 7 0 1000000000000
RG8 8 0 1000000000000
RG9 9 0 1000000000000
RG10 10 0 1000000000000
RG11 11 0 1000000000000
RG12 12 0 1000000000000
RG13 13 0 1000000000000
RG14 14 0 1000000000000
RG15 15 0 1000000000000
RG16 16 0 1000000000000
RG17 17 0 1000000000000
RG18 18 0 1000000000000
RG19 19 0 1000000000000
RG20 20 0 1000000000000
RG21 21 0 1000000000000
RG22 22 0 1000000000000
RG23 23 0 1000000000000
RG24 24 0 1000000000000
RG25 25 0 1000000000000
VS0 6 s0 0
R0 s0 13 33e3
VS1 21 s1 0
C1 s1 12 56e-6
VS2 19 s2 0
R2 s2 17 47e0
VS3 9 s3 0
C3 s3 25 82e-6
VS4 0 s4 0
V4 e4 s4 DC 0 AC 33e-1 120
RI4 e4 12 18e-3
VS5 18 s5 0
R5 s5 4 27e3
VS6 20 s6 0
L6 s6 4 27e-4
VS7 14 s7 0
R7 s7 1 56e1
VS8 17 s8 0
C8 s8 15 15e-7
VS9 4 s9 0
C9 s9 3 47e-4
VS10 24 s10 0
L10 s10 19 47e-4
VS11 19 s11 0
L11 s11 1 15e-4
VS12 25 s12 0
C12 s12 8 39e-5
VS13 11 s13 0
C13 s13 21 68e-4
VS14 22 s14 0
V14 e14 s14 DC 0 AC 47e-1 0
RI14 e14 7 12e-1
VS15 23 s15 0
C15 s15 11 10e-5
VS16 21 s16 0
L16 s16 8 47e-3
VS17 18 s17 0
C17 s17 9 15e-5
VS18 2 s18 0
V18 e18 s18 DC 0 AC 39e0 -120
RI18 e18 6 22e-2
VS19 15 s19 0
C19 s19 25 33e-5
VS20 23 s20 0
R20 s20 25 15e0
VS21 3 s21 0
L21 s21 12 33e-5
VS22 13 s22 0
R22 s22 23 47e-2
VS23 6 s23 0
V23 e23 s23 DC 0 AC 47e1 180
RI23 e23 3 10e-2
VS24 4 s24 0
R24 s24 9 82e1
VS25 21 s25 0
C25 s25 23 22e-7
VS26 6 s26 0
R26 s26 17 12e1
VS27 16 s27 0
L27 s27 5 47e-4
VS28 12 s28 0
C28 s28 5 15e-5
VS29 4 s29 0
V29 e29 s29 DC 0 AC 56e0 0
RI29 e29 11 10e-2
VS30 9 s30 0
C30 s30 10 18e-7
VS31 22 s31 0
R31 s31 8 33e0
VS32 21 s32 0
L32 s32 15 68e-2
VS33 22 s33 0
R33 s33 13 56e3
VS34 9 s34 0
R34 s34 12 56e2
VS35 24 s35 0
R35 s35 18 33e-2
VS36 14 s36 0
C36 s36 13 10e-4
VS37 7 s37 0
R37 s37 18 27e3
VS38 6 s38 0
L38 s38 24 27e-4
VS39 5 s39 0
V39 e39 s39 DC 0 AC 12e0 -120
RI39 e39 18 15e-3
VS40 0 s40 0
R40 s40 19 15e-2
VS41 4 s41 0
L41 s41 19 22e-5
VS42 20 s42 0
R42 s42 1 39e1
VS43 11 s43 0
R43 s43 13 10e0
VS44 0 s44 0
C44 s44 12 68e-7
VS45 9 s45 0
R45 s45 2 68e-2
VS46 12 s46 0
C46 s46 14 12e-6
VS47 9 s47 0
R47 s47 4 12e-1
.control
set numdgt=17
ac lin 1 60 60
print v(1) v(2) v(3) v(4) v(5) v(6) v(7) v(8) v(9) v(10)
print v(11) v(12) v(13) v(14) v(15) v(16) v(17) v(18) v(19) v(20)
print v(21) v(22) v(23) v(24) v(25)
print i(vs0) i(vs1) i(vs2) i(vs3) i(vs4) i(vs5) i(vs6) i(vs7) i(vs8) i(vs9)
print i(vs10) i(vs11) i(vs12) i(vs13) i(vs14) i(vs15) i(vs16) i(vs17) i(vs18) i(vs19)
print i(vs20) i(vs21) i(vs22) i(vs23) i(vs24) i(vs25) i(vs26) i(vs27) i(vs28) i(vs29)
print i(vs30) i(vs31) i(vs32) i(vs33) i(vs34) i(vs35) i(vs36) i(vs37) i(vs38) i(vs39)
print i(vs40) i(vs41) i(vs42) i(vs43) i(vs44) i(vs45) i(vs46) i(vs47)
.endc
.end
