controls oracle ac-0318
* Generated (plan F2.7, ADR 0012): do not edit; regenerate with `pnpm sim oracle regen`. ac seed 20261031 index 318 nodes 26 elements 50
.options sparse gmin=1e-12 noopac
RG1 1 0 1000000000000
RG2 2 0 1000000000000
RG3 3 0 1000000000000
RG4 4 0 1000000000000
RG5 5 0 1000000000000
RG6 6 0 1000000000000
RG7 7 0 1000000000000
RG8 8 0 1000000000000
RG9 9 0 1000000000000
RG10 10 0 1000000000000
RG11 11 0 1000000000000
RG12 12 0 1000000000000
RG13 13 0 1000000000000
RG14 14 0 1000000000000
RG15 15 0 1000000000000
RG16 16 0 1000000000000
RG17 17 0 1000000000000
RG18 18 0 1000000000000
RG19 19 0 1000000000000
RG20 20 0 1000000000000
RG21 21 0 1000000000000
RG22 22 0 1000000000000
RG23 23 0 1000000000000
RG24 24 0 1000000000000
RG25 25 0 1000000000000
VS0 8 s0 0
C0 s0 10 12e-4
VS1 6 s1 0
L1 s1 24 27e-4
VS2 4 s2 0
R2 s2 9 82e1
VS3 6 s3 0
R3 s3 13 33e3
VS4 13 s4 0
R4 s4 23 47e-2
VS5 16 s5 0
R5 s5 4 82e0
VS6 0 s6 0
V6 e6 s6 DC 0 AC 12e0 -120
RI6 e6 n6 15e-3
H6 n6 h6 VS19 39e-4
ED6 h6 5 d6 0 -10e-6
F6 0 d6 VS19 1
LD6 d6 0 1
VS7 7 s7 0
R7 s7 5 27e3
VS8 21 s8 0
C8 s8 23 22e-7
VS9 4 s9 0
C9 s9 3 47e-4
VS10 15 s10 0
C10 s10 25 33e-5
VS11 9 s11 0
C11 s11 10 18e-7
VS12 9 s12 0
C12 s12 25 82e-6
VS13 18 s13 0
R13 s13 19 15e-2
VS14 5 s14 0
C14 s14 9 15e-5
VS15 19 s15 0
L15 s15 1 15e-4
VS16 24 s16 0
L16 s16 19 47e-4
VS17 5 s17 0
R17 s17 4 27e3
VS18 14 s18 0
R18 s18 1 56e1
VS19 22 s19 0
V19 e19 s19 DC 0 AC 47e-1 0
RI19 e19 m19 12e-1
LI19 m19 n19 56e-5
H19 n19 h19 VS6 39e-4
ED19 h19 7 d19 0 -10e-6
F19 0 d19 VS6 1
LD19 d19 0 1
VS20 6 s20 0
V20 e20 s20 DC 0 AC 47e1 180
RI20 e20 3 10e-2
VS21 2 s21 0
V21 e21 s21 DC 0 AC 39e0 -120
RI21 e21 m21 22e-2
LI21 m21 6 68e-6
VS22 21 s22 0
C22 s22 12 56e-6
VS23 24 s23 0
R23 s23 5 33e-2
VS24 14 s24 0
C24 s24 13 10e-4
VS25 11 s25 0
R25 s25 13 10e0
VS26 4 s26 0
L26 s26 19 22e-5
VS27 11 s27 0
C27 s27 21 68e-4
VS28 20 s28 0
L28 s28 4 27e-4
VS29 22 s29 0
R29 s29 13 56e3
VS30 23 s30 0
R30 s30 25 15e0
VS31 6 s31 0
R31 s31 17 12e1
VS32 12 s32 0
C32 s32 14 12e-6
VS33 9 s33 0
R33 s33 12 56e2
VS34 21 s34 0
L34 s34 8 47e-3
VS35 9 s35 0
R35 s35 2 68e-2
VS36 22 s36 0
R36 s36 8 33e0
VS37 17 s37 0
C37 s37 15 15e-7
VS38 4 s38 0
V38 e38 s38 DC 0 AC 56e0 0
RI38 e38 11 10e-2
VS39 20 s39 0
R39 s39 1 39e1
VS40 12 s40 0
C40 s40 0 15e-5
VS41 16 s41 0
L41 s41 0 47e-4
VS42 9 s42 0
R42 s42 4 12e-1
VS43 25 s43 0
C43 s43 8 39e-5
VS44 21 s44 0
L44 s44 15 68e-2
VS45 18 s45 0
V45 e45 s45 DC 0 AC 33e-1 120
RI45 e45 m45 18e-3
LI45 m45 12 18e-5
VS46 19 s46 0
R46 s46 17 47e0
VS47 3 s47 0
L47 s47 12 33e-5
VS48 18 s48 0
C48 s48 12 68e-7
VS49 23 s49 0
C49 s49 11 10e-5
.control
set numdgt=17
ac lin 1 60 60
print v(1) v(2) v(3) v(4) v(5) v(6) v(7) v(8) v(9) v(10)
print v(11) v(12) v(13) v(14) v(15) v(16) v(17) v(18) v(19) v(20)
print v(21) v(22) v(23) v(24) v(25)
print i(vs0) i(vs1) i(vs2) i(vs3) i(vs4) i(vs5) i(vs6) i(vs7) i(vs8) i(vs9)
print i(vs10) i(vs11) i(vs12) i(vs13) i(vs14) i(vs15) i(vs16) i(vs17) i(vs18) i(vs19)
print i(vs20) i(vs21) i(vs22) i(vs23) i(vs24) i(vs25) i(vs26) i(vs27) i(vs28) i(vs29)
print i(vs30) i(vs31) i(vs32) i(vs33) i(vs34) i(vs35) i(vs36) i(vs37) i(vs38) i(vs39)
print i(vs40) i(vs41) i(vs42) i(vs43) i(vs44) i(vs45) i(vs46) i(vs47) i(vs48) i(vs49)
.endc
.end
