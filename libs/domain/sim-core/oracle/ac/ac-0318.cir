controls oracle ac-0318
* Generated (plan F2.7, ADR 0012): do not edit; regenerate with `pnpm sim oracle regen`. ac seed 20261031 index 318 nodes 26 elements 49
.options sparse gmin=1e-12 noopac
RG1 1 0 1000000000000
RG2 2 0 1000000000000
RG3 3 0 1000000000000
RG4 4 0 1000000000000
RG5 5 0 1000000000000
RG6 6 0 1000000000000
RG7 7 0 1000000000000
RG8 8 0 1000000000000
RG9 9 0 1000000000000
RG10 10 0 1000000000000
RG11 11 0 1000000000000
RG12 12 0 1000000000000
RG13 13 0 1000000000000
RG14 14 0 1000000000000
RG15 15 0 1000000000000
RG16 16 0 1000000000000
RG17 17 0 1000000000000
RG18 18 0 1000000000000
RG19 19 0 1000000000000
RG20 20 0 1000000000000
RG21 21 0 1000000000000
RG22 22 0 1000000000000
RG23 23 0 1000000000000
RG24 24 0 1000000000000
RG25 25 0 1000000000000
VS0 3 s0 0
R0 s0 7 10e-1
VS1 20 s1 0
C1 s1 8 18e-7
VS2 17 s2 0
R2 s2 0 39e-1
VS3 7 s3 0
L3 s3 9 47e-3
VS4 3 s4 0
C4 s4 20 18e-7
VS5 6 s5 0
R5 s5 13 33e3
VS6 24 s6 0
L6 s6 19 47e-4
VS7 9 s7 0
R7 s7 14 18e0
VS8 12 s8 0
C8 s8 14 12e-6
VS9 22 s9 0
R9 s9 13 56e3
VS10 0 s10 0
V10 e10 s10 DC 0 AC 39e0 -120
RI10 e10 m10 22e-2
LI10 m10 6 18e-7
VS11 16 s11 0
L11 s11 4 18e-3
VS12 18 s12 0
C12 s12 25 68e-7
VS13 24 s13 0
C13 s13 1 33e-6
VS14 21 s14 0
C14 s14 8 18e-5
VS15 12 s15 0
L15 s15 1 56e-2
VS16 19 s16 0
V16 e16 s16 DC 0 AC 10e-1 -120
RI16 e16 m16 56e-3
LI16 m16 11 68e-5
VS17 4 s17 0
L17 s17 19 22e-5
VS18 11 s18 0
L18 s18 8 33e-3
VS19 14 s19 0
C19 s19 13 10e-4
VS20 11 s20 0
R20 s20 8 10e-1
VS21 23 s21 0
R21 s21 0 68e0
VS22 9 s22 0
C22 s22 25 82e-6
VS23 21 s23 0
C23 s23 12 56e-6
VS24 18 s24 0
V24 e24 s24 DC 0 AC 33e-1 120
RI24 e24 12 18e-3
VS25 5 s25 0
L25 s25 10 10e-4
VS26 9 s26 0
C26 s26 10 18e-7
VS27 21 s27 0
L27 s27 8 47e-3
VS28 21 s28 0
L28 s28 13 15e-3
VS29 0 s29 0
C29 s29 1 18e-6
VS30 6 s30 0
L30 s30 25 82e-5
VS31 13 s31 0
C31 s31 11 10e-5
VS32 3 s32 0
L32 s32 12 33e-5
VS33 5 s33 0
V33 e33 s33 DC 0 AC 12e0 -120
RI33 e33 m33 15e-3
LI33 m33 2 68e-7
VS34 2 s34 0
C34 s34 9 15e-5
VS35 25 s35 0
V35 e35 s35 DC 0 AC 56e1 0
RI35 e35 m35 47e-2
LI35 m35 16 18e-5
VS36 4 s36 0
L36 s36 3 18e-2
VS37 23 s37 0
R37 s37 25 15e0
VS38 24 s38 0
R38 s38 2 33e-2
VS39 17 s39 0
C39 s39 15 56e-4
VS40 17 s40 0
R40 s40 22 39e1
VS41 15 s41 0
C41 s41 23 56e-4
VS42 23 s42 0
V42 e42 s42 DC 0 AC 22e1 0
RI42 e42 17 39e-1
VS43 14 s43 0
L43 s43 2 68e-4
VS44 19 s44 0
R44 s44 16 22e1
VS45 1 s45 0
L45 s45 9 27e-4
VS46 0 s46 0
L46 s46 16 22e-5
VS47 17 s47 0
C47 s47 15 15e-7
VS48 7 s48 0
R48 s48 2 27e3
.control
set numdgt=17
ac lin 1 60 60
print v(1) v(2) v(3) v(4) v(5) v(6) v(7) v(8) v(9) v(10)
print v(11) v(12) v(13) v(14) v(15) v(16) v(17) v(18) v(19) v(20)
print v(21) v(22) v(23) v(24) v(25)
print i(vs0) i(vs1) i(vs2) i(vs3) i(vs4) i(vs5) i(vs6) i(vs7) i(vs8) i(vs9)
print i(vs10) i(vs11) i(vs12) i(vs13) i(vs14) i(vs15) i(vs16) i(vs17) i(vs18) i(vs19)
print i(vs20) i(vs21) i(vs22) i(vs23) i(vs24) i(vs25) i(vs26) i(vs27) i(vs28) i(vs29)
print i(vs30) i(vs31) i(vs32) i(vs33) i(vs34) i(vs35) i(vs36) i(vs37) i(vs38) i(vs39)
print i(vs40) i(vs41) i(vs42) i(vs43) i(vs44) i(vs45) i(vs46) i(vs47) i(vs48)
.endc
.end
