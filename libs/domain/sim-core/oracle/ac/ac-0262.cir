controls oracle ac-0262
* Generated (plan F2.7, ADR 0012): do not edit; regenerate with `pnpm sim oracle regen`. ac seed 20261031 index 262 nodes 20 elements 22
.options sparse gmin=1e-12 noopac
RG1 1 0 1000000000000
RG2 2 0 1000000000000
RG3 3 0 1000000000000
RG4 4 0 1000000000000
RG5 5 0 1000000000000
RG6 6 0 1000000000000
RG7 7 0 1000000000000
RG8 8 0 1000000000000
RG9 9 0 1000000000000
RG10 10 0 1000000000000
RG11 11 0 1000000000000
RG12 12 0 1000000000000
RG13 13 0 1000000000000
RG14 14 0 1000000000000
RG15 15 0 1000000000000
RG16 16 0 1000000000000
RG17 17 0 1000000000000
RG18 18 0 1000000000000
RG19 19 0 1000000000000
VS0 0 s0 0
L0 s0 11 39e-2
VS1 11 s1 0
R1 s1 19 82e-2
VS2 0 s2 0
V2 e2 s2 DC 0 AC 82e1 0
RI2 e2 12 33e-1
VS3 18 s3 0
V3 e3 s3 DC 0 AC 18e0 -120
RI3 e3 13 47e-2
VS4 9 s4 0
V4 e4 s4 DC 0 AC 82e-1 -120
RI4 e4 10 39e-3
VS5 7 s5 0
R5 s5 17 56e-2
VS6 19 s6 0
C6 s6 0 56e-7
VS7 1 s7 0
R7 s7 13 68e-2
VS8 6 s8 0
R8 s8 0 68e-1
VS9 19 s9 0
L9 s9 2 47e-4
VS10 0 s10 0
V10 e10 s10 DC 0 AC 47e0 -120
RI10 e10 16 12e-2
VS11 13 s11 0
V11 e11 s11 DC 0 AC 68e0 -120
RI11 e11 8 56e-3
VS12 4 s12 0
V12 e12 s12 DC 0 AC 27e0 0
RI12 e12 19 39e-1
VS13 2 s13 0
L13 s13 5 68e-5
VS14 7 s14 0
C14 s14 18 39e-4
VS15 3 s15 0
V15 e15 s15 DC 0 AC 82e1 -120
RI15 e15 6 68e-2
VS16 14 s16 0
R16 s16 17 15e3
VS17 13 s17 0
L17 s17 8 12e-3
VS18 6 s18 0
V18 e18 s18 DC 0 AC 10e1 -120
RI18 e18 9 27e-2
VS19 11 s19 0
V19 e19 s19 DC 0 AC 82e-1 0
RI19 e19 18 39e-3
VS20 15 s20 0
V20 e20 s20 DC 0 AC 27e-1 -120
RI20 e20 11 27e-3
VS21 1 s21 0
L21 s21 14 27e-3
.control
set numdgt=17
ac lin 1 60 60
print v(1) v(2) v(3) v(4) v(5) v(6) v(7) v(8) v(9) v(10)
print v(11) v(12) v(13) v(14) v(15) v(16) v(17) v(18) v(19)
print i(vs0) i(vs1) i(vs2) i(vs3) i(vs4) i(vs5) i(vs6) i(vs7) i(vs8) i(vs9)
print i(vs10) i(vs11) i(vs12) i(vs13) i(vs14) i(vs15) i(vs16) i(vs17) i(vs18) i(vs19)
print i(vs20) i(vs21)
.endc
.end
