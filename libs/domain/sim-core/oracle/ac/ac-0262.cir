controls oracle ac-0262
* Generated (plan F2.7, ADR 0012): do not edit; regenerate with `pnpm sim oracle regen`. ac seed 20261031 index 262 nodes 20 elements 29
.options sparse gmin=1e-12 noopac
RG1 1 0 1000000000000
RG2 2 0 1000000000000
RG3 3 0 1000000000000
RG4 4 0 1000000000000
RG5 5 0 1000000000000
RG6 6 0 1000000000000
RG7 7 0 1000000000000
RG8 8 0 1000000000000
RG9 9 0 1000000000000
RG10 10 0 1000000000000
RG11 11 0 1000000000000
RG12 12 0 1000000000000
RG13 13 0 1000000000000
RG14 14 0 1000000000000
RG15 15 0 1000000000000
RG16 16 0 1000000000000
RG17 17 0 1000000000000
RG18 18 0 1000000000000
RG19 19 0 1000000000000
VS0 0 s0 0
V0 e0 s0 DC 0 AC 68e1 180
RI0 e0 17 15e-3
VS1 16 s1 0
L1 s1 1 82e-3
VS2 10 s2 0
L2 s2 5 15e-5
VS3 0 s3 0
R3 s3 4 12e0
VS4 6 s4 0
V4 e4 s4 DC 0 AC 68e1 180
RI4 e4 11 10e-2
VS5 12 s5 0
V5 e5 s5 DC 0 AC 39e-1 180
RI5 e5 m5 27e-3
LI5 m5 17 27e-7
VS6 13 s6 0
V6 e6 s6 DC 0 AC 47e0 -120
RI6 e6 14 12e-2
VS7 15 s7 0
L7 s7 12 27e-3
VS8 11 s8 0
L8 s8 3 39e-2
VS9 13 s9 0
R9 s9 2 22e-1
VS10 2 s10 0
V10 e10 s10 DC 0 AC 27e0 180
RI10 e10 m10 68e-2
LI10 m10 18 18e-6
VS11 3 s11 0
V11 e11 s11 DC 0 AC 82e-1 0
RI11 e11 m11 39e-3
LI11 m11 18 27e-7
VS12 9 s12 0
V12 e12 s12 DC 0 AC 10e-1 -120
RI12 e12 4 22e-3
VS13 19 s13 0
R13 s13 17 15e3
VS14 1 s14 0
L14 s14 9 10e-5
VS15 5 s15 0
C15 s15 8 27e-6
VS16 13 s16 0
C16 s16 11 47e-6
VS17 15 s17 0
R17 s17 11 18e3
VS18 11 s18 0
V18 e18 s18 DC 0 AC 82e1 0
RI18 e18 m18 33e-1
LI18 m18 12 22e-6
VS19 6 s19 0
V19 e19 s19 DC 0 AC 10e0 120
RI19 e19 4 39e-2
VS20 15 s20 0
C20 s20 6 15e-7
VS21 14 s21 0
R21 s21 17 27e-1
VS22 16 s22 0
L22 s22 4 82e-2
VS23 18 s23 0
V23 e23 s23 DC 0 AC 22e-1 180
RI23 e23 3 82e-1
VS24 1 s24 0
V24 e24 s24 DC 0 AC 12e1 -120
RI24 e24 3 15e-3
VS25 7 s25 0
R25 s25 8 10e0
VS26 7 s26 0
L26 s26 13 39e-4
VS27 19 s27 0
V27 e27 s27 DC 0 AC 33e1 180
RI27 e27 m27 33e-2
LI27 m27 3 27e-6
VS28 10 s28 0
L28 s28 6 56e-4
.control
set numdgt=17
ac lin 1 60 60
print v(1) v(2) v(3) v(4) v(5) v(6) v(7) v(8) v(9) v(10)
print v(11) v(12) v(13) v(14) v(15) v(16) v(17) v(18) v(19)
print i(vs0) i(vs1) i(vs2) i(vs3) i(vs4) i(vs5) i(vs6) i(vs7) i(vs8) i(vs9)
print i(vs10) i(vs11) i(vs12) i(vs13) i(vs14) i(vs15) i(vs16) i(vs17) i(vs18) i(vs19)
print i(vs20) i(vs21) i(vs22) i(vs23) i(vs24) i(vs25) i(vs26) i(vs27) i(vs28)
.endc
.end
