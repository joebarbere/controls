controls oracle ac-0455
* Generated (plan F2.7, ADR 0012): do not edit; regenerate with `pnpm sim oracle regen`. ac seed 20261031 index 455 nodes 14 elements 19
.options sparse gmin=1e-12 noopac
RG1 1 0 1000000000000
RG2 2 0 1000000000000
RG3 3 0 1000000000000
RG4 4 0 1000000000000
RG5 5 0 1000000000000
RG6 6 0 1000000000000
RG7 7 0 1000000000000
RG8 8 0 1000000000000
RG9 9 0 1000000000000
RG10 10 0 1000000000000
RG11 11 0 1000000000000
RG12 12 0 1000000000000
RG13 13 0 1000000000000
VS0 0 s0 0
V0 e0 s0 DC 0 AC 82e-1 0
RI0 e0 13 47e-1
VS1 11 s1 0
L1 s1 13 18e-5
VS2 0 s2 0
C2 s2 7 82e-7
VS3 7 s3 0
L3 s3 5 27e-3
VS4 6 s4 0
L4 s4 10 82e-3
VS5 1 s5 0
R5 s5 9 10e2
VS6 11 s6 0
C6 s6 5 68e-5
VS7 8 s7 0
L7 s7 6 22e-2
VS8 0 s8 0
L8 s8 1 22e-5
VS9 10 s9 0
C9 s9 2 27e-6
VS10 3 s10 0
C10 s10 9 27e-5
VS11 9 s11 0
R11 s11 10 18e-1
VS12 13 s12 0
L12 s12 10 15e-3
VS13 12 s13 0
L13 s13 4 39e-2
VS14 4 s14 0
L14 s14 7 22e-5
VS15 8 s15 0
C15 s15 2 15e-7
VS16 13 s16 0
C16 s16 12 47e-7
VS17 2 s17 0
C17 s17 12 12e-7
VS18 13 s18 0
V18 e18 s18 DC 0 AC 82e-1 120
RI18 e18 3 82e-3
.control
set numdgt=17
ac lin 1 60 60
print v(1) v(2) v(3) v(4) v(5) v(6) v(7) v(8) v(9) v(10)
print v(11) v(12) v(13)
print i(vs0) i(vs1) i(vs2) i(vs3) i(vs4) i(vs5) i(vs6) i(vs7) i(vs8) i(vs9)
print i(vs10) i(vs11) i(vs12) i(vs13) i(vs14) i(vs15) i(vs16) i(vs17) i(vs18)
.endc
.end
