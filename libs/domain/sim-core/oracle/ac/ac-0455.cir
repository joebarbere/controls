controls oracle ac-0455
* Generated (plan F2.7, ADR 0012): do not edit; regenerate with `pnpm sim oracle regen`. ac seed 20261031 index 455 nodes 14 elements 27
.options sparse gmin=1e-12 noopac
RG1 1 0 1000000000000
RG2 2 0 1000000000000
RG3 3 0 1000000000000
RG4 4 0 1000000000000
RG5 5 0 1000000000000
RG6 6 0 1000000000000
RG7 7 0 1000000000000
RG8 8 0 1000000000000
RG9 9 0 1000000000000
RG10 10 0 1000000000000
RG11 11 0 1000000000000
RG12 12 0 1000000000000
RG13 13 0 1000000000000
VS0 3 s0 0
R0 s0 0 10e-2
VS1 0 s1 0
V1 e1 s1 DC 0 AC 47e0 -120
RI1 e1 2 82e-2
VS2 12 s2 0
L2 s2 13 56e-3
VS3 11 s3 0
C3 s3 13 68e-7
VS4 9 s4 0
R4 s4 0 47e3
VS5 5 s5 0
R5 s5 3 68e1
VS6 2 s6 0
V6 e6 s6 DC 0 AC 12e-1 0
RI6 e6 11 56e-3
VS7 1 s7 0
V7 e7 s7 DC 0 AC 82e1 0
RI7 e7 8 10e-2
VS8 6 s8 0
L8 s8 0 82e-3
VS9 2 s9 0
L9 s9 4 47e-4
VS10 3 s10 0
L10 s10 9 22e-4
VS11 11 s11 0
R11 s11 7 18e-2
VS12 3 s12 0
C12 s12 7 33e-4
VS13 3 s13 0
R13 s13 6 12e-2
VS14 8 s14 0
V14 e14 s14 DC 0 AC 39e0 120
RI14 e14 11 22e-2
VS15 3 s15 0
R15 s15 6 82e-2
VS16 4 s16 0
L16 s16 10 15e-3
VS17 1 s17 0
L17 s17 10 39e-5
VS18 8 s18 0
R18 s18 6 10e-2
VS19 12 s19 0
C19 s19 6 15e-5
VS20 10 s20 0
C20 s20 8 22e-4
VS21 9 s21 0
V21 e21 s21 DC 0 AC 33e0 0
RI21 e21 8 27e-2
VS22 11 s22 0
V22 e22 s22 DC 0 AC 33e1 180
RI22 e22 5 12e-3
VS23 13 s23 0
V23 e23 s23 DC 0 AC 82e-1 0
RI23 e23 4 47e-1
VS24 12 s24 0
C24 s24 13 18e-7
VS25 12 s25 0
C25 s25 13 22e-6
VS26 2 s26 0
R26 s26 0 10e1
.control
set numdgt=17
ac lin 1 60 60
print v(1) v(2) v(3) v(4) v(5) v(6) v(7) v(8) v(9) v(10)
print v(11) v(12) v(13)
print i(vs0) i(vs1) i(vs2) i(vs3) i(vs4) i(vs5) i(vs6) i(vs7) i(vs8) i(vs9)
print i(vs10) i(vs11) i(vs12) i(vs13) i(vs14) i(vs15) i(vs16) i(vs17) i(vs18) i(vs19)
print i(vs20) i(vs21) i(vs22) i(vs23) i(vs24) i(vs25) i(vs26)
.endc
.end
