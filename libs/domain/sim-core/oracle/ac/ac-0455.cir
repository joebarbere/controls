controls oracle ac-0455
* Generated (plan F2.7, ADR 0012): do not edit; regenerate with `pnpm sim oracle regen`. ac seed 20261031 index 455 nodes 14 elements 26
.options sparse gmin=1e-12 noopac
RG1 1 0 1000000000000
RG2 2 0 1000000000000
RG3 3 0 1000000000000
RG4 4 0 1000000000000
RG5 5 0 1000000000000
RG6 6 0 1000000000000
RG7 7 0 1000000000000
RG8 8 0 1000000000000
RG9 9 0 1000000000000
RG10 10 0 1000000000000
RG11 11 0 1000000000000
RG12 12 0 1000000000000
RG13 13 0 1000000000000
VS0 11 s0 0
C0 s0 13 68e-7
VS1 11 s1 0
R1 s1 7 18e-2
VS2 3 s2 0
R2 s2 4 10e-2
VS3 0 s3 0
V3 e3 s3 DC 0 AC 33e0 0
RI3 e3 8 27e-2
VS4 2 s4 0
R4 s4 4 10e1
VS5 2 s5 0
V5 e5 s5 DC 0 AC 12e-1 0
RI5 e5 11 56e-3
VS6 9 s6 0
L6 s6 10 15e-3
VS7 3 s7 0
R7 s7 6 12e-2
VS8 2 s8 0
L8 s8 9 47e-4
VS9 4 s9 0
V9 e9 s9 DC 0 AC 47e0 -120
RI9 e9 2 82e-2
VS10 6 s10 0
L10 s10 4 82e-3
VS11 5 s11 0
R11 s11 3 68e1
VS12 13 s12 0
V12 e12 s12 DC 0 AC 82e-1 0
RI12 e12 9 47e-1
VS13 0 s13 0
R13 s13 4 47e3
VS14 12 s14 0
C14 s14 13 22e-6
VS15 10 s15 0
C15 s15 8 22e-4
VS16 1 s16 0
V16 e16 s16 DC 0 AC 82e1 0
RI16 e16 8 10e-2
VS17 8 s17 0
R17 s17 6 10e-2
VS18 12 s18 0
C18 s18 13 18e-7
VS19 11 s19 0
V19 e19 s19 DC 0 AC 33e1 180
RI19 e19 5 12e-3
VS20 3 s20 0
R20 s20 6 82e-2
VS21 12 s21 0
L21 s21 13 56e-3
VS22 8 s22 0
V22 e22 s22 DC 0 AC 39e0 120
RI22 e22 11 22e-2
VS23 3 s23 0
C23 s23 7 33e-4
VS24 3 s24 0
L24 s24 0 22e-4
VS25 1 s25 0
L25 s25 10 39e-5
.control
set numdgt=17
ac lin 1 60 60
print v(1) v(2) v(3) v(4) v(5) v(6) v(7) v(8) v(9) v(10)
print v(11) v(12) v(13)
print i(vs0) i(vs1) i(vs2) i(vs3) i(vs4) i(vs5) i(vs6) i(vs7) i(vs8) i(vs9)
print i(vs10) i(vs11) i(vs12) i(vs13) i(vs14) i(vs15) i(vs16) i(vs17) i(vs18) i(vs19)
print i(vs20) i(vs21) i(vs22) i(vs23) i(vs24) i(vs25)
.endc
.end
