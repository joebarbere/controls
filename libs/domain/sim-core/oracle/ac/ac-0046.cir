controls oracle ac-0046
* Generated (plan F2.7, ADR 0012): do not edit; regenerate with `pnpm sim oracle regen`. ac seed 20261031 index 46 nodes 6 elements 12
.options sparse gmin=1e-12 noopac
RG1 1 0 1000000000000
RG2 2 0 1000000000000
RG3 3 0 1000000000000
RG4 4 0 1000000000000
RG5 5 0 1000000000000
VS0 4 s0 0
L0 s0 2 68e-2
VS1 1 s1 0
R1 s1 2 15e0
VS2 1 s2 0
R2 s2 0 33e2
VS3 1 s3 0
C3 s3 2 10e-6
VS4 0 s4 0
V4 e4 s4 DC 0 AC 15e0 0
RI4 e4 5 47e-1
VS5 3 s5 0
C5 s5 1 82e-5
VS6 4 s6 0
C6 s6 0 47e-5
VS7 5 s7 0
C7 s7 1 39e-5
VS8 5 s8 0
R8 s8 1 68e2
VS9 4 s9 0
R9 s9 5 15e2
VS10 0 s10 0
C10 s10 5 68e-7
VS11 3 s11 0
V11 e11 s11 DC 0 AC 47e1 -120
RI11 e11 2 22e-2
.control
set numdgt=17
ac lin 1 60 60
print v(1) v(2) v(3) v(4) v(5)
print i(vs0) i(vs1) i(vs2) i(vs3) i(vs4) i(vs5) i(vs6) i(vs7) i(vs8) i(vs9)
print i(vs10) i(vs11)
.endc
.end
