controls oracle ac-0046
* Generated (plan F2.7, ADR 0012): do not edit; regenerate with `pnpm sim oracle regen`. ac seed 20261031 index 46 nodes 6 elements 9
.options sparse gmin=1e-12 noopac
RG1 1 0 1000000000000
RG2 2 0 1000000000000
RG3 3 0 1000000000000
RG4 4 0 1000000000000
RG5 5 0 1000000000000
VS0 1 s0 0
R0 s0 3 27e-2
VS1 0 s1 0
V1 e1 s1 DC 0 AC 47e1 -120
RI1 e1 m1 22e-2
LI1 m1 3 39e-6
VS2 2 s2 0
V2 e2 s2 DC 0 AC 15e0 0
RI2 e2 m2 10e-2
LI2 m2 5 18e-6
VS3 2 s3 0
C3 s3 5 68e-7
VS4 5 s4 0
R4 s4 4 10e0
VS5 1 s5 0
L5 s5 0 47e-4
VS6 1 s6 0
R6 s6 5 27e3
VS7 0 s7 0
R7 s7 2 15e3
VS8 4 s8 0
R8 s8 3 15e0
.control
set numdgt=17
ac lin 1 60 60
print v(1) v(2) v(3) v(4) v(5)
print i(vs0) i(vs1) i(vs2) i(vs3) i(vs4) i(vs5) i(vs6) i(vs7) i(vs8)
.endc
.end
