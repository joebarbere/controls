controls oracle ac-0067
* Generated (plan F2.7, ADR 0012): do not edit; regenerate with `pnpm sim oracle regen`. ac seed 20261031 index 67 nodes 4 elements 5
.options sparse gmin=1e-12 noopac
RG1 1 0 1000000000000
RG2 2 0 1000000000000
RG3 3 0 1000000000000
VS0 0 s0 0
V0 e0 s0 DC 0 AC 15e1 0
RI0 e0 m0 68e-2
LI0 m0 n0 82e-7
H0 n0 h0 VS1 47e-3
ED0 h0 1 d0 0 -12e-7
F0 0 d0 VS1 1
LD0 d0 0 1
VS1 1 s1 0
V1 e1 s1 DC 0 AC 33e1 -120
RI1 e1 n1 56e-2
H1 n1 h1 VS0 47e-3
ED1 h1 3 d1 0 -12e-7
F1 0 d1 VS0 1
LD1 d1 0 1
VS2 0 s2 0
V2 e2 s2 DC 0 AC 10e-1 -120
RI2 e2 2 22e-3
VS3 1 s3 0
C3 s3 2 10e-5
VS4 3 s4 0
R4 s4 0 10e1
.control
set numdgt=17
ac lin 1 60 60
print v(1) v(2) v(3)
print i(vs0) i(vs1) i(vs2) i(vs3) i(vs4)
.endc
.end
