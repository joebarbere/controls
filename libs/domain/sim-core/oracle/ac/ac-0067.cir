controls oracle ac-0067
* Generated (plan F2.7, ADR 0012): do not edit; regenerate with `pnpm sim oracle regen`. ac seed 20261031 index 67 nodes 4 elements 5
.options sparse gmin=1e-12 noopac
RG1 1 0 1000000000000
RG2 2 0 1000000000000
RG3 3 0 1000000000000
VS0 0 s0 0
V0 e0 s0 DC 0 AC 10e-1 -120
RI0 e0 m0 22e-3
LI0 m0 2 22e-7
VS1 1 s1 0
V1 e1 s1 DC 0 AC 68e0 0
RI1 e1 3 12e-2
VS2 3 s2 0
V2 e2 s2 DC 0 AC 68e1 180
RI2 e2 m2 18e-3
LI2 m2 0 68e-6
VS3 2 s3 0
R3 s3 1 39e3
VS4 2 s4 0
R4 s4 3 15e-1
.control
set numdgt=17
ac lin 1 60 60
print v(1) v(2) v(3)
print i(vs0) i(vs1) i(vs2) i(vs3) i(vs4)
.endc
.end
