controls oracle ac-0217
* Generated (plan F2.7, ADR 0012): do not edit; regenerate with `pnpm sim oracle regen`. ac seed 20261031 index 217 nodes 18 elements 33
.options sparse gmin=1e-12 noopac
RG1 1 0 1000000000000
RG2 2 0 1000000000000
RG3 3 0 1000000000000
RG4 4 0 1000000000000
RG5 5 0 1000000000000
RG6 6 0 1000000000000
RG7 7 0 1000000000000
RG8 8 0 1000000000000
RG9 9 0 1000000000000
RG10 10 0 1000000000000
RG11 11 0 1000000000000
RG12 12 0 1000000000000
RG13 13 0 1000000000000
RG14 14 0 1000000000000
RG15 15 0 1000000000000
RG16 16 0 1000000000000
RG17 17 0 1000000000000
VS0 5 s0 0
R0 s0 8 82e-2
VS1 16 s1 0
L1 s1 5 39e-5
VS2 7 s2 0
R2 s2 13 56e1
VS3 0 s3 0
V3 e3 s3 DC 0 AC 33e1 -120
RI3 e3 m3 47e-3
LI3 m3 3 47e-7
VS4 9 s4 0
L4 s4 14 10e-3
VS5 16 s5 0
V5 e5 s5 DC 0 AC 47e-1 0
RI5 e5 10 47e-2
VS6 9 s6 0
V6 e6 s6 DC 0 AC 15e0 0
RI6 e6 m6 82e-2
LI6 m6 3 39e-6
VS7 14 s7 0
R7 s7 9 12e-2
VS8 4 s8 0
L8 s8 8 56e-2
VS9 8 s9 0
R9 s9 5 18e1
VS10 1 s10 0
L10 s10 11 68e-2
VS11 2 s11 0
L11 s11 5 82e-4
VS12 15 s12 0
L12 s12 17 47e-4
VS13 6 s13 0
L13 s13 3 68e-3
VS14 4 s14 0
R14 s14 17 15e1
VS15 5 s15 0
V15 e15 s15 DC 0 AC 47e1 -120
RI15 e15 m15 39e-3
LI15 m15 17 18e-5
VS16 2 s16 0
R16 s16 9 22e0
VS17 5 s17 0
R17 s17 14 68e0
VS18 0 s18 0
C18 s18 1 10e-5
VS19 13 s19 0
R19 s19 2 68e1
VS20 6 s20 0
R20 s20 12 39e0
VS21 13 s21 0
C21 s21 1 10e-7
VS22 4 s22 0
C22 s22 14 82e-4
VS23 1 s23 0
V23 e23 s23 DC 0 AC 22e1 180
RI23 e23 12 22e-2
VS24 17 s24 0
R24 s24 16 39e-2
VS25 2 s25 0
C25 s25 15 56e-4
VS26 12 s26 0
L26 s26 4 15e-3
VS27 8 s27 0
C27 s27 3 39e-6
VS28 12 s28 0
R28 s28 2 68e2
VS29 11 s29 0
V29 e29 s29 DC 0 AC 27e1 0
RI29 e29 7 47e-3
VS30 16 s30 0
L30 s30 17 22e-4
VS31 17 s31 0
C31 s31 3 82e-7
VS32 10 s32 0
V32 e32 s32 DC 0 AC 82e1 120
RI32 e32 m32 15e-1
LI32 m32 15 33e-5
.control
set numdgt=17
ac lin 1 60 60
print v(1) v(2) v(3) v(4) v(5) v(6) v(7) v(8) v(9) v(10)
print v(11) v(12) v(13) v(14) v(15) v(16) v(17)
print i(vs0) i(vs1) i(vs2) i(vs3) i(vs4) i(vs5) i(vs6) i(vs7) i(vs8) i(vs9)
print i(vs10) i(vs11) i(vs12) i(vs13) i(vs14) i(vs15) i(vs16) i(vs17) i(vs18) i(vs19)
print i(vs20) i(vs21) i(vs22) i(vs23) i(vs24) i(vs25) i(vs26) i(vs27) i(vs28) i(vs29)
print i(vs30) i(vs31) i(vs32)
.endc
.end
