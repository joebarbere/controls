controls oracle ac-0217
* Generated (plan F2.7, ADR 0012): do not edit; regenerate with `pnpm sim oracle regen`. ac seed 20261031 index 217 nodes 18 elements 29
.options sparse gmin=1e-12 noopac
RG1 1 0 1000000000000
RG2 2 0 1000000000000
RG3 3 0 1000000000000
RG4 4 0 1000000000000
RG5 5 0 1000000000000
RG6 6 0 1000000000000
RG7 7 0 1000000000000
RG8 8 0 1000000000000
RG9 9 0 1000000000000
RG10 10 0 1000000000000
RG11 11 0 1000000000000
RG12 12 0 1000000000000
RG13 13 0 1000000000000
RG14 14 0 1000000000000
RG15 15 0 1000000000000
RG16 16 0 1000000000000
RG17 17 0 1000000000000
VS0 0 s0 0
V0 e0 s0 DC 0 AC 33e1 -120
RI0 e0 12 47e-3
VS1 3 s1 0
C1 s1 14 10e-7
VS2 6 s2 0
R2 s2 4 47e2
VS3 5 s3 0
R3 s3 13 10e-2
VS4 16 s4 0
R4 s4 17 18e-2
VS5 3 s5 0
L5 s5 1 47e-4
VS6 0 s6 0
C6 s6 6 68e-7
VS7 16 s7 0
L7 s7 5 39e-5
VS8 10 s8 0
L8 s8 11 15e-3
VS9 15 s9 0
C9 s9 17 82e-6
VS10 1 s10 0
V10 e10 s10 DC 0 AC 18e-1 0
RI10 e10 11 12e-3
VS11 5 s11 0
L11 s11 6 18e-4
VS12 7 s12 0
R12 s12 6 82e1
VS13 7 s13 0
V13 e13 s13 DC 0 AC 82e1 120
RI13 e13 13 22e-1
VS14 8 s14 0
R14 s14 15 10e1
VS15 3 s15 0
C15 s15 9 10e-7
VS16 17 s16 0
V16 e16 s16 DC 0 AC 15e1 -120
RI16 e16 8 33e-1
VS17 2 s17 0
R17 s17 9 18e1
VS18 11 s18 0
C18 s18 2 27e-4
VS19 17 s19 0
V19 e19 s19 DC 0 AC 82e1 180
RI19 e19 11 33e-2
VS20 17 s20 0
L20 s20 7 27e-3
VS21 5 s21 0
L21 s21 12 10e-3
VS22 10 s22 0
L22 s22 1 15e-3
VS23 5 s23 0
L23 s23 14 10e-2
VS24 3 s24 0
C24 s24 17 82e-4
VS25 5 s25 0
V25 e25 s25 DC 0 AC 47e1 -120
RI25 e25 m25 39e-3
LI25 m25 17 82e-6
VS26 9 s26 0
V26 e26 s26 DC 0 AC 15e0 0
RI26 e26 m26 82e-2
LI26 m26 3 12e-5
VS27 4 s27 0
R27 s27 8 39e-2
VS28 1 s28 0
L28 s28 5 82e-4
.control
set numdgt=17
ac lin 1 60 60
print v(1) v(2) v(3) v(4) v(5) v(6) v(7) v(8) v(9) v(10)
print v(11) v(12) v(13) v(14) v(15) v(16) v(17)
print i(vs0) i(vs1) i(vs2) i(vs3) i(vs4) i(vs5) i(vs6) i(vs7) i(vs8) i(vs9)
print i(vs10) i(vs11) i(vs12) i(vs13) i(vs14) i(vs15) i(vs16) i(vs17) i(vs18) i(vs19)
print i(vs20) i(vs21) i(vs22) i(vs23) i(vs24) i(vs25) i(vs26) i(vs27) i(vs28)
.endc
.end
