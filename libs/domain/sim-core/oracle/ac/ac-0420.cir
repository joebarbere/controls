controls oracle ac-0420
* Generated (plan F2.7, ADR 0012): do not edit; regenerate with `pnpm sim oracle regen`. ac seed 20261031 index 420 nodes 11 elements 15
.options sparse gmin=1e-12 noopac
RG1 1 0 1000000000000
RG2 2 0 1000000000000
RG3 3 0 1000000000000
RG4 4 0 1000000000000
RG5 5 0 1000000000000
RG6 6 0 1000000000000
RG7 7 0 1000000000000
RG8 8 0 1000000000000
RG9 9 0 1000000000000
RG10 10 0 1000000000000
VS0 5 s0 0
C0 s0 8 22e-6
VS1 3 s1 0
R1 s1 9 18e-1
VS2 1 s2 0
R2 s2 2 47e-1
VS3 4 s3 0
C3 s3 7 27e-7
VS4 8 s4 0
L4 s4 4 56e-3
VS5 4 s5 0
R5 s5 6 39e1
VS6 6 s6 0
R6 s6 10 22e3
VS7 0 s7 0
V7 e7 s7 DC 0 AC 47e1 120
RI7 e7 m7 22e-1
LI7 m7 9 47e-7
VS8 0 s8 0
V8 e8 s8 DC 0 AC 56e1 180
RI8 e8 m8 33e-3
LI8 m8 6 47e-6
VS9 0 s9 0
L9 s9 2 47e-2
VS10 7 s10 0
C10 s10 10 12e-7
VS11 6 s11 0
C11 s11 5 22e-4
VS12 1 s12 0
L12 s12 10 68e-4
VS13 3 s13 0
C13 s13 6 12e-6
VS14 10 s14 0
C14 s14 0 56e-7
.control
set numdgt=17
ac lin 1 60 60
print v(1) v(2) v(3) v(4) v(5) v(6) v(7) v(8) v(9) v(10)
print i(vs0) i(vs1) i(vs2) i(vs3) i(vs4) i(vs5) i(vs6) i(vs7) i(vs8) i(vs9)
print i(vs10) i(vs11) i(vs12) i(vs13) i(vs14)
.endc
.end
