controls oracle ac-0365
* Generated (plan F2.7, ADR 0012): do not edit; regenerate with `pnpm sim oracle regen`. ac seed 20261031 index 365 nodes 29 elements 31
.options sparse gmin=1e-12 noopac
RG1 1 0 1000000000000
RG2 2 0 1000000000000
RG3 3 0 1000000000000
RG4 4 0 1000000000000
RG5 5 0 1000000000000
RG6 6 0 1000000000000
RG7 7 0 1000000000000
RG8 8 0 1000000000000
RG9 9 0 1000000000000
RG10 10 0 1000000000000
RG11 11 0 1000000000000
RG12 12 0 1000000000000
RG13 13 0 1000000000000
RG14 14 0 1000000000000
RG15 15 0 1000000000000
RG16 16 0 1000000000000
RG17 17 0 1000000000000
RG18 18 0 1000000000000
RG19 19 0 1000000000000
RG20 20 0 1000000000000
RG21 21 0 1000000000000
RG22 22 0 1000000000000
RG23 23 0 1000000000000
RG24 24 0 1000000000000
RG25 25 0 1000000000000
RG26 26 0 1000000000000
RG27 27 0 1000000000000
RG28 28 0 1000000000000
VS0 4 s0 0
R0 s0 12 56e3
VS1 11 s1 0
R1 s1 16 18e-1
VS2 2 s2 0
C2 s2 22 12e-4
VS3 0 s3 0
V3 e3 s3 DC 0 AC 10e1 -120
RI3 e3 26 27e-2
VS4 13 s4 0
R4 s4 20 56e-1
VS5 16 s5 0
L5 s5 19 56e-3
VS6 16 s6 0
C6 s6 7 39e-6
VS7 28 s7 0
L7 s7 6 27e-3
VS8 24 s8 0
R8 s8 26 68e3
VS9 28 s9 0
R9 s9 8 68e0
VS10 2 s10 0
C10 s10 19 27e-7
VS11 26 s11 0
R11 s11 8 33e0
VS12 25 s12 0
R12 s12 18 68e1
VS13 16 s13 0
R13 s13 9 27e3
VS14 10 s14 0
R14 s14 16 82e-1
VS15 1 s15 0
V15 e15 s15 DC 0 AC 15e0 -120
RI15 e15 15 82e-1
VS16 14 s16 0
R16 s16 1 10e-2
VS17 12 s17 0
V17 e17 s17 DC 0 AC 15e0 180
RI17 e17 1 47e-1
VS18 26 s18 0
R18 s18 21 68e-2
VS19 18 s19 0
R19 s19 24 47e3
VS20 27 s20 0
L20 s20 19 10e-3
VS21 13 s21 0
L21 s21 19 33e-3
VS22 17 s22 0
R22 s22 19 33e-1
VS23 7 s23 0
R23 s23 27 47e3
VS24 19 s24 0
R24 s24 22 39e0
VS25 11 s25 0
R25 s25 3 56e1
VS26 24 s26 0
V26 e26 s26 DC 0 AC 39e1 0
RI26 e26 19 22e-2
VS27 18 s27 0
C27 s27 23 10e-7
VS28 1 s28 0
L28 s28 27 39e-3
VS29 23 s29 0
C29 s29 5 68e-6
VS30 19 s30 0
C30 s30 24 10e-4
.control
set numdgt=17
ac lin 1 60 60
print v(1) v(2) v(3) v(4) v(5) v(6) v(7) v(8) v(9) v(10)
print v(11) v(12) v(13) v(14) v(15) v(16) v(17) v(18) v(19) v(20)
print v(21) v(22) v(23) v(24) v(25) v(26) v(27) v(28)
print i(vs0) i(vs1) i(vs2) i(vs3) i(vs4) i(vs5) i(vs6) i(vs7) i(vs8) i(vs9)
print i(vs10) i(vs11) i(vs12) i(vs13) i(vs14) i(vs15) i(vs16) i(vs17) i(vs18) i(vs19)
print i(vs20) i(vs21) i(vs22) i(vs23) i(vs24) i(vs25) i(vs26) i(vs27) i(vs28) i(vs29)
print i(vs30)
.endc
.end
