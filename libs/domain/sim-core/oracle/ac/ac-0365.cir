controls oracle ac-0365
* Generated (plan F2.7, ADR 0012): do not edit; regenerate with `pnpm sim oracle regen`. ac seed 20261031 index 365 nodes 29 elements 47
.options sparse gmin=1e-12 noopac
RG1 1 0 1000000000000
RG2 2 0 1000000000000
RG3 3 0 1000000000000
RG4 4 0 1000000000000
RG5 5 0 1000000000000
RG6 6 0 1000000000000
RG7 7 0 1000000000000
RG8 8 0 1000000000000
RG9 9 0 1000000000000
RG10 10 0 1000000000000
RG11 11 0 1000000000000
RG12 12 0 1000000000000
RG13 13 0 1000000000000
RG14 14 0 1000000000000
RG15 15 0 1000000000000
RG16 16 0 1000000000000
RG17 17 0 1000000000000
RG18 18 0 1000000000000
RG19 19 0 1000000000000
RG20 20 0 1000000000000
RG21 21 0 1000000000000
RG22 22 0 1000000000000
RG23 23 0 1000000000000
RG24 24 0 1000000000000
RG25 25 0 1000000000000
RG26 26 0 1000000000000
RG27 27 0 1000000000000
RG28 28 0 1000000000000
VS0 12 s0 0
C0 s0 28 82e-5
VS1 27 s1 0
L1 s1 10 12e-3
VS2 21 s2 0
R2 s2 7 27e0
VS3 16 s3 0
L3 s3 2 82e-3
VS4 7 s4 0
C4 s4 22 33e-6
VS5 2 s5 0
L5 s5 10 22e-4
VS6 0 s6 0
V6 e6 s6 DC 0 AC 22e-1 -120
RI6 e6 18 56e-2
VS7 4 s7 0
L7 s7 8 39e-5
VS8 24 s8 0
L8 s8 25 18e-2
VS9 6 s9 0
L9 s9 23 33e-2
VS10 3 s10 0
R10 s10 25 47e-1
VS11 15 s11 0
L11 s11 1 33e-3
VS12 11 s12 0
R12 s12 15 27e3
VS13 22 s13 0
C13 s13 18 15e-5
VS14 0 s14 0
V14 e14 s14 DC 0 AC 39e1 0
RI14 e14 m14 22e-2
LI14 m14 19 18e-5
VS15 5 s15 0
V15 e15 s15 DC 0 AC 12e0 0
RI15 e15 9 18e-3
VS16 8 s16 0
L16 s16 21 10e-2
VS17 17 s17 0
R17 s17 3 22e1
VS18 14 s18 0
R18 s18 11 39e1
VS19 1 s19 0
C19 s19 13 27e-4
VS20 23 s20 0
R20 s20 8 12e2
VS21 17 s21 0
C21 s21 22 18e-4
VS22 18 s22 0
R22 s22 5 39e2
VS23 23 s23 0
C23 s23 24 15e-5
VS24 18 s24 0
R24 s24 0 47e3
VS25 19 s25 0
R25 s25 10 27e0
VS26 8 s26 0
R26 s26 17 33e1
VS27 9 s27 0
L27 s27 4 15e-5
VS28 1 s28 0
L28 s28 22 27e-2
VS29 7 s29 0
V29 e29 s29 DC 0 AC 68e0 180
RI29 e29 26 82e-3
VS30 2 s30 0
R30 s30 18 56e-2
VS31 27 s31 0
R31 s31 24 22e2
VS32 13 s32 0
R32 s32 25 12e3
VS33 0 s33 0
V33 e33 s33 DC 0 AC 39e-1 -120
RI33 e33 m33 82e-3
LI33 m33 20 22e-5
VS34 4 s34 0
L34 s34 5 56e-4
VS35 20 s35 0
C35 s35 6 10e-6
VS36 28 s36 0
R36 s36 23 15e3
VS37 6 s37 0
C37 s37 12 27e-4
VS38 13 s38 0
C38 s38 16 56e-7
VS39 16 s39 0
R39 s39 8 39e0
VS40 5 s40 0
V40 e40 s40 DC 0 AC 22e0 0
RI40 e40 11 27e-1
VS41 18 s41 0
L41 s41 24 33e-2
VS42 26 s42 0
L42 s42 2 18e-2
VS43 18 s43 0
V43 e43 s43 DC 0 AC 12e0 0
RI43 e43 m43 22e-3
LI43 m43 13 39e-5
VS44 2 s44 0
V44 e44 s44 DC 0 AC 39e1 0
RI44 e44 12 82e-2
VS45 0 s45 0
R45 s45 24 68e3
VS46 14 s46 0
R46 s46 22 15e1
.control
set numdgt=17
ac lin 1 60 60
print v(1) v(2) v(3) v(4) v(5) v(6) v(7) v(8) v(9) v(10)
print v(11) v(12) v(13) v(14) v(15) v(16) v(17) v(18) v(19) v(20)
print v(21) v(22) v(23) v(24) v(25) v(26) v(27) v(28)
print i(vs0) i(vs1) i(vs2) i(vs3) i(vs4) i(vs5) i(vs6) i(vs7) i(vs8) i(vs9)
print i(vs10) i(vs11) i(vs12) i(vs13) i(vs14) i(vs15) i(vs16) i(vs17) i(vs18) i(vs19)
print i(vs20) i(vs21) i(vs22) i(vs23) i(vs24) i(vs25) i(vs26) i(vs27) i(vs28) i(vs29)
print i(vs30) i(vs31) i(vs32) i(vs33) i(vs34) i(vs35) i(vs36) i(vs37) i(vs38) i(vs39)
print i(vs40) i(vs41) i(vs42) i(vs43) i(vs44) i(vs45) i(vs46)
.endc
.end
