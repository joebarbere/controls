controls oracle ac-0365
* Generated (plan F2.7, ADR 0012): do not edit; regenerate with `pnpm sim oracle regen`. ac seed 20261031 index 365 nodes 29 elements 42
.options sparse gmin=1e-12 noopac
RG1 1 0 1000000000000
RG2 2 0 1000000000000
RG3 3 0 1000000000000
RG4 4 0 1000000000000
RG5 5 0 1000000000000
RG6 6 0 1000000000000
RG7 7 0 1000000000000
RG8 8 0 1000000000000
RG9 9 0 1000000000000
RG10 10 0 1000000000000
RG11 11 0 1000000000000
RG12 12 0 1000000000000
RG13 13 0 1000000000000
RG14 14 0 1000000000000
RG15 15 0 1000000000000
RG16 16 0 1000000000000
RG17 17 0 1000000000000
RG18 18 0 1000000000000
RG19 19 0 1000000000000
RG20 20 0 1000000000000
RG21 21 0 1000000000000
RG22 22 0 1000000000000
RG23 23 0 1000000000000
RG24 24 0 1000000000000
RG25 25 0 1000000000000
RG26 26 0 1000000000000
RG27 27 0 1000000000000
RG28 28 0 1000000000000
VS0 10 s0 0
R0 s0 16 82e-1
VS1 2 s1 0
C1 s1 22 12e-4
VS2 0 s2 0
V2 e2 s2 DC 0 AC 39e1 0
RI2 e2 n2 22e-2
H2 n2 h2 VS5 10e-4
ED2 h2 19 d2 0 10e-5
F2 0 d2 VS5 1
LD2 d2 0 1
VS3 23 s3 0
C3 s3 5 68e-6
VS4 13 s4 0
R4 s4 20 56e-1
VS5 20 s5 0
V5 e5 s5 DC 0 AC 15e0 180
RI5 e5 m5 27e-3
LI5 m5 n5 47e-7
H5 n5 h5 VS2 10e-4
ED5 h5 10 d5 0 10e-5
F5 0 d5 VS2 1
LD5 d5 0 1
VS6 0 s6 0
R6 s6 24 68e3
VS7 25 s7 0
L7 s7 26 82e-4
VS8 25 s8 0
R8 s8 18 68e1
VS9 27 s9 0
L9 s9 19 10e-3
VS10 14 s10 0
R10 s10 5 27e-2
VS11 16 s11 0
L11 s11 19 56e-3
VS12 18 s12 0
C12 s12 23 10e-7
VS13 1 s13 0
V13 e13 s13 DC 0 AC 15e0 -120
RI13 e13 m13 82e-1
LI13 m13 15 15e-5
VS14 9 s14 0
L14 s14 18 56e-4
VS15 6 s15 0
L15 s15 12 15e-4
VS16 17 s16 0
R16 s16 7 27e3
VS17 16 s17 0
C17 s17 7 39e-6
VS18 24 s18 0
R18 s18 21 68e-2
VS19 21 s19 0
L19 s19 1 33e-5
VS20 18 s20 0
R20 s20 0 47e3
VS21 13 s21 0
L21 s21 19 33e-3
VS22 28 s22 0
R22 s22 8 68e0
VS23 19 s23 0
R23 s23 22 39e0
VS24 17 s24 0
R24 s24 19 33e-1
VS25 11 s25 0
R25 s25 3 56e1
VS26 22 s26 0
L26 s26 27 22e-4
VS27 28 s27 0
L27 s27 6 27e-3
VS28 24 s28 0
R28 s28 8 33e0
VS29 1 s29 0
L29 s29 27 39e-3
VS30 14 s30 0
R30 s30 1 10e-2
VS31 12 s31 0
V31 e31 s31 DC 0 AC 15e0 180
RI31 e31 m31 47e-1
LI31 m31 1 68e-6
VS32 26 s32 0
V32 e32 s32 DC 0 AC 10e1 -120
RI32 e32 24 27e-2
VS33 8 s33 0
R33 s33 3 39e-2
VS34 20 s34 0
L34 s34 17 68e-5
VS35 5 s35 0
R35 s35 4 82e1
VS36 15 s36 0
L36 s36 18 33e-2
VS37 16 s37 0
R37 s37 9 27e3
VS38 11 s38 0
R38 s38 16 18e-1
VS39 2 s39 0
C39 s39 19 27e-7
VS40 4 s40 0
R40 s40 12 56e3
VS41 7 s41 0
R41 s41 27 47e3
.control
set numdgt=17
ac lin 1 60 60
print v(1) v(2) v(3) v(4) v(5) v(6) v(7) v(8) v(9) v(10)
print v(11) v(12) v(13) v(14) v(15) v(16) v(17) v(18) v(19) v(20)
print v(21) v(22) v(23) v(24) v(25) v(26) v(27) v(28)
print i(vs0) i(vs1) i(vs2) i(vs3) i(vs4) i(vs5) i(vs6) i(vs7) i(vs8) i(vs9)
print i(vs10) i(vs11) i(vs12) i(vs13) i(vs14) i(vs15) i(vs16) i(vs17) i(vs18) i(vs19)
print i(vs20) i(vs21) i(vs22) i(vs23) i(vs24) i(vs25) i(vs26) i(vs27) i(vs28) i(vs29)
print i(vs30) i(vs31) i(vs32) i(vs33) i(vs34) i(vs35) i(vs36) i(vs37) i(vs38) i(vs39)
print i(vs40) i(vs41)
.endc
.end
