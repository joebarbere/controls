controls oracle ac-0110
* Generated (plan F2.7, ADR 0012): do not edit; regenerate with `pnpm sim oracle regen`. ac seed 20261031 index 110 nodes 9 elements 14
.options sparse gmin=1e-12 noopac
RG1 1 0 1000000000000
RG2 2 0 1000000000000
RG3 3 0 1000000000000
RG4 4 0 1000000000000
RG5 5 0 1000000000000
RG6 6 0 1000000000000
RG7 7 0 1000000000000
RG8 8 0 1000000000000
VS0 2 s0 0
R0 s0 0 82e1
VS1 1 s1 0
C1 s1 3 56e-5
VS2 1 s2 0
R2 s2 4 33e0
VS3 7 s3 0
R3 s3 3 12e-1
VS4 6 s4 0
L4 s4 5 82e-4
VS5 7 s5 0
L5 s5 1 22e-4
VS6 1 s6 0
C6 s6 4 18e-6
VS7 0 s7 0
V7 e7 s7 DC 0 AC 82e-1 120
RI7 e7 4 68e-3
VS8 5 s8 0
L8 s8 8 47e-3
VS9 7 s9 0
L9 s9 1 82e-2
VS10 8 s10 0
R10 s10 6 56e-1
VS11 5 s11 0
L11 s11 3 68e-2
VS12 0 s12 0
L12 s12 2 68e-3
VS13 0 s13 0
R13 s13 5 47e0
.control
set numdgt=17
ac lin 1 60 60
print v(1) v(2) v(3) v(4) v(5) v(6) v(7) v(8)
print i(vs0) i(vs1) i(vs2) i(vs3) i(vs4) i(vs5) i(vs6) i(vs7) i(vs8) i(vs9)
print i(vs10) i(vs11) i(vs12) i(vs13)
.endc
.end
