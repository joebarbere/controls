controls oracle ac-0110
* Generated (plan F2.7, ADR 0012): do not edit; regenerate with `pnpm sim oracle regen`. ac seed 20261031 index 110 nodes 9 elements 16
.options sparse gmin=1e-12 noopac
RG1 1 0 1000000000000
RG2 2 0 1000000000000
RG3 3 0 1000000000000
RG4 4 0 1000000000000
RG5 5 0 1000000000000
RG6 6 0 1000000000000
RG7 7 0 1000000000000
RG8 8 0 1000000000000
VS0 5 s0 0
L0 s0 8 47e-3
VS1 1 s1 0
R1 s1 4 33e0
VS2 8 s2 0
R2 s2 6 56e-1
VS3 1 s3 0
C3 s3 4 18e-6
VS4 0 s4 0
L4 s4 2 68e-3
VS5 7 s5 0
R5 s5 3 12e-1
VS6 6 s6 0
L6 s6 5 82e-4
VS7 2 s7 0
R7 s7 0 82e1
VS8 8 s8 0
R8 s8 3 33e-2
VS9 1 s9 0
C9 s9 3 56e-5
VS10 7 s10 0
L10 s10 1 22e-4
VS11 0 s11 0
V11 e11 s11 DC 0 AC 82e-1 120
RI11 e11 4 68e-3
VS12 0 s12 0
R12 s12 5 47e0
VS13 5 s13 0
L13 s13 3 68e-2
VS14 7 s14 0
L14 s14 1 82e-2
VS15 2 s15 0
L15 s15 1 15e-4
.control
set numdgt=17
ac lin 1 60 60
print v(1) v(2) v(3) v(4) v(5) v(6) v(7) v(8)
print i(vs0) i(vs1) i(vs2) i(vs3) i(vs4) i(vs5) i(vs6) i(vs7) i(vs8) i(vs9)
print i(vs10) i(vs11) i(vs12) i(vs13) i(vs14) i(vs15)
.endc
.end
