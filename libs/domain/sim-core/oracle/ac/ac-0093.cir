controls oracle ac-0093
* Generated (plan F2.7, ADR 0012): do not edit; regenerate with `pnpm sim oracle regen`. ac seed 20261031 index 93 nodes 4 elements 4
.options sparse gmin=1e-12 noopac
RG1 1 0 1000000000000
RG2 2 0 1000000000000
RG3 3 0 1000000000000
VS0 0 s0 0
V0 e0 s0 DC 0 AC 10e1 120
RI0 e0 1 39e-2
VS1 0 s1 0
R1 s1 1 33e0
VS2 1 s2 0
R2 s2 3 39e2
VS3 2 s3 0
R3 s3 0 10e2
.control
set numdgt=17
ac lin 1 60 60
print v(1) v(2) v(3)
print i(vs0) i(vs1) i(vs2) i(vs3)
.endc
.end
