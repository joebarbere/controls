controls oracle ac-0093
* Generated (plan F2.7, ADR 0012): do not edit; regenerate with `pnpm sim oracle regen`. ac seed 20261031 index 93 nodes 4 elements 6
.options sparse gmin=1e-12 noopac
RG1 1 0 1000000000000
RG2 2 0 1000000000000
RG3 3 0 1000000000000
VS0 2 s0 0
R0 s0 0 10e2
VS1 3 s1 0
L1 s1 0 33e-5
VS2 0 s2 0
V2 e2 s2 DC 0 AC 10e1 120
RI2 e2 1 39e-2
VS3 1 s3 0
R3 s3 3 39e2
VS4 0 s4 0
R4 s4 1 33e0
VS5 1 s5 0
R5 s5 2 47e-1
.control
set numdgt=17
ac lin 1 60 60
print v(1) v(2) v(3)
print i(vs0) i(vs1) i(vs2) i(vs3) i(vs4) i(vs5)
.endc
.end
