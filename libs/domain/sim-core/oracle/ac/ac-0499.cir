controls oracle ac-0499
* Generated (plan F2.7, ADR 0012): do not edit; regenerate with `pnpm sim oracle regen`. ac seed 20261031 index 499 nodes 12 elements 19
.options sparse gmin=1e-12 noopac
RG1 1 0 1000000000000
RG2 2 0 1000000000000
RG3 3 0 1000000000000
RG4 4 0 1000000000000
RG5 5 0 1000000000000
RG6 6 0 1000000000000
RG7 7 0 1000000000000
RG8 8 0 1000000000000
RG9 9 0 1000000000000
RG10 10 0 1000000000000
RG11 11 0 1000000000000
VS0 9 s0 0
L0 s0 6 47e-2
VS1 7 s1 0
R1 s1 5 47e2
VS2 0 s2 0
V2 e2 s2 DC 0 AC 47e0 0
RI2 e2 4 82e-2
VS3 1 s3 0
L3 s3 4 12e-4
VS4 6 s4 0
R4 s4 5 15e-2
VS5 10 s5 0
L5 s5 1 56e-4
VS6 1 s6 0
V6 e6 s6 DC 0 AC 22e-1 180
RI6 e6 m6 27e-2
LI6 m6 9 82e-7
VS7 0 s7 0
L7 s7 2 68e-4
VS8 0 s8 0
R8 s8 7 15e3
VS9 10 s9 0
L9 s9 11 12e-5
VS10 5 s10 0
R10 s10 10 10e0
VS11 0 s11 0
L11 s11 8 12e-4
VS12 4 s12 0
R12 s12 10 18e3
VS13 3 s13 0
L13 s13 1 33e-4
VS14 9 s14 0
R14 s14 0 12e-2
VS15 11 s15 0
L15 s15 2 82e-3
VS16 10 s16 0
V16 e16 s16 DC 0 AC 56e0 180
RI16 e16 6 39e-1
VS17 8 s17 0
C17 s17 6 56e-4
VS18 3 s18 0
L18 s18 0 33e-3
.control
set numdgt=17
ac lin 1 60 60
print v(1) v(2) v(3) v(4) v(5) v(6) v(7) v(8) v(9) v(10)
print v(11)
print i(vs0) i(vs1) i(vs2) i(vs3) i(vs4) i(vs5) i(vs6) i(vs7) i(vs8) i(vs9)
print i(vs10) i(vs11) i(vs12) i(vs13) i(vs14) i(vs15) i(vs16) i(vs17) i(vs18)
.endc
.end
