controls oracle ac-0137
* Generated (plan F2.7, ADR 0012): do not edit; regenerate with `pnpm sim oracle regen`. ac seed 20261031 index 137 nodes 22 elements 40
.options sparse gmin=1e-12 noopac
RG1 1 0 1000000000000
RG2 2 0 1000000000000
RG3 3 0 1000000000000
RG4 4 0 1000000000000
RG5 5 0 1000000000000
RG6 6 0 1000000000000
RG7 7 0 1000000000000
RG8 8 0 1000000000000
RG9 9 0 1000000000000
RG10 10 0 1000000000000
RG11 11 0 1000000000000
RG12 12 0 1000000000000
RG13 13 0 1000000000000
RG14 14 0 1000000000000
RG15 15 0 1000000000000
RG16 16 0 1000000000000
RG17 17 0 1000000000000
RG18 18 0 1000000000000
RG19 19 0 1000000000000
RG20 20 0 1000000000000
RG21 21 0 1000000000000
VS0 0 s0 0
V0 e0 s0 DC 0 AC 47e1 -120
RI0 e0 15 39e-3
VS1 12 s1 0
L1 s1 10 33e-5
VS2 11 s2 0
V2 e2 s2 DC 0 AC 68e0 180
RI2 e2 8 56e-1
VS3 11 s3 0
L3 s3 1 68e-4
VS4 0 s4 0
V4 e4 s4 DC 0 AC 68e1 120
RI4 e4 20 15e-1
VS5 21 s5 0
L5 s5 6 47e-4
VS6 13 s6 0
L6 s6 7 56e-3
VS7 8 s7 0
L7 s7 13 22e-4
VS8 7 s8 0
R8 s8 15 33e-1
VS9 12 s9 0
V9 e9 s9 DC 0 AC 15e1 0
RI9 e9 3 27e-3
VS10 2 s10 0
R10 s10 13 18e3
VS11 10 s11 0
R11 s11 2 27e2
VS12 19 s12 0
C12 s12 3 10e-6
VS13 18 s13 0
L13 s13 21 56e-2
VS14 3 s14 0
L14 s14 6 12e-3
VS15 15 s15 0
C15 s15 19 82e-5
VS16 4 s16 0
R16 s16 16 33e2
VS17 16 s17 0
L17 s17 2 18e-3
VS18 9 s18 0
R18 s18 17 47e-1
VS19 6 s19 0
R19 s19 18 22e-2
VS20 13 s20 0
V20 e20 s20 DC 0 AC 18e-1 0
RI20 e20 3 15e-1
VS21 8 s21 0
R21 s21 21 47e2
VS22 5 s22 0
C22 s22 6 10e-5
VS23 16 s23 0
L23 s23 11 56e-4
VS24 9 s24 0
L24 s24 2 39e-3
VS25 0 s25 0
R25 s25 4 15e-1
VS26 5 s26 0
L26 s26 19 27e-4
VS27 4 s27 0
L27 s27 5 33e-4
VS28 6 s28 0
R28 s28 1 10e3
VS29 21 s29 0
V29 e29 s29 DC 0 AC 82e1 -120
RI29 e29 m29 47e-3
LI29 m29 20 27e-7
VS30 14 s30 0
R30 s30 2 56e-1
VS31 17 s31 0
V31 e31 s31 DC 0 AC 68e-1 -120
RI31 e31 6 18e-3
VS32 3 s32 0
V32 e32 s32 DC 0 AC 15e-1 -120
RI32 e32 20 39e-3
VS33 9 s33 0
C33 s33 11 15e-6
VS34 19 s34 0
C34 s34 3 22e-7
VS35 15 s35 0
R35 s35 14 10e3
VS36 7 s36 0
R36 s36 10 27e2
VS37 15 s37 0
R37 s37 11 39e1
VS38 8 s38 0
V38 e38 s38 DC 0 AC 33e-1 180
RI38 e38 m38 68e-1
LI38 m38 20 68e-5
VS39 2 s39 0
V39 e39 s39 DC 0 AC 10e1 180
RI39 e39 14 33e-2
.control
set numdgt=17
ac lin 1 60 60
print v(1) v(2) v(3) v(4) v(5) v(6) v(7) v(8) v(9) v(10)
print v(11) v(12) v(13) v(14) v(15) v(16) v(17) v(18) v(19) v(20)
print v(21)
print i(vs0) i(vs1) i(vs2) i(vs3) i(vs4) i(vs5) i(vs6) i(vs7) i(vs8) i(vs9)
print i(vs10) i(vs11) i(vs12) i(vs13) i(vs14) i(vs15) i(vs16) i(vs17) i(vs18) i(vs19)
print i(vs20) i(vs21) i(vs22) i(vs23) i(vs24) i(vs25) i(vs26) i(vs27) i(vs28) i(vs29)
print i(vs30) i(vs31) i(vs32) i(vs33) i(vs34) i(vs35) i(vs36) i(vs37) i(vs38) i(vs39)
.endc
.end
