controls oracle ac-0137
* Generated (plan F2.7, ADR 0012): do not edit; regenerate with `pnpm sim oracle regen`. ac seed 20261031 index 137 nodes 22 elements 30
.options sparse gmin=1e-12 noopac
RG1 1 0 1000000000000
RG2 2 0 1000000000000
RG3 3 0 1000000000000
RG4 4 0 1000000000000
RG5 5 0 1000000000000
RG6 6 0 1000000000000
RG7 7 0 1000000000000
RG8 8 0 1000000000000
RG9 9 0 1000000000000
RG10 10 0 1000000000000
RG11 11 0 1000000000000
RG12 12 0 1000000000000
RG13 13 0 1000000000000
RG14 14 0 1000000000000
RG15 15 0 1000000000000
RG16 16 0 1000000000000
RG17 17 0 1000000000000
RG18 18 0 1000000000000
RG19 19 0 1000000000000
RG20 20 0 1000000000000
RG21 21 0 1000000000000
VS0 0 s0 0
V0 e0 s0 DC 0 AC 12e1 180
RI0 e0 12 15e-2
VS1 20 s1 0
L1 s1 18 18e-3
VS2 11 s2 0
L2 s2 2 47e-3
VS3 9 s3 0
L3 s3 7 33e-5
VS4 2 s4 0
R4 s4 0 18e3
VS5 4 s5 0
R5 s5 5 47e0
VS6 19 s6 0
R6 s6 13 10e3
VS7 13 s7 0
R7 s7 3 33e2
VS8 21 s8 0
V8 e8 s8 DC 0 AC 47e1 120
RI8 e8 4 15e-1
VS9 8 s9 0
C9 s9 6 15e-7
VS10 9 s10 0
L10 s10 5 15e-3
VS11 15 s11 0
C11 s11 3 10e-5
VS12 4 s12 0
L12 s12 5 33e-4
VS13 3 s13 0
R13 s13 17 82e-1
VS14 7 s14 0
R14 s14 15 33e-1
VS15 16 s15 0
R15 s15 11 27e2
VS16 0 s16 0
C16 s16 20 82e-5
VS17 10 s17 0
R17 s17 3 56e-1
VS18 14 s18 0
R18 s18 21 10e2
VS19 17 s19 0
C19 s19 9 12e-7
VS20 7 s20 0
L20 s20 8 39e-2
VS21 17 s21 0
R21 s21 2 22e-1
VS22 1 s22 0
C22 s22 10 56e-5
VS23 12 s23 0
L23 s23 6 39e-3
VS24 21 s24 0
R24 s24 3 18e0
VS25 10 s25 0
V25 e25 s25 DC 0 AC 15e-1 -120
RI25 e25 1 39e-3
VS26 17 s26 0
V26 e26 s26 DC 0 AC 68e-1 -120
RI26 e26 6 18e-3
VS27 6 s27 0
R27 s27 18 18e1
VS28 8 s28 0
R28 s28 21 47e2
VS29 15 s29 0
R29 s29 11 39e1
.control
set numdgt=17
ac lin 1 60 60
print v(1) v(2) v(3) v(4) v(5) v(6) v(7) v(8) v(9) v(10)
print v(11) v(12) v(13) v(14) v(15) v(16) v(17) v(18) v(19) v(20)
print v(21)
print i(vs0) i(vs1) i(vs2) i(vs3) i(vs4) i(vs5) i(vs6) i(vs7) i(vs8) i(vs9)
print i(vs10) i(vs11) i(vs12) i(vs13) i(vs14) i(vs15) i(vs16) i(vs17) i(vs18) i(vs19)
print i(vs20) i(vs21) i(vs22) i(vs23) i(vs24) i(vs25) i(vs26) i(vs27) i(vs28) i(vs29)
.endc
.end
