controls oracle ac-0063
* Generated (plan F2.7, ADR 0012): do not edit; regenerate with `pnpm sim oracle regen`. ac seed 20261031 index 63 nodes 25 elements 47
.options sparse gmin=1e-12 noopac
RG1 1 0 1000000000000
RG2 2 0 1000000000000
RG3 3 0 1000000000000
RG4 4 0 1000000000000
RG5 5 0 1000000000000
RG6 6 0 1000000000000
RG7 7 0 1000000000000
RG8 8 0 1000000000000
RG9 9 0 1000000000000
RG10 10 0 1000000000000
RG11 11 0 1000000000000
RG12 12 0 1000000000000
RG13 13 0 1000000000000
RG14 14 0 1000000000000
RG15 15 0 1000000000000
RG16 16 0 1000000000000
RG17 17 0 1000000000000
RG18 18 0 1000000000000
RG19 19 0 1000000000000
RG20 20 0 1000000000000
RG21 21 0 1000000000000
RG22 22 0 1000000000000
RG23 23 0 1000000000000
RG24 24 0 1000000000000
VS0 16 s0 0
R0 s0 17 12e1
VS1 19 s1 0
R1 s1 12 56e-2
VS2 0 s2 0
V2 e2 s2 DC 0 AC 82e-1 180
RI2 e2 1 15e-3
VS3 17 s3 0
R3 s3 3 10e0
VS4 11 s4 0
R4 s4 3 18e0
VS5 2 s5 0
V5 e5 s5 DC 0 AC 10e1 120
RI5 e5 m5 39e-2
LI5 m5 15 22e-6
VS6 8 s6 0
R6 s6 2 68e0
VS7 14 s7 0
R7 s7 1 15e3
VS8 20 s8 0
L8 s8 14 15e-4
VS9 15 s9 0
R9 s9 22 47e-2
VS10 13 s10 0
V10 e10 s10 DC 0 AC 47e0 120
RI10 e10 m10 39e-3
LI10 m10 8 18e-6
VS11 1 s11 0
V11 e11 s11 DC 0 AC 82e-1 -120
RI11 e11 m11 47e-1
LI11 m11 2 12e-5
VS12 23 s12 0
C12 s12 2 68e-4
VS13 22 s13 0
R13 s13 19 68e2
VS14 18 s14 0
L14 s14 8 39e-4
VS15 23 s15 0
R15 s15 8 15e1
VS16 20 s16 0
R16 s16 17 68e-2
VS17 5 s17 0
R17 s17 2 68e2
VS18 17 s18 0
V18 e18 s18 DC 0 AC 39e0 180
RI18 e18 21 12e-3
VS19 7 s19 0
C19 s19 14 10e-4
VS20 9 s20 0
V20 e20 s20 DC 0 AC 27e1 -120
RI20 e20 m20 12e-3
LI20 m20 17 12e-5
VS21 10 s21 0
R21 s21 5 39e2
VS22 22 s22 0
V22 e22 s22 DC 0 AC 27e-1 0
RI22 e22 m22 10e-1
LI22 m22 17 27e-6
VS23 21 s23 0
R23 s23 20 47e1
VS24 18 s24 0
R24 s24 16 56e1
VS25 3 s25 0
L25 s25 4 18e-5
VS26 19 s26 0
V26 e26 s26 DC 0 AC 47e0 120
RI26 e26 m26 15e-3
LI26 m26 13 82e-6
VS27 21 s27 0
L27 s27 18 82e-5
VS28 20 s28 0
R28 s28 4 82e0
VS29 11 s29 0
V29 e29 s29 DC 0 AC 47e1 -120
RI29 e29 m29 47e-3
LI29 m29 4 68e-5
VS30 18 s30 0
R30 s30 24 12e-1
VS31 7 s31 0
V31 e31 s31 DC 0 AC 82e1 180
RI31 e31 5 56e-1
VS32 13 s32 0
V32 e32 s32 DC 0 AC 10e-1 120
RI32 e32 m32 39e-3
LI32 m32 15 33e-6
VS33 11 s33 0
R33 s33 6 39e3
VS34 16 s34 0
R34 s34 8 39e-1
VS35 16 s35 0
C35 s35 17 82e-6
VS36 10 s36 0
V36 e36 s36 DC 0 AC 18e1 -120
RI36 e36 12 12e-2
VS37 17 s37 0
L37 s37 11 10e-5
VS38 11 s38 0
L38 s38 9 18e-3
VS39 2 s39 0
L39 s39 0 18e-5
VS40 1 s40 0
R40 s40 12 33e-2
VS41 10 s41 0
V41 e41 s41 DC 0 AC 68e-1 180
RI41 e41 12 33e-3
VS42 17 s42 0
R42 s42 24 10e0
VS43 1 s43 0
L43 s43 8 47e-2
VS44 14 s44 0
R44 s44 6 12e2
VS45 22 s45 0
V45 e45 s45 DC 0 AC 22e1 120
RI45 e45 8 82e-1
VS46 3 s46 0
L46 s46 9 22e-3
.control
set numdgt=17
ac lin 1 60 60
print v(1) v(2) v(3) v(4) v(5) v(6) v(7) v(8) v(9) v(10)
print v(11) v(12) v(13) v(14) v(15) v(16) v(17) v(18) v(19) v(20)
print v(21) v(22) v(23) v(24)
print i(vs0) i(vs1) i(vs2) i(vs3) i(vs4) i(vs5) i(vs6) i(vs7) i(vs8) i(vs9)
print i(vs10) i(vs11) i(vs12) i(vs13) i(vs14) i(vs15) i(vs16) i(vs17) i(vs18) i(vs19)
print i(vs20) i(vs21) i(vs22) i(vs23) i(vs24) i(vs25) i(vs26) i(vs27) i(vs28) i(vs29)
print i(vs30) i(vs31) i(vs32) i(vs33) i(vs34) i(vs35) i(vs36) i(vs37) i(vs38) i(vs39)
print i(vs40) i(vs41) i(vs42) i(vs43) i(vs44) i(vs45) i(vs46)
.endc
.end
