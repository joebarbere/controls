controls oracle ac-0063
* Generated (plan F2.7, ADR 0012): do not edit; regenerate with `pnpm sim oracle regen`. ac seed 20261031 index 63 nodes 25 elements 36
.options sparse gmin=1e-12 noopac
RG1 1 0 1000000000000
RG2 2 0 1000000000000
RG3 3 0 1000000000000
RG4 4 0 1000000000000
RG5 5 0 1000000000000
RG6 6 0 1000000000000
RG7 7 0 1000000000000
RG8 8 0 1000000000000
RG9 9 0 1000000000000
RG10 10 0 1000000000000
RG11 11 0 1000000000000
RG12 12 0 1000000000000
RG13 13 0 1000000000000
RG14 14 0 1000000000000
RG15 15 0 1000000000000
RG16 16 0 1000000000000
RG17 17 0 1000000000000
RG18 18 0 1000000000000
RG19 19 0 1000000000000
RG20 20 0 1000000000000
RG21 21 0 1000000000000
RG22 22 0 1000000000000
RG23 23 0 1000000000000
RG24 24 0 1000000000000
VS0 22 s0 0
R0 s0 16 82e0
VS1 21 s1 0
R1 s1 3 47e2
VS2 0 s2 0
V2 e2 s2 DC 0 AC 47e1 -120
RI2 e2 21 47e-3
VS3 8 s3 0
V3 e3 s3 DC 0 AC 12e1 0
RI3 e3 14 47e-3
VS4 7 s4 0
R4 s4 17 68e2
VS5 17 s5 0
R5 s5 8 56e2
VS6 19 s6 0
R6 s6 0 22e-1
VS7 1 s7 0
L7 s7 20 22e-5
VS8 18 s8 0
C8 s8 23 39e-5
VS9 3 s9 0
R9 s9 2 68e2
VS10 6 s10 0
R10 s10 15 15e-2
VS11 24 s11 0
R11 s11 17 18e-1
VS12 4 s12 0
R12 s12 18 56e0
VS13 2 s13 0
R13 s13 22 47e2
VS14 23 s14 0
L14 s14 5 18e-3
VS15 12 s15 0
R15 s15 17 18e1
VS16 6 s16 0
C16 s16 12 10e-6
VS17 10 s17 0
V17 e17 s17 DC 0 AC 82e1 180
RI17 e17 2 56e-1
VS18 7 s18 0
R18 s18 0 47e1
VS19 11 s19 0
C19 s19 2 18e-7
VS20 18 s20 0
L20 s20 12 15e-5
VS21 16 s21 0
V21 e21 s21 DC 0 AC 39e0 -120
RI21 e21 20 22e-2
VS22 16 s22 0
C22 s22 9 68e-5
VS23 1 s23 0
R23 s23 23 12e-1
VS24 8 s24 0
R24 s24 13 33e1
VS25 21 s25 0
R25 s25 14 47e-1
VS26 11 s26 0
R26 s26 16 68e3
VS27 3 s27 0
R27 s27 24 82e3
VS28 12 s28 0
C28 s28 13 47e-4
VS29 19 s29 0
V29 e29 s29 DC 0 AC 27e-1 0
RI29 e29 17 10e-1
VS30 11 s30 0
V30 e30 s30 DC 0 AC 15e1 120
RI30 e30 17 22e-3
VS31 9 s31 0
C31 s31 17 33e-6
VS32 0 s32 0
R32 s32 10 33e-1
VS33 5 s33 0
R33 s33 4 10e0
VS34 16 s34 0
R34 s34 15 68e1
VS35 23 s35 0
C35 s35 0 33e-5
.control
set numdgt=17
ac lin 1 60 60
print v(1) v(2) v(3) v(4) v(5) v(6) v(7) v(8) v(9) v(10)
print v(11) v(12) v(13) v(14) v(15) v(16) v(17) v(18) v(19) v(20)
print v(21) v(22) v(23) v(24)
print i(vs0) i(vs1) i(vs2) i(vs3) i(vs4) i(vs5) i(vs6) i(vs7) i(vs8) i(vs9)
print i(vs10) i(vs11) i(vs12) i(vs13) i(vs14) i(vs15) i(vs16) i(vs17) i(vs18) i(vs19)
print i(vs20) i(vs21) i(vs22) i(vs23) i(vs24) i(vs25) i(vs26) i(vs27) i(vs28) i(vs29)
print i(vs30) i(vs31) i(vs32) i(vs33) i(vs34) i(vs35)
.endc
.end
