controls oracle ac-0063
* Generated (plan F2.7, ADR 0012): do not edit; regenerate with `pnpm sim oracle regen`. ac seed 20261031 index 63 nodes 25 elements 28
.options sparse gmin=1e-12 noopac
RG1 1 0 1000000000000
RG2 2 0 1000000000000
RG3 3 0 1000000000000
RG4 4 0 1000000000000
RG5 5 0 1000000000000
RG6 6 0 1000000000000
RG7 7 0 1000000000000
RG8 8 0 1000000000000
RG9 9 0 1000000000000
RG10 10 0 1000000000000
RG11 11 0 1000000000000
RG12 12 0 1000000000000
RG13 13 0 1000000000000
RG14 14 0 1000000000000
RG15 15 0 1000000000000
RG16 16 0 1000000000000
RG17 17 0 1000000000000
RG18 18 0 1000000000000
RG19 19 0 1000000000000
RG20 20 0 1000000000000
RG21 21 0 1000000000000
RG22 22 0 1000000000000
RG23 23 0 1000000000000
RG24 24 0 1000000000000
VS0 11 s0 0
R0 s0 16 68e3
VS1 3 s1 0
R1 s1 2 68e2
VS2 18 s2 0
L2 s2 12 15e-5
VS3 17 s3 0
R3 s3 8 56e2
VS4 22 s4 0
R4 s4 16 82e0
VS5 1 s5 0
R5 s5 23 12e-1
VS6 16 s6 0
C6 s6 9 68e-5
VS7 23 s7 0
C7 s7 0 33e-5
VS8 19 s8 0
R8 s8 0 22e-1
VS9 6 s9 0
R9 s9 15 15e-2
VS10 23 s10 0
L10 s10 5 18e-3
VS11 0 s11 0
V11 e11 s11 DC 0 AC 47e1 -120
RI11 e11 21 47e-3
VS12 18 s12 0
C12 s12 23 39e-5
VS13 9 s13 0
C13 s13 17 33e-6
VS14 12 s14 0
R14 s14 17 18e1
VS15 21 s15 0
R15 s15 14 47e-1
VS16 7 s16 0
R16 s16 0 47e1
VS17 11 s17 0
C17 s17 2 18e-7
VS18 7 s18 0
R18 s18 17 68e2
VS19 16 s19 0
V19 e19 s19 DC 0 AC 39e0 -120
RI19 e19 20 22e-2
VS20 12 s20 0
C20 s20 13 47e-4
VS21 24 s21 0
R21 s21 17 18e-1
VS22 19 s22 0
V22 e22 s22 DC 0 AC 27e-1 0
RI22 e22 17 10e-1
VS23 16 s23 0
R23 s23 15 68e1
VS24 11 s24 0
V24 e24 s24 DC 0 AC 15e1 120
RI24 e24 17 22e-3
VS25 10 s25 0
V25 e25 s25 DC 0 AC 82e1 180
RI25 e25 2 56e-1
VS26 5 s26 0
R26 s26 4 10e0
VS27 2 s27 0
R27 s27 22 47e2
.control
set numdgt=17
ac lin 1 60 60
print v(1) v(2) v(3) v(4) v(5) v(6) v(7) v(8) v(9) v(10)
print v(11) v(12) v(13) v(14) v(15) v(16) v(17) v(18) v(19) v(20)
print v(21) v(22) v(23) v(24)
print i(vs0) i(vs1) i(vs2) i(vs3) i(vs4) i(vs5) i(vs6) i(vs7) i(vs8) i(vs9)
print i(vs10) i(vs11) i(vs12) i(vs13) i(vs14) i(vs15) i(vs16) i(vs17) i(vs18) i(vs19)
print i(vs20) i(vs21) i(vs22) i(vs23) i(vs24) i(vs25) i(vs26) i(vs27)
.endc
.end
