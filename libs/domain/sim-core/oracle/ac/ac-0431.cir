controls oracle ac-0431
* Generated (plan F2.7, ADR 0012): do not edit; regenerate with `pnpm sim oracle regen`. ac seed 20261031 index 431 nodes 20 elements 36
.options sparse gmin=1e-12 noopac
RG1 1 0 1000000000000
RG2 2 0 1000000000000
RG3 3 0 1000000000000
RG4 4 0 1000000000000
RG5 5 0 1000000000000
RG6 6 0 1000000000000
RG7 7 0 1000000000000
RG8 8 0 1000000000000
RG9 9 0 1000000000000
RG10 10 0 1000000000000
RG11 11 0 1000000000000
RG12 12 0 1000000000000
RG13 13 0 1000000000000
RG14 14 0 1000000000000
RG15 15 0 1000000000000
RG16 16 0 1000000000000
RG17 17 0 1000000000000
RG18 18 0 1000000000000
RG19 19 0 1000000000000
VS0 8 s0 0
L0 s0 18 82e-5
VS1 3 s1 0
L1 s1 9 15e-4
VS2 12 s2 0
L2 s2 0 18e-3
VS3 3 s3 0
L3 s3 5 15e-4
VS4 19 s4 0
R4 s4 18 15e1
VS5 0 s5 0
V5 e5 s5 DC 0 AC 18e0 -120
RI5 e5 m5 39e-3
LI5 m5 15 27e-7
VS6 10 s6 0
L6 s6 11 27e-3
VS7 8 s7 0
R7 s7 15 12e-2
VS8 5 s8 0
L8 s8 0 27e-4
VS9 4 s9 0
L9 s9 18 18e-2
VS10 18 s10 0
C10 s10 11 10e-4
VS11 3 s11 0
L11 s11 15 33e-3
VS12 7 s12 0
L12 s12 6 56e-5
VS13 11 s13 0
R13 s13 8 33e-1
VS14 11 s14 0
L14 s14 0 56e-4
VS15 13 s15 0
R15 s15 9 12e2
VS16 7 s16 0
R16 s16 12 12e3
VS17 2 s17 0
C17 s17 1 22e-4
VS18 7 s18 0
L18 s18 19 33e-2
VS19 16 s19 0
R19 s19 3 10e-1
VS20 17 s20 0
R20 s20 3 68e1
VS21 1 s21 0
V21 e21 s21 DC 0 AC 47e0 120
RI21 e21 12 33e-3
VS22 10 s22 0
R22 s22 8 12e-2
VS23 14 s23 0
C23 s23 13 68e-5
VS24 9 s24 0
R24 s24 2 12e-2
VS25 1 s25 0
V25 e25 s25 DC 0 AC 27e-1 0
RI25 e25 m25 15e-2
LI25 m25 8 12e-6
VS26 0 s26 0
L26 s26 18 22e-2
VS27 16 s27 0
R27 s27 14 10e-1
VS28 10 s28 0
V28 e28 s28 DC 0 AC 82e1 120
RI28 e28 11 27e-3
VS29 8 s29 0
R29 s29 16 27e2
VS30 0 s30 0
R30 s30 3 39e1
VS31 3 s31 0
R31 s31 4 15e3
VS32 12 s32 0
C32 s32 6 68e-4
VS33 15 s33 0
L33 s33 17 27e-2
VS34 15 s34 0
V34 e34 s34 DC 0 AC 12e1 180
RI34 e34 2 33e-2
VS35 6 s35 0
V35 e35 s35 DC 0 AC 33e-1 120
RI35 e35 m35 12e-1
LI35 m35 3 22e-5
.control
set numdgt=17
ac lin 1 60 60
print v(1) v(2) v(3) v(4) v(5) v(6) v(7) v(8) v(9) v(10)
print v(11) v(12) v(13) v(14) v(15) v(16) v(17) v(18) v(19)
print i(vs0) i(vs1) i(vs2) i(vs3) i(vs4) i(vs5) i(vs6) i(vs7) i(vs8) i(vs9)
print i(vs10) i(vs11) i(vs12) i(vs13) i(vs14) i(vs15) i(vs16) i(vs17) i(vs18) i(vs19)
print i(vs20) i(vs21) i(vs22) i(vs23) i(vs24) i(vs25) i(vs26) i(vs27) i(vs28) i(vs29)
print i(vs30) i(vs31) i(vs32) i(vs33) i(vs34) i(vs35)
.endc
.end
