controls oracle ac-0061
* Generated (plan F2.7, ADR 0012): do not edit; regenerate with `pnpm sim oracle regen`. ac seed 20261031 index 61 nodes 15 elements 23
.options sparse gmin=1e-12 noopac
RG1 1 0 1000000000000
RG2 2 0 1000000000000
RG3 3 0 1000000000000
RG4 4 0 1000000000000
RG5 5 0 1000000000000
RG6 6 0 1000000000000
RG7 7 0 1000000000000
RG8 8 0 1000000000000
RG9 9 0 1000000000000
RG10 10 0 1000000000000
RG11 11 0 1000000000000
RG12 12 0 1000000000000
RG13 13 0 1000000000000
RG14 14 0 1000000000000
VS0 2 s0 0
R0 s0 11 47e2
VS1 2 s1 0
R1 s1 12 39e1
VS2 14 s2 0
L2 s2 13 56e-4
VS3 10 s3 0
C3 s3 11 15e-5
VS4 12 s4 0
R4 s4 8 56e1
VS5 1 s5 0
C5 s5 4 10e-6
VS6 12 s6 0
R6 s6 8 56e-2
VS7 11 s7 0
R7 s7 4 68e-1
VS8 9 s8 0
C8 s8 5 10e-4
VS9 9 s9 0
L9 s9 3 12e-2
VS10 10 s10 0
L10 s10 5 47e-2
VS11 0 s11 0
V11 e11 s11 DC 0 AC 15e-1 0
RI11 e11 3 15e-3
VS12 9 s12 0
L12 s12 4 82e-5
VS13 1 s13 0
L13 s13 10 33e-2
VS14 9 s14 0
C14 s14 3 33e-7
VS15 7 s15 0
C15 s15 14 12e-6
VS16 4 s16 0
R16 s16 7 82e-1
VS17 4 s17 0
L17 s17 0 18e-3
VS18 6 s18 0
R18 s18 11 15e2
VS19 11 s19 0
L19 s19 13 10e-5
VS20 1 s20 0
R20 s20 14 10e-1
VS21 2 s21 0
R21 s21 9 12e3
VS22 8 s22 0
L22 s22 4 47e-3
.control
set numdgt=17
ac lin 1 60 60
print v(1) v(2) v(3) v(4) v(5) v(6) v(7) v(8) v(9) v(10)
print v(11) v(12) v(13) v(14)
print i(vs0) i(vs1) i(vs2) i(vs3) i(vs4) i(vs5) i(vs6) i(vs7) i(vs8) i(vs9)
print i(vs10) i(vs11) i(vs12) i(vs13) i(vs14) i(vs15) i(vs16) i(vs17) i(vs18) i(vs19)
print i(vs20) i(vs21) i(vs22)
.endc
.end
