controls oracle ac-0061
* Generated (plan F2.7, ADR 0012): do not edit; regenerate with `pnpm sim oracle regen`. ac seed 20261031 index 61 nodes 15 elements 24
.options sparse gmin=1e-12 noopac
RG1 1 0 1000000000000
RG2 2 0 1000000000000
RG3 3 0 1000000000000
RG4 4 0 1000000000000
RG5 5 0 1000000000000
RG6 6 0 1000000000000
RG7 7 0 1000000000000
RG8 8 0 1000000000000
RG9 9 0 1000000000000
RG10 10 0 1000000000000
RG11 11 0 1000000000000
RG12 12 0 1000000000000
RG13 13 0 1000000000000
RG14 14 0 1000000000000
VS0 10 s0 0
C0 s0 11 15e-5
VS1 12 s1 0
R1 s1 8 56e1
VS2 10 s2 0
L2 s2 5 47e-2
VS3 9 s3 0
L3 s3 4 82e-5
VS4 0 s4 0
V4 e4 s4 DC 0 AC 15e-1 0
RI4 e4 3 15e-3
VS5 4 s5 0
L5 s5 0 18e-3
VS6 2 s6 0
R6 s6 11 47e2
VS7 11 s7 0
L7 s7 13 10e-5
VS8 14 s8 0
L8 s8 13 56e-4
VS9 9 s9 0
C9 s9 3 33e-7
VS10 1 s10 0
L10 s10 10 33e-2
VS11 1 s11 0
C11 s11 4 10e-6
VS12 2 s12 0
R12 s12 12 39e1
VS13 1 s13 0
R13 s13 14 10e-1
VS14 7 s14 0
C14 s14 14 12e-6
VS15 6 s15 0
R15 s15 11 15e2
VS16 8 s16 0
L16 s16 4 47e-3
VS17 2 s17 0
R17 s17 9 12e3
VS18 9 s18 0
L18 s18 3 12e-2
VS19 6 s19 0
C19 s19 7 18e-6
VS20 12 s20 0
R20 s20 8 56e-2
VS21 4 s21 0
R21 s21 7 82e-1
VS22 9 s22 0
C22 s22 5 10e-4
VS23 11 s23 0
R23 s23 4 68e-1
.control
set numdgt=17
ac lin 1 60 60
print v(1) v(2) v(3) v(4) v(5) v(6) v(7) v(8) v(9) v(10)
print v(11) v(12) v(13) v(14)
print i(vs0) i(vs1) i(vs2) i(vs3) i(vs4) i(vs5) i(vs6) i(vs7) i(vs8) i(vs9)
print i(vs10) i(vs11) i(vs12) i(vs13) i(vs14) i(vs15) i(vs16) i(vs17) i(vs18) i(vs19)
print i(vs20) i(vs21) i(vs22) i(vs23)
.endc
.end
