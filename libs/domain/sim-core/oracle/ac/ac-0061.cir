controls oracle ac-0061
* Generated (plan F2.7, ADR 0012): do not edit; regenerate with `pnpm sim oracle regen`. ac seed 20261031 index 61 nodes 15 elements 22
.options sparse gmin=1e-12 noopac
RG1 1 0 1000000000000
RG2 2 0 1000000000000
RG3 3 0 1000000000000
RG4 4 0 1000000000000
RG5 5 0 1000000000000
RG6 6 0 1000000000000
RG7 7 0 1000000000000
RG8 8 0 1000000000000
RG9 9 0 1000000000000
RG10 10 0 1000000000000
RG11 11 0 1000000000000
RG12 12 0 1000000000000
RG13 13 0 1000000000000
RG14 14 0 1000000000000
VS0 8 s0 0
R0 s0 14 18e-2
VS1 12 s1 0
C1 s1 13 39e-5
VS2 0 s2 0
V2 e2 s2 DC 0 AC 56e-1 -120
RI2 e2 m2 82e-2
LI2 m2 9 10e-7
VS3 14 s3 0
R3 s3 12 12e1
VS4 4 s4 0
V4 e4 s4 DC 0 AC 15e-1 0
RI4 e4 m4 15e-3
LI4 m4 3 47e-7
VS5 5 s5 0
R5 s5 1 15e-1
VS6 13 s6 0
L6 s6 4 18e-3
VS7 10 s7 0
R7 s7 4 18e2
VS8 0 s8 0
C8 s8 6 10e-7
VS9 5 s9 0
C9 s9 2 27e-5
VS10 3 s10 0
R10 s10 13 12e0
VS11 11 s11 0
R11 s11 6 15e0
VS12 2 s12 0
V12 e12 s12 DC 0 AC 27e1 0
RI12 e12 7 12e-1
VS13 7 s13 0
L13 s13 14 15e-2
VS14 13 s14 0
R14 s14 7 82e-1
VS15 7 s15 0
C15 s15 6 10e-7
VS16 10 s16 0
R16 s16 2 68e2
VS17 4 s17 0
V17 e17 s17 DC 0 AC 56e1 0
RI17 e17 m17 22e-2
LI17 m17 1 15e-6
VS18 13 s18 0
R18 s18 9 18e3
VS19 11 s19 0
R19 s19 13 68e-1
VS20 2 s20 0
C20 s20 12 22e-4
VS21 8 s21 0
L21 s21 0 27e-3
.control
set numdgt=17
ac lin 1 60 60
print v(1) v(2) v(3) v(4) v(5) v(6) v(7) v(8) v(9) v(10)
print v(11) v(12) v(13) v(14)
print i(vs0) i(vs1) i(vs2) i(vs3) i(vs4) i(vs5) i(vs6) i(vs7) i(vs8) i(vs9)
print i(vs10) i(vs11) i(vs12) i(vs13) i(vs14) i(vs15) i(vs16) i(vs17) i(vs18) i(vs19)
print i(vs20) i(vs21)
.endc
.end
