controls oracle ac-0097
* Generated (plan F2.7, ADR 0012): do not edit; regenerate with `pnpm sim oracle regen`. ac seed 20261031 index 97 nodes 17 elements 24
.options sparse gmin=1e-12 noopac
RG1 1 0 1000000000000
RG2 2 0 1000000000000
RG3 3 0 1000000000000
RG4 4 0 1000000000000
RG5 5 0 1000000000000
RG6 6 0 1000000000000
RG7 7 0 1000000000000
RG8 8 0 1000000000000
RG9 9 0 1000000000000
RG10 10 0 1000000000000
RG11 11 0 1000000000000
RG12 12 0 1000000000000
RG13 13 0 1000000000000
RG14 14 0 1000000000000
RG15 15 0 1000000000000
RG16 16 0 1000000000000
VS0 15 s0 0
L0 s0 8 12e-2
VS1 3 s1 0
C1 s1 4 68e-5
VS2 7 s2 0
L2 s2 16 27e-2
VS3 1 s3 0
R3 s3 8 18e1
VS4 8 s4 0
L4 s4 13 27e-4
VS5 0 s5 0
V5 e5 s5 DC 0 AC 12e1 120
RI5 e5 13 39e-2
VS6 9 s6 0
R6 s6 6 27e0
VS7 6 s7 0
V7 e7 s7 DC 0 AC 39e0 0
RI7 e7 12 10e-3
VS8 9 s8 0
C8 s8 13 56e-4
VS9 0 s9 0
C9 s9 10 39e-4
VS10 16 s10 0
R10 s10 2 39e-2
VS11 12 s11 0
V11 e11 s11 DC 0 AC 47e0 180
RI11 e11 6 10e-3
VS12 12 s12 0
R12 s12 14 82e1
VS13 10 s13 0
C13 s13 1 12e-7
VS14 3 s14 0
L14 s14 8 68e-5
VS15 7 s15 0
V15 e15 s15 DC 0 AC 12e-1 -120
RI15 e15 8 33e-3
VS16 1 s16 0
R16 s16 11 18e3
VS17 6 s17 0
L17 s17 5 12e-5
VS18 9 s18 0
C18 s18 16 82e-5
VS19 1 s19 0
R19 s19 5 18e1
VS20 3 s20 0
C20 s20 0 56e-6
VS21 2 s21 0
C21 s21 13 33e-7
VS22 12 s22 0
L22 s22 16 82e-5
VS23 7 s23 0
V23 e23 s23 DC 0 AC 47e-1 180
RI23 e23 9 10e-2
.control
set numdgt=17
ac lin 1 60 60
print v(1) v(2) v(3) v(4) v(5) v(6) v(7) v(8) v(9) v(10)
print v(11) v(12) v(13) v(14) v(15) v(16)
print i(vs0) i(vs1) i(vs2) i(vs3) i(vs4) i(vs5) i(vs6) i(vs7) i(vs8) i(vs9)
print i(vs10) i(vs11) i(vs12) i(vs13) i(vs14) i(vs15) i(vs16) i(vs17) i(vs18) i(vs19)
print i(vs20) i(vs21) i(vs22) i(vs23)
.endc
.end
