controls oracle ac-0097
* Generated (plan F2.7, ADR 0012): do not edit; regenerate with `pnpm sim oracle regen`. ac seed 20261031 index 97 nodes 17 elements 28
.options sparse gmin=1e-12 noopac
RG1 1 0 1000000000000
RG2 2 0 1000000000000
RG3 3 0 1000000000000
RG4 4 0 1000000000000
RG5 5 0 1000000000000
RG6 6 0 1000000000000
RG7 7 0 1000000000000
RG8 8 0 1000000000000
RG9 9 0 1000000000000
RG10 10 0 1000000000000
RG11 11 0 1000000000000
RG12 12 0 1000000000000
RG13 13 0 1000000000000
RG14 14 0 1000000000000
RG15 15 0 1000000000000
RG16 16 0 1000000000000
VS0 0 s0 0
V0 e0 s0 DC 0 AC 12e1 120
RI0 e0 13 39e-2
VS1 9 s1 0
C1 s1 13 56e-4
VS2 7 s2 0
V2 e2 s2 DC 0 AC 12e-1 -120
RI2 e2 8 33e-3
VS3 1 s3 0
R3 s3 11 18e3
VS4 3 s4 0
C4 s4 4 68e-5
VS5 13 s5 0
L5 s5 14 82e-5
VS6 10 s6 0
R6 s6 4 22e1
VS7 9 s7 0
C7 s7 16 82e-5
VS8 9 s8 0
R8 s8 6 27e0
VS9 10 s9 0
C9 s9 1 12e-7
VS10 15 s10 0
R10 s10 2 12e1
VS11 1 s11 0
R11 s11 8 18e1
VS12 7 s12 0
L12 s12 16 27e-2
VS13 15 s13 0
L13 s13 8 12e-2
VS14 12 s14 0
R14 s14 14 82e1
VS15 7 s15 0
V15 e15 s15 DC 0 AC 47e-1 180
RI15 e15 9 10e-2
VS16 12 s16 0
V16 e16 s16 DC 0 AC 47e0 180
RI16 e16 6 10e-3
VS17 0 s17 0
C17 s17 10 39e-4
VS18 2 s18 0
C18 s18 13 33e-7
VS19 3 s19 0
L19 s19 8 68e-5
VS20 1 s20 0
R20 s20 5 18e1
VS21 3 s21 0
R21 s21 11 22e3
VS22 6 s22 0
V22 e22 s22 DC 0 AC 39e0 0
RI22 e22 12 10e-3
VS23 3 s23 0
C23 s23 0 56e-6
VS24 6 s24 0
L24 s24 5 12e-5
VS25 16 s25 0
R25 s25 2 39e-2
VS26 12 s26 0
L26 s26 16 82e-5
VS27 8 s27 0
L27 s27 13 27e-4
.control
set numdgt=17
ac lin 1 60 60
print v(1) v(2) v(3) v(4) v(5) v(6) v(7) v(8) v(9) v(10)
print v(11) v(12) v(13) v(14) v(15) v(16)
print i(vs0) i(vs1) i(vs2) i(vs3) i(vs4) i(vs5) i(vs6) i(vs7) i(vs8) i(vs9)
print i(vs10) i(vs11) i(vs12) i(vs13) i(vs14) i(vs15) i(vs16) i(vs17) i(vs18) i(vs19)
print i(vs20) i(vs21) i(vs22) i(vs23) i(vs24) i(vs25) i(vs26) i(vs27)
.endc
.end
