controls oracle ac-0097
* Generated (plan F2.7, ADR 0012): do not edit; regenerate with `pnpm sim oracle regen`. ac seed 20261031 index 97 nodes 17 elements 31
.options sparse gmin=1e-12 noopac
RG1 1 0 1000000000000
RG2 2 0 1000000000000
RG3 3 0 1000000000000
RG4 4 0 1000000000000
RG5 5 0 1000000000000
RG6 6 0 1000000000000
RG7 7 0 1000000000000
RG8 8 0 1000000000000
RG9 9 0 1000000000000
RG10 10 0 1000000000000
RG11 11 0 1000000000000
RG12 12 0 1000000000000
RG13 13 0 1000000000000
RG14 14 0 1000000000000
RG15 15 0 1000000000000
RG16 16 0 1000000000000
VS0 12 s0 0
C0 s0 0 12e-6
VS1 11 s1 0
R1 s1 12 33e2
VS2 0 s2 0
V2 e2 s2 DC 0 AC 18e-1 0
RI2 e2 m2 47e-3
LI2 m2 7 18e-6
VS3 7 s3 0
R3 s3 4 15e-1
VS4 14 s4 0
C4 s4 7 56e-4
VS5 8 s5 0
V5 e5 s5 DC 0 AC 18e-1 -120
RI5 e5 14 18e-1
VS6 16 s6 0
R6 s6 8 18e1
VS7 0 s7 0
L7 s7 11 33e-4
VS8 11 s8 0
R8 s8 13 47e3
VS9 1 s9 0
L9 s9 8 82e-2
VS10 0 s10 0
V10 e10 s10 DC 0 AC 47e0 180
RI10 e10 2 33e-2
VS11 0 s11 0
R11 s11 13 56e1
VS12 0 s12 0
V12 e12 s12 DC 0 AC 47e0 180
RI12 e12 m12 12e-3
LI12 m12 10 10e-6
VS13 7 s13 0
L13 s13 10 10e-5
VS14 6 s14 0
C14 s14 7 33e-4
VS15 15 s15 0
L15 s15 8 12e-2
VS16 6 s16 0
L16 s16 16 82e-3
VS17 2 s17 0
R17 s17 13 33e0
VS18 0 s18 0
C18 s18 1 18e-7
VS19 9 s19 0
C19 s19 3 15e-6
VS20 8 s20 0
C20 s20 11 39e-6
VS21 5 s21 0
L21 s21 0 68e-2
VS22 10 s22 0
C22 s22 16 10e-7
VS23 5 s23 0
C23 s23 0 18e-4
VS24 15 s24 0
C24 s24 5 47e-4
VS25 12 s25 0
L25 s25 9 18e-4
VS26 7 s26 0
V26 e26 s26 DC 0 AC 12e-1 -120
RI26 e26 8 33e-3
VS27 3 s27 0
C27 s27 15 10e-7
VS28 7 s28 0
R28 s28 3 10e1
VS29 4 s29 0
R29 s29 11 27e2
VS30 8 s30 0
R30 s30 3 47e0
.control
set numdgt=17
ac lin 1 60 60
print v(1) v(2) v(3) v(4) v(5) v(6) v(7) v(8) v(9) v(10)
print v(11) v(12) v(13) v(14) v(15) v(16)
print i(vs0) i(vs1) i(vs2) i(vs3) i(vs4) i(vs5) i(vs6) i(vs7) i(vs8) i(vs9)
print i(vs10) i(vs11) i(vs12) i(vs13) i(vs14) i(vs15) i(vs16) i(vs17) i(vs18) i(vs19)
print i(vs20) i(vs21) i(vs22) i(vs23) i(vs24) i(vs25) i(vs26) i(vs27) i(vs28) i(vs29)
print i(vs30)
.endc
.end
