controls oracle ac-0426
* Generated (plan F2.7, ADR 0012): do not edit; regenerate with `pnpm sim oracle regen`. ac seed 20261031 index 426 nodes 15 elements 27
.options sparse gmin=1e-12 noopac
RG1 1 0 1000000000000
RG2 2 0 1000000000000
RG3 3 0 1000000000000
RG4 4 0 1000000000000
RG5 5 0 1000000000000
RG6 6 0 1000000000000
RG7 7 0 1000000000000
RG8 8 0 1000000000000
RG9 9 0 1000000000000
RG10 10 0 1000000000000
RG11 11 0 1000000000000
RG12 12 0 1000000000000
RG13 13 0 1000000000000
RG14 14 0 1000000000000
VS0 0 s0 0
V0 e0 s0 DC 0 AC 10e1 120
RI0 e0 m0 10e-1
LI0 m0 5 82e-6
VS1 8 s1 0
L1 s1 14 33e-3
VS2 4 s2 0
L2 s2 7 33e-2
VS3 5 s3 0
R3 s3 6 39e0
VS4 14 s4 0
L4 s4 3 33e-3
VS5 14 s5 0
C5 s5 3 47e-7
VS6 6 s6 0
R6 s6 7 12e0
VS7 1 s7 0
V7 e7 s7 DC 0 AC 47e0 -120
RI7 e7 8 39e-1
VS8 12 s8 0
V8 e8 s8 DC 0 AC 56e-1 120
RI8 e8 m8 15e-2
LI8 m8 11 22e-5
VS9 6 s9 0
V9 e9 s9 DC 0 AC 15e0 120
RI9 e9 13 56e-1
VS10 14 s10 0
R10 s10 2 27e-2
VS11 9 s11 0
R11 s11 3 33e3
VS12 9 s12 0
C12 s12 2 12e-4
VS13 10 s13 0
R13 s13 4 15e3
VS14 2 s14 0
L14 s14 11 33e-3
VS15 10 s15 0
R15 s15 14 68e0
VS16 12 s16 0
C16 s16 5 39e-6
VS17 4 s17 0
C17 s17 2 68e-4
VS18 9 s18 0
R18 s18 11 39e-2
VS19 0 s19 0
R19 s19 10 47e0
VS20 2 s20 0
R20 s20 13 12e1
VS21 10 s21 0
C21 s21 4 27e-6
VS22 9 s22 0
L22 s22 4 22e-5
VS23 12 s23 0
C23 s23 4 27e-7
VS24 8 s24 0
R24 s24 3 82e2
VS25 3 s25 0
V25 e25 s25 DC 0 AC 15e0 0
RI25 e25 m25 27e-1
LI25 m25 12 12e-7
VS26 6 s26 0
R26 s26 1 22e1
.control
set numdgt=17
ac lin 1 60 60
print v(1) v(2) v(3) v(4) v(5) v(6) v(7) v(8) v(9) v(10)
print v(11) v(12) v(13) v(14)
print i(vs0) i(vs1) i(vs2) i(vs3) i(vs4) i(vs5) i(vs6) i(vs7) i(vs8) i(vs9)
print i(vs10) i(vs11) i(vs12) i(vs13) i(vs14) i(vs15) i(vs16) i(vs17) i(vs18) i(vs19)
print i(vs20) i(vs21) i(vs22) i(vs23) i(vs24) i(vs25) i(vs26)
.endc
.end
