controls oracle ac-0008
* Generated (plan F2.7, ADR 0012): do not edit; regenerate with `pnpm sim oracle regen`. ac seed 20261031 index 8 nodes 21 elements 32
.options sparse gmin=1e-12 noopac
RG1 1 0 1000000000000
RG2 2 0 1000000000000
RG3 3 0 1000000000000
RG4 4 0 1000000000000
RG5 5 0 1000000000000
RG6 6 0 1000000000000
RG7 7 0 1000000000000
RG8 8 0 1000000000000
RG9 9 0 1000000000000
RG10 10 0 1000000000000
RG11 11 0 1000000000000
RG12 12 0 1000000000000
RG13 13 0 1000000000000
RG14 14 0 1000000000000
RG15 15 0 1000000000000
RG16 16 0 1000000000000
RG17 17 0 1000000000000
RG18 18 0 1000000000000
RG19 19 0 1000000000000
RG20 20 0 1000000000000
VS0 9 s0 0
L0 s0 11 27e-3
VS1 15 s1 0
L1 s1 20 39e-2
VS2 15 s2 0
R2 s2 19 10e-2
VS3 11 s3 0
L3 s3 14 33e-4
VS4 12 s4 0
C4 s4 16 47e-4
VS5 3 s5 0
C5 s5 12 15e-5
VS6 6 s6 0
L6 s6 18 15e-5
VS7 7 s7 0
R7 s7 17 82e1
VS8 8 s8 0
R8 s8 10 15e1
VS9 15 s9 0
R9 s9 20 56e0
VS10 2 s10 0
C10 s10 16 68e-4
VS11 0 s11 0
V11 e11 s11 DC 0 AC 15e1 120
RI11 e11 m11 68e-1
LI11 m11 n11 12e-5
H11 n11 h11 VS17 82e-4
ED11 h11 4 d11 0 47e-7
F11 0 d11 VS17 1
LD11 d11 0 1
VS12 2 s12 0
R12 s12 19 68e1
VS13 19 s13 0
R13 s13 10 15e-1
VS14 20 s14 0
L14 s14 1 68e-4
VS15 3 s15 0
R15 s15 0 10e-2
VS16 20 s16 0
C16 s16 19 27e-4
VS17 1 s17 0
V17 e17 s17 DC 0 AC 15e-1 120
RI17 e17 n17 47e-3
H17 n17 h17 VS11 82e-4
ED17 h17 7 d17 0 47e-7
F17 0 d17 VS11 1
LD17 d17 0 1
VS18 11 s18 0
R18 s18 7 18e-2
VS19 0 s19 0
V19 e19 s19 DC 0 AC 18e1 0
RI19 e19 m19 10e-2
LI19 m19 7 47e-6
VS20 9 s20 0
L20 s20 3 18e-3
VS21 7 s21 0
R21 s21 18 82e1
VS22 9 s22 0
L22 s22 13 15e-5
VS23 19 s23 0
R23 s23 6 15e1
VS24 17 s24 0
C24 s24 5 15e-5
VS25 5 s25 0
L25 s25 1 27e-4
VS26 13 s26 0
V26 e26 s26 DC 0 AC 56e-1 0
RI26 e26 m26 18e-1
LI26 m26 15 27e-5
VS27 8 s27 0
C27 s27 14 12e-5
VS28 14 s28 0
R28 s28 9 22e2
VS29 1 s29 0
V29 e29 s29 DC 0 AC 22e1 180
RI29 e29 m29 33e-2
LI29 m29 19 27e-6
VS30 4 s30 0
R30 s30 9 12e2
VS31 4 s31 0
R31 s31 6 82e1
.control
set numdgt=17
ac lin 1 60 60
print v(1) v(2) v(3) v(4) v(5) v(6) v(7) v(8) v(9) v(10)
print v(11) v(12) v(13) v(14) v(15) v(16) v(17) v(18) v(19) v(20)
print i(vs0) i(vs1) i(vs2) i(vs3) i(vs4) i(vs5) i(vs6) i(vs7) i(vs8) i(vs9)
print i(vs10) i(vs11) i(vs12) i(vs13) i(vs14) i(vs15) i(vs16) i(vs17) i(vs18) i(vs19)
print i(vs20) i(vs21) i(vs22) i(vs23) i(vs24) i(vs25) i(vs26) i(vs27) i(vs28) i(vs29)
print i(vs30) i(vs31)
.endc
.end
