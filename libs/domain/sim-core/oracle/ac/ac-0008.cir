controls oracle ac-0008
* Generated (plan F2.7, ADR 0012): do not edit; regenerate with `pnpm sim oracle regen`. ac seed 20261031 index 8 nodes 21 elements 31
.options sparse gmin=1e-12 noopac
RG1 1 0 1000000000000
RG2 2 0 1000000000000
RG3 3 0 1000000000000
RG4 4 0 1000000000000
RG5 5 0 1000000000000
RG6 6 0 1000000000000
RG7 7 0 1000000000000
RG8 8 0 1000000000000
RG9 9 0 1000000000000
RG10 10 0 1000000000000
RG11 11 0 1000000000000
RG12 12 0 1000000000000
RG13 13 0 1000000000000
RG14 14 0 1000000000000
RG15 15 0 1000000000000
RG16 16 0 1000000000000
RG17 17 0 1000000000000
RG18 18 0 1000000000000
RG19 19 0 1000000000000
RG20 20 0 1000000000000
VS0 20 s0 0
C0 s0 19 27e-4
VS1 11 s1 0
R1 s1 7 18e-2
VS2 8 s2 0
C2 s2 14 12e-5
VS3 19 s3 0
R3 s3 6 15e1
VS4 4 s4 0
R4 s4 9 12e2
VS5 11 s5 0
L5 s5 14 33e-4
VS6 9 s6 0
L6 s6 11 27e-3
VS7 6 s7 0
L7 s7 18 15e-5
VS8 0 s8 0
V8 e8 s8 DC 0 AC 18e1 0
RI8 e8 7 10e-2
VS9 3 s9 0
R9 s9 0 10e-2
VS10 1 s10 0
V10 e10 s10 DC 0 AC 15e-1 120
RI10 e10 7 47e-3
VS11 9 s11 0
L11 s11 3 18e-3
VS12 2 s12 0
R12 s12 19 68e1
VS13 7 s13 0
R13 s13 17 82e1
VS14 2 s14 0
C14 s14 16 68e-4
VS15 19 s15 0
R15 s15 10 15e-1
VS16 8 s16 0
R16 s16 10 15e1
VS17 14 s17 0
R17 s17 9 22e2
VS18 20 s18 0
L18 s18 1 68e-4
VS19 12 s19 0
C19 s19 16 47e-4
VS20 15 s20 0
L20 s20 20 39e-2
VS21 0 s21 0
V21 e21 s21 DC 0 AC 15e1 120
RI21 e21 4 68e-1
VS22 9 s22 0
L22 s22 13 15e-5
VS23 5 s23 0
L23 s23 1 27e-4
VS24 4 s24 0
R24 s24 6 82e1
VS25 13 s25 0
V25 e25 s25 DC 0 AC 56e-1 0
RI25 e25 15 18e-1
VS26 1 s26 0
V26 e26 s26 DC 0 AC 22e1 180
RI26 e26 19 33e-2
VS27 15 s27 0
R27 s27 20 56e0
VS28 15 s28 0
R28 s28 19 10e-2
VS29 3 s29 0
C29 s29 12 15e-5
VS30 7 s30 0
R30 s30 18 82e1
.control
set numdgt=17
ac lin 1 60 60
print v(1) v(2) v(3) v(4) v(5) v(6) v(7) v(8) v(9) v(10)
print v(11) v(12) v(13) v(14) v(15) v(16) v(17) v(18) v(19) v(20)
print i(vs0) i(vs1) i(vs2) i(vs3) i(vs4) i(vs5) i(vs6) i(vs7) i(vs8) i(vs9)
print i(vs10) i(vs11) i(vs12) i(vs13) i(vs14) i(vs15) i(vs16) i(vs17) i(vs18) i(vs19)
print i(vs20) i(vs21) i(vs22) i(vs23) i(vs24) i(vs25) i(vs26) i(vs27) i(vs28) i(vs29)
print i(vs30)
.endc
.end
