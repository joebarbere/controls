controls oracle ac-0008
* Generated (plan F2.7, ADR 0012): do not edit; regenerate with `pnpm sim oracle regen`. ac seed 20261031 index 8 nodes 21 elements 30
.options sparse gmin=1e-12 noopac
RG1 1 0 1000000000000
RG2 2 0 1000000000000
RG3 3 0 1000000000000
RG4 4 0 1000000000000
RG5 5 0 1000000000000
RG6 6 0 1000000000000
RG7 7 0 1000000000000
RG8 8 0 1000000000000
RG9 9 0 1000000000000
RG10 10 0 1000000000000
RG11 11 0 1000000000000
RG12 12 0 1000000000000
RG13 13 0 1000000000000
RG14 14 0 1000000000000
RG15 15 0 1000000000000
RG16 16 0 1000000000000
RG17 17 0 1000000000000
RG18 18 0 1000000000000
RG19 19 0 1000000000000
RG20 20 0 1000000000000
VS0 2 s0 0
L0 s0 16 18e-3
VS1 7 s1 0
R1 s1 19 33e3
VS2 0 s2 0
V2 e2 s2 DC 0 AC 56e-1 0
RI2 e2 15 18e-1
VS3 1 s3 0
R3 s3 8 82e2
VS4 2 s4 0
R4 s4 9 33e-1
VS5 3 s5 0
R5 s5 9 68e2
VS6 14 s6 0
L6 s6 1 33e-3
VS7 18 s7 0
C7 s7 17 22e-6
VS8 15 s8 0
R8 s8 9 10e-2
VS9 4 s9 0
R9 s9 14 22e3
VS10 1 s10 0
R10 s10 13 18e2
VS11 6 s11 0
R11 s11 16 15e1
VS12 20 s12 0
V12 e12 s12 DC 0 AC 33e0 120
RI12 e12 12 18e-1
VS13 10 s13 0
R13 s13 7 27e1
VS14 17 s14 0
R14 s14 16 10e-2
VS15 19 s15 0
C15 s15 8 68e-6
VS16 0 s16 0
V16 e16 s16 DC 0 AC 15e0 0
RI16 e16 18 27e-3
VS17 5 s17 0
L17 s17 11 56e-2
VS18 9 s18 0
L18 s18 6 56e-5
VS19 13 s19 0
L19 s19 11 18e-2
VS20 3 s20 0
R20 s20 19 10e0
VS21 11 s21 0
R21 s21 2 12e2
VS22 18 s22 0
L22 s22 11 39e-5
VS23 12 s23 0
R23 s23 19 12e2
VS24 16 s24 0
L24 s24 3 47e-5
VS25 5 s25 0
V25 e25 s25 DC 0 AC 22e0 180
RI25 e25 19 27e-2
VS26 4 s26 0
L26 s26 20 68e-2
VS27 10 s27 0
C27 s27 14 47e-5
VS28 11 s28 0
C28 s28 0 68e-4
VS29 9 s29 0
R29 s29 14 22e3
.control
set numdgt=17
ac lin 1 60 60
print v(1) v(2) v(3) v(4) v(5) v(6) v(7) v(8) v(9) v(10)
print v(11) v(12) v(13) v(14) v(15) v(16) v(17) v(18) v(19) v(20)
print i(vs0) i(vs1) i(vs2) i(vs3) i(vs4) i(vs5) i(vs6) i(vs7) i(vs8) i(vs9)
print i(vs10) i(vs11) i(vs12) i(vs13) i(vs14) i(vs15) i(vs16) i(vs17) i(vs18) i(vs19)
print i(vs20) i(vs21) i(vs22) i(vs23) i(vs24) i(vs25) i(vs26) i(vs27) i(vs28) i(vs29)
.endc
.end
