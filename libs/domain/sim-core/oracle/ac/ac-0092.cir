controls oracle ac-0092
* Generated (plan F2.7, ADR 0012): do not edit; regenerate with `pnpm sim oracle regen`. ac seed 20261031 index 92 nodes 12 elements 19
.options sparse gmin=1e-12 noopac
RG1 1 0 1000000000000
RG2 2 0 1000000000000
RG3 3 0 1000000000000
RG4 4 0 1000000000000
RG5 5 0 1000000000000
RG6 6 0 1000000000000
RG7 7 0 1000000000000
RG8 8 0 1000000000000
RG9 9 0 1000000000000
RG10 10 0 1000000000000
RG11 11 0 1000000000000
VS0 4 s0 0
R0 s0 5 15e-1
VS1 2 s1 0
R1 s1 1 15e1
VS2 5 s2 0
L2 s2 6 56e-2
VS3 2 s3 0
R3 s3 3 47e1
VS4 8 s4 0
C4 s4 1 12e-4
VS5 4 s5 0
R5 s5 6 68e3
VS6 9 s6 0
R6 s6 11 27e1
VS7 2 s7 0
R7 s7 5 15e3
VS8 0 s8 0
L8 s8 4 12e-3
VS9 7 s9 0
R9 s9 5 22e3
VS10 8 s10 0
R10 s10 3 18e0
VS11 7 s11 0
L11 s11 0 12e-5
VS12 10 s12 0
R12 s12 0 68e-1
VS13 1 s13 0
L13 s13 0 68e-2
VS14 2 s14 0
C14 s14 11 56e-4
VS15 9 s15 0
R15 s15 10 39e1
VS16 6 s16 0
R16 s16 1 22e0
VS17 2 s17 0
R17 s17 0 47e2
VS18 0 s18 0
V18 e18 s18 DC 0 AC 15e0 180
RI18 e18 11 27e-1
.control
set numdgt=17
ac lin 1 60 60
print v(1) v(2) v(3) v(4) v(5) v(6) v(7) v(8) v(9) v(10)
print v(11)
print i(vs0) i(vs1) i(vs2) i(vs3) i(vs4) i(vs5) i(vs6) i(vs7) i(vs8) i(vs9)
print i(vs10) i(vs11) i(vs12) i(vs13) i(vs14) i(vs15) i(vs16) i(vs17) i(vs18)
.endc
.end
