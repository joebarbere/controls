controls oracle ac-0092
* Generated (plan F2.7, ADR 0012): do not edit; regenerate with `pnpm sim oracle regen`. ac seed 20261031 index 92 nodes 12 elements 22
.options sparse gmin=1e-12 noopac
RG1 1 0 1000000000000
RG2 2 0 1000000000000
RG3 3 0 1000000000000
RG4 4 0 1000000000000
RG5 5 0 1000000000000
RG6 6 0 1000000000000
RG7 7 0 1000000000000
RG8 8 0 1000000000000
RG9 9 0 1000000000000
RG10 10 0 1000000000000
RG11 11 0 1000000000000
VS0 5 s0 0
L0 s0 1 18e-3
VS1 2 s1 0
R1 s1 6 47e2
VS2 10 s2 0
C2 s2 7 10e-6
VS3 3 s3 0
R3 s3 0 22e-2
VS4 0 s4 0
V4 e4 s4 DC 0 AC 12e0 0
RI4 e4 2 15e-3
VS5 7 s5 0
C5 s5 6 22e-6
VS6 2 s6 0
C6 s6 3 47e-4
VS7 11 s7 0
C7 s7 10 33e-6
VS8 10 s8 0
L8 s8 0 18e-5
VS9 6 s9 0
V9 e9 s9 DC 0 AC 15e0 180
RI9 e9 11 27e-1
VS10 7 s10 0
R10 s10 1 12e-1
VS11 3 s11 0
V11 e11 s11 DC 0 AC 15e1 -120
RI11 e11 0 33e-2
VS12 9 s12 0
R12 s12 3 12e-2
VS13 10 s13 0
R13 s13 11 47e-1
VS14 7 s14 0
C14 s14 4 68e-5
VS15 10 s15 0
C15 s15 0 68e-6
VS16 5 s16 0
V16 e16 s16 DC 0 AC 56e0 -120
RI16 e16 1 15e-2
VS17 1 s17 0
R17 s17 8 12e0
VS18 9 s18 0
R18 s18 0 56e-2
VS19 5 s19 0
C19 s19 4 18e-4
VS20 8 s20 0
L20 s20 4 33e-5
VS21 1 s21 0
R21 s21 11 82e2
.control
set numdgt=17
ac lin 1 60 60
print v(1) v(2) v(3) v(4) v(5) v(6) v(7) v(8) v(9) v(10)
print v(11)
print i(vs0) i(vs1) i(vs2) i(vs3) i(vs4) i(vs5) i(vs6) i(vs7) i(vs8) i(vs9)
print i(vs10) i(vs11) i(vs12) i(vs13) i(vs14) i(vs15) i(vs16) i(vs17) i(vs18) i(vs19)
print i(vs20) i(vs21)
.endc
.end
