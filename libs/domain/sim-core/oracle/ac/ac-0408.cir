controls oracle ac-0408
* Generated (plan F2.7, ADR 0012): do not edit; regenerate with `pnpm sim oracle regen`. ac seed 20261031 index 408 nodes 12 elements 15
.options sparse gmin=1e-12 noopac
RG1 1 0 1000000000000
RG2 2 0 1000000000000
RG3 3 0 1000000000000
RG4 4 0 1000000000000
RG5 5 0 1000000000000
RG6 6 0 1000000000000
RG7 7 0 1000000000000
RG8 8 0 1000000000000
RG9 9 0 1000000000000
RG10 10 0 1000000000000
RG11 11 0 1000000000000
VS0 0 s0 0
V0 e0 s0 DC 0 AC 82e-1 0
RI0 e0 1 33e-2
VS1 3 s1 0
C1 s1 6 82e-5
VS2 7 s2 0
R2 s2 6 18e2
VS3 3 s3 0
L3 s3 8 12e-3
VS4 8 s4 0
L4 s4 2 12e-4
VS5 4 s5 0
L5 s5 11 56e-3
VS6 11 s6 0
R6 s6 8 15e-1
VS7 7 s7 0
L7 s7 1 10e-2
VS8 2 s8 0
R8 s8 9 68e0
VS9 4 s9 0
C9 s9 5 47e-4
VS10 5 s10 0
C10 s10 9 47e-6
VS11 10 s11 0
R11 s11 11 82e2
VS12 0 s12 0
L12 s12 4 10e-3
VS13 10 s13 0
L13 s13 7 15e-5
VS14 4 s14 0
C14 s14 6 82e-4
.control
set numdgt=17
ac lin 1 60 60
print v(1) v(2) v(3) v(4) v(5) v(6) v(7) v(8) v(9) v(10)
print v(11)
print i(vs0) i(vs1) i(vs2) i(vs3) i(vs4) i(vs5) i(vs6) i(vs7) i(vs8) i(vs9)
print i(vs10) i(vs11) i(vs12) i(vs13) i(vs14)
.endc
.end
