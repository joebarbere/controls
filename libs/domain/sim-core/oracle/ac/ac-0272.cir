controls oracle ac-0272
* Generated (plan F2.7, ADR 0012): do not edit; regenerate with `pnpm sim oracle regen`. ac seed 20261031 index 272 nodes 19 elements 30
.options sparse gmin=1e-12 noopac
RG1 1 0 1000000000000
RG2 2 0 1000000000000
RG3 3 0 1000000000000
RG4 4 0 1000000000000
RG5 5 0 1000000000000
RG6 6 0 1000000000000
RG7 7 0 1000000000000
RG8 8 0 1000000000000
RG9 9 0 1000000000000
RG10 10 0 1000000000000
RG11 11 0 1000000000000
RG12 12 0 1000000000000
RG13 13 0 1000000000000
RG14 14 0 1000000000000
RG15 15 0 1000000000000
RG16 16 0 1000000000000
RG17 17 0 1000000000000
RG18 18 0 1000000000000
VS0 0 s0 0
V0 e0 s0 DC 0 AC 27e0 180
RI0 e0 5 18e-3
VS1 4 s1 0
L1 s1 6 68e-2
VS2 9 s2 0
R2 s2 1 18e0
VS3 18 s3 0
L3 s3 14 15e-4
VS4 9 s4 0
C4 s4 18 27e-4
VS5 7 s5 0
L5 s5 10 39e-2
VS6 12 s6 0
C6 s6 8 27e-5
VS7 7 s7 0
R7 s7 15 12e0
VS8 6 s8 0
R8 s8 3 27e2
VS9 14 s9 0
R9 s9 16 18e3
VS10 11 s10 0
V10 e10 s10 DC 0 AC 10e-1 -120
RI10 e10 10 12e-1
VS11 5 s11 0
V11 e11 s11 DC 0 AC 33e1 0
RI11 e11 m11 39e-2
LI11 m11 8 39e-6
VS12 13 s12 0
V12 e12 s12 DC 0 AC 68e0 0
RI12 e12 m12 22e-2
LI12 m12 6 39e-7
VS13 6 s13 0
L13 s13 8 12e-5
VS14 9 s14 0
V14 e14 s14 DC 0 AC 18e0 120
RI14 e14 0 68e-2
VS15 3 s15 0
C15 s15 2 82e-6
VS16 14 s16 0
C16 s16 6 18e-4
VS17 17 s17 0
R17 s17 15 12e2
VS18 6 s18 0
C18 s18 11 10e-7
VS19 6 s19 0
C19 s19 15 18e-4
VS20 4 s20 0
V20 e20 s20 DC 0 AC 27e0 120
RI20 e20 13 68e-3
VS21 17 s21 0
L21 s21 16 22e-5
VS22 2 s22 0
C22 s22 0 47e-6
VS23 8 s23 0
R23 s23 1 56e1
VS24 5 s24 0
L24 s24 3 39e-5
VS25 4 s25 0
V25 e25 s25 DC 0 AC 18e1 120
RI25 e25 m25 56e-3
LI25 m25 18 15e-6
VS26 12 s26 0
L26 s26 9 22e-2
VS27 16 s27 0
V27 e27 s27 DC 0 AC 68e0 120
RI27 e27 6 33e-1
VS28 9 s28 0
R28 s28 6 82e0
VS29 15 s29 0
R29 s29 17 22e-1
.control
set numdgt=17
ac lin 1 60 60
print v(1) v(2) v(3) v(4) v(5) v(6) v(7) v(8) v(9) v(10)
print v(11) v(12) v(13) v(14) v(15) v(16) v(17) v(18)
print i(vs0) i(vs1) i(vs2) i(vs3) i(vs4) i(vs5) i(vs6) i(vs7) i(vs8) i(vs9)
print i(vs10) i(vs11) i(vs12) i(vs13) i(vs14) i(vs15) i(vs16) i(vs17) i(vs18) i(vs19)
print i(vs20) i(vs21) i(vs22) i(vs23) i(vs24) i(vs25) i(vs26) i(vs27) i(vs28) i(vs29)
.endc
.end
