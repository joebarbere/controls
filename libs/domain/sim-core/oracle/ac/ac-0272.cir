controls oracle ac-0272
* Generated (plan F2.7, ADR 0012): do not edit; regenerate with `pnpm sim oracle regen`. ac seed 20261031 index 272 nodes 19 elements 36
.options sparse gmin=1e-12 noopac
RG1 1 0 1000000000000
RG2 2 0 1000000000000
RG3 3 0 1000000000000
RG4 4 0 1000000000000
RG5 5 0 1000000000000
RG6 6 0 1000000000000
RG7 7 0 1000000000000
RG8 8 0 1000000000000
RG9 9 0 1000000000000
RG10 10 0 1000000000000
RG11 11 0 1000000000000
RG12 12 0 1000000000000
RG13 13 0 1000000000000
RG14 14 0 1000000000000
RG15 15 0 1000000000000
RG16 16 0 1000000000000
RG17 17 0 1000000000000
RG18 18 0 1000000000000
VS0 6 s0 0
R0 s0 3 18e0
VS1 5 s1 0
R1 s1 1 39e3
VS2 2 s2 0
L2 s2 18 47e-2
VS3 0 s3 0
V3 e3 s3 DC 0 AC 22e-1 -120
RI3 e3 8 12e-1
VS4 8 s4 0
V4 e4 s4 DC 0 AC 39e0 180
RI4 e4 5 18e-3
VS5 3 s5 0
L5 s5 4 56e-5
VS6 12 s6 0
V6 e6 s6 DC 0 AC 18e-1 -120
RI6 e6 18 47e-2
VS7 14 s7 0
C7 s7 8 82e-7
VS8 9 s8 0
V8 e8 s8 DC 0 AC 18e0 120
RI8 e8 6 68e-2
VS9 12 s9 0
L9 s9 7 39e-4
VS10 16 s10 0
V10 e10 s10 DC 0 AC 12e1 180
RI10 e10 5 22e-1
VS11 13 s11 0
L11 s11 12 12e-4
VS12 1 s12 0
C12 s12 9 22e-5
VS13 3 s13 0
L13 s13 11 68e-5
VS14 10 s14 0
R14 s14 3 68e-1
VS15 6 s15 0
C15 s15 3 22e-6
VS16 5 s16 0
R16 s16 1 15e1
VS17 17 s17 0
V17 e17 s17 DC 0 AC 47e1 -120
RI17 e17 0 18e-2
VS18 9 s18 0
R18 s18 1 18e0
VS19 13 s19 0
C19 s19 11 10e-7
VS20 13 s20 0
C20 s20 17 56e-5
VS21 13 s21 0
L21 s21 7 68e-4
VS22 4 s22 0
C22 s22 10 82e-7
VS23 2 s23 0
R23 s23 6 68e2
VS24 7 s24 0
L24 s24 11 68e-4
VS25 3 s25 0
V25 e25 s25 DC 0 AC 10e-1 180
RI25 e25 0 47e-2
VS26 10 s26 0
L26 s26 12 22e-3
VS27 15 s27 0
C27 s27 13 22e-5
VS28 13 s28 0
C28 s28 15 18e-4
VS29 16 s29 0
V29 e29 s29 DC 0 AC 18e0 180
RI29 e29 12 82e-2
VS30 9 s30 0
R30 s30 13 82e0
VS31 7 s31 0
V31 e31 s31 DC 0 AC 27e-1 180
RI31 e31 17 68e-2
VS32 9 s32 0
L32 s32 0 56e-3
VS33 14 s33 0
V33 e33 s33 DC 0 AC 27e0 120
RI33 e33 2 68e-3
VS34 8 s34 0
R34 s34 14 10e3
VS35 7 s35 0
L35 s35 1 33e-4
.control
set numdgt=17
ac lin 1 60 60
print v(1) v(2) v(3) v(4) v(5) v(6) v(7) v(8) v(9) v(10)
print v(11) v(12) v(13) v(14) v(15) v(16) v(17) v(18)
print i(vs0) i(vs1) i(vs2) i(vs3) i(vs4) i(vs5) i(vs6) i(vs7) i(vs8) i(vs9)
print i(vs10) i(vs11) i(vs12) i(vs13) i(vs14) i(vs15) i(vs16) i(vs17) i(vs18) i(vs19)
print i(vs20) i(vs21) i(vs22) i(vs23) i(vs24) i(vs25) i(vs26) i(vs27) i(vs28) i(vs29)
print i(vs30) i(vs31) i(vs32) i(vs33) i(vs34) i(vs35)
.endc
.end
