controls oracle ac-0272
* Generated (plan F2.7, ADR 0012): do not edit; regenerate with `pnpm sim oracle regen`. ac seed 20261031 index 272 nodes 19 elements 37
.options sparse gmin=1e-12 noopac
RG1 1 0 1000000000000
RG2 2 0 1000000000000
RG3 3 0 1000000000000
RG4 4 0 1000000000000
RG5 5 0 1000000000000
RG6 6 0 1000000000000
RG7 7 0 1000000000000
RG8 8 0 1000000000000
RG9 9 0 1000000000000
RG10 10 0 1000000000000
RG11 11 0 1000000000000
RG12 12 0 1000000000000
RG13 13 0 1000000000000
RG14 14 0 1000000000000
RG15 15 0 1000000000000
RG16 16 0 1000000000000
RG17 17 0 1000000000000
RG18 18 0 1000000000000
VS0 13 s0 0
L0 s0 12 12e-4
VS1 13 s1 0
C1 s1 11 10e-7
VS2 4 s2 0
C2 s2 10 82e-7
VS3 3 s3 0
L3 s3 11 68e-5
VS4 9 s4 0
R4 s4 1 18e0
VS5 0 s5 0
V5 e5 s5 DC 0 AC 22e-1 -120
RI5 e5 8 12e-1
VS6 15 s6 0
C6 s6 13 22e-5
VS7 14 s7 0
C7 s7 8 82e-7
VS8 6 s8 0
C8 s8 3 22e-6
VS9 16 s9 0
V9 e9 s9 DC 0 AC 18e0 180
RI9 e9 12 82e-2
VS10 9 s10 0
R10 s10 13 82e0
VS11 13 s11 0
L11 s11 7 68e-4
VS12 5 s12 0
R12 s12 1 15e1
VS13 9 s13 0
L13 s13 0 56e-3
VS14 8 s14 0
R14 s14 14 10e3
VS15 6 s15 0
R15 s15 3 18e0
VS16 1 s16 0
C16 s16 9 22e-5
VS17 12 s17 0
L17 s17 7 39e-4
VS18 10 s18 0
R18 s18 3 68e-1
VS19 14 s19 0
L19 s19 15 56e-5
VS20 13 s20 0
C20 s20 15 18e-4
VS21 5 s21 0
R21 s21 1 39e3
VS22 3 s22 0
V22 e22 s22 DC 0 AC 10e-1 180
RI22 e22 0 47e-2
VS23 12 s23 0
V23 e23 s23 DC 0 AC 18e-1 -120
RI23 e23 18 47e-2
VS24 17 s24 0
V24 e24 s24 DC 0 AC 47e1 -120
RI24 e24 0 18e-2
VS25 2 s25 0
R25 s25 6 68e2
VS26 7 s26 0
V26 e26 s26 DC 0 AC 27e-1 180
RI26 e26 17 68e-2
VS27 10 s27 0
L27 s27 12 22e-3
VS28 14 s28 0
V28 e28 s28 DC 0 AC 27e0 120
RI28 e28 2 68e-3
VS29 7 s29 0
L29 s29 11 68e-4
VS30 8 s30 0
V30 e30 s30 DC 0 AC 39e0 180
RI30 e30 5 18e-3
VS31 3 s31 0
L31 s31 4 56e-5
VS32 9 s32 0
V32 e32 s32 DC 0 AC 18e0 120
RI32 e32 6 68e-2
VS33 13 s33 0
C33 s33 17 56e-5
VS34 2 s34 0
L34 s34 18 47e-2
VS35 16 s35 0
V35 e35 s35 DC 0 AC 12e1 180
RI35 e35 m35 22e-1
LI35 m35 5 27e-5
VS36 7 s36 0
L36 s36 1 33e-4
.control
set numdgt=17
ac lin 1 60 60
print v(1) v(2) v(3) v(4) v(5) v(6) v(7) v(8) v(9) v(10)
print v(11) v(12) v(13) v(14) v(15) v(16) v(17) v(18)
print i(vs0) i(vs1) i(vs2) i(vs3) i(vs4) i(vs5) i(vs6) i(vs7) i(vs8) i(vs9)
print i(vs10) i(vs11) i(vs12) i(vs13) i(vs14) i(vs15) i(vs16) i(vs17) i(vs18) i(vs19)
print i(vs20) i(vs21) i(vs22) i(vs23) i(vs24) i(vs25) i(vs26) i(vs27) i(vs28) i(vs29)
print i(vs30) i(vs31) i(vs32) i(vs33) i(vs34) i(vs35) i(vs36)
.endc
.end
