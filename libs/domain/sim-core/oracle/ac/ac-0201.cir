controls oracle ac-0201
* Generated (plan F2.7, ADR 0012): do not edit; regenerate with `pnpm sim oracle regen`. ac seed 20261031 index 201 nodes 17 elements 34
.options sparse gmin=1e-12 noopac
RG1 1 0 1000000000000
RG2 2 0 1000000000000
RG3 3 0 1000000000000
RG4 4 0 1000000000000
RG5 5 0 1000000000000
RG6 6 0 1000000000000
RG7 7 0 1000000000000
RG8 8 0 1000000000000
RG9 9 0 1000000000000
RG10 10 0 1000000000000
RG11 11 0 1000000000000
RG12 12 0 1000000000000
RG13 13 0 1000000000000
RG14 14 0 1000000000000
RG15 15 0 1000000000000
RG16 16 0 1000000000000
VS0 0 s0 0
V0 e0 s0 DC 0 AC 82e0 0
RI0 e0 m0 47e-3
LI0 m0 15 18e-7
VS1 5 s1 0
C1 s1 14 56e-7
VS2 15 s2 0
C2 s2 9 56e-7
VS3 7 s3 0
R3 s3 6 12e-1
VS4 3 s4 0
R4 s4 15 56e1
VS5 2 s5 0
R5 s5 4 68e-2
VS6 10 s6 0
R6 s6 7 22e0
VS7 16 s7 0
V7 e7 s7 DC 0 AC 18e-1 180
RI7 e7 8 39e-2
VS8 3 s8 0
V8 e8 s8 DC 0 AC 15e0 120
RI8 e8 4 27e-1
VS9 7 s9 0
L9 s9 4 10e-4
VS10 6 s10 0
L10 s10 11 47e-2
VS11 3 s11 0
R11 s11 2 10e-2
VS12 8 s12 0
R12 s12 10 18e0
VS13 13 s13 0
R13 s13 4 10e1
VS14 2 s14 0
V14 e14 s14 DC 0 AC 68e0 180
RI14 e14 m14 47e-2
LI14 m14 3 47e-5
VS15 9 s15 0
R15 s15 13 47e2
VS16 4 s16 0
L16 s16 6 15e-5
VS17 3 s17 0
R17 s17 14 22e-1
VS18 0 s18 0
C18 s18 5 18e-7
VS19 16 s19 0
C19 s19 0 39e-5
VS20 7 s20 0
V20 e20 s20 DC 0 AC 56e-1 120
RI20 e20 m20 47e-3
LI20 m20 16 27e-7
VS21 7 s21 0
C21 s21 8 82e-4
VS22 1 s22 0
V22 e22 s22 DC 0 AC 12e0 -120
RI22 e22 m22 10e-2
LI22 m22 8 82e-7
VS23 6 s23 0
C23 s23 11 47e-4
VS24 12 s24 0
R24 s24 5 12e-1
VS25 13 s25 0
L25 s25 1 56e-4
VS26 8 s26 0
C26 s26 0 47e-4
VS27 5 s27 0
R27 s27 6 12e-2
VS28 11 s28 0
C28 s28 15 39e-5
VS29 1 s29 0
V29 e29 s29 DC 0 AC 10e1 -120
RI29 e29 m29 39e-2
LI29 m29 12 12e-7
VS30 2 s30 0
R30 s30 9 82e2
VS31 5 s31 0
C31 s31 11 12e-7
VS32 3 s32 0
R32 s32 2 12e0
VS33 6 s33 0
R33 s33 15 12e-1
.control
set numdgt=17
ac lin 1 60 60
print v(1) v(2) v(3) v(4) v(5) v(6) v(7) v(8) v(9) v(10)
print v(11) v(12) v(13) v(14) v(15) v(16)
print i(vs0) i(vs1) i(vs2) i(vs3) i(vs4) i(vs5) i(vs6) i(vs7) i(vs8) i(vs9)
print i(vs10) i(vs11) i(vs12) i(vs13) i(vs14) i(vs15) i(vs16) i(vs17) i(vs18) i(vs19)
print i(vs20) i(vs21) i(vs22) i(vs23) i(vs24) i(vs25) i(vs26) i(vs27) i(vs28) i(vs29)
print i(vs30) i(vs31) i(vs32) i(vs33)
.endc
.end
