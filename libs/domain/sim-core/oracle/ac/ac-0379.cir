controls oracle ac-0379
* Generated (plan F2.7, ADR 0012): do not edit; regenerate with `pnpm sim oracle regen`. ac seed 20261031 index 379 nodes 11 elements 14
.options sparse gmin=1e-12 noopac
RG1 1 0 1000000000000
RG2 2 0 1000000000000
RG3 3 0 1000000000000
RG4 4 0 1000000000000
RG5 5 0 1000000000000
RG6 6 0 1000000000000
RG7 7 0 1000000000000
RG8 8 0 1000000000000
RG9 9 0 1000000000000
RG10 10 0 1000000000000
VS0 3 s0 0
L0 s0 5 27e-5
VS1 7 s1 0
L1 s1 10 56e-5
VS2 1 s2 0
R2 s2 5 47e1
VS3 4 s3 0
R3 s3 6 10e0
VS4 2 s4 0
L4 s4 5 18e-5
VS5 0 s5 0
V5 e5 s5 DC 0 AC 22e-1 180
RI5 e5 6 33e-3
VS6 4 s6 0
V6 e6 s6 DC 0 AC 10e-1 180
RI6 e6 3 12e-1
VS7 4 s7 0
V7 e7 s7 DC 0 AC 82e-1 -120
RI7 e7 9 33e-2
VS8 2 s8 0
L8 s8 6 18e-3
VS9 7 s9 0
R9 s9 2 12e-1
VS10 9 s10 0
L10 s10 10 39e-2
VS11 0 s11 0
L11 s11 8 22e-3
VS12 5 s12 0
V12 e12 s12 DC 0 AC 10e0 120
RI12 e12 2 39e-1
VS13 1 s13 0
C13 s13 8 10e-5
.control
set numdgt=17
ac lin 1 60 60
print v(1) v(2) v(3) v(4) v(5) v(6) v(7) v(8) v(9) v(10)
print i(vs0) i(vs1) i(vs2) i(vs3) i(vs4) i(vs5) i(vs6) i(vs7) i(vs8) i(vs9)
print i(vs10) i(vs11) i(vs12) i(vs13)
.endc
.end
