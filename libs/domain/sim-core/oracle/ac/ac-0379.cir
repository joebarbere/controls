controls oracle ac-0379
* Generated (plan F2.7, ADR 0012): do not edit; regenerate with `pnpm sim oracle regen`. ac seed 20261031 index 379 nodes 11 elements 16
.options sparse gmin=1e-12 noopac
RG1 1 0 1000000000000
RG2 2 0 1000000000000
RG3 3 0 1000000000000
RG4 4 0 1000000000000
RG5 5 0 1000000000000
RG6 6 0 1000000000000
RG7 7 0 1000000000000
RG8 8 0 1000000000000
RG9 9 0 1000000000000
RG10 10 0 1000000000000
VS0 7 s0 0
R0 s0 1 18e-1
VS1 6 s1 0
L1 s1 8 47e-2
VS2 5 s2 0
C2 s2 0 39e-5
VS3 10 s3 0
C3 s3 1 18e-5
VS4 1 s4 0
C4 s4 3 12e-7
VS5 0 s5 0
R5 s5 4 10e0
VS6 2 s6 0
L6 s6 4 18e-3
VS7 0 s7 0
V7 e7 s7 DC 0 AC 82e-1 -120
RI7 e7 n7 33e-2
H7 n7 h7 VS10 -82e-3
ED7 h7 9 d7 0 -18e-7
F7 0 d7 VS10 1
LD7 d7 0 1
VS8 0 s8 0
L8 s8 6 56e-3
VS9 2 s9 0
R9 s9 9 27e-2
VS10 8 s10 0
V10 e10 s10 DC 0 AC 68e-1 0
RI10 e10 n10 15e-2
H10 n10 h10 VS7 -82e-3
ED10 h10 10 d10 0 -18e-7
F10 0 d10 VS7 1
LD10 d10 0 1
VS11 3 s11 0
L11 s11 5 27e-5
VS12 10 s12 0
V12 e12 s12 DC 0 AC 68e-1 0
RI12 e12 m12 33e-3
LI12 m12 2 47e-5
VS13 2 s13 0
L13 s13 5 18e-5
VS14 4 s14 0
V14 e14 s14 DC 0 AC 10e1 120
RI14 e14 3 10e-3
VS15 2 s15 0
C15 s15 7 15e-6
.control
set numdgt=17
ac lin 1 60 60
print v(1) v(2) v(3) v(4) v(5) v(6) v(7) v(8) v(9) v(10)
print i(vs0) i(vs1) i(vs2) i(vs3) i(vs4) i(vs5) i(vs6) i(vs7) i(vs8) i(vs9)
print i(vs10) i(vs11) i(vs12) i(vs13) i(vs14) i(vs15)
.endc
.end
