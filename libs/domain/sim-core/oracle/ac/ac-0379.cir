controls oracle ac-0379
* Generated (plan F2.7, ADR 0012): do not edit; regenerate with `pnpm sim oracle regen`. ac seed 20261031 index 379 nodes 11 elements 14
.options sparse gmin=1e-12 noopac
RG1 1 0 1000000000000
RG2 2 0 1000000000000
RG3 3 0 1000000000000
RG4 4 0 1000000000000
RG5 5 0 1000000000000
RG6 6 0 1000000000000
RG7 7 0 1000000000000
RG8 8 0 1000000000000
RG9 9 0 1000000000000
RG10 10 0 1000000000000
VS0 3 s0 0
L0 s0 5 27e-5
VS1 2 s1 0
C1 s1 7 15e-6
VS2 4 s2 0
L2 s2 6 56e-3
VS3 4 s3 0
R3 s3 8 10e0
VS4 2 s4 0
L4 s4 8 18e-3
VS5 2 s5 0
L5 s5 5 18e-5
VS6 0 s6 0
V6 e6 s6 DC 0 AC 68e-1 0
RI6 e6 10 15e-2
VS7 10 s7 0
C7 s7 1 18e-5
VS8 7 s8 0
R8 s8 1 18e-1
VS9 10 s9 0
V9 e9 s9 DC 0 AC 68e-1 0
RI9 e9 2 33e-3
VS10 1 s10 0
C10 s10 3 12e-7
VS11 4 s11 0
V11 e11 s11 DC 0 AC 82e-1 -120
RI11 e11 9 33e-2
VS12 5 s12 0
C12 s12 4 39e-5
VS13 8 s13 0
V13 e13 s13 DC 0 AC 10e1 120
RI13 e13 3 10e-3
.control
set numdgt=17
ac lin 1 60 60
print v(1) v(2) v(3) v(4) v(5) v(6) v(7) v(8) v(9) v(10)
print i(vs0) i(vs1) i(vs2) i(vs3) i(vs4) i(vs5) i(vs6) i(vs7) i(vs8) i(vs9)
print i(vs10) i(vs11) i(vs12) i(vs13)
.endc
.end
