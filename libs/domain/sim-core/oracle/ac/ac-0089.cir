controls oracle ac-0089
* Generated (plan F2.7, ADR 0012): do not edit; regenerate with `pnpm sim oracle regen`. ac seed 20261031 index 89 nodes 28 elements 43
.options sparse gmin=1e-12 noopac
RG1 1 0 1000000000000
RG2 2 0 1000000000000
RG3 3 0 1000000000000
RG4 4 0 1000000000000
RG5 5 0 1000000000000
RG6 6 0 1000000000000
RG7 7 0 1000000000000
RG8 8 0 1000000000000
RG9 9 0 1000000000000
RG10 10 0 1000000000000
RG11 11 0 1000000000000
RG12 12 0 1000000000000
RG13 13 0 1000000000000
RG14 14 0 1000000000000
RG15 15 0 1000000000000
RG16 16 0 1000000000000
RG17 17 0 1000000000000
RG18 18 0 1000000000000
RG19 19 0 1000000000000
RG20 20 0 1000000000000
RG21 21 0 1000000000000
RG22 22 0 1000000000000
RG23 23 0 1000000000000
RG24 24 0 1000000000000
RG25 25 0 1000000000000
RG26 26 0 1000000000000
RG27 27 0 1000000000000
VS0 0 s0 0
V0 e0 s0 DC 0 AC 27e0 120
RI0 e0 m0 56e-3
LI0 m0 26 39e-5
VS1 10 s1 0
R1 s1 23 82e1
VS2 11 s2 0
L2 s2 25 68e-4
VS3 1 s3 0
R3 s3 3 12e-2
VS4 9 s4 0
V4 e4 s4 DC 0 AC 27e-1 -120
RI4 e4 14 56e-2
VS5 21 s5 0
L5 s5 19 18e-2
VS6 16 s6 0
C6 s6 13 18e-7
VS7 17 s7 0
R7 s7 26 82e0
VS8 15 s8 0
L8 s8 19 12e-2
VS9 25 s9 0
R9 s9 26 56e-2
VS10 4 s10 0
C10 s10 15 22e-6
VS11 17 s11 0
V11 e11 s11 DC 0 AC 68e1 -120
RI11 e11 24 12e-2
VS12 8 s12 0
L12 s12 5 12e-2
VS13 5 s13 0
L13 s13 24 39e-4
VS14 27 s14 0
V14 e14 s14 DC 0 AC 22e-1 0
RI14 e14 m14 10e-3
LI14 m14 20 10e-5
VS15 19 s15 0
C15 s15 27 68e-7
VS16 5 s16 0
R16 s16 7 47e-1
VS17 27 s17 0
L17 s17 2 39e-5
VS18 21 s18 0
L18 s18 20 10e-3
VS19 4 s19 0
R19 s19 21 33e3
VS20 23 s20 0
R20 s20 27 22e-1
VS21 15 s21 0
R21 s21 17 68e-1
VS22 20 s22 0
L22 s22 13 39e-5
VS23 16 s23 0
R23 s23 11 18e-1
VS24 14 s24 0
C24 s24 22 39e-7
VS25 2 s25 0
L25 s25 7 22e-4
VS26 12 s26 0
R26 s26 23 12e0
VS27 14 s27 0
R27 s27 13 56e-1
VS28 0 s28 0
R28 s28 9 27e0
VS29 2 s29 0
R29 s29 18 33e1
VS30 13 s30 0
L30 s30 18 15e-4
VS31 14 s31 0
R31 s31 17 33e2
VS32 10 s32 0
V32 e32 s32 DC 0 AC 56e-1 120
RI32 e32 m32 27e-3
LI32 m32 7 15e-5
VS33 14 s33 0
R33 s33 6 47e1
VS34 1 s34 0
V34 e34 s34 DC 0 AC 27e0 -120
RI34 e34 12 82e-3
VS35 22 s35 0
R35 s35 18 27e-1
VS36 8 s36 0
R36 s36 2 15e2
VS37 6 s37 0
C37 s37 16 39e-6
VS38 3 s38 0
L38 s38 7 10e-5
VS39 2 s39 0
V39 e39 s39 DC 0 AC 68e1 0
RI39 e39 m39 47e-1
LI39 m39 26 22e-5
VS40 13 s40 0
R40 s40 21 56e-1
VS41 0 s41 0
V41 e41 s41 DC 0 AC 12e0 180
RI41 e41 m41 22e-2
LI41 m41 16 12e-7
VS42 14 s42 0
V42 e42 s42 DC 0 AC 39e0 -120
RI42 e42 m42 22e-1
LI42 m42 26 12e-6
.control
set numdgt=17
ac lin 1 60 60
print v(1) v(2) v(3) v(4) v(5) v(6) v(7) v(8) v(9) v(10)
print v(11) v(12) v(13) v(14) v(15) v(16) v(17) v(18) v(19) v(20)
print v(21) v(22) v(23) v(24) v(25) v(26) v(27)
print i(vs0) i(vs1) i(vs2) i(vs3) i(vs4) i(vs5) i(vs6) i(vs7) i(vs8) i(vs9)
print i(vs10) i(vs11) i(vs12) i(vs13) i(vs14) i(vs15) i(vs16) i(vs17) i(vs18) i(vs19)
print i(vs20) i(vs21) i(vs22) i(vs23) i(vs24) i(vs25) i(vs26) i(vs27) i(vs28) i(vs29)
print i(vs30) i(vs31) i(vs32) i(vs33) i(vs34) i(vs35) i(vs36) i(vs37) i(vs38) i(vs39)
print i(vs40) i(vs41) i(vs42)
.endc
.end
