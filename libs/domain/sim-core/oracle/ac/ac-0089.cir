controls oracle ac-0089
* Generated (plan F2.7, ADR 0012): do not edit; regenerate with `pnpm sim oracle regen`. ac seed 20261031 index 89 nodes 28 elements 38
.options sparse gmin=1e-12 noopac
RG1 1 0 1000000000000
RG2 2 0 1000000000000
RG3 3 0 1000000000000
RG4 4 0 1000000000000
RG5 5 0 1000000000000
RG6 6 0 1000000000000
RG7 7 0 1000000000000
RG8 8 0 1000000000000
RG9 9 0 1000000000000
RG10 10 0 1000000000000
RG11 11 0 1000000000000
RG12 12 0 1000000000000
RG13 13 0 1000000000000
RG14 14 0 1000000000000
RG15 15 0 1000000000000
RG16 16 0 1000000000000
RG17 17 0 1000000000000
RG18 18 0 1000000000000
RG19 19 0 1000000000000
RG20 20 0 1000000000000
RG21 21 0 1000000000000
RG22 22 0 1000000000000
RG23 23 0 1000000000000
RG24 24 0 1000000000000
RG25 25 0 1000000000000
RG26 26 0 1000000000000
RG27 27 0 1000000000000
VS0 7 s0 0
C0 s0 6 18e-5
VS1 8 s1 0
R1 s1 9 56e3
VS2 17 s2 0
R2 s2 16 18e-2
VS3 0 s3 0
V3 e3 s3 DC 0 AC 56e1 180
RI3 e3 11 68e-2
VS4 1 s4 0
L4 s4 10 82e-4
VS5 5 s5 0
V5 e5 s5 DC 0 AC 12e1 120
RI5 e5 17 68e-2
VS6 26 s6 0
V6 e6 s6 DC 0 AC 18e0 120
RI6 e6 21 27e-3
VS7 23 s7 0
L7 s7 5 18e-5
VS8 14 s8 0
R8 s8 16 82e-2
VS9 2 s9 0
C9 s9 26 39e-7
VS10 24 s10 0
V10 e10 s10 DC 0 AC 22e0 120
RI10 e10 27 68e-1
VS11 18 s11 0
L11 s11 21 68e-2
VS12 26 s12 0
C12 s12 13 47e-5
VS13 27 s13 0
R13 s13 20 10e-1
VS14 6 s14 0
L14 s14 17 68e-2
VS15 3 s15 0
C15 s15 0 56e-4
VS16 19 s16 0
L16 s16 16 18e-2
VS17 25 s17 0
V17 e17 s17 DC 0 AC 33e1 -120
RI17 e17 18 18e-3
VS18 13 s18 0
L18 s18 22 22e-2
VS19 7 s19 0
V19 e19 s19 DC 0 AC 10e0 180
RI19 e19 16 39e-3
VS20 1 s20 0
R20 s20 6 39e0
VS21 26 s21 0
R21 s21 13 82e-2
VS22 27 s22 0
V22 e22 s22 DC 0 AC 68e1 0
RI22 e22 26 47e-1
VS23 0 s23 0
L23 s23 12 10e-4
VS24 24 s24 0
C24 s24 8 18e-4
VS25 7 s25 0
L25 s25 20 39e-5
VS26 5 s26 0
L26 s26 7 10e-5
VS27 27 s27 0
L27 s27 7 22e-4
VS28 25 s28 0
R28 s28 26 22e0
VS29 17 s29 0
R29 s29 20 68e-1
VS30 17 s30 0
R30 s30 18 68e1
VS31 22 s31 0
L31 s31 17 27e-4
VS32 11 s32 0
V32 e32 s32 DC 0 AC 68e0 120
RI32 e32 13 82e-1
VS33 0 s33 0
L33 s33 27 39e-5
VS34 20 s34 0
R34 s34 15 12e2
VS35 7 s35 0
V35 e35 s35 DC 0 AC 56e-1 0
RI35 e35 18 82e-3
VS36 20 s36 0
V36 e36 s36 DC 0 AC 82e0 180
RI36 e36 4 22e-2
VS37 2 s37 0
L37 s37 0 12e-5
.control
set numdgt=17
ac lin 1 60 60
print v(1) v(2) v(3) v(4) v(5) v(6) v(7) v(8) v(9) v(10)
print v(11) v(12) v(13) v(14) v(15) v(16) v(17) v(18) v(19) v(20)
print v(21) v(22) v(23) v(24) v(25) v(26) v(27)
print i(vs0) i(vs1) i(vs2) i(vs3) i(vs4) i(vs5) i(vs6) i(vs7) i(vs8) i(vs9)
print i(vs10) i(vs11) i(vs12) i(vs13) i(vs14) i(vs15) i(vs16) i(vs17) i(vs18) i(vs19)
print i(vs20) i(vs21) i(vs22) i(vs23) i(vs24) i(vs25) i(vs26) i(vs27) i(vs28) i(vs29)
print i(vs30) i(vs31) i(vs32) i(vs33) i(vs34) i(vs35) i(vs36) i(vs37)
.endc
.end
