controls oracle ac-0089
* Generated (plan F2.7, ADR 0012): do not edit; regenerate with `pnpm sim oracle regen`. ac seed 20261031 index 89 nodes 28 elements 45
.options sparse gmin=1e-12 noopac
RG1 1 0 1000000000000
RG2 2 0 1000000000000
RG3 3 0 1000000000000
RG4 4 0 1000000000000
RG5 5 0 1000000000000
RG6 6 0 1000000000000
RG7 7 0 1000000000000
RG8 8 0 1000000000000
RG9 9 0 1000000000000
RG10 10 0 1000000000000
RG11 11 0 1000000000000
RG12 12 0 1000000000000
RG13 13 0 1000000000000
RG14 14 0 1000000000000
RG15 15 0 1000000000000
RG16 16 0 1000000000000
RG17 17 0 1000000000000
RG18 18 0 1000000000000
RG19 19 0 1000000000000
RG20 20 0 1000000000000
RG21 21 0 1000000000000
RG22 22 0 1000000000000
RG23 23 0 1000000000000
RG24 24 0 1000000000000
RG25 25 0 1000000000000
RG26 26 0 1000000000000
RG27 27 0 1000000000000
VS0 2 s0 0
L0 s0 27 12e-5
VS1 0 s1 0
V1 e1 s1 DC 0 AC 27e0 120
RI1 e1 n1 56e-3
H1 n1 h1 VS9 -15e-4
ED1 h1 26 d1 0 -15e-6
F1 0 d1 VS9 1
LD1 d1 0 1
VS2 23 s2 0
L2 s2 5 18e-5
VS3 1 s3 0
L3 s3 0 82e-4
VS4 9 s4 0
L4 s4 4 12e-2
VS5 13 s5 0
R5 s5 15 56e0
VS6 24 s6 0
C6 s6 8 18e-4
VS7 14 s7 0
R7 s7 3 47e1
VS8 27 s8 0
L8 s8 10 39e-5
VS9 11 s9 0
V9 e9 s9 DC 0 AC 68e0 120
RI9 e9 m9 82e-1
LI9 m9 n9 12e-6
H9 n9 h9 VS1 -15e-4
ED9 h9 13 d9 0 -15e-6
F9 0 d9 VS1 1
LD9 d9 0 1
VS10 20 s10 0
V10 e10 s10 DC 0 AC 82e0 180
RI10 e10 m10 22e-2
LI10 m10 4 47e-5
VS11 26 s11 0
V11 e11 s11 DC 0 AC 18e0 120
RI11 e11 21 27e-3
VS12 5 s12 0
V12 e12 s12 DC 0 AC 12e1 120
RI12 e12 m12 68e-2
LI12 m12 17 47e-6
VS13 14 s13 0
R13 s13 16 82e-2
VS14 4 s14 0
V14 e14 s14 DC 0 AC 18e1 -120
RI14 e14 m14 82e-3
LI14 m14 23 82e-5
VS15 17 s15 0
R15 s15 18 68e1
VS16 25 s16 0
V16 e16 s16 DC 0 AC 33e1 -120
RI16 e16 m16 18e-3
LI16 m16 18 10e-7
VS17 22 s17 0
L17 s17 17 27e-4
VS18 19 s18 0
L18 s18 16 18e-2
VS19 10 s19 0
V19 e19 s19 DC 0 AC 68e1 0
RI19 e19 26 47e-1
VS20 25 s20 0
R20 s20 26 22e0
VS21 10 s21 0
L21 s21 7 22e-4
VS22 1 s22 0
R22 s22 6 39e0
VS23 18 s23 0
L23 s23 21 68e-2
VS24 26 s24 0
C24 s24 13 47e-5
VS25 2 s25 0
C25 s25 26 39e-7
VS26 7 s26 0
L26 s26 20 39e-5
VS27 7 s27 0
C27 s27 6 18e-5
VS28 5 s28 0
L28 s28 7 10e-5
VS29 27 s29 0
L29 s29 12 10e-4
VS30 19 s30 0
R30 s30 21 33e3
VS31 6 s31 0
L31 s31 17 68e-2
VS32 7 s32 0
V32 e32 s32 DC 0 AC 56e-1 0
RI32 e32 18 82e-3
VS33 17 s33 0
R33 s33 20 68e-1
VS34 24 s34 0
V34 e34 s34 DC 0 AC 22e0 120
RI34 e34 10 68e-1
VS35 13 s35 0
L35 s35 22 22e-2
VS36 26 s36 0
R36 s36 13 82e-2
VS37 3 s37 0
C37 s37 27 56e-4
VS38 8 s38 0
R38 s38 9 56e3
VS39 2 s39 0
R39 s39 12 27e0
VS40 17 s40 0
R40 s40 16 18e-2
VS41 27 s41 0
V41 e41 s41 DC 0 AC 56e1 180
RI41 e41 m41 68e-2
LI41 m41 11 39e-6
VS42 7 s42 0
V42 e42 s42 DC 0 AC 10e0 180
RI42 e42 16 39e-3
VS43 10 s43 0
R43 s43 20 10e-1
VS44 20 s44 0
R44 s44 15 12e2
.control
set numdgt=17
ac lin 1 60 60
print v(1) v(2) v(3) v(4) v(5) v(6) v(7) v(8) v(9) v(10)
print v(11) v(12) v(13) v(14) v(15) v(16) v(17) v(18) v(19) v(20)
print v(21) v(22) v(23) v(24) v(25) v(26) v(27)
print i(vs0) i(vs1) i(vs2) i(vs3) i(vs4) i(vs5) i(vs6) i(vs7) i(vs8) i(vs9)
print i(vs10) i(vs11) i(vs12) i(vs13) i(vs14) i(vs15) i(vs16) i(vs17) i(vs18) i(vs19)
print i(vs20) i(vs21) i(vs22) i(vs23) i(vs24) i(vs25) i(vs26) i(vs27) i(vs28) i(vs29)
print i(vs30) i(vs31) i(vs32) i(vs33) i(vs34) i(vs35) i(vs36) i(vs37) i(vs38) i(vs39)
print i(vs40) i(vs41) i(vs42) i(vs43) i(vs44)
.endc
.end
