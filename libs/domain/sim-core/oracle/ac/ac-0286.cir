controls oracle ac-0286
* Generated (plan F2.7, ADR 0012): do not edit; regenerate with `pnpm sim oracle regen`. ac seed 20261031 index 286 nodes 27 elements 48
.options sparse gmin=1e-12 noopac
RG1 1 0 1000000000000
RG2 2 0 1000000000000
RG3 3 0 1000000000000
RG4 4 0 1000000000000
RG5 5 0 1000000000000
RG6 6 0 1000000000000
RG7 7 0 1000000000000
RG8 8 0 1000000000000
RG9 9 0 1000000000000
RG10 10 0 1000000000000
RG11 11 0 1000000000000
RG12 12 0 1000000000000
RG13 13 0 1000000000000
RG14 14 0 1000000000000
RG15 15 0 1000000000000
RG16 16 0 1000000000000
RG17 17 0 1000000000000
RG18 18 0 1000000000000
RG19 19 0 1000000000000
RG20 20 0 1000000000000
RG21 21 0 1000000000000
RG22 22 0 1000000000000
RG23 23 0 1000000000000
RG24 24 0 1000000000000
RG25 25 0 1000000000000
RG26 26 0 1000000000000
VS0 19 s0 0
L0 s0 18 39e-2
VS1 7 s1 0
L1 s1 18 15e-2
VS2 20 s2 0
R2 s2 11 68e1
VS3 15 s3 0
L3 s3 24 18e-2
VS4 26 s4 0
R4 s4 3 39e1
VS5 21 s5 0
L5 s5 12 15e-2
VS6 21 s6 0
L6 s6 25 33e-4
VS7 0 s7 0
V7 e7 s7 DC 0 AC 39e-1 0
RI7 e7 6 33e-1
VS8 7 s8 0
V8 e8 s8 DC 0 AC 47e1 120
RI8 e8 6 10e-2
VS9 0 s9 0
V9 e9 s9 DC 0 AC 10e1 120
RI9 e9 7 12e-2
VS10 23 s10 0
R10 s10 8 82e-1
VS11 17 s11 0
C11 s11 1 10e-6
VS12 17 s12 0
R12 s12 19 15e-1
VS13 15 s13 0
C13 s13 14 18e-7
VS14 24 s14 0
R14 s14 17 15e0
VS15 5 s15 0
V15 e15 s15 DC 0 AC 12e0 0
RI15 e15 6 27e-3
VS16 20 s16 0
R16 s16 21 18e-2
VS17 22 s17 0
L17 s17 17 10e-4
VS18 14 s18 0
R18 s18 8 68e3
VS19 3 s19 0
C19 s19 2 68e-7
VS20 14 s20 0
L20 s20 24 82e-3
VS21 10 s21 0
L21 s21 5 10e-5
VS22 2 s22 0
V22 e22 s22 DC 0 AC 22e1 120
RI22 e22 3 15e-1
VS23 16 s23 0
L23 s23 10 10e-3
VS24 3 s24 0
R24 s24 1 68e-1
VS25 24 s25 0
L25 s25 15 18e-5
VS26 8 s26 0
C26 s26 4 15e-7
VS27 15 s27 0
R27 s27 12 47e3
VS28 10 s28 0
C28 s28 2 47e-5
VS29 9 s29 0
V29 e29 s29 DC 0 AC 47e-1 120
RI29 e29 11 47e-2
VS30 9 s30 0
R30 s30 23 10e0
VS31 3 s31 0
R31 s31 15 27e-2
VS32 22 s32 0
L32 s32 25 82e-4
VS33 19 s33 0
R33 s33 23 33e3
VS34 13 s34 0
R34 s34 24 39e2
VS35 9 s35 0
R35 s35 13 47e1
VS36 9 s36 0
R36 s36 25 18e-2
VS37 0 s37 0
L37 s37 16 10e-3
VS38 3 s38 0
C38 s38 6 82e-7
VS39 10 s39 0
C39 s39 11 27e-5
VS40 26 s40 0
R40 s40 22 12e1
VS41 20 s41 0
C41 s41 1 47e-4
VS42 21 s42 0
L42 s42 1 82e-5
VS43 11 s43 0
L43 s43 19 18e-5
VS44 3 s44 0
L44 s44 12 18e-2
VS45 25 s45 0
C45 s45 12 33e-4
VS46 4 s46 0
C46 s46 1 68e-7
VS47 4 s47 0
L47 s47 21 27e-2
.control
set numdgt=17
ac lin 1 60 60
print v(1) v(2) v(3) v(4) v(5) v(6) v(7) v(8) v(9) v(10)
print v(11) v(12) v(13) v(14) v(15) v(16) v(17) v(18) v(19) v(20)
print v(21) v(22) v(23) v(24) v(25) v(26)
print i(vs0) i(vs1) i(vs2) i(vs3) i(vs4) i(vs5) i(vs6) i(vs7) i(vs8) i(vs9)
print i(vs10) i(vs11) i(vs12) i(vs13) i(vs14) i(vs15) i(vs16) i(vs17) i(vs18) i(vs19)
print i(vs20) i(vs21) i(vs22) i(vs23) i(vs24) i(vs25) i(vs26) i(vs27) i(vs28) i(vs29)
print i(vs30) i(vs31) i(vs32) i(vs33) i(vs34) i(vs35) i(vs36) i(vs37) i(vs38) i(vs39)
print i(vs40) i(vs41) i(vs42) i(vs43) i(vs44) i(vs45) i(vs46) i(vs47)
.endc
.end
