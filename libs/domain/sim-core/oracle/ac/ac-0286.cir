controls oracle ac-0286
* Generated (plan F2.7, ADR 0012): do not edit; regenerate with `pnpm sim oracle regen`. ac seed 20261031 index 286 nodes 27 elements 45
.options sparse gmin=1e-12 noopac
RG1 1 0 1000000000000
RG2 2 0 1000000000000
RG3 3 0 1000000000000
RG4 4 0 1000000000000
RG5 5 0 1000000000000
RG6 6 0 1000000000000
RG7 7 0 1000000000000
RG8 8 0 1000000000000
RG9 9 0 1000000000000
RG10 10 0 1000000000000
RG11 11 0 1000000000000
RG12 12 0 1000000000000
RG13 13 0 1000000000000
RG14 14 0 1000000000000
RG15 15 0 1000000000000
RG16 16 0 1000000000000
RG17 17 0 1000000000000
RG18 18 0 1000000000000
RG19 19 0 1000000000000
RG20 20 0 1000000000000
RG21 21 0 1000000000000
RG22 22 0 1000000000000
RG23 23 0 1000000000000
RG24 24 0 1000000000000
RG25 25 0 1000000000000
RG26 26 0 1000000000000
VS0 20 s0 0
R0 s0 11 68e1
VS1 20 s1 0
C1 s1 1 47e-4
VS2 3 s2 0
C2 s2 2 68e-7
VS3 3 s3 0
C3 s3 6 82e-7
VS4 3 s4 0
L4 s4 12 18e-2
VS5 22 s5 0
L5 s5 25 82e-4
VS6 17 s6 0
C6 s6 1 10e-6
VS7 0 s7 0
L7 s7 16 10e-3
VS8 10 s8 0
L8 s8 5 10e-5
VS9 21 s9 0
L9 s9 12 15e-2
VS10 0 s10 0
V10 e10 s10 DC 0 AC 39e-1 0
RI10 e10 6 33e-1
VS11 14 s11 0
R11 s11 8 68e3
VS12 19 s12 0
L12 s12 18 39e-2
VS13 7 s13 0
L13 s13 18 15e-2
VS14 15 s14 0
R14 s14 12 47e3
VS15 10 s15 0
C15 s15 11 27e-5
VS16 8 s16 0
C16 s16 4 15e-7
VS17 9 s17 0
V17 e17 s17 DC 0 AC 47e-1 120
RI17 e17 11 47e-2
VS18 9 s18 0
R18 s18 25 18e-2
VS19 16 s19 0
L19 s19 10 10e-3
VS20 24 s20 0
R20 s20 17 15e0
VS21 24 s21 0
L21 s21 15 18e-5
VS22 4 s22 0
L22 s22 21 27e-2
VS23 13 s23 0
R23 s23 24 39e2
VS24 11 s24 0
L24 s24 19 18e-5
VS25 2 s25 0
V25 e25 s25 DC 0 AC 22e1 120
RI25 e25 3 15e-1
VS26 19 s26 0
R26 s26 23 33e3
VS27 17 s27 0
R27 s27 19 15e-1
VS28 4 s28 0
C28 s28 1 68e-7
VS29 14 s29 0
L29 s29 24 82e-3
VS30 9 s30 0
R30 s30 23 10e0
VS31 25 s31 0
C31 s31 12 33e-4
VS32 15 s32 0
L32 s32 24 18e-2
VS33 26 s33 0
R33 s33 22 12e1
VS34 7 s34 0
V34 e34 s34 DC 0 AC 47e1 120
RI34 e34 6 10e-2
VS35 9 s35 0
R35 s35 13 47e1
VS36 0 s36 0
V36 e36 s36 DC 0 AC 10e1 120
RI36 e36 7 12e-2
VS37 3 s37 0
R37 s37 1 68e-1
VS38 21 s38 0
L38 s38 1 82e-5
VS39 21 s39 0
L39 s39 25 33e-4
VS40 3 s40 0
R40 s40 15 27e-2
VS41 22 s41 0
L41 s41 17 10e-4
VS42 23 s42 0
R42 s42 8 82e-1
VS43 15 s43 0
C43 s43 14 18e-7
VS44 20 s44 0
R44 s44 21 18e-2
.control
set numdgt=17
ac lin 1 60 60
print v(1) v(2) v(3) v(4) v(5) v(6) v(7) v(8) v(9) v(10)
print v(11) v(12) v(13) v(14) v(15) v(16) v(17) v(18) v(19) v(20)
print v(21) v(22) v(23) v(24) v(25) v(26)
print i(vs0) i(vs1) i(vs2) i(vs3) i(vs4) i(vs5) i(vs6) i(vs7) i(vs8) i(vs9)
print i(vs10) i(vs11) i(vs12) i(vs13) i(vs14) i(vs15) i(vs16) i(vs17) i(vs18) i(vs19)
print i(vs20) i(vs21) i(vs22) i(vs23) i(vs24) i(vs25) i(vs26) i(vs27) i(vs28) i(vs29)
print i(vs30) i(vs31) i(vs32) i(vs33) i(vs34) i(vs35) i(vs36) i(vs37) i(vs38) i(vs39)
print i(vs40) i(vs41) i(vs42) i(vs43) i(vs44)
.endc
.end
