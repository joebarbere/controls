controls oracle ac-0286
* Generated (plan F2.7, ADR 0012): do not edit; regenerate with `pnpm sim oracle regen`. ac seed 20261031 index 286 nodes 27 elements 39
.options sparse gmin=1e-12 noopac
RG1 1 0 1000000000000
RG2 2 0 1000000000000
RG3 3 0 1000000000000
RG4 4 0 1000000000000
RG5 5 0 1000000000000
RG6 6 0 1000000000000
RG7 7 0 1000000000000
RG8 8 0 1000000000000
RG9 9 0 1000000000000
RG10 10 0 1000000000000
RG11 11 0 1000000000000
RG12 12 0 1000000000000
RG13 13 0 1000000000000
RG14 14 0 1000000000000
RG15 15 0 1000000000000
RG16 16 0 1000000000000
RG17 17 0 1000000000000
RG18 18 0 1000000000000
RG19 19 0 1000000000000
RG20 20 0 1000000000000
RG21 21 0 1000000000000
RG22 22 0 1000000000000
RG23 23 0 1000000000000
RG24 24 0 1000000000000
RG25 25 0 1000000000000
RG26 26 0 1000000000000
VS0 23 s0 0
R0 s0 20 68e3
VS1 0 s1 0
V1 e1 s1 DC 0 AC 82e-1 0
RI1 e1 26 33e-3
VS2 9 s2 0
V2 e2 s2 DC 0 AC 47e-1 120
RI2 e2 m2 47e-2
LI2 m2 11 18e-6
VS3 2 s3 0
C3 s3 11 33e-7
VS4 10 s4 0
L4 s4 3 10e-4
VS5 4 s5 0
R5 s5 26 68e-2
VS6 12 s6 0
C6 s6 10 15e-6
VS7 5 s7 0
L7 s7 9 27e-2
VS8 26 s8 0
R8 s8 1 15e-1
VS9 12 s9 0
L9 s9 18 39e-2
VS10 6 s10 0
L10 s10 10 56e-2
VS11 22 s11 0
R11 s11 13 27e2
VS12 22 s12 0
L12 s12 17 10e-4
VS13 11 s13 0
V13 e13 s13 DC 0 AC 12e0 -120
RI13 e13 m13 10e-3
LI13 m13 19 68e-7
VS14 8 s14 0
R14 s14 21 10e0
VS15 4 s15 0
R15 s15 11 47e-1
VS16 13 s16 0
R16 s16 0 15e0
VS17 23 s17 0
L17 s17 26 56e-3
VS18 19 s18 0
R18 s18 21 18e0
VS19 12 s19 0
R19 s19 6 12e0
VS20 26 s20 0
R20 s20 3 82e1
VS21 5 s21 0
V21 e21 s21 DC 0 AC 12e-1 180
RI21 e21 2 22e-1
VS22 14 s22 0
L22 s22 8 18e-5
VS23 16 s23 0
R23 s23 10 10e-2
VS24 15 s24 0
V24 e24 s24 DC 0 AC 82e0 0
RI24 e24 m24 22e-3
LI24 m24 24 68e-7
VS25 15 s25 0
C25 s25 1 82e-7
VS26 2 s26 0
R26 s26 12 27e-1
VS27 2 s27 0
R27 s27 14 33e-1
VS28 13 s28 0
V28 e28 s28 DC 0 AC 82e-1 180
RI28 e28 24 39e-2
VS29 23 s29 0
L29 s29 17 10e-5
VS30 25 s30 0
L30 s30 7 68e-4
VS31 11 s31 0
C31 s31 16 12e-5
VS32 7 s32 0
R32 s32 13 12e3
VS33 17 s33 0
R33 s33 12 15e-1
VS34 7 s34 0
V34 e34 s34 DC 0 AC 10e1 180
RI34 e34 m34 15e-2
LI34 m34 20 33e-6
VS35 17 s35 0
V35 e35 s35 DC 0 AC 12e1 0
RI35 e35 8 56e-2
VS36 11 s36 0
L36 s36 12 18e-5
VS37 7 s37 0
L37 s37 17 56e-2
VS38 18 s38 0
C38 s38 25 39e-4
.control
set numdgt=17
ac lin 1 60 60
print v(1) v(2) v(3) v(4) v(5) v(6) v(7) v(8) v(9) v(10)
print v(11) v(12) v(13) v(14) v(15) v(16) v(17) v(18) v(19) v(20)
print v(21) v(22) v(23) v(24) v(25) v(26)
print i(vs0) i(vs1) i(vs2) i(vs3) i(vs4) i(vs5) i(vs6) i(vs7) i(vs8) i(vs9)
print i(vs10) i(vs11) i(vs12) i(vs13) i(vs14) i(vs15) i(vs16) i(vs17) i(vs18) i(vs19)
print i(vs20) i(vs21) i(vs22) i(vs23) i(vs24) i(vs25) i(vs26) i(vs27) i(vs28) i(vs29)
print i(vs30) i(vs31) i(vs32) i(vs33) i(vs34) i(vs35) i(vs36) i(vs37) i(vs38)
.endc
.end
