controls oracle ac-0130
* Generated (plan F2.7, ADR 0012): do not edit; regenerate with `pnpm sim oracle regen`. ac seed 20261031 index 130 nodes 24 elements 46
.options sparse gmin=1e-12 noopac
RG1 1 0 1000000000000
RG2 2 0 1000000000000
RG3 3 0 1000000000000
RG4 4 0 1000000000000
RG5 5 0 1000000000000
RG6 6 0 1000000000000
RG7 7 0 1000000000000
RG8 8 0 1000000000000
RG9 9 0 1000000000000
RG10 10 0 1000000000000
RG11 11 0 1000000000000
RG12 12 0 1000000000000
RG13 13 0 1000000000000
RG14 14 0 1000000000000
RG15 15 0 1000000000000
RG16 16 0 1000000000000
RG17 17 0 1000000000000
RG18 18 0 1000000000000
RG19 19 0 1000000000000
RG20 20 0 1000000000000
RG21 21 0 1000000000000
RG22 22 0 1000000000000
RG23 23 0 1000000000000
VS0 0 s0 0
V0 e0 s0 DC 0 AC 18e0 120
RI0 e0 n0 68e-2
H0 n0 h0 VS1 39e-4
ED0 h0 6 d0 0 -12e-7
F0 0 d0 VS1 1
LD0 d0 0 1
VS1 14 s1 0
V1 e1 s1 DC 0 AC 56e0 180
RI1 e1 n1 12e-3
H1 n1 h1 VS0 39e-4
ED1 h1 13 d1 0 -12e-7
F1 0 d1 VS0 1
LD1 d1 0 1
VS2 16 s2 0
V2 e2 s2 DC 0 AC 15e1 180
RI2 e2 m2 47e-1
LI2 m2 10 33e-5
VS3 4 s3 0
C3 s3 8 22e-7
VS4 3 s4 0
C4 s4 0 27e-7
VS5 8 s5 0
V5 e5 s5 DC 0 AC 33e0 0
RI5 e5 18 22e-3
VS6 0 s6 0
R6 s6 22 47e-1
VS7 6 s7 0
R7 s7 19 15e-1
VS8 14 s8 0
V8 e8 s8 DC 0 AC 12e-1 120
RI8 e8 17 56e-2
VS9 15 s9 0
V9 e9 s9 DC 0 AC 68e-1 180
RI9 e9 5 27e-1
VS10 20 s10 0
R10 s10 10 10e2
VS11 22 s11 0
V11 e11 s11 DC 0 AC 12e1 -120
RI11 e11 m11 15e-3
LI11 m11 8 56e-6
VS12 11 s12 0
R12 s12 16 22e-2
VS13 23 s13 0
C13 s13 2 27e-5
VS14 17 s14 0
V14 e14 s14 DC 0 AC 68e1 120
RI14 e14 m14 56e-2
LI14 m14 19 39e-6
VS15 1 s15 0
L15 s15 17 82e-5
VS16 0 s16 0
L16 s16 12 12e-5
VS17 17 s17 0
L17 s17 21 10e-3
VS18 7 s18 0
L18 s18 1 33e-3
VS19 4 s19 0
R19 s19 1 22e3
VS20 11 s20 0
C20 s20 8 33e-4
VS21 10 s21 0
R21 s21 9 12e-2
VS22 20 s22 0
V22 e22 s22 DC 0 AC 18e-1 -120
RI22 e22 17 39e-2
VS23 11 s23 0
L23 s23 14 56e-2
VS24 14 s24 0
R24 s24 9 33e-2
VS25 21 s25 0
L25 s25 3 47e-3
VS26 21 s26 0
R26 s26 9 22e-2
VS27 13 s27 0
C27 s27 18 15e-5
VS28 5 s28 0
R28 s28 22 56e0
VS29 17 s29 0
L29 s29 1 27e-4
VS30 7 s30 0
R30 s30 22 22e3
VS31 16 s31 0
C31 s31 11 33e-6
VS32 21 s32 0
V32 e32 s32 DC 0 AC 27e0 0
RI32 e32 m32 68e-3
LI32 m32 22 27e-6
VS33 17 s33 0
C33 s33 15 12e-5
VS34 2 s34 0
C34 s34 16 68e-7
VS35 12 s35 0
V35 e35 s35 DC 0 AC 39e-1 180
RI35 e35 m35 68e-3
LI35 m35 23 22e-6
VS36 7 s36 0
V36 e36 s36 DC 0 AC 27e0 120
RI36 e36 m36 10e-1
LI36 m36 8 82e-6
VS37 8 s37 0
V37 e37 s37 DC 0 AC 15e-1 -120
RI37 e37 6 68e-1
VS38 9 s38 0
L38 s38 18 15e-4
VS39 17 s39 0
L39 s39 0 12e-4
VS40 2 s40 0
V40 e40 s40 DC 0 AC 27e0 120
RI40 e40 18 15e-3
VS41 13 s41 0
V41 e41 s41 DC 0 AC 12e1 -120
RI41 e41 11 10e-2
VS42 19 s42 0
R42 s42 6 22e-1
VS43 3 s43 0
C43 s43 13 10e-6
VS44 8 s44 0
L44 s44 5 15e-4
VS45 17 s45 0
L45 s45 4 22e-2
.control
set numdgt=17
ac lin 1 60 60
print v(1) v(2) v(3) v(4) v(5) v(6) v(7) v(8) v(9) v(10)
print v(11) v(12) v(13) v(14) v(15) v(16) v(17) v(18) v(19) v(20)
print v(21) v(22) v(23)
print i(vs0) i(vs1) i(vs2) i(vs3) i(vs4) i(vs5) i(vs6) i(vs7) i(vs8) i(vs9)
print i(vs10) i(vs11) i(vs12) i(vs13) i(vs14) i(vs15) i(vs16) i(vs17) i(vs18) i(vs19)
print i(vs20) i(vs21) i(vs22) i(vs23) i(vs24) i(vs25) i(vs26) i(vs27) i(vs28) i(vs29)
print i(vs30) i(vs31) i(vs32) i(vs33) i(vs34) i(vs35) i(vs36) i(vs37) i(vs38) i(vs39)
print i(vs40) i(vs41) i(vs42) i(vs43) i(vs44) i(vs45)
.endc
.end
