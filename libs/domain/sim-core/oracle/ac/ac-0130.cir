controls oracle ac-0130
* Generated (plan F2.7, ADR 0012): do not edit; regenerate with `pnpm sim oracle regen`. ac seed 20261031 index 130 nodes 24 elements 48
.options sparse gmin=1e-12 noopac
RG1 1 0 1000000000000
RG2 2 0 1000000000000
RG3 3 0 1000000000000
RG4 4 0 1000000000000
RG5 5 0 1000000000000
RG6 6 0 1000000000000
RG7 7 0 1000000000000
RG8 8 0 1000000000000
RG9 9 0 1000000000000
RG10 10 0 1000000000000
RG11 11 0 1000000000000
RG12 12 0 1000000000000
RG13 13 0 1000000000000
RG14 14 0 1000000000000
RG15 15 0 1000000000000
RG16 16 0 1000000000000
RG17 17 0 1000000000000
RG18 18 0 1000000000000
RG19 19 0 1000000000000
RG20 20 0 1000000000000
RG21 21 0 1000000000000
RG22 22 0 1000000000000
RG23 23 0 1000000000000
VS0 21 s0 0
R0 s0 6 10e-1
VS1 7 s1 0
R1 s1 21 10e2
VS2 0 s2 0
V2 e2 s2 DC 0 AC 68e1 120
RI2 e2 m2 22e-1
LI2 m2 5 56e-6
VS3 9 s3 0
C3 s3 2 68e-5
VS4 16 s4 0
R4 s4 20 27e3
VS5 14 s5 0
R5 s5 23 18e3
VS6 4 s6 0
V6 e6 s6 DC 0 AC 15e0 180
RI6 e6 22 47e-2
VS7 5 s7 0
L7 s7 0 12e-5
VS8 7 s8 0
L8 s8 14 39e-3
VS9 5 s9 0
V9 e9 s9 DC 0 AC 12e0 120
RI9 e9 21 27e-3
VS10 8 s10 0
R10 s10 12 10e-2
VS11 12 s11 0
C11 s11 18 33e-6
VS12 14 s12 0
R12 s12 1 15e1
VS13 18 s13 0
R13 s13 4 10e-1
VS14 23 s14 0
C14 s14 11 27e-7
VS15 3 s15 0
R15 s15 9 12e1
VS16 1 s16 0
L16 s16 23 47e-3
VS17 1 s17 0
R17 s17 20 10e-2
VS18 5 s18 0
C18 s18 10 18e-5
VS19 11 s19 0
C19 s19 16 10e-6
VS20 15 s20 0
R20 s20 13 47e2
VS21 16 s21 0
C21 s21 11 33e-6
VS22 22 s22 0
V22 e22 s22 DC 0 AC 18e-1 -120
RI22 e22 m22 39e-2
LI22 m22 17 18e-7
VS23 16 s23 0
V23 e23 s23 DC 0 AC 15e1 180
RI23 e23 10 47e-1
VS24 13 s24 0
R24 s24 17 22e2
VS25 16 s25 0
L25 s25 7 10e-3
VS26 13 s26 0
V26 e26 s26 DC 0 AC 12e1 180
RI26 e26 m26 56e-1
LI26 m26 12 27e-7
VS27 17 s27 0
C27 s27 5 47e-5
VS28 19 s28 0
L28 s28 17 12e-3
VS29 9 s29 0
C29 s29 5 68e-7
VS30 12 s30 0
C30 s30 4 27e-5
VS31 0 s31 0
L31 s31 21 27e-2
VS32 3 s32 0
R32 s32 8 22e0
VS33 3 s33 0
R33 s33 15 68e1
VS34 20 s34 0
L34 s34 17 22e-3
VS35 19 s35 0
V35 e35 s35 DC 0 AC 15e-1 180
RI35 e35 17 12e-1
VS36 1 s36 0
R36 s36 9 47e2
VS37 13 s37 0
V37 e37 s37 DC 0 AC 82e1 -120
RI37 e37 10 12e-2
VS38 20 s38 0
R38 s38 3 33e-2
VS39 6 s39 0
R39 s39 19 15e-1
VS40 4 s40 0
L40 s40 0 39e-4
VS41 22 s41 0
L41 s41 23 10e-5
VS42 4 s42 0
R42 s42 1 22e3
VS43 12 s43 0
R43 s43 6 22e2
VS44 14 s44 0
L44 s44 20 39e-3
VS45 17 s45 0
L45 s45 6 10e-5
VS46 17 s46 0
L46 s46 21 56e-3
VS47 2 s47 0
R47 s47 4 27e3
.control
set numdgt=17
ac lin 1 60 60
print v(1) v(2) v(3) v(4) v(5) v(6) v(7) v(8) v(9) v(10)
print v(11) v(12) v(13) v(14) v(15) v(16) v(17) v(18) v(19) v(20)
print v(21) v(22) v(23)
print i(vs0) i(vs1) i(vs2) i(vs3) i(vs4) i(vs5) i(vs6) i(vs7) i(vs8) i(vs9)
print i(vs10) i(vs11) i(vs12) i(vs13) i(vs14) i(vs15) i(vs16) i(vs17) i(vs18) i(vs19)
print i(vs20) i(vs21) i(vs22) i(vs23) i(vs24) i(vs25) i(vs26) i(vs27) i(vs28) i(vs29)
print i(vs30) i(vs31) i(vs32) i(vs33) i(vs34) i(vs35) i(vs36) i(vs37) i(vs38) i(vs39)
print i(vs40) i(vs41) i(vs42) i(vs43) i(vs44) i(vs45) i(vs46) i(vs47)
.endc
.end
