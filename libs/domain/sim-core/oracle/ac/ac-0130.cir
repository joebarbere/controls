controls oracle ac-0130
* Generated (plan F2.7, ADR 0012): do not edit; regenerate with `pnpm sim oracle regen`. ac seed 20261031 index 130 nodes 24 elements 45
.options sparse gmin=1e-12 noopac
RG1 1 0 1000000000000
RG2 2 0 1000000000000
RG3 3 0 1000000000000
RG4 4 0 1000000000000
RG5 5 0 1000000000000
RG6 6 0 1000000000000
RG7 7 0 1000000000000
RG8 8 0 1000000000000
RG9 9 0 1000000000000
RG10 10 0 1000000000000
RG11 11 0 1000000000000
RG12 12 0 1000000000000
RG13 13 0 1000000000000
RG14 14 0 1000000000000
RG15 15 0 1000000000000
RG16 16 0 1000000000000
RG17 17 0 1000000000000
RG18 18 0 1000000000000
RG19 19 0 1000000000000
RG20 20 0 1000000000000
RG21 21 0 1000000000000
RG22 22 0 1000000000000
RG23 23 0 1000000000000
VS0 17 s0 0
L0 s0 20 12e-4
VS1 17 s1 0
L1 s1 1 27e-4
VS2 11 s2 0
R2 s2 16 22e-2
VS3 17 s3 0
C3 s3 15 12e-5
VS4 9 s4 0
L4 s4 18 15e-4
VS5 17 s5 0
L5 s5 21 10e-3
VS6 0 s6 0
V6 e6 s6 DC 0 AC 12e1 -120
RI6 e6 11 10e-2
VS7 1 s7 0
L7 s7 17 82e-5
VS8 14 s8 0
V8 e8 s8 DC 0 AC 56e0 180
RI8 e8 0 12e-3
VS9 8 s9 0
V9 e9 s9 DC 0 AC 33e0 0
RI9 e9 18 22e-3
VS10 20 s10 0
L10 s10 12 12e-5
VS11 15 s11 0
V11 e11 s11 DC 0 AC 68e-1 180
RI11 e11 5 27e-1
VS12 10 s12 0
R12 s12 9 12e-2
VS13 17 s13 0
V13 e13 s13 DC 0 AC 68e1 120
RI13 e13 19 56e-2
VS14 21 s14 0
V14 e14 s14 DC 0 AC 27e0 0
RI14 e14 22 68e-3
VS15 4 s15 0
R15 s15 1 22e3
VS16 2 s16 0
V16 e16 s16 DC 0 AC 27e0 120
RI16 e16 18 15e-3
VS17 3 s17 0
C17 s17 0 10e-6
VS18 16 s18 0
V18 e18 s18 DC 0 AC 15e1 180
RI18 e18 10 47e-1
VS19 22 s19 0
V19 e19 s19 DC 0 AC 12e1 -120
RI19 e19 8 15e-3
VS20 8 s20 0
V20 e20 s20 DC 0 AC 15e-1 -120
RI20 e20 6 68e-1
VS21 13 s21 0
V21 e21 s21 DC 0 AC 18e-1 -120
RI21 e21 17 39e-2
VS22 7 s22 0
R22 s22 22 22e3
VS23 3 s23 0
C23 s23 20 27e-7
VS24 7 s24 0
V24 e24 s24 DC 0 AC 27e0 120
RI24 e24 8 10e-1
VS25 20 s25 0
V25 e25 s25 DC 0 AC 18e0 120
RI25 e25 6 68e-2
VS26 21 s26 0
L26 s26 3 47e-3
VS27 2 s27 0
C27 s27 16 68e-7
VS28 19 s28 0
R28 s28 6 22e-1
VS29 14 s29 0
R29 s29 9 33e-2
VS30 11 s30 0
L30 s30 14 56e-2
VS31 0 s31 0
C31 s31 18 15e-5
VS32 4 s32 0
C32 s32 8 22e-7
VS33 11 s33 0
C33 s33 8 33e-4
VS34 21 s34 0
R34 s34 9 22e-2
VS35 5 s35 0
R35 s35 22 56e0
VS36 17 s36 0
L36 s36 4 22e-2
VS37 8 s37 0
L37 s37 5 15e-4
VS38 16 s38 0
C38 s38 11 33e-6
VS39 14 s39 0
V39 e39 s39 DC 0 AC 12e-1 120
RI39 e39 17 56e-2
VS40 12 s40 0
V40 e40 s40 DC 0 AC 39e-1 180
RI40 e40 23 68e-3
VS41 20 s41 0
R41 s41 22 47e-1
VS42 13 s42 0
R42 s42 10 10e2
VS43 6 s43 0
R43 s43 19 15e-1
VS44 7 s44 0
L44 s44 1 33e-3
.control
set numdgt=17
ac lin 1 60 60
print v(1) v(2) v(3) v(4) v(5) v(6) v(7) v(8) v(9) v(10)
print v(11) v(12) v(13) v(14) v(15) v(16) v(17) v(18) v(19) v(20)
print v(21) v(22) v(23)
print i(vs0) i(vs1) i(vs2) i(vs3) i(vs4) i(vs5) i(vs6) i(vs7) i(vs8) i(vs9)
print i(vs10) i(vs11) i(vs12) i(vs13) i(vs14) i(vs15) i(vs16) i(vs17) i(vs18) i(vs19)
print i(vs20) i(vs21) i(vs22) i(vs23) i(vs24) i(vs25) i(vs26) i(vs27) i(vs28) i(vs29)
print i(vs30) i(vs31) i(vs32) i(vs33) i(vs34) i(vs35) i(vs36) i(vs37) i(vs38) i(vs39)
print i(vs40) i(vs41) i(vs42) i(vs43) i(vs44)
.endc
.end
