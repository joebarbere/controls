controls oracle ac-0414
* Generated (plan F2.7, ADR 0012): do not edit; regenerate with `pnpm sim oracle regen`. ac seed 20261031 index 414 nodes 10 elements 19
.options sparse gmin=1e-12 noopac
RG1 1 0 1000000000000
RG2 2 0 1000000000000
RG3 3 0 1000000000000
RG4 4 0 1000000000000
RG5 5 0 1000000000000
RG6 6 0 1000000000000
RG7 7 0 1000000000000
RG8 8 0 1000000000000
RG9 9 0 1000000000000
VS0 9 s0 0
C0 s0 0 15e-4
VS1 2 s1 0
L1 s1 9 33e-4
VS2 6 s2 0
R2 s2 4 68e1
VS3 7 s3 0
L3 s3 8 22e-4
VS4 9 s4 0
R4 s4 8 27e3
VS5 1 s5 0
R5 s5 0 39e-1
VS6 0 s6 0
V6 e6 s6 DC 0 AC 27e1 120
RI6 e6 5 33e-3
VS7 6 s7 0
L7 s7 8 68e-3
VS8 7 s8 0
L8 s8 3 33e-3
VS9 0 s9 0
C9 s9 4 15e-4
VS10 5 s10 0
C10 s10 7 82e-6
VS11 5 s11 0
R11 s11 3 18e3
VS12 2 s12 0
L12 s12 4 27e-2
VS13 4 s13 0
R13 s13 1 47e0
VS14 1 s14 0
C14 s14 3 39e-7
VS15 8 s15 0
C15 s15 5 68e-4
VS16 4 s16 0
R16 s16 0 39e3
VS17 7 s17 0
R17 s17 0 10e1
VS18 3 s18 0
R18 s18 1 12e-2
.control
set numdgt=17
ac lin 1 60 60
print v(1) v(2) v(3) v(4) v(5) v(6) v(7) v(8) v(9)
print i(vs0) i(vs1) i(vs2) i(vs3) i(vs4) i(vs5) i(vs6) i(vs7) i(vs8) i(vs9)
print i(vs10) i(vs11) i(vs12) i(vs13) i(vs14) i(vs15) i(vs16) i(vs17) i(vs18)
.endc
.end
