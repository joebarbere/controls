controls oracle ac-0414
* Generated (plan F2.7, ADR 0012): do not edit; regenerate with `pnpm sim oracle regen`. ac seed 20261031 index 414 nodes 10 elements 17
.options sparse gmin=1e-12 noopac
RG1 1 0 1000000000000
RG2 2 0 1000000000000
RG3 3 0 1000000000000
RG4 4 0 1000000000000
RG5 5 0 1000000000000
RG6 6 0 1000000000000
RG7 7 0 1000000000000
RG8 8 0 1000000000000
RG9 9 0 1000000000000
VS0 8 s0 0
R0 s0 7 56e1
VS1 6 s1 0
R1 s1 3 68e2
VS2 0 s2 0
R2 s2 6 56e-1
VS3 7 s3 0
R3 s3 5 18e3
VS4 1 s4 0
R4 s4 9 39e-1
VS5 2 s5 0
L5 s5 8 18e-5
VS6 0 s6 0
V6 e6 s6 DC 0 AC 47e0 180
RI6 e6 m6 56e-1
LI6 m6 7 22e-5
VS7 8 s7 0
C7 s7 3 18e-5
VS8 5 s8 0
R8 s8 8 27e3
VS9 2 s9 0
R9 s9 3 82e1
VS10 9 s10 0
V10 e10 s10 DC 0 AC 27e1 120
RI10 e10 0 33e-3
VS11 8 s11 0
V11 e11 s11 DC 0 AC 27e1 120
RI11 e11 1 82e-1
VS12 1 s12 0
C12 s12 6 15e-5
VS13 5 s13 0
C13 s13 9 15e-4
VS14 8 s14 0
R14 s14 7 56e-2
VS15 4 s15 0
R15 s15 5 27e1
VS16 7 s16 0
L16 s16 4 33e-2
.control
set numdgt=17
ac lin 1 60 60
print v(1) v(2) v(3) v(4) v(5) v(6) v(7) v(8) v(9)
print i(vs0) i(vs1) i(vs2) i(vs3) i(vs4) i(vs5) i(vs6) i(vs7) i(vs8) i(vs9)
print i(vs10) i(vs11) i(vs12) i(vs13) i(vs14) i(vs15) i(vs16)
.endc
.end
