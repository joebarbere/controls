controls oracle ac-0386
* Generated (plan F2.7, ADR 0012): do not edit; regenerate with `pnpm sim oracle regen`. ac seed 20261031 index 386 nodes 24 elements 38
.options sparse gmin=1e-12 noopac
RG1 1 0 1000000000000
RG2 2 0 1000000000000
RG3 3 0 1000000000000
RG4 4 0 1000000000000
RG5 5 0 1000000000000
RG6 6 0 1000000000000
RG7 7 0 1000000000000
RG8 8 0 1000000000000
RG9 9 0 1000000000000
RG10 10 0 1000000000000
RG11 11 0 1000000000000
RG12 12 0 1000000000000
RG13 13 0 1000000000000
RG14 14 0 1000000000000
RG15 15 0 1000000000000
RG16 16 0 1000000000000
RG17 17 0 1000000000000
RG18 18 0 1000000000000
RG19 19 0 1000000000000
RG20 20 0 1000000000000
RG21 21 0 1000000000000
RG22 22 0 1000000000000
RG23 23 0 1000000000000
VS0 8 s0 0
R0 s0 3 22e0
VS1 18 s1 0
C1 s1 14 56e-7
VS2 1 s2 0
R2 s2 5 27e0
VS3 2 s3 0
C3 s3 20 27e-6
VS4 14 s4 0
L4 s4 19 82e-4
VS5 0 s5 0
V5 e5 s5 DC 0 AC 27e0 -120
RI5 e5 1 39e-3
VS6 12 s6 0
R6 s6 19 47e0
VS7 13 s7 0
C7 s7 6 12e-4
VS8 17 s8 0
L8 s8 14 12e-3
VS9 8 s9 0
L9 s9 7 33e-2
VS10 13 s10 0
L10 s10 17 82e-3
VS11 9 s11 0
C11 s11 6 18e-5
VS12 8 s12 0
L12 s12 4 82e-3
VS13 16 s13 0
R13 s13 22 56e0
VS14 4 s14 0
R14 s14 13 56e-1
VS15 5 s15 0
V15 e15 s15 DC 0 AC 27e1 180
RI15 e15 22 18e-1
VS16 21 s16 0
C16 s16 0 18e-7
VS17 11 s17 0
L17 s17 15 10e-3
VS18 3 s18 0
R18 s18 16 18e-1
VS19 6 s19 0
L19 s19 23 18e-3
VS20 5 s20 0
V20 e20 s20 DC 0 AC 47e-1 180
RI20 e20 18 39e-2
VS21 4 s21 0
V21 e21 s21 DC 0 AC 56e0 0
RI21 e21 20 10e-1
VS22 23 s22 0
R22 s22 13 22e1
VS23 9 s23 0
L23 s23 19 18e-2
VS24 17 s24 0
R24 s24 0 33e1
VS25 0 s25 0
R25 s25 8 68e1
VS26 10 s26 0
V26 e26 s26 DC 0 AC 47e1 -120
RI26 e26 15 82e-2
VS27 21 s27 0
V27 e27 s27 DC 0 AC 56e0 -120
RI27 e27 14 68e-3
VS28 15 s28 0
L28 s28 18 12e-3
VS29 3 s29 0
L29 s29 8 12e-3
VS30 0 s30 0
R30 s30 7 33e3
VS31 12 s31 0
L31 s31 15 82e-4
VS32 17 s32 0
C32 s32 2 33e-4
VS33 2 s33 0
L33 s33 22 15e-2
VS34 2 s34 0
C34 s34 3 12e-5
VS35 9 s35 0
L35 s35 10 47e-5
VS36 11 s36 0
R36 s36 4 82e0
VS37 12 s37 0
R37 s37 22 10e1
.control
set numdgt=17
ac lin 1 60 60
print v(1) v(2) v(3) v(4) v(5) v(6) v(7) v(8) v(9) v(10)
print v(11) v(12) v(13) v(14) v(15) v(16) v(17) v(18) v(19) v(20)
print v(21) v(22) v(23)
print i(vs0) i(vs1) i(vs2) i(vs3) i(vs4) i(vs5) i(vs6) i(vs7) i(vs8) i(vs9)
print i(vs10) i(vs11) i(vs12) i(vs13) i(vs14) i(vs15) i(vs16) i(vs17) i(vs18) i(vs19)
print i(vs20) i(vs21) i(vs22) i(vs23) i(vs24) i(vs25) i(vs26) i(vs27) i(vs28) i(vs29)
print i(vs30) i(vs31) i(vs32) i(vs33) i(vs34) i(vs35) i(vs36) i(vs37)
.endc
.end
