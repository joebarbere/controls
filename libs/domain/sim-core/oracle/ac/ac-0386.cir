controls oracle ac-0386
* Generated (plan F2.7, ADR 0012): do not edit; regenerate with `pnpm sim oracle regen`. ac seed 20261031 index 386 nodes 24 elements 34
.options sparse gmin=1e-12 noopac
RG1 1 0 1000000000000
RG2 2 0 1000000000000
RG3 3 0 1000000000000
RG4 4 0 1000000000000
RG5 5 0 1000000000000
RG6 6 0 1000000000000
RG7 7 0 1000000000000
RG8 8 0 1000000000000
RG9 9 0 1000000000000
RG10 10 0 1000000000000
RG11 11 0 1000000000000
RG12 12 0 1000000000000
RG13 13 0 1000000000000
RG14 14 0 1000000000000
RG15 15 0 1000000000000
RG16 16 0 1000000000000
RG17 17 0 1000000000000
RG18 18 0 1000000000000
RG19 19 0 1000000000000
RG20 20 0 1000000000000
RG21 21 0 1000000000000
RG22 22 0 1000000000000
RG23 23 0 1000000000000
VS0 0 s0 0
V0 e0 s0 DC 0 AC 47e1 -120
RI0 e0 15 82e-2
VS1 4 s1 0
V1 e1 s1 DC 0 AC 56e0 0
RI1 e1 20 10e-1
VS2 18 s2 0
R2 s2 7 33e3
VS3 2 s3 0
C3 s3 3 12e-5
VS4 13 s4 0
L4 s4 17 82e-3
VS5 8 s5 0
L5 s5 4 82e-3
VS6 5 s6 0
V6 e6 s6 DC 0 AC 47e-1 180
RI6 e6 10 39e-2
VS7 15 s7 0
L7 s7 10 12e-3
VS8 6 s8 0
L8 s8 23 18e-3
VS9 9 s9 0
C9 s9 6 18e-5
VS10 21 s10 0
C10 s10 18 18e-7
VS11 18 s11 0
R11 s11 8 68e1
VS12 3 s12 0
L12 s12 8 12e-3
VS13 3 s13 0
R13 s13 16 18e-1
VS14 2 s14 0
L14 s14 22 15e-2
VS15 4 s15 0
R15 s15 13 56e-1
VS16 11 s16 0
L16 s16 15 10e-3
VS17 21 s17 0
V17 e17 s17 DC 0 AC 56e0 -120
RI17 e17 14 68e-3
VS18 5 s18 0
V18 e18 s18 DC 0 AC 27e1 180
RI18 e18 22 18e-1
VS19 12 s19 0
R19 s19 22 10e1
VS20 8 s20 0
R20 s20 3 22e0
VS21 12 s21 0
R21 s21 19 47e0
VS22 1 s22 0
R22 s22 5 27e0
VS23 17 s23 0
R23 s23 18 33e1
VS24 17 s24 0
L24 s24 14 12e-3
VS25 12 s25 0
L25 s25 15 82e-4
VS26 13 s26 0
C26 s26 6 12e-4
VS27 16 s27 0
R27 s27 22 56e0
VS28 8 s28 0
L28 s28 7 33e-2
VS29 14 s29 0
L29 s29 19 82e-4
VS30 10 s30 0
C30 s30 14 56e-7
VS31 17 s31 0
C31 s31 2 33e-4
VS32 23 s32 0
R32 s32 13 22e1
VS33 9 s33 0
L33 s33 19 18e-2
.control
set numdgt=17
ac lin 1 60 60
print v(1) v(2) v(3) v(4) v(5) v(6) v(7) v(8) v(9) v(10)
print v(11) v(12) v(13) v(14) v(15) v(16) v(17) v(18) v(19) v(20)
print v(21) v(22) v(23)
print i(vs0) i(vs1) i(vs2) i(vs3) i(vs4) i(vs5) i(vs6) i(vs7) i(vs8) i(vs9)
print i(vs10) i(vs11) i(vs12) i(vs13) i(vs14) i(vs15) i(vs16) i(vs17) i(vs18) i(vs19)
print i(vs20) i(vs21) i(vs22) i(vs23) i(vs24) i(vs25) i(vs26) i(vs27) i(vs28) i(vs29)
print i(vs30) i(vs31) i(vs32) i(vs33)
.endc
.end
