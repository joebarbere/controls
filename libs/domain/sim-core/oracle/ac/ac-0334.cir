controls oracle ac-0334
* Generated (plan F2.7, ADR 0012): do not edit; regenerate with `pnpm sim oracle regen`. ac seed 20261031 index 334 nodes 2 elements 3
.options sparse gmin=1e-12 noopac
RG1 1 0 1000000000000
VS0 0 s0 0
V0 e0 s0 DC 0 AC 82e0 180
RI0 e0 m0 47e-1
LI0 m0 1 10e-5
VS1 1 s1 0
C1 s1 0 10e-4
VS2 0 s2 0
L2 s2 1 12e-3
.control
set numdgt=17
ac lin 1 60 60
print v(1)
print i(vs0) i(vs1) i(vs2)
.endc
.end
