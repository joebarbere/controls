controls oracle ac-0492
* Generated (plan F2.7, ADR 0012): do not edit; regenerate with `pnpm sim oracle regen`. ac seed 20261031 index 492 nodes 18 elements 26
.options sparse gmin=1e-12 noopac
RG1 1 0 1000000000000
RG2 2 0 1000000000000
RG3 3 0 1000000000000
RG4 4 0 1000000000000
RG5 5 0 1000000000000
RG6 6 0 1000000000000
RG7 7 0 1000000000000
RG8 8 0 1000000000000
RG9 9 0 1000000000000
RG10 10 0 1000000000000
RG11 11 0 1000000000000
RG12 12 0 1000000000000
RG13 13 0 1000000000000
RG14 14 0 1000000000000
RG15 15 0 1000000000000
RG16 16 0 1000000000000
RG17 17 0 1000000000000
VS0 10 s0 0
C0 s0 0 56e-5
VS1 2 s1 0
R1 s1 11 15e1
VS2 5 s2 0
R2 s2 3 12e3
VS3 9 s3 0
C3 s3 13 15e-4
VS4 16 s4 0
L4 s4 10 56e-2
VS5 15 s5 0
R5 s5 1 10e2
VS6 1 s6 0
R6 s6 5 10e2
VS7 0 s7 0
V7 e7 s7 DC 0 AC 39e0 0
RI7 e7 10 15e-3
VS8 17 s8 0
R8 s8 3 47e3
VS9 1 s9 0
R9 s9 11 39e0
VS10 16 s10 0
L10 s10 7 10e-3
VS11 11 s11 0
R11 s11 9 33e3
VS12 4 s12 0
V12 e12 s12 DC 0 AC 15e0 180
RI12 e12 6 68e-2
VS13 6 s13 0
C13 s13 17 82e-5
VS14 1 s14 0
L14 s14 4 82e-5
VS15 9 s15 0
L15 s15 6 68e-3
VS16 5 s16 0
C16 s16 2 10e-5
VS17 4 s17 0
C17 s17 14 68e-5
VS18 5 s18 0
R18 s18 8 10e3
VS19 10 s19 0
R19 s19 2 47e0
VS20 10 s20 0
V20 e20 s20 DC 0 AC 22e1 120
RI20 e20 8 15e-3
VS21 12 s21 0
L21 s21 7 39e-5
VS22 2 s22 0
C22 s22 1 22e-5
VS23 7 s23 0
R23 s23 2 47e-1
VS24 14 s24 0
V24 e24 s24 DC 0 AC 56e1 180
RI24 e24 0 10e-2
VS25 12 s25 0
R25 s25 5 27e2
.control
set numdgt=17
ac lin 1 60 60
print v(1) v(2) v(3) v(4) v(5) v(6) v(7) v(8) v(9) v(10)
print v(11) v(12) v(13) v(14) v(15) v(16) v(17)
print i(vs0) i(vs1) i(vs2) i(vs3) i(vs4) i(vs5) i(vs6) i(vs7) i(vs8) i(vs9)
print i(vs10) i(vs11) i(vs12) i(vs13) i(vs14) i(vs15) i(vs16) i(vs17) i(vs18) i(vs19)
print i(vs20) i(vs21) i(vs22) i(vs23) i(vs24) i(vs25)
.endc
.end
