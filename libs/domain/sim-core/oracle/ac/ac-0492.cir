controls oracle ac-0492
* Generated (plan F2.7, ADR 0012): do not edit; regenerate with `pnpm sim oracle regen`. ac seed 20261031 index 492 nodes 18 elements 28
.options sparse gmin=1e-12 noopac
RG1 1 0 1000000000000
RG2 2 0 1000000000000
RG3 3 0 1000000000000
RG4 4 0 1000000000000
RG5 5 0 1000000000000
RG6 6 0 1000000000000
RG7 7 0 1000000000000
RG8 8 0 1000000000000
RG9 9 0 1000000000000
RG10 10 0 1000000000000
RG11 11 0 1000000000000
RG12 12 0 1000000000000
RG13 13 0 1000000000000
RG14 14 0 1000000000000
RG15 15 0 1000000000000
RG16 16 0 1000000000000
RG17 17 0 1000000000000
VS0 6 s0 0
C0 s0 1 22e-5
VS1 2 s1 0
L1 s1 3 10e-3
VS2 12 s2 0
L2 s2 10 33e-5
VS3 12 s3 0
R3 s3 15 12e-1
VS4 15 s4 0
R4 s4 6 10e0
VS5 15 s5 0
L5 s5 13 22e-3
VS6 8 s6 0
R6 s6 16 12e-1
VS7 0 s7 0
V7 e7 s7 DC 0 AC 12e-1 120
RI7 e7 m7 33e-3
LI7 m7 15 10e-6
VS8 2 s8 0
R8 s8 7 15e-2
VS9 8 s9 0
R9 s9 1 27e0
VS10 15 s10 0
L10 s10 7 10e-2
VS11 11 s11 0
R11 s11 13 22e-2
VS12 15 s12 0
R12 s12 1 10e2
VS13 17 s13 0
L13 s13 5 33e-2
VS14 10 s14 0
R14 s14 6 47e0
VS15 1 s15 0
L15 s15 4 82e-5
VS16 2 s16 0
V16 e16 s16 DC 0 AC 33e1 0
RI16 e16 14 56e-3
VS17 8 s17 0
C17 s17 9 47e-6
VS18 12 s18 0
R18 s18 3 10e2
VS19 2 s19 0
L19 s19 17 22e-4
VS20 9 s20 0
L20 s20 14 33e-4
VS21 11 s21 0
R21 s21 9 82e2
VS22 11 s22 0
C22 s22 4 39e-7
VS23 16 s23 0
C23 s23 5 56e-5
VS24 4 s24 0
V24 e24 s24 DC 0 AC 15e0 180
RI24 e24 m24 68e-2
LI24 m24 0 10e-6
VS25 5 s25 0
C25 s25 6 10e-5
VS26 8 s26 0
V26 e26 s26 DC 0 AC 56e1 120
RI26 e26 14 15e-2
VS27 1 s27 0
C27 s27 10 47e-5
.control
set numdgt=17
ac lin 1 60 60
print v(1) v(2) v(3) v(4) v(5) v(6) v(7) v(8) v(9) v(10)
print v(11) v(12) v(13) v(14) v(15) v(16) v(17)
print i(vs0) i(vs1) i(vs2) i(vs3) i(vs4) i(vs5) i(vs6) i(vs7) i(vs8) i(vs9)
print i(vs10) i(vs11) i(vs12) i(vs13) i(vs14) i(vs15) i(vs16) i(vs17) i(vs18) i(vs19)
print i(vs20) i(vs21) i(vs22) i(vs23) i(vs24) i(vs25) i(vs26) i(vs27)
.endc
.end
