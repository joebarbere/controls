controls oracle ac-0492
* Generated (plan F2.7, ADR 0012): do not edit; regenerate with `pnpm sim oracle regen`. ac seed 20261031 index 492 nodes 18 elements 28
.options sparse gmin=1e-12 noopac
RG1 1 0 1000000000000
RG2 2 0 1000000000000
RG3 3 0 1000000000000
RG4 4 0 1000000000000
RG5 5 0 1000000000000
RG6 6 0 1000000000000
RG7 7 0 1000000000000
RG8 8 0 1000000000000
RG9 9 0 1000000000000
RG10 10 0 1000000000000
RG11 11 0 1000000000000
RG12 12 0 1000000000000
RG13 13 0 1000000000000
RG14 14 0 1000000000000
RG15 15 0 1000000000000
RG16 16 0 1000000000000
RG17 17 0 1000000000000
VS0 7 s0 0
R0 s0 4 47e-1
VS1 4 s1 0
C1 s1 1 22e-5
VS2 0 s2 0
V2 e2 s2 DC 0 AC 15e0 180
RI2 e2 6 68e-2
VS3 0 s3 0
C3 s3 14 68e-5
VS4 12 s4 0
L4 s4 7 39e-5
VS5 15 s5 0
L5 s5 4 18e-3
VS6 1 s6 0
R6 s6 11 39e0
VS7 6 s7 0
C7 s7 17 82e-5
VS8 17 s8 0
R8 s8 3 47e3
VS9 10 s9 0
R9 s9 4 47e0
VS10 11 s10 0
R10 s10 9 33e3
VS11 1 s11 0
L11 s11 0 82e-5
VS12 5 s12 0
R12 s12 3 12e3
VS13 10 s13 0
C13 s13 2 56e-5
VS14 4 s14 0
R14 s14 11 15e1
VS15 16 s15 0
L15 s15 10 56e-2
VS16 12 s16 0
R16 s16 5 27e2
VS17 13 s17 0
R17 s17 2 33e-2
VS18 2 s18 0
V18 e18 s18 DC 0 AC 39e0 0
RI18 e18 m18 15e-3
LI18 m18 10 12e-7
VS19 15 s19 0
R19 s19 1 10e2
VS20 9 s20 0
C20 s20 13 15e-4
VS21 14 s21 0
V21 e21 s21 DC 0 AC 56e1 180
RI21 e21 m21 10e-2
LI21 m21 2 47e-7
VS22 10 s22 0
V22 e22 s22 DC 0 AC 22e1 120
RI22 e22 8 15e-3
VS23 16 s23 0
L23 s23 7 10e-3
VS24 5 s24 0
R24 s24 8 10e3
VS25 1 s25 0
R25 s25 5 10e2
VS26 5 s26 0
C26 s26 4 10e-5
VS27 9 s27 0
L27 s27 6 68e-3
.control
set numdgt=17
ac lin 1 60 60
print v(1) v(2) v(3) v(4) v(5) v(6) v(7) v(8) v(9) v(10)
print v(11) v(12) v(13) v(14) v(15) v(16) v(17)
print i(vs0) i(vs1) i(vs2) i(vs3) i(vs4) i(vs5) i(vs6) i(vs7) i(vs8) i(vs9)
print i(vs10) i(vs11) i(vs12) i(vs13) i(vs14) i(vs15) i(vs16) i(vs17) i(vs18) i(vs19)
print i(vs20) i(vs21) i(vs22) i(vs23) i(vs24) i(vs25) i(vs26) i(vs27)
.endc
.end
