controls oracle ac-0161
* Generated (plan F2.7, ADR 0012): do not edit; regenerate with `pnpm sim oracle regen`. ac seed 20261031 index 161 nodes 24 elements 34
.options sparse gmin=1e-12 noopac
RG1 1 0 1000000000000
RG2 2 0 1000000000000
RG3 3 0 1000000000000
RG4 4 0 1000000000000
RG5 5 0 1000000000000
RG6 6 0 1000000000000
RG7 7 0 1000000000000
RG8 8 0 1000000000000
RG9 9 0 1000000000000
RG10 10 0 1000000000000
RG11 11 0 1000000000000
RG12 12 0 1000000000000
RG13 13 0 1000000000000
RG14 14 0 1000000000000
RG15 15 0 1000000000000
RG16 16 0 1000000000000
RG17 17 0 1000000000000
RG18 18 0 1000000000000
RG19 19 0 1000000000000
RG20 20 0 1000000000000
RG21 21 0 1000000000000
RG22 22 0 1000000000000
RG23 23 0 1000000000000
VS0 0 s0 0
V0 e0 s0 DC 0 AC 39e1 -120
RI0 e0 m0 27e-2
LI0 m0 16 18e-7
VS1 20 s1 0
C1 s1 12 82e-5
VS2 7 s2 0
C2 s2 0 18e-4
VS3 15 s3 0
R3 s3 3 56e0
VS4 2 s4 0
V4 e4 s4 DC 0 AC 22e1 0
RI4 e4 19 22e-1
VS5 20 s5 0
V5 e5 s5 DC 0 AC 27e0 120
RI5 e5 18 68e-2
VS6 10 s6 0
C6 s6 3 18e-7
VS7 2 s7 0
R7 s7 20 39e-2
VS8 3 s8 0
R8 s8 4 10e-2
VS9 22 s9 0
L9 s9 15 56e-5
VS10 10 s10 0
V10 e10 s10 DC 0 AC 27e-1 -120
RI10 e10 7 22e-2
VS11 14 s11 0
R11 s11 8 18e3
VS12 23 s12 0
C12 s12 12 47e-4
VS13 8 s13 0
C13 s13 4 22e-4
VS14 1 s14 0
L14 s14 6 82e-5
VS15 23 s15 0
R15 s15 11 33e2
VS16 6 s16 0
R16 s16 3 18e-2
VS17 9 s17 0
R17 s17 5 10e2
VS18 19 s18 0
L18 s18 6 22e-2
VS19 13 s19 0
C19 s19 0 22e-4
VS20 4 s20 0
L20 s20 19 39e-4
VS21 20 s21 0
C21 s21 8 68e-6
VS22 20 s22 0
R22 s22 5 12e1
VS23 9 s23 0
L23 s23 19 47e-2
VS24 4 s24 0
R24 s24 21 39e2
VS25 19 s25 0
V25 e25 s25 DC 0 AC 56e1 0
RI25 e25 m25 68e-3
LI25 m25 14 15e-6
VS26 21 s26 0
R26 s26 8 10e2
VS27 17 s27 0
L27 s27 1 56e-4
VS28 15 s28 0
L28 s28 11 10e-5
VS29 9 s29 0
L29 s29 17 18e-2
VS30 12 s30 0
R30 s30 13 56e3
VS31 18 s31 0
R31 s31 10 12e3
VS32 22 s32 0
C32 s32 20 82e-6
VS33 4 s33 0
C33 s33 16 39e-4
.control
set numdgt=17
ac lin 1 60 60
print v(1) v(2) v(3) v(4) v(5) v(6) v(7) v(8) v(9) v(10)
print v(11) v(12) v(13) v(14) v(15) v(16) v(17) v(18) v(19) v(20)
print v(21) v(22) v(23)
print i(vs0) i(vs1) i(vs2) i(vs3) i(vs4) i(vs5) i(vs6) i(vs7) i(vs8) i(vs9)
print i(vs10) i(vs11) i(vs12) i(vs13) i(vs14) i(vs15) i(vs16) i(vs17) i(vs18) i(vs19)
print i(vs20) i(vs21) i(vs22) i(vs23) i(vs24) i(vs25) i(vs26) i(vs27) i(vs28) i(vs29)
print i(vs30) i(vs31) i(vs32) i(vs33)
.endc
.end
