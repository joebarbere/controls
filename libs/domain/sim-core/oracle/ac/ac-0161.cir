controls oracle ac-0161
* Generated (plan F2.7, ADR 0012): do not edit; regenerate with `pnpm sim oracle regen`. ac seed 20261031 index 161 nodes 24 elements 37
.options sparse gmin=1e-12 noopac
RG1 1 0 1000000000000
RG2 2 0 1000000000000
RG3 3 0 1000000000000
RG4 4 0 1000000000000
RG5 5 0 1000000000000
RG6 6 0 1000000000000
RG7 7 0 1000000000000
RG8 8 0 1000000000000
RG9 9 0 1000000000000
RG10 10 0 1000000000000
RG11 11 0 1000000000000
RG12 12 0 1000000000000
RG13 13 0 1000000000000
RG14 14 0 1000000000000
RG15 15 0 1000000000000
RG16 16 0 1000000000000
RG17 17 0 1000000000000
RG18 18 0 1000000000000
RG19 19 0 1000000000000
RG20 20 0 1000000000000
RG21 21 0 1000000000000
RG22 22 0 1000000000000
RG23 23 0 1000000000000
VS0 0 s0 0
V0 e0 s0 DC 0 AC 68e0 -120
RI0 e0 2 33e-1
VS1 10 s1 0
V1 e1 s1 DC 0 AC 27e-1 -120
RI1 e1 7 22e-2
VS2 12 s2 0
V2 e2 s2 DC 0 AC 47e-1 120
RI2 e2 22 82e-1
VS3 16 s3 0
L3 s3 19 47e-2
VS4 12 s4 0
C4 s4 21 82e-7
VS5 20 s5 0
L5 s5 2 15e-2
VS6 20 s6 0
C6 s6 23 47e-4
VS7 12 s7 0
C7 s7 3 68e-6
VS8 18 s8 0
R8 s8 21 15e3
VS9 14 s9 0
R9 s9 6 27e3
VS10 9 s10 0
V10 e10 s10 DC 0 AC 39e1 -120
RI10 e10 0 27e-2
VS11 3 s11 0
R11 s11 14 12e2
VS12 6 s12 0
R12 s12 19 56e-2
VS13 4 s13 0
C13 s13 0 39e-4
VS14 16 s14 0
R14 s14 15 15e3
VS15 7 s15 0
V15 e15 s15 DC 0 AC 12e0 180
RI15 e15 13 27e-2
VS16 15 s16 0
R16 s16 22 56e3
VS17 8 s17 0
C17 s17 4 22e-4
VS18 4 s18 0
V18 e18 s18 DC 0 AC 56e0 -120
RI18 e18 14 27e-1
VS19 21 s19 0
C19 s19 3 47e-4
VS20 15 s20 0
V20 e20 s20 DC 0 AC 18e-1 -120
RI20 e20 13 18e-1
VS21 11 s21 0
R21 s21 22 10e-1
VS22 5 s22 0
R22 s22 10 10e-2
VS23 9 s23 0
C23 s23 10 39e-6
VS24 6 s24 0
C24 s24 23 27e-7
VS25 19 s25 0
L25 s25 6 22e-2
VS26 18 s26 0
L26 s26 3 18e-5
VS27 20 s27 0
R27 s27 5 82e-1
VS28 4 s28 0
R28 s28 17 10e1
VS29 1 s29 0
R29 s29 2 56e3
VS30 3 s30 0
R30 s30 4 10e-2
VS31 6 s31 0
C31 s31 4 33e-4
VS32 0 s32 0
R32 s32 16 82e2
VS33 20 s33 0
R33 s33 4 10e-2
VS34 17 s34 0
C34 s34 12 10e-5
VS35 4 s35 0
L35 s35 19 39e-4
VS36 11 s36 0
L36 s36 3 47e-5
.control
set numdgt=17
ac lin 1 60 60
print v(1) v(2) v(3) v(4) v(5) v(6) v(7) v(8) v(9) v(10)
print v(11) v(12) v(13) v(14) v(15) v(16) v(17) v(18) v(19) v(20)
print v(21) v(22) v(23)
print i(vs0) i(vs1) i(vs2) i(vs3) i(vs4) i(vs5) i(vs6) i(vs7) i(vs8) i(vs9)
print i(vs10) i(vs11) i(vs12) i(vs13) i(vs14) i(vs15) i(vs16) i(vs17) i(vs18) i(vs19)
print i(vs20) i(vs21) i(vs22) i(vs23) i(vs24) i(vs25) i(vs26) i(vs27) i(vs28) i(vs29)
print i(vs30) i(vs31) i(vs32) i(vs33) i(vs34) i(vs35) i(vs36)
.endc
.end
