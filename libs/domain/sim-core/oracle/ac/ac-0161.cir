controls oracle ac-0161
* Generated (plan F2.7, ADR 0012): do not edit; regenerate with `pnpm sim oracle regen`. ac seed 20261031 index 161 nodes 24 elements 39
.options sparse gmin=1e-12 noopac
RG1 1 0 1000000000000
RG2 2 0 1000000000000
RG3 3 0 1000000000000
RG4 4 0 1000000000000
RG5 5 0 1000000000000
RG6 6 0 1000000000000
RG7 7 0 1000000000000
RG8 8 0 1000000000000
RG9 9 0 1000000000000
RG10 10 0 1000000000000
RG11 11 0 1000000000000
RG12 12 0 1000000000000
RG13 13 0 1000000000000
RG14 14 0 1000000000000
RG15 15 0 1000000000000
RG16 16 0 1000000000000
RG17 17 0 1000000000000
RG18 18 0 1000000000000
RG19 19 0 1000000000000
RG20 20 0 1000000000000
RG21 21 0 1000000000000
RG22 22 0 1000000000000
RG23 23 0 1000000000000
VS0 0 s0 0
V0 e0 s0 DC 0 AC 39e0 -120
RI0 e0 10 15e-3
VS1 10 s1 0
V1 e1 s1 DC 0 AC 27e-1 -120
RI1 e1 7 22e-2
VS2 18 s2 0
R2 s2 21 15e3
VS3 4 s3 0
C3 s3 16 39e-4
VS4 4 s4 0
V4 e4 s4 DC 0 AC 56e0 -120
RI4 e4 14 27e-1
VS5 3 s5 0
R5 s5 14 12e2
VS6 21 s6 0
C6 s6 3 47e-4
VS7 19 s7 0
L7 s7 6 22e-2
VS8 9 s8 0
V8 e8 s8 DC 0 AC 39e1 -120
RI8 e8 16 27e-2
VS9 5 s9 0
R9 s9 10 10e-2
VS10 15 s10 0
R10 s10 22 56e3
VS11 0 s11 0
C11 s11 4 22e-4
VS12 1 s12 0
R12 s12 2 56e3
VS13 8 s13 0
R13 s13 15 15e3
VS14 6 s14 0
R14 s14 19 56e-2
VS15 16 s15 0
V15 e15 s15 DC 0 AC 68e0 -120
RI15 e15 2 33e-1
VS16 12 s16 0
C16 s16 21 82e-7
VS17 20 s17 0
R17 s17 4 10e-2
VS18 17 s18 0
C18 s18 12 10e-5
VS19 4 s19 0
R19 s19 17 10e1
VS20 11 s20 0
L20 s20 3 47e-5
VS21 12 s21 0
V21 e21 s21 DC 0 AC 47e-1 120
RI21 e21 22 82e-1
VS22 3 s22 0
R22 s22 4 10e-2
VS23 8 s23 0
L23 s23 19 47e-2
VS24 12 s24 0
C24 s24 3 68e-6
VS25 14 s25 0
R25 s25 6 27e3
VS26 7 s26 0
V26 e26 s26 DC 0 AC 12e0 180
RI26 e26 13 27e-2
VS27 16 s27 0
R27 s27 8 82e2
VS28 20 s28 0
L28 s28 2 15e-2
VS29 4 s29 0
L29 s29 19 39e-4
VS30 9 s30 0
C30 s30 10 39e-6
VS31 6 s31 0
C31 s31 23 27e-7
VS32 6 s32 0
C32 s32 4 33e-4
VS33 18 s33 0
L33 s33 3 18e-5
VS34 11 s34 0
R34 s34 22 10e-1
VS35 20 s35 0
C35 s35 23 47e-4
VS36 20 s36 0
R36 s36 5 82e-1
VS37 1 s37 0
V37 e37 s37 DC 0 AC 18e1 120
RI37 e37 20 68e-2
VS38 15 s38 0
V38 e38 s38 DC 0 AC 18e-1 -120
RI38 e38 13 18e-1
.control
set numdgt=17
ac lin 1 60 60
print v(1) v(2) v(3) v(4) v(5) v(6) v(7) v(8) v(9) v(10)
print v(11) v(12) v(13) v(14) v(15) v(16) v(17) v(18) v(19) v(20)
print v(21) v(22) v(23)
print i(vs0) i(vs1) i(vs2) i(vs3) i(vs4) i(vs5) i(vs6) i(vs7) i(vs8) i(vs9)
print i(vs10) i(vs11) i(vs12) i(vs13) i(vs14) i(vs15) i(vs16) i(vs17) i(vs18) i(vs19)
print i(vs20) i(vs21) i(vs22) i(vs23) i(vs24) i(vs25) i(vs26) i(vs27) i(vs28) i(vs29)
print i(vs30) i(vs31) i(vs32) i(vs33) i(vs34) i(vs35) i(vs36) i(vs37) i(vs38)
.endc
.end
