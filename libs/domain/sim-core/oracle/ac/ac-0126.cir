controls oracle ac-0126
* Generated (plan F2.7, ADR 0012): do not edit; regenerate with `pnpm sim oracle regen`. ac seed 20261031 index 126 nodes 24 elements 49
.options sparse gmin=1e-12 noopac
RG1 1 0 1000000000000
RG2 2 0 1000000000000
RG3 3 0 1000000000000
RG4 4 0 1000000000000
RG5 5 0 1000000000000
RG6 6 0 1000000000000
RG7 7 0 1000000000000
RG8 8 0 1000000000000
RG9 9 0 1000000000000
RG10 10 0 1000000000000
RG11 11 0 1000000000000
RG12 12 0 1000000000000
RG13 13 0 1000000000000
RG14 14 0 1000000000000
RG15 15 0 1000000000000
RG16 16 0 1000000000000
RG17 17 0 1000000000000
RG18 18 0 1000000000000
RG19 19 0 1000000000000
RG20 20 0 1000000000000
RG21 21 0 1000000000000
RG22 22 0 1000000000000
RG23 23 0 1000000000000
VS0 16 s0 0
R0 s0 15 39e0
VS1 0 s1 0
V1 e1 s1 DC 0 AC 39e-1 180
RI1 e1 m1 47e-2
LI1 m1 11 47e-7
VS2 8 s2 0
L2 s2 3 68e-2
VS3 8 s3 0
C3 s3 20 33e-5
VS4 6 s4 0
C4 s4 9 56e-5
VS5 19 s5 0
R5 s5 8 22e-1
VS6 5 s6 0
C6 s6 6 47e-4
VS7 16 s7 0
C7 s7 11 27e-4
VS8 12 s8 0
R8 s8 2 82e1
VS9 2 s9 0
C9 s9 18 10e-5
VS10 1 s10 0
V10 e10 s10 DC 0 AC 47e-1 -120
RI10 e10 m10 68e-3
LI10 m10 10 15e-7
VS11 14 s11 0
C11 s11 10 10e-4
VS12 2 s12 0
L12 s12 0 22e-4
VS13 6 s13 0
R13 s13 15 15e2
VS14 5 s14 0
L14 s14 1 15e-3
VS15 23 s15 0
L15 s15 21 47e-3
VS16 9 s16 0
L16 s16 6 47e-5
VS17 13 s17 0
C17 s17 17 15e-5
VS18 11 s18 0
C18 s18 16 47e-6
VS19 10 s19 0
R19 s19 5 12e1
VS20 17 s20 0
R20 s20 0 18e2
VS21 20 s21 0
R21 s21 19 68e0
VS22 23 s22 0
R22 s22 4 10e1
VS23 9 s23 0
R23 s23 22 39e-2
VS24 6 s24 0
C24 s24 11 10e-6
VS25 5 s25 0
R25 s25 0 15e-2
VS26 3 s26 0
C26 s26 14 15e-6
VS27 18 s27 0
R27 s27 19 18e1
VS28 9 s28 0
R28 s28 21 27e3
VS29 9 s29 0
L29 s29 1 27e-2
VS30 20 s30 0
C30 s30 0 56e-6
VS31 14 s31 0
L31 s31 7 18e-2
VS32 4 s32 0
C32 s32 9 18e-6
VS33 23 s33 0
R33 s33 6 22e1
VS34 9 s34 0
L34 s34 22 12e-2
VS35 22 s35 0
V35 e35 s35 DC 0 AC 22e-1 0
RI35 e35 18 82e-3
VS36 14 s36 0
V36 e36 s36 DC 0 AC 47e-1 0
RI36 e36 23 39e-3
VS37 18 s37 0
R37 s37 19 27e-2
VS38 8 s38 0
R38 s38 13 47e-1
VS39 8 s39 0
V39 e39 s39 DC 0 AC 10e0 120
RI39 e39 m39 47e-2
LI39 m39 15 18e-6
VS40 1 s40 0
L40 s40 4 18e-5
VS41 14 s41 0
C41 s41 15 47e-6
VS42 18 s42 0
L42 s42 11 33e-4
VS43 13 s43 0
C43 s43 3 56e-4
VS44 16 s44 0
L44 s44 13 15e-4
VS45 19 s45 0
R45 s45 12 39e2
VS46 7 s46 0
L46 s46 8 27e-2
VS47 3 s47 0
C47 s47 0 33e-5
VS48 18 s48 0
V48 e48 s48 DC 0 AC 39e1 0
RI48 e48 10 82e-1
.control
set numdgt=17
ac lin 1 60 60
print v(1) v(2) v(3) v(4) v(5) v(6) v(7) v(8) v(9) v(10)
print v(11) v(12) v(13) v(14) v(15) v(16) v(17) v(18) v(19) v(20)
print v(21) v(22) v(23)
print i(vs0) i(vs1) i(vs2) i(vs3) i(vs4) i(vs5) i(vs6) i(vs7) i(vs8) i(vs9)
print i(vs10) i(vs11) i(vs12) i(vs13) i(vs14) i(vs15) i(vs16) i(vs17) i(vs18) i(vs19)
print i(vs20) i(vs21) i(vs22) i(vs23) i(vs24) i(vs25) i(vs26) i(vs27) i(vs28) i(vs29)
print i(vs30) i(vs31) i(vs32) i(vs33) i(vs34) i(vs35) i(vs36) i(vs37) i(vs38) i(vs39)
print i(vs40) i(vs41) i(vs42) i(vs43) i(vs44) i(vs45) i(vs46) i(vs47) i(vs48)
.endc
.end
