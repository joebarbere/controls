controls oracle ac-0126
* Generated (plan F2.7, ADR 0012): do not edit; regenerate with `pnpm sim oracle regen`. ac seed 20261031 index 126 nodes 24 elements 47
.options sparse gmin=1e-12 noopac
RG1 1 0 1000000000000
RG2 2 0 1000000000000
RG3 3 0 1000000000000
RG4 4 0 1000000000000
RG5 5 0 1000000000000
RG6 6 0 1000000000000
RG7 7 0 1000000000000
RG8 8 0 1000000000000
RG9 9 0 1000000000000
RG10 10 0 1000000000000
RG11 11 0 1000000000000
RG12 12 0 1000000000000
RG13 13 0 1000000000000
RG14 14 0 1000000000000
RG15 15 0 1000000000000
RG16 16 0 1000000000000
RG17 17 0 1000000000000
RG18 18 0 1000000000000
RG19 19 0 1000000000000
RG20 20 0 1000000000000
RG21 21 0 1000000000000
RG22 22 0 1000000000000
RG23 23 0 1000000000000
VS0 18 s0 0
R0 s0 0 27e-2
VS1 2 s1 0
C1 s1 18 10e-5
VS2 18 s2 0
L2 s2 11 33e-4
VS3 3 s3 0
C3 s3 14 15e-6
VS4 12 s4 0
C4 s4 23 56e-5
VS5 9 s5 0
R5 s5 21 27e3
VS6 20 s6 0
C6 s6 19 56e-6
VS7 8 s7 0
L7 s7 3 68e-2
VS8 0 s8 0
V8 e8 s8 DC 0 AC 27e1 180
RI8 e8 m8 22e-3
LI8 m8 3 56e-7
VS9 9 s9 0
L9 s9 1 27e-2
VS10 6 s10 0
R10 s10 15 15e2
VS11 14 s11 0
R11 s11 2 12e-2
VS12 1 s12 0
L12 s12 4 18e-5
VS13 0 s13 0
R13 s13 12 39e2
VS14 6 s14 0
C14 s14 9 68e-6
VS15 12 s15 0
C15 s15 1 56e-6
VS16 18 s16 0
L16 s16 23 22e-4
VS17 23 s17 0
R17 s17 13 10e0
VS18 1 s18 0
C18 s18 23 12e-6
VS19 9 s19 0
R19 s19 6 39e3
VS20 4 s20 0
R20 s20 16 47e3
VS21 14 s21 0
C21 s21 15 47e-6
VS22 18 s22 0
R22 s22 0 18e1
VS23 12 s23 0
V23 e23 s23 DC 0 AC 68e1 180
RI23 e23 6 18e-2
VS24 17 s24 0
R24 s24 22 56e2
VS25 9 s25 0
L25 s25 6 47e-5
VS26 20 s26 0
C26 s26 16 47e-7
VS27 20 s27 0
R27 s27 0 68e0
VS28 13 s28 0
C28 s28 3 56e-4
VS29 6 s29 0
R29 s29 9 33e0
VS30 8 s30 0
R30 s30 21 22e3
VS31 3 s31 0
C31 s31 12 39e-4
VS32 19 s32 0
V32 e32 s32 DC 0 AC 39e-1 180
RI32 e32 m32 47e-2
LI32 m32 11 82e-5
VS33 0 s33 0
L33 s33 18 10e-2
VS34 17 s34 0
R34 s34 14 27e2
VS35 10 s35 0
R35 s35 5 12e1
VS36 7 s36 0
V36 e36 s36 DC 0 AC 39e-1 0
RI36 e36 m36 47e-3
LI36 m36 17 56e-6
VS37 11 s37 0
R37 s37 5 47e3
VS38 10 s38 0
L38 s38 17 56e-3
VS39 15 s39 0
V39 e39 s39 DC 0 AC 68e1 -120
RI39 e39 m39 27e-3
LI39 m39 7 56e-7
VS40 5 s40 0
R40 s40 0 33e0
VS41 4 s41 0
C41 s41 9 18e-6
VS42 14 s42 0
V42 e42 s42 DC 0 AC 18e1 120
RI42 e42 3 47e-1
VS43 4 s43 0
R43 s43 2 82e0
VS44 8 s44 0
V44 e44 s44 DC 0 AC 10e0 120
RI44 e44 15 47e-2
VS45 0 s45 0
R45 s45 8 22e-1
VS46 22 s46 0
V46 e46 s46 DC 0 AC 22e-1 0
RI46 e46 m46 82e-3
LI46 m46 18 82e-7
.control
set numdgt=17
ac lin 1 60 60
print v(1) v(2) v(3) v(4) v(5) v(6) v(7) v(8) v(9) v(10)
print v(11) v(12) v(13) v(14) v(15) v(16) v(17) v(18) v(19) v(20)
print v(21) v(22) v(23)
print i(vs0) i(vs1) i(vs2) i(vs3) i(vs4) i(vs5) i(vs6) i(vs7) i(vs8) i(vs9)
print i(vs10) i(vs11) i(vs12) i(vs13) i(vs14) i(vs15) i(vs16) i(vs17) i(vs18) i(vs19)
print i(vs20) i(vs21) i(vs22) i(vs23) i(vs24) i(vs25) i(vs26) i(vs27) i(vs28) i(vs29)
print i(vs30) i(vs31) i(vs32) i(vs33) i(vs34) i(vs35) i(vs36) i(vs37) i(vs38) i(vs39)
print i(vs40) i(vs41) i(vs42) i(vs43) i(vs44) i(vs45) i(vs46)
.endc
.end
