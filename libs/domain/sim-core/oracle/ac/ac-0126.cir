controls oracle ac-0126
* Generated (plan F2.7, ADR 0012): do not edit; regenerate with `pnpm sim oracle regen`. ac seed 20261031 index 126 nodes 24 elements 46
.options sparse gmin=1e-12 noopac
RG1 1 0 1000000000000
RG2 2 0 1000000000000
RG3 3 0 1000000000000
RG4 4 0 1000000000000
RG5 5 0 1000000000000
RG6 6 0 1000000000000
RG7 7 0 1000000000000
RG8 8 0 1000000000000
RG9 9 0 1000000000000
RG10 10 0 1000000000000
RG11 11 0 1000000000000
RG12 12 0 1000000000000
RG13 13 0 1000000000000
RG14 14 0 1000000000000
RG15 15 0 1000000000000
RG16 16 0 1000000000000
RG17 17 0 1000000000000
RG18 18 0 1000000000000
RG19 19 0 1000000000000
RG20 20 0 1000000000000
RG21 21 0 1000000000000
RG22 22 0 1000000000000
RG23 23 0 1000000000000
VS0 7 s0 0
L0 s0 18 10e-2
VS1 11 s1 0
R1 s1 5 47e3
VS2 9 s2 0
R2 s2 21 27e3
VS3 6 s3 0
R3 s3 9 33e0
VS4 3 s4 0
C4 s4 12 39e-4
VS5 14 s5 0
R5 s5 2 12e-2
VS6 4 s6 0
C6 s6 9 18e-6
VS7 18 s7 0
R7 s7 7 18e1
VS8 0 s8 0
V8 e8 s8 DC 0 AC 39e-1 0
RI8 e8 17 47e-3
VS9 8 s9 0
L9 s9 3 68e-2
VS10 10 s10 0
L10 s10 17 56e-3
VS11 15 s11 0
V11 e11 s11 DC 0 AC 68e1 -120
RI11 e11 0 27e-3
VS12 12 s12 0
C12 s12 23 56e-5
VS13 9 s13 0
L13 s13 1 27e-2
VS14 12 s14 0
V14 e14 s14 DC 0 AC 68e1 180
RI14 e14 6 18e-2
VS15 20 s15 0
C15 s15 19 56e-6
VS16 9 s16 0
L16 s16 6 47e-5
VS17 18 s17 0
R17 s17 7 27e-2
VS18 18 s18 0
L18 s18 11 33e-4
VS19 6 s19 0
R19 s19 15 15e2
VS20 18 s20 0
L20 s20 23 22e-4
VS21 4 s21 0
R21 s21 2 82e0
VS22 7 s22 0
R22 s22 8 22e-1
VS23 17 s23 0
R23 s23 14 27e2
VS24 13 s24 0
C24 s24 3 56e-4
VS25 14 s25 0
V25 e25 s25 DC 0 AC 18e1 120
RI25 e25 3 47e-1
VS26 1 s26 0
C26 s26 23 12e-6
VS27 10 s27 0
R27 s27 5 12e1
VS28 6 s28 0
C28 s28 9 68e-6
VS29 8 s29 0
V29 e29 s29 DC 0 AC 10e0 120
RI29 e29 15 47e-2
VS30 22 s30 0
V30 e30 s30 DC 0 AC 22e-1 0
RI30 e30 18 82e-3
VS31 7 s31 0
V31 e31 s31 DC 0 AC 27e1 180
RI31 e31 3 22e-3
VS32 7 s32 0
R32 s32 12 39e2
VS33 9 s33 0
R33 s33 6 39e3
VS34 14 s34 0
C34 s34 15 47e-6
VS35 4 s35 0
R35 s35 16 47e3
VS36 2 s36 0
C36 s36 18 10e-5
VS37 19 s37 0
V37 e37 s37 DC 0 AC 39e-1 180
RI37 e37 11 47e-2
VS38 23 s38 0
R38 s38 13 10e0
VS39 3 s39 0
C39 s39 14 15e-6
VS40 12 s40 0
C40 s40 1 56e-6
VS41 20 s41 0
C41 s41 16 47e-7
VS42 17 s42 0
R42 s42 22 56e2
VS43 1 s43 0
L43 s43 4 18e-5
VS44 20 s44 0
R44 s44 7 68e0
VS45 5 s45 0
R45 s45 7 33e0
.control
set numdgt=17
ac lin 1 60 60
print v(1) v(2) v(3) v(4) v(5) v(6) v(7) v(8) v(9) v(10)
print v(11) v(12) v(13) v(14) v(15) v(16) v(17) v(18) v(19) v(20)
print v(21) v(22) v(23)
print i(vs0) i(vs1) i(vs2) i(vs3) i(vs4) i(vs5) i(vs6) i(vs7) i(vs8) i(vs9)
print i(vs10) i(vs11) i(vs12) i(vs13) i(vs14) i(vs15) i(vs16) i(vs17) i(vs18) i(vs19)
print i(vs20) i(vs21) i(vs22) i(vs23) i(vs24) i(vs25) i(vs26) i(vs27) i(vs28) i(vs29)
print i(vs30) i(vs31) i(vs32) i(vs33) i(vs34) i(vs35) i(vs36) i(vs37) i(vs38) i(vs39)
print i(vs40) i(vs41) i(vs42) i(vs43) i(vs44) i(vs45)
.endc
.end
