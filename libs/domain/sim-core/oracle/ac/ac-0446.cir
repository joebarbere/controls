controls oracle ac-0446
* Generated (plan F2.7, ADR 0012): do not edit; regenerate with `pnpm sim oracle regen`. ac seed 20261031 index 446 nodes 8 elements 11
.options sparse gmin=1e-12 noopac
RG1 1 0 1000000000000
RG2 2 0 1000000000000
RG3 3 0 1000000000000
RG4 4 0 1000000000000
RG5 5 0 1000000000000
RG6 6 0 1000000000000
RG7 7 0 1000000000000
VS0 0 s0 0
R0 s0 5 68e0
VS1 0 s1 0
V1 e1 s1 DC 0 AC 18e0 180
RI1 e1 6 82e-1
VS2 1 s2 0
L2 s2 2 27e-5
VS3 3 s3 0
R3 s3 0 18e-1
VS4 7 s4 0
L4 s4 1 47e-2
VS5 2 s5 0
V5 e5 s5 DC 0 AC 15e0 0
RI5 e5 0 27e-3
VS6 5 s6 0
L6 s6 6 33e-3
VS7 3 s7 0
L7 s7 1 47e-4
VS8 6 s8 0
R8 s8 7 33e-2
VS9 5 s9 0
L9 s9 4 47e-2
VS10 4 s10 0
L10 s10 0 15e-4
.control
set numdgt=17
ac lin 1 60 60
print v(1) v(2) v(3) v(4) v(5) v(6) v(7)
print i(vs0) i(vs1) i(vs2) i(vs3) i(vs4) i(vs5) i(vs6) i(vs7) i(vs8) i(vs9)
print i(vs10)
.endc
.end
