controls oracle ac-0446
* Generated (plan F2.7, ADR 0012): do not edit; regenerate with `pnpm sim oracle regen`. ac seed 20261031 index 446 nodes 8 elements 10
.options sparse gmin=1e-12 noopac
RG1 1 0 1000000000000
RG2 2 0 1000000000000
RG3 3 0 1000000000000
RG4 4 0 1000000000000
RG5 5 0 1000000000000
RG6 6 0 1000000000000
RG7 7 0 1000000000000
VS0 0 s0 0
V0 e0 s0 DC 0 AC 15e0 0
RI0 e0 7 27e-3
VS1 3 s1 0
L1 s1 1 47e-4
VS2 2 s2 0
L2 s2 1 47e-2
VS3 6 s3 0
R3 s3 2 33e-2
VS4 7 s4 0
V4 e4 s4 DC 0 AC 18e0 180
RI4 e4 6 82e-1
VS5 7 s5 0
R5 s5 5 68e0
VS6 3 s6 0
R6 s6 7 18e-1
VS7 4 s7 0
L7 s7 7 15e-4
VS8 5 s8 0
L8 s8 4 47e-2
VS9 5 s9 0
L9 s9 6 33e-3
.control
set numdgt=17
ac lin 1 60 60
print v(1) v(2) v(3) v(4) v(5) v(6) v(7)
print i(vs0) i(vs1) i(vs2) i(vs3) i(vs4) i(vs5) i(vs6) i(vs7) i(vs8) i(vs9)
.endc
.end
