controls oracle ac-0446
* Generated (plan F2.7, ADR 0012): do not edit; regenerate with `pnpm sim oracle regen`. ac seed 20261031 index 446 nodes 8 elements 16
.options sparse gmin=1e-12 noopac
RG1 1 0 1000000000000
RG2 2 0 1000000000000
RG3 3 0 1000000000000
RG4 4 0 1000000000000
RG5 5 0 1000000000000
RG6 6 0 1000000000000
RG7 7 0 1000000000000
VS0 0 s0 0
V0 e0 s0 DC 0 AC 68e1 120
RI0 e0 3 56e-2
VS1 3 s1 0
V1 e1 s1 DC 0 AC 10e1 180
RI1 e1 5 47e-3
VS2 1 s2 0
L2 s2 6 27e-5
VS3 5 s3 0
L3 s3 4 47e-2
VS4 2 s4 0
L4 s4 7 39e-4
VS5 5 s5 0
L5 s5 4 39e-4
VS6 1 s6 0
L6 s6 5 10e-3
VS7 3 s7 0
R7 s7 0 82e-1
VS8 7 s8 0
V8 e8 s8 DC 0 AC 27e-1 180
RI8 e8 0 18e-2
VS9 2 s9 0
L9 s9 4 39e-3
VS10 1 s10 0
L10 s10 4 56e-5
VS11 0 s11 0
R11 s11 6 33e-2
VS12 4 s12 0
L12 s12 7 12e-3
VS13 7 s13 0
V13 e13 s13 DC 0 AC 18e0 180
RI13 e13 m13 82e-1
LI13 m13 0 47e-5
VS14 4 s14 0
V14 e14 s14 DC 0 AC 22e1 180
RI14 e14 7 18e-1
VS15 1 s15 0
L15 s15 6 39e-3
.control
set numdgt=17
ac lin 1 60 60
print v(1) v(2) v(3) v(4) v(5) v(6) v(7)
print i(vs0) i(vs1) i(vs2) i(vs3) i(vs4) i(vs5) i(vs6) i(vs7) i(vs8) i(vs9)
print i(vs10) i(vs11) i(vs12) i(vs13) i(vs14) i(vs15)
.endc
.end
