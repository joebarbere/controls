controls oracle ac-0259
* Generated (plan F2.7, ADR 0012): do not edit; regenerate with `pnpm sim oracle regen`. ac seed 20261031 index 259 nodes 19 elements 31
.options sparse gmin=1e-12 noopac
RG1 1 0 1000000000000
RG2 2 0 1000000000000
RG3 3 0 1000000000000
RG4 4 0 1000000000000
RG5 5 0 1000000000000
RG6 6 0 1000000000000
RG7 7 0 1000000000000
RG8 8 0 1000000000000
RG9 9 0 1000000000000
RG10 10 0 1000000000000
RG11 11 0 1000000000000
RG12 12 0 1000000000000
RG13 13 0 1000000000000
RG14 14 0 1000000000000
RG15 15 0 1000000000000
RG16 16 0 1000000000000
RG17 17 0 1000000000000
RG18 18 0 1000000000000
VS0 7 s0 0
R0 s0 5 15e0
VS1 14 s1 0
R1 s1 0 39e2
VS2 10 s2 0
R2 s2 8 10e2
VS3 6 s3 0
C3 s3 5 33e-5
VS4 0 s4 0
C4 s4 10 68e-6
VS5 9 s5 0
R5 s5 18 15e3
VS6 0 s6 0
V6 e6 s6 DC 0 AC 10e1 120
RI6 e6 m6 22e-2
LI6 m6 1 33e-7
VS7 5 s7 0
L7 s7 14 22e-4
VS8 13 s8 0
L8 s8 3 33e-2
VS9 0 s9 0
R9 s9 6 15e-2
VS10 16 s10 0
L10 s10 18 10e-5
VS11 8 s11 0
R11 s11 0 33e-1
VS12 13 s12 0
V12 e12 s12 DC 0 AC 27e1 180
RI12 e12 m12 39e-1
LI12 m12 14 27e-7
VS13 3 s13 0
V13 e13 s13 DC 0 AC 68e-1 -120
RI13 e13 8 68e-2
VS14 1 s14 0
R14 s14 12 18e2
VS15 17 s15 0
R15 s15 1 33e-2
VS16 2 s16 0
L16 s16 4 39e-2
VS17 15 s17 0
R17 s17 0 12e3
VS18 6 s18 0
R18 s18 0 15e-2
VS19 8 s19 0
R19 s19 16 18e2
VS20 13 s20 0
C20 s20 9 12e-5
VS21 11 s21 0
V21 e21 s21 DC 0 AC 82e-1 0
RI21 e21 0 10e-1
VS22 4 s22 0
L22 s22 16 82e-5
VS23 15 s23 0
R23 s23 1 56e2
VS24 17 s24 0
R24 s24 0 39e1
VS25 15 s25 0
L25 s25 11 56e-5
VS26 12 s26 0
C26 s26 5 27e-5
VS27 9 s27 0
L27 s27 7 12e-5
VS28 2 s28 0
V28 e28 s28 DC 0 AC 47e1 180
RI28 e28 9 22e-3
VS29 1 s29 0
C29 s29 18 56e-5
VS30 5 s30 0
R30 s30 16 18e0
.control
set numdgt=17
ac lin 1 60 60
print v(1) v(2) v(3) v(4) v(5) v(6) v(7) v(8) v(9) v(10)
print v(11) v(12) v(13) v(14) v(15) v(16) v(17) v(18)
print i(vs0) i(vs1) i(vs2) i(vs3) i(vs4) i(vs5) i(vs6) i(vs7) i(vs8) i(vs9)
print i(vs10) i(vs11) i(vs12) i(vs13) i(vs14) i(vs15) i(vs16) i(vs17) i(vs18) i(vs19)
print i(vs20) i(vs21) i(vs22) i(vs23) i(vs24) i(vs25) i(vs26) i(vs27) i(vs28) i(vs29)
print i(vs30)
.endc
.end
