controls oracle ac-0417
* Generated (plan F2.7, ADR 0012): do not edit; regenerate with `pnpm sim oracle regen`. ac seed 20261031 index 417 nodes 27 elements 54
.options sparse gmin=1e-12 noopac
RG1 1 0 1000000000000
RG2 2 0 1000000000000
RG3 3 0 1000000000000
RG4 4 0 1000000000000
RG5 5 0 1000000000000
RG6 6 0 1000000000000
RG7 7 0 1000000000000
RG8 8 0 1000000000000
RG9 9 0 1000000000000
RG10 10 0 1000000000000
RG11 11 0 1000000000000
RG12 12 0 1000000000000
RG13 13 0 1000000000000
RG14 14 0 1000000000000
RG15 15 0 1000000000000
RG16 16 0 1000000000000
RG17 17 0 1000000000000
RG18 18 0 1000000000000
RG19 19 0 1000000000000
RG20 20 0 1000000000000
RG21 21 0 1000000000000
RG22 22 0 1000000000000
RG23 23 0 1000000000000
RG24 24 0 1000000000000
RG25 25 0 1000000000000
RG26 26 0 1000000000000
VS0 23 s0 0
R0 s0 17 47e0
VS1 2 s1 0
C1 s1 20 18e-4
VS2 23 s2 0
R2 s2 9 33e1
VS3 4 s3 0
C3 s3 18 10e-5
VS4 2 s4 0
R4 s4 22 12e-2
VS5 19 s5 0
C5 s5 6 10e-6
VS6 5 s6 0
L6 s6 3 56e-5
VS7 19 s7 0
R7 s7 18 15e3
VS8 16 s8 0
C8 s8 24 33e-6
VS9 16 s9 0
R9 s9 5 56e3
VS10 0 s10 0
V10 e10 s10 DC 0 AC 33e1 180
RI10 e10 9 82e-2
VS11 22 s11 0
V11 e11 s11 DC 0 AC 68e-1 180
RI11 e11 m11 33e-2
LI11 m11 3 22e-7
VS12 4 s12 0
R12 s12 25 18e-2
VS13 19 s13 0
C13 s13 2 82e-4
VS14 20 s14 0
L14 s14 10 56e-4
VS15 12 s15 0
R15 s15 5 15e-2
VS16 13 s16 0
V16 e16 s16 DC 0 AC 22e-1 -120
RI16 e16 m16 47e-2
LI16 m16 3 27e-6
VS17 23 s17 0
V17 e17 s17 DC 0 AC 68e0 120
RI17 e17 11 47e-3
VS18 9 s18 0
V18 e18 s18 DC 0 AC 15e1 -120
RI18 e18 10 12e-1
VS19 12 s19 0
L19 s19 6 56e-3
VS20 8 s20 0
R20 s20 23 68e1
VS21 17 s21 0
L21 s21 25 47e-2
VS22 6 s22 0
C22 s22 15 82e-4
VS23 21 s23 0
R23 s23 20 33e-2
VS24 0 s24 0
R24 s24 17 56e1
VS25 3 s25 0
L25 s25 10 27e-5
VS26 7 s26 0
C26 s26 1 10e-7
VS27 20 s27 0
L27 s27 11 12e-3
VS28 12 s28 0
C28 s28 17 47e-4
VS29 18 s29 0
V29 e29 s29 DC 0 AC 18e1 0
RI29 e29 3 27e-1
VS30 6 s30 0
V30 e30 s30 DC 0 AC 82e0 180
RI30 e30 14 10e-1
VS31 24 s31 0
V31 e31 s31 DC 0 AC 18e0 120
RI31 e31 m31 47e-1
LI31 m31 20 68e-5
VS32 18 s32 0
V32 e32 s32 DC 0 AC 15e-1 -120
RI32 e32 2 47e-1
VS33 7 s33 0
R33 s33 10 33e-2
VS34 17 s34 0
R34 s34 24 22e1
VS35 22 s35 0
R35 s35 14 10e1
VS36 19 s36 0
V36 e36 s36 DC 0 AC 18e-1 0
RI36 e36 m36 33e-1
LI36 m36 15 82e-5
VS37 8 s37 0
L37 s37 14 33e-2
VS38 14 s38 0
C38 s38 18 68e-7
VS39 5 s39 0
R39 s39 13 39e0
VS40 19 s40 0
L40 s40 15 33e-3
VS41 11 s41 0
R41 s41 14 22e-1
VS42 4 s42 0
L42 s42 11 10e-4
VS43 10 s43 0
C43 s43 26 27e-4
VS44 16 s44 0
R44 s44 21 47e-2
VS45 19 s45 0
R45 s45 22 10e-1
VS46 25 s46 0
V46 e46 s46 DC 0 AC 10e0 -120
RI46 e46 m46 22e-3
LI46 m46 10 47e-5
VS47 24 s47 0
C47 s47 6 15e-4
VS48 5 s48 0
R48 s48 26 27e1
VS49 24 s49 0
C49 s49 19 12e-7
VS50 1 s50 0
L50 s50 19 82e-2
VS51 17 s51 0
R51 s51 1 10e2
VS52 11 s52 0
C52 s52 6 33e-6
VS53 7 s53 0
R53 s53 17 15e3
.control
set numdgt=17
ac lin 1 60 60
print v(1) v(2) v(3) v(4) v(5) v(6) v(7) v(8) v(9) v(10)
print v(11) v(12) v(13) v(14) v(15) v(16) v(17) v(18) v(19) v(20)
print v(21) v(22) v(23) v(24) v(25) v(26)
print i(vs0) i(vs1) i(vs2) i(vs3) i(vs4) i(vs5) i(vs6) i(vs7) i(vs8) i(vs9)
print i(vs10) i(vs11) i(vs12) i(vs13) i(vs14) i(vs15) i(vs16) i(vs17) i(vs18) i(vs19)
print i(vs20) i(vs21) i(vs22) i(vs23) i(vs24) i(vs25) i(vs26) i(vs27) i(vs28) i(vs29)
print i(vs30) i(vs31) i(vs32) i(vs33) i(vs34) i(vs35) i(vs36) i(vs37) i(vs38) i(vs39)
print i(vs40) i(vs41) i(vs42) i(vs43) i(vs44) i(vs45) i(vs46) i(vs47) i(vs48) i(vs49)
print i(vs50) i(vs51) i(vs52) i(vs53)
.endc
.end
