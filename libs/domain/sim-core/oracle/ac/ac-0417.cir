controls oracle ac-0417
* Generated (plan F2.7, ADR 0012): do not edit; regenerate with `pnpm sim oracle regen`. ac seed 20261031 index 417 nodes 27 elements 52
.options sparse gmin=1e-12 noopac
RG1 1 0 1000000000000
RG2 2 0 1000000000000
RG3 3 0 1000000000000
RG4 4 0 1000000000000
RG5 5 0 1000000000000
RG6 6 0 1000000000000
RG7 7 0 1000000000000
RG8 8 0 1000000000000
RG9 9 0 1000000000000
RG10 10 0 1000000000000
RG11 11 0 1000000000000
RG12 12 0 1000000000000
RG13 13 0 1000000000000
RG14 14 0 1000000000000
RG15 15 0 1000000000000
RG16 16 0 1000000000000
RG17 17 0 1000000000000
RG18 18 0 1000000000000
RG19 19 0 1000000000000
RG20 20 0 1000000000000
RG21 21 0 1000000000000
RG22 22 0 1000000000000
RG23 23 0 1000000000000
RG24 24 0 1000000000000
RG25 25 0 1000000000000
RG26 26 0 1000000000000
VS0 9 s0 0
L0 s0 14 10e-2
VS1 24 s1 0
R1 s1 12 82e2
VS2 7 s2 0
R2 s2 17 15e3
VS3 0 s3 0
V3 e3 s3 DC 0 AC 82e0 120
RI3 e3 n3 10e-3
H3 n3 h3 VS7 -22e-4
ED3 h3 20 d3 0 82e-5
F3 0 d3 VS7 1
LD3 d3 0 1
VS4 17 s4 0
C4 s4 23 82e-5
VS5 6 s5 0
R5 s5 23 27e0
VS6 17 s6 0
R6 s6 11 82e-2
VS7 6 s7 0
V7 e7 s7 DC 0 AC 33e1 180
RI7 e7 m7 82e-2
LI7 m7 n7 33e-7
H7 n7 h7 VS3 -22e-4
ED7 h7 9 d7 0 82e-5
F7 0 d7 VS3 1
LD7 d7 0 1
VS8 10 s8 0
R8 s8 24 33e1
VS9 18 s9 0
V9 e9 s9 DC 0 AC 33e0 0
RI9 e9 m9 82e-1
LI9 m9 21 39e-7
VS10 16 s10 0
V10 e10 s10 DC 0 AC 68e0 0
RI10 e10 15 33e-1
VS11 17 s11 0
V11 e11 s11 DC 0 AC 15e1 -120
RI11 e11 8 12e-1
VS12 13 s12 0
R12 s12 3 18e-1
VS13 22 s13 0
V13 e13 s13 DC 0 AC 33e-1 120
RI13 e13 m13 33e-1
LI13 m13 17 18e-7
VS14 12 s14 0
R14 s14 4 10e2
VS15 23 s15 0
L15 s15 20 12e-4
VS16 25 s16 0
C16 s16 0 33e-6
VS17 17 s17 0
R17 s17 24 22e1
VS18 1 s18 0
V18 e18 s18 DC 0 AC 18e1 120
RI18 e18 10 22e-1
VS19 1 s19 0
C19 s19 23 82e-6
VS20 0 s20 0
R20 s20 4 33e-2
VS21 6 s21 0
R21 s21 17 56e1
VS22 19 s22 0
V22 e22 s22 DC 0 AC 12e-1 180
RI22 e22 9 10e-2
VS23 26 s23 0
C23 s23 10 27e-6
VS24 8 s24 0
R24 s24 3 18e-2
VS25 7 s25 0
C25 s25 6 15e-6
VS26 19 s26 0
L26 s26 14 47e-2
VS27 21 s27 0
L27 s27 2 47e-4
VS28 21 s28 0
L28 s28 25 27e-3
VS29 15 s29 0
R29 s29 19 18e2
VS30 25 s30 0
L30 s30 11 10e-4
VS31 6 s31 0
C31 s31 0 22e-4
VS32 24 s32 0
L32 s32 4 10e-4
VS33 16 s33 0
V33 e33 s33 DC 0 AC 18e-1 180
RI33 e33 m33 47e-1
LI33 m33 9 10e-6
VS34 10 s34 0
V34 e34 s34 DC 0 AC 39e1 0
RI34 e34 17 56e-1
VS35 5 s35 0
L35 s35 21 68e-5
VS36 24 s36 0
C36 s36 5 15e-4
VS37 18 s37 0
C37 s37 11 68e-4
VS38 25 s38 0
R38 s38 6 56e-2
VS39 11 s39 0
C39 s39 18 15e-5
VS40 12 s40 0
L40 s40 4 47e-2
VS41 5 s41 0
C41 s41 0 82e-7
VS42 17 s42 0
L42 s42 16 27e-2
VS43 16 s43 0
C43 s43 24 33e-6
VS44 21 s44 0
V44 e44 s44 DC 0 AC 39e0 -120
RI44 e44 8 68e-1
VS45 26 s45 0
V45 e45 s45 DC 0 AC 18e0 0
RI45 e45 9 39e-3
VS46 8 s46 0
V46 e46 s46 DC 0 AC 10e1 -120
RI46 e46 2 10e-3
VS47 13 s47 0
L47 s47 17 56e-3
VS48 23 s48 0
C48 s48 25 39e-6
VS49 19 s49 0
V49 e49 s49 DC 0 AC 10e1 180
RI49 e49 m49 15e-2
LI49 m49 21 39e-7
VS50 8 s50 0
L50 s50 22 39e-5
VS51 23 s51 0
C51 s51 25 10e-4
.control
set numdgt=17
ac lin 1 60 60
print v(1) v(2) v(3) v(4) v(5) v(6) v(7) v(8) v(9) v(10)
print v(11) v(12) v(13) v(14) v(15) v(16) v(17) v(18) v(19) v(20)
print v(21) v(22) v(23) v(24) v(25) v(26)
print i(vs0) i(vs1) i(vs2) i(vs3) i(vs4) i(vs5) i(vs6) i(vs7) i(vs8) i(vs9)
print i(vs10) i(vs11) i(vs12) i(vs13) i(vs14) i(vs15) i(vs16) i(vs17) i(vs18) i(vs19)
print i(vs20) i(vs21) i(vs22) i(vs23) i(vs24) i(vs25) i(vs26) i(vs27) i(vs28) i(vs29)
print i(vs30) i(vs31) i(vs32) i(vs33) i(vs34) i(vs35) i(vs36) i(vs37) i(vs38) i(vs39)
print i(vs40) i(vs41) i(vs42) i(vs43) i(vs44) i(vs45) i(vs46) i(vs47) i(vs48) i(vs49)
print i(vs50) i(vs51)
.endc
.end
