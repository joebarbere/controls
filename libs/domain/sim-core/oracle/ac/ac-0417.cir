controls oracle ac-0417
* Generated (plan F2.7, ADR 0012): do not edit; regenerate with `pnpm sim oracle regen`. ac seed 20261031 index 417 nodes 27 elements 47
.options sparse gmin=1e-12 noopac
RG1 1 0 1000000000000
RG2 2 0 1000000000000
RG3 3 0 1000000000000
RG4 4 0 1000000000000
RG5 5 0 1000000000000
RG6 6 0 1000000000000
RG7 7 0 1000000000000
RG8 8 0 1000000000000
RG9 9 0 1000000000000
RG10 10 0 1000000000000
RG11 11 0 1000000000000
RG12 12 0 1000000000000
RG13 13 0 1000000000000
RG14 14 0 1000000000000
RG15 15 0 1000000000000
RG16 16 0 1000000000000
RG17 17 0 1000000000000
RG18 18 0 1000000000000
RG19 19 0 1000000000000
RG20 20 0 1000000000000
RG21 21 0 1000000000000
RG22 22 0 1000000000000
RG23 23 0 1000000000000
RG24 24 0 1000000000000
RG25 25 0 1000000000000
RG26 26 0 1000000000000
VS0 16 s0 0
C0 s0 24 33e-6
VS1 9 s1 0
L1 s1 14 10e-2
VS2 0 s2 0
C2 s2 23 82e-5
VS3 17 s3 0
C3 s3 5 82e-7
VS4 23 s4 0
C4 s4 25 10e-4
VS5 11 s5 0
C5 s5 18 15e-5
VS6 6 s6 0
C6 s6 5 22e-4
VS7 23 s7 0
L7 s7 20 12e-4
VS8 0 s8 0
V8 e8 s8 DC 0 AC 15e1 -120
RI8 e8 8 12e-1
VS9 24 s9 0
C9 s9 17 15e-4
VS10 25 s10 0
R10 s10 6 56e-2
VS11 19 s11 0
L11 s11 14 47e-2
VS12 0 s12 0
L12 s12 16 27e-2
VS13 10 s13 0
V13 e13 s13 DC 0 AC 39e1 0
RI13 e13 0 56e-1
VS14 10 s14 0
R14 s14 24 33e1
VS15 6 s15 0
R15 s15 0 56e1
VS16 25 s16 0
C16 s16 5 33e-6
VS17 12 s17 0
L17 s17 4 47e-2
VS18 5 s18 0
R18 s18 4 33e-2
VS19 12 s19 0
R19 s19 4 10e2
VS20 24 s20 0
L20 s20 4 10e-4
VS21 1 s21 0
C21 s21 23 82e-6
VS22 22 s22 0
V22 e22 s22 DC 0 AC 33e-1 120
RI22 e22 0 33e-1
VS23 0 s23 0
R23 s23 11 82e-2
VS24 13 s24 0
R24 s24 3 18e-1
VS25 7 s25 0
R25 s25 0 15e3
VS26 18 s26 0
C26 s26 11 68e-4
VS27 23 s27 0
C27 s27 25 39e-6
VS28 19 s28 0
V28 e28 s28 DC 0 AC 12e-1 180
RI28 e28 9 10e-2
VS29 8 s29 0
V29 e29 s29 DC 0 AC 10e1 -120
RI29 e29 2 10e-3
VS30 6 s30 0
R30 s30 23 27e0
VS31 26 s31 0
V31 e31 s31 DC 0 AC 18e0 0
RI31 e31 9 39e-3
VS32 5 s32 0
V32 e32 s32 DC 0 AC 82e0 120
RI32 e32 20 10e-3
VS33 8 s33 0
L33 s33 22 39e-5
VS34 0 s34 0
R34 s34 24 22e1
VS35 16 s35 0
V35 e35 s35 DC 0 AC 68e0 0
RI35 e35 15 33e-1
VS36 18 s36 0
V36 e36 s36 DC 0 AC 33e0 0
RI36 e36 21 82e-1
VS37 16 s37 0
V37 e37 s37 DC 0 AC 18e-1 180
RI37 e37 9 47e-1
VS38 6 s38 0
V38 e38 s38 DC 0 AC 33e1 180
RI38 e38 9 82e-2
VS39 21 s39 0
L39 s39 25 27e-3
VS40 26 s40 0
C40 s40 10 27e-6
VS41 24 s41 0
R41 s41 12 82e2
VS42 21 s42 0
V42 e42 s42 DC 0 AC 39e0 -120
RI42 e42 8 68e-1
VS43 19 s43 0
V43 e43 s43 DC 0 AC 10e1 180
RI43 e43 21 15e-2
VS44 25 s44 0
L44 s44 11 10e-4
VS45 8 s45 0
R45 s45 3 18e-2
VS46 17 s46 0
L46 s46 21 68e-5
.control
set numdgt=17
ac lin 1 60 60
print v(1) v(2) v(3) v(4) v(5) v(6) v(7) v(8) v(9) v(10)
print v(11) v(12) v(13) v(14) v(15) v(16) v(17) v(18) v(19) v(20)
print v(21) v(22) v(23) v(24) v(25) v(26)
print i(vs0) i(vs1) i(vs2) i(vs3) i(vs4) i(vs5) i(vs6) i(vs7) i(vs8) i(vs9)
print i(vs10) i(vs11) i(vs12) i(vs13) i(vs14) i(vs15) i(vs16) i(vs17) i(vs18) i(vs19)
print i(vs20) i(vs21) i(vs22) i(vs23) i(vs24) i(vs25) i(vs26) i(vs27) i(vs28) i(vs29)
print i(vs30) i(vs31) i(vs32) i(vs33) i(vs34) i(vs35) i(vs36) i(vs37) i(vs38) i(vs39)
print i(vs40) i(vs41) i(vs42) i(vs43) i(vs44) i(vs45) i(vs46)
.endc
.end
