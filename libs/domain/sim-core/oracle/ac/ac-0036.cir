controls oracle ac-0036
* Generated (plan F2.7, ADR 0012): do not edit; regenerate with `pnpm sim oracle regen`. ac seed 20261031 index 36 nodes 30 elements 39
.options sparse gmin=1e-12 noopac
RG1 1 0 1000000000000
RG2 2 0 1000000000000
RG3 3 0 1000000000000
RG4 4 0 1000000000000
RG5 5 0 1000000000000
RG6 6 0 1000000000000
RG7 7 0 1000000000000
RG8 8 0 1000000000000
RG9 9 0 1000000000000
RG10 10 0 1000000000000
RG11 11 0 1000000000000
RG12 12 0 1000000000000
RG13 13 0 1000000000000
RG14 14 0 1000000000000
RG15 15 0 1000000000000
RG16 16 0 1000000000000
RG17 17 0 1000000000000
RG18 18 0 1000000000000
RG19 19 0 1000000000000
RG20 20 0 1000000000000
RG21 21 0 1000000000000
RG22 22 0 1000000000000
RG23 23 0 1000000000000
RG24 24 0 1000000000000
RG25 25 0 1000000000000
RG26 26 0 1000000000000
RG27 27 0 1000000000000
RG28 28 0 1000000000000
RG29 29 0 1000000000000
VS0 27 s0 0
C0 s0 10 47e-5
VS1 22 s1 0
L1 s1 25 10e-5
VS2 0 s2 0
V2 e2 s2 DC 0 AC 39e1 -120
RI2 e2 3 56e-1
VS3 3 s3 0
L3 s3 15 27e-3
VS4 23 s4 0
C4 s4 0 12e-4
VS5 18 s5 0
R5 s5 11 39e3
VS6 6 s6 0
C6 s6 20 82e-7
VS7 16 s7 0
V7 e7 s7 DC 0 AC 82e1 180
RI7 e7 18 39e-2
VS8 2 s8 0
V8 e8 s8 DC 0 AC 33e-1 120
RI8 e8 9 15e-2
VS9 23 s9 0
L9 s9 27 56e-4
VS10 26 s10 0
R10 s10 10 18e3
VS11 5 s11 0
R11 s11 17 82e3
VS12 15 s12 0
C12 s12 1 47e-7
VS13 17 s13 0
L13 s13 19 12e-4
VS14 17 s14 0
V14 e14 s14 DC 0 AC 33e0 0
RI14 e14 21 18e-3
VS15 18 s15 0
R15 s15 17 15e3
VS16 0 s16 0
L16 s16 24 56e-5
VS17 19 s17 0
L17 s17 25 22e-5
VS18 21 s18 0
R18 s18 13 33e-2
VS19 3 s19 0
R19 s19 29 15e0
VS20 13 s20 0
L20 s20 19 68e-3
VS21 24 s21 0
R21 s21 25 56e2
VS22 8 s22 0
V22 e22 s22 DC 0 AC 15e1 120
RI22 e22 0 39e-1
VS23 2 s23 0
L23 s23 24 22e-5
VS24 0 s24 0
V24 e24 s24 DC 0 AC 10e1 0
RI24 e24 5 10e-1
VS25 4 s25 0
R25 s25 28 12e0
VS26 25 s26 0
L26 s26 23 56e-3
VS27 17 s27 0
V27 e27 s27 DC 0 AC 27e-1 -120
RI27 e27 6 10e-2
VS28 5 s28 0
C28 s28 2 27e-5
VS29 28 s29 0
L29 s29 23 22e-2
VS30 12 s30 0
L30 s30 7 33e-5
VS31 26 s31 0
V31 e31 s31 DC 0 AC 18e1 180
RI31 e31 9 33e-2
VS32 22 s32 0
L32 s32 14 68e-3
VS33 2 s33 0
L33 s33 25 18e-3
VS34 24 s34 0
C34 s34 4 10e-7
VS35 1 s35 0
C35 s35 2 15e-6
VS36 12 s36 0
R36 s36 23 33e0
VS37 23 s37 0
L37 s37 4 68e-2
VS38 29 s38 0
C38 s38 7 68e-4
.control
set numdgt=17
ac lin 1 60 60
print v(1) v(2) v(3) v(4) v(5) v(6) v(7) v(8) v(9) v(10)
print v(11) v(12) v(13) v(14) v(15) v(16) v(17) v(18) v(19) v(20)
print v(21) v(22) v(23) v(24) v(25) v(26) v(27) v(28) v(29)
print i(vs0) i(vs1) i(vs2) i(vs3) i(vs4) i(vs5) i(vs6) i(vs7) i(vs8) i(vs9)
print i(vs10) i(vs11) i(vs12) i(vs13) i(vs14) i(vs15) i(vs16) i(vs17) i(vs18) i(vs19)
print i(vs20) i(vs21) i(vs22) i(vs23) i(vs24) i(vs25) i(vs26) i(vs27) i(vs28) i(vs29)
print i(vs30) i(vs31) i(vs32) i(vs33) i(vs34) i(vs35) i(vs36) i(vs37) i(vs38)
.endc
.end
