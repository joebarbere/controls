controls oracle ac-0036
* Generated (plan F2.7, ADR 0012): do not edit; regenerate with `pnpm sim oracle regen`. ac seed 20261031 index 36 nodes 30 elements 44
.options sparse gmin=1e-12 noopac
RG1 1 0 1000000000000
RG2 2 0 1000000000000
RG3 3 0 1000000000000
RG4 4 0 1000000000000
RG5 5 0 1000000000000
RG6 6 0 1000000000000
RG7 7 0 1000000000000
RG8 8 0 1000000000000
RG9 9 0 1000000000000
RG10 10 0 1000000000000
RG11 11 0 1000000000000
RG12 12 0 1000000000000
RG13 13 0 1000000000000
RG14 14 0 1000000000000
RG15 15 0 1000000000000
RG16 16 0 1000000000000
RG17 17 0 1000000000000
RG18 18 0 1000000000000
RG19 19 0 1000000000000
RG20 20 0 1000000000000
RG21 21 0 1000000000000
RG22 22 0 1000000000000
RG23 23 0 1000000000000
RG24 24 0 1000000000000
RG25 25 0 1000000000000
RG26 26 0 1000000000000
RG27 27 0 1000000000000
RG28 28 0 1000000000000
RG29 29 0 1000000000000
VS0 0 s0 0
R0 s0 22 15e1
VS1 23 s1 0
L1 s1 27 56e-4
VS2 0 s2 0
V2 e2 s2 DC 0 AC 15e1 120
RI2 e2 m2 39e-1
LI2 m2 n2 82e-7
H2 n2 h2 VS7 12e-3
ED2 h2 17 d2 0 82e-7
F2 0 d2 VS7 1
LD2 d2 0 1
VS3 2 s3 0
L3 s3 24 22e-5
VS4 4 s4 0
R4 s4 28 12e0
VS5 15 s5 0
C5 s5 1 47e-7
VS6 21 s6 0
R6 s6 13 33e-2
VS7 2 s7 0
V7 e7 s7 DC 0 AC 33e-1 120
RI7 e7 m7 15e-2
LI7 m7 n7 10e-5
H7 n7 h7 VS2 12e-3
ED7 h7 9 d7 0 82e-7
F7 0 d7 VS2 1
LD7 d7 0 1
VS8 23 s8 0
C8 s8 17 12e-4
VS9 27 s9 0
C9 s9 10 47e-5
VS10 27 s10 0
R10 s10 11 12e3
VS11 5 s11 0
V11 e11 s11 DC 0 AC 10e0 0
RI11 e11 m11 56e-2
LI11 m11 16 39e-6
VS12 16 s12 0
V12 e12 s12 DC 0 AC 82e1 180
RI12 e12 m12 39e-2
LI12 m12 18 18e-5
VS13 2 s13 0
L13 s13 25 18e-3
VS14 17 s14 0
L14 s14 24 56e-5
VS15 22 s15 0
V15 e15 s15 DC 0 AC 47e1 -120
RI15 e15 m15 39e-1
LI15 m15 20 47e-6
VS16 12 s16 0
L16 s16 7 33e-5
VS17 26 s17 0
R17 s17 10 18e3
VS18 8 s18 0
V18 e18 s18 DC 0 AC 33e0 0
RI18 e18 21 18e-3
VS19 17 s19 0
V19 e19 s19 DC 0 AC 10e1 0
RI19 e19 m19 10e-1
LI19 m19 5 12e-7
VS20 18 s20 0
R20 s20 11 39e3
VS21 24 s21 0
R21 s21 25 56e2
VS22 5 s22 0
R22 s22 8 82e3
VS23 3 s23 0
R23 s23 29 15e0
VS24 26 s24 0
V24 e24 s24 DC 0 AC 18e1 180
RI24 e24 m24 33e-2
LI24 m24 9 39e-7
VS25 8 s25 0
L25 s25 19 12e-4
VS26 22 s26 0
L26 s26 14 68e-3
VS27 19 s27 0
L27 s27 25 22e-5
VS28 14 s28 0
C28 s28 25 56e-5
VS29 29 s29 0
C29 s29 7 68e-4
VS30 5 s30 0
C30 s30 2 27e-5
VS31 25 s31 0
L31 s31 23 56e-3
VS32 23 s32 0
L32 s32 4 68e-2
VS33 22 s33 0
L33 s33 25 10e-5
VS34 3 s34 0
L34 s34 15 27e-3
VS35 8 s35 0
V35 e35 s35 DC 0 AC 27e-1 -120
RI35 e35 m35 10e-2
LI35 m35 6 56e-7
VS36 24 s36 0
C36 s36 4 10e-7
VS37 1 s37 0
C37 s37 2 15e-6
VS38 12 s38 0
R38 s38 23 33e0
VS39 6 s39 0
C39 s39 20 82e-7
VS40 28 s40 0
L40 s40 23 22e-2
VS41 18 s41 0
R41 s41 8 15e3
VS42 17 s42 0
V42 e42 s42 DC 0 AC 39e1 -120
RI42 e42 m42 56e-1
LI42 m42 3 56e-5
VS43 13 s43 0
L43 s43 19 68e-3
.control
set numdgt=17
ac lin 1 60 60
print v(1) v(2) v(3) v(4) v(5) v(6) v(7) v(8) v(9) v(10)
print v(11) v(12) v(13) v(14) v(15) v(16) v(17) v(18) v(19) v(20)
print v(21) v(22) v(23) v(24) v(25) v(26) v(27) v(28) v(29)
print i(vs0) i(vs1) i(vs2) i(vs3) i(vs4) i(vs5) i(vs6) i(vs7) i(vs8) i(vs9)
print i(vs10) i(vs11) i(vs12) i(vs13) i(vs14) i(vs15) i(vs16) i(vs17) i(vs18) i(vs19)
print i(vs20) i(vs21) i(vs22) i(vs23) i(vs24) i(vs25) i(vs26) i(vs27) i(vs28) i(vs29)
print i(vs30) i(vs31) i(vs32) i(vs33) i(vs34) i(vs35) i(vs36) i(vs37) i(vs38) i(vs39)
print i(vs40) i(vs41) i(vs42) i(vs43)
.endc
.end
