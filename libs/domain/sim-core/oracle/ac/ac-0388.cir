controls oracle ac-0388
* Generated (plan F2.7, ADR 0012): do not edit; regenerate with `pnpm sim oracle regen`. ac seed 20261031 index 388 nodes 6 elements 9
.options sparse gmin=1e-12 noopac
RG1 1 0 1000000000000
RG2 2 0 1000000000000
RG3 3 0 1000000000000
RG4 4 0 1000000000000
RG5 5 0 1000000000000
VS0 1 s0 0
C0 s0 3 22e-6
VS1 2 s1 0
C1 s1 4 47e-6
VS2 4 s2 0
R2 s2 2 47e-2
VS3 0 s3 0
V3 e3 s3 DC 0 AC 56e-1 120
RI3 e3 m3 18e-2
LI3 m3 5 47e-6
VS4 2 s4 0
L4 s4 0 15e-2
VS5 4 s5 0
C5 s5 5 82e-6
VS6 3 s6 0
L6 s6 2 18e-2
VS7 4 s7 0
V7 e7 s7 DC 0 AC 82e-1 0
RI7 e7 m7 18e-3
LI7 m7 5 10e-7
VS8 5 s8 0
L8 s8 1 68e-3
.control
set numdgt=17
ac lin 1 60 60
print v(1) v(2) v(3) v(4) v(5)
print i(vs0) i(vs1) i(vs2) i(vs3) i(vs4) i(vs5) i(vs6) i(vs7) i(vs8)
.endc
.end
