controls oracle ac-0388
* Generated (plan F2.7, ADR 0012): do not edit; regenerate with `pnpm sim oracle regen`. ac seed 20261031 index 388 nodes 6 elements 10
.options sparse gmin=1e-12 noopac
RG1 1 0 1000000000000
RG2 2 0 1000000000000
RG3 3 0 1000000000000
RG4 4 0 1000000000000
RG5 5 0 1000000000000
VS0 3 s0 0
L0 s0 0 12e-3
VS1 0 s1 0
L1 s1 4 18e-2
VS2 2 s2 0
L2 s2 4 15e-2
VS3 0 s3 0
V3 e3 s3 DC 0 AC 22e0 120
RI3 e3 1 68e-1
VS4 1 s4 0
V4 e4 s4 DC 0 AC 27e0 0
RI4 e4 3 22e-1
VS5 1 s5 0
R5 s5 2 47e-2
VS6 1 s6 0
C6 s6 5 82e-6
VS7 1 s7 0
V7 e7 s7 DC 0 AC 82e-1 0
RI7 e7 5 18e-3
VS8 4 s8 0
V8 e8 s8 DC 0 AC 56e-1 120
RI8 e8 5 18e-2
VS9 2 s9 0
C9 s9 1 47e-6
.control
set numdgt=17
ac lin 1 60 60
print v(1) v(2) v(3) v(4) v(5)
print i(vs0) i(vs1) i(vs2) i(vs3) i(vs4) i(vs5) i(vs6) i(vs7) i(vs8) i(vs9)
.endc
.end
