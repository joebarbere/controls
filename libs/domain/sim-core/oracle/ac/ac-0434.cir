controls oracle ac-0434
* Generated (plan F2.7, ADR 0012): do not edit; regenerate with `pnpm sim oracle regen`. ac seed 20261031 index 434 nodes 20 elements 41
.options sparse gmin=1e-12 noopac
RG1 1 0 1000000000000
RG2 2 0 1000000000000
RG3 3 0 1000000000000
RG4 4 0 1000000000000
RG5 5 0 1000000000000
RG6 6 0 1000000000000
RG7 7 0 1000000000000
RG8 8 0 1000000000000
RG9 9 0 1000000000000
RG10 10 0 1000000000000
RG11 11 0 1000000000000
RG12 12 0 1000000000000
RG13 13 0 1000000000000
RG14 14 0 1000000000000
RG15 15 0 1000000000000
RG16 16 0 1000000000000
RG17 17 0 1000000000000
RG18 18 0 1000000000000
RG19 19 0 1000000000000
VS0 0 s0 0
R0 s0 10 33e3
VS1 0 s1 0
V1 e1 s1 DC 0 AC 47e-1 120
RI1 e1 m1 22e-2
LI1 m1 n1 68e-5
H1 n1 h1 VS9 18e-3
ED1 h1 7 d1 0 -68e-5
F1 0 d1 VS9 1
LD1 d1 0 1
VS2 5 s2 0
R2 s2 11 39e1
VS3 3 s3 0
R3 s3 5 12e1
VS4 14 s4 0
C4 s4 12 15e-7
VS5 7 s5 0
C5 s5 12 10e-7
VS6 18 s6 0
R6 s6 4 39e3
VS7 13 s7 0
L7 s7 19 47e-4
VS8 0 s8 0
R8 s8 11 12e3
VS9 1 s9 0
V9 e9 s9 DC 0 AC 68e0 180
RI9 e9 n9 18e-2
H9 n9 h9 VS1 18e-3
ED9 h9 8 d9 0 -68e-5
F9 0 d9 VS1 1
LD9 d9 0 1
VS10 15 s10 0
R10 s10 13 22e2
VS11 6 s11 0
L11 s11 16 47e-2
VS12 4 s12 0
R12 s12 17 82e-1
VS13 8 s13 0
R13 s13 7 22e1
VS14 0 s14 0
L14 s14 17 18e-2
VS15 11 s15 0
L15 s15 0 12e-4
VS16 14 s16 0
C16 s16 2 39e-6
VS17 8 s17 0
L17 s17 0 18e-5
VS18 19 s18 0
R18 s18 6 47e1
VS19 14 s19 0
R19 s19 5 56e-2
VS20 10 s20 0
C20 s20 15 47e-4
VS21 2 s21 0
C21 s21 11 12e-6
VS22 6 s22 0
L22 s22 7 15e-5
VS23 7 s23 0
L23 s23 2 47e-5
VS24 0 s24 0
R24 s24 12 15e-1
VS25 4 s25 0
L25 s25 1 10e-3
VS26 17 s26 0
C26 s26 8 56e-7
VS27 1 s27 0
C27 s27 9 56e-5
VS28 18 s28 0
V28 e28 s28 DC 0 AC 33e1 120
RI28 e28 m28 39e-1
LI28 m28 7 22e-5
VS29 4 s29 0
C29 s29 9 15e-4
VS30 7 s30 0
C30 s30 4 10e-5
VS31 17 s31 0
L31 s31 15 82e-5
VS32 15 s32 0
C32 s32 8 56e-6
VS33 6 s33 0
R33 s33 5 12e2
VS34 19 s34 0
R34 s34 2 33e0
VS35 13 s35 0
R35 s35 15 33e-2
VS36 6 s36 0
L36 s36 3 68e-4
VS37 15 s37 0
R37 s37 14 12e-1
VS38 7 s38 0
R38 s38 5 68e3
VS39 7 s39 0
R39 s39 16 10e3
VS40 6 s40 0
L40 s40 5 33e-3
.control
set numdgt=17
ac lin 1 60 60
print v(1) v(2) v(3) v(4) v(5) v(6) v(7) v(8) v(9) v(10)
print v(11) v(12) v(13) v(14) v(15) v(16) v(17) v(18) v(19)
print i(vs0) i(vs1) i(vs2) i(vs3) i(vs4) i(vs5) i(vs6) i(vs7) i(vs8) i(vs9)
print i(vs10) i(vs11) i(vs12) i(vs13) i(vs14) i(vs15) i(vs16) i(vs17) i(vs18) i(vs19)
print i(vs20) i(vs21) i(vs22) i(vs23) i(vs24) i(vs25) i(vs26) i(vs27) i(vs28) i(vs29)
print i(vs30) i(vs31) i(vs32) i(vs33) i(vs34) i(vs35) i(vs36) i(vs37) i(vs38) i(vs39)
print i(vs40)
.endc
.end
