controls oracle ac-0434
* Generated (plan F2.7, ADR 0012): do not edit; regenerate with `pnpm sim oracle regen`. ac seed 20261031 index 434 nodes 20 elements 40
.options sparse gmin=1e-12 noopac
RG1 1 0 1000000000000
RG2 2 0 1000000000000
RG3 3 0 1000000000000
RG4 4 0 1000000000000
RG5 5 0 1000000000000
RG6 6 0 1000000000000
RG7 7 0 1000000000000
RG8 8 0 1000000000000
RG9 9 0 1000000000000
RG10 10 0 1000000000000
RG11 11 0 1000000000000
RG12 12 0 1000000000000
RG13 13 0 1000000000000
RG14 14 0 1000000000000
RG15 15 0 1000000000000
RG16 16 0 1000000000000
RG17 17 0 1000000000000
RG18 18 0 1000000000000
RG19 19 0 1000000000000
VS0 1 s0 0
C0 s0 9 56e-5
VS1 0 s1 0
V1 e1 s1 DC 0 AC 27e1 180
RI1 e1 2 12e-3
VS2 12 s2 0
V2 e2 s2 DC 0 AC 33e-1 120
RI2 e2 14 27e-3
VS3 2 s3 0
L3 s3 6 27e-2
VS4 12 s4 0
L4 s4 3 18e-2
VS5 2 s5 0
R5 s5 1 12e-1
VS6 14 s6 0
C6 s6 12 15e-7
VS7 4 s7 0
V7 e7 s7 DC 0 AC 82e-1 -120
RI7 e7 m7 56e-3
LI7 m7 15 56e-6
VS8 7 s8 0
C8 s8 12 10e-7
VS9 5 s9 0
L9 s9 8 22e-3
VS10 8 s10 0
R10 s10 7 22e1
VS11 19 s11 0
R11 s11 2 33e0
VS12 15 s12 0
L12 s12 19 56e-5
VS13 15 s13 0
R13 s13 14 12e-1
VS14 17 s14 0
V14 e14 s14 DC 0 AC 68e0 180
RI14 e14 m14 56e-3
LI14 m14 10 47e-7
VS15 7 s15 0
C15 s15 4 10e-5
VS16 0 s16 0
R16 s16 2 10e1
VS17 11 s17 0
C17 s17 3 27e-6
VS18 19 s18 0
C18 s18 9 15e-4
VS19 14 s19 0
L19 s19 3 47e-5
VS20 1 s20 0
V20 e20 s20 DC 0 AC 68e0 180
RI20 e20 8 18e-2
VS21 7 s21 0
L21 s21 18 68e-3
VS22 15 s22 0
R22 s22 6 47e1
VS23 4 s23 0
R23 s23 17 82e-1
VS24 13 s24 0
L24 s24 7 15e-5
VS25 18 s25 0
C25 s25 0 56e-7
VS26 17 s26 0
C26 s26 3 15e-4
VS27 19 s27 0
R27 s27 17 47e2
VS28 19 s28 0
V28 e28 s28 DC 0 AC 56e0 -120
RI28 e28 6 39e-1
VS29 7 s29 0
R29 s29 15 68e1
VS30 17 s30 0
V30 e30 s30 DC 0 AC 12e1 180
RI30 e30 5 22e-3
VS31 10 s31 0
L31 s31 14 68e-3
VS32 2 s32 0
C32 s32 4 12e-4
VS33 19 s33 0
R33 s33 3 82e-1
VS34 0 s34 0
V34 e34 s34 DC 0 AC 27e-1 120
RI34 e34 m34 47e-1
LI34 m34 4 39e-7
VS35 8 s35 0
L35 s35 6 18e-5
VS36 6 s36 0
V36 e36 s36 DC 0 AC 47e-1 120
RI36 e36 m36 22e-2
LI36 m36 7 10e-5
VS37 0 s37 0
R37 s37 16 33e-1
VS38 13 s38 0
V38 e38 s38 DC 0 AC 82e1 120
RI38 e38 m38 33e-2
LI38 m38 16 82e-7
VS39 6 s39 0
C39 s39 11 39e-4
.control
set numdgt=17
ac lin 1 60 60
print v(1) v(2) v(3) v(4) v(5) v(6) v(7) v(8) v(9) v(10)
print v(11) v(12) v(13) v(14) v(15) v(16) v(17) v(18) v(19)
print i(vs0) i(vs1) i(vs2) i(vs3) i(vs4) i(vs5) i(vs6) i(vs7) i(vs8) i(vs9)
print i(vs10) i(vs11) i(vs12) i(vs13) i(vs14) i(vs15) i(vs16) i(vs17) i(vs18) i(vs19)
print i(vs20) i(vs21) i(vs22) i(vs23) i(vs24) i(vs25) i(vs26) i(vs27) i(vs28) i(vs29)
print i(vs30) i(vs31) i(vs32) i(vs33) i(vs34) i(vs35) i(vs36) i(vs37) i(vs38) i(vs39)
.endc
.end
