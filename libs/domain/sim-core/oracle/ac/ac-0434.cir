controls oracle ac-0434
* Generated (plan F2.7, ADR 0012): do not edit; regenerate with `pnpm sim oracle regen`. ac seed 20261031 index 434 nodes 20 elements 38
.options sparse gmin=1e-12 noopac
RG1 1 0 1000000000000
RG2 2 0 1000000000000
RG3 3 0 1000000000000
RG4 4 0 1000000000000
RG5 5 0 1000000000000
RG6 6 0 1000000000000
RG7 7 0 1000000000000
RG8 8 0 1000000000000
RG9 9 0 1000000000000
RG10 10 0 1000000000000
RG11 11 0 1000000000000
RG12 12 0 1000000000000
RG13 13 0 1000000000000
RG14 14 0 1000000000000
RG15 15 0 1000000000000
RG16 16 0 1000000000000
RG17 17 0 1000000000000
RG18 18 0 1000000000000
RG19 19 0 1000000000000
VS0 5 s0 0
R0 s0 11 39e1
VS1 15 s1 0
C1 s1 8 56e-6
VS2 0 s2 0
V2 e2 s2 DC 0 AC 47e-1 120
RI2 e2 7 22e-2
VS3 4 s3 0
L3 s3 1 10e-3
VS4 0 s4 0
R4 s4 10 33e3
VS5 17 s5 0
C5 s5 8 56e-7
VS6 6 s6 0
L6 s6 5 33e-3
VS7 0 s7 0
R7 s7 12 15e-1
VS8 6 s8 0
L8 s8 7 15e-5
VS9 7 s9 0
L9 s9 2 47e-5
VS10 14 s10 0
C10 s10 12 15e-7
VS11 19 s11 0
R11 s11 6 47e1
VS12 14 s12 0
C12 s12 2 39e-6
VS13 18 s13 0
V13 e13 s13 DC 0 AC 33e1 120
RI13 e13 7 39e-1
VS14 7 s14 0
R14 s14 5 68e3
VS15 8 s15 0
R15 s15 7 22e1
VS16 11 s16 0
L16 s16 0 12e-4
VS17 0 s17 0
L17 s17 17 18e-2
VS18 2 s18 0
C18 s18 11 12e-6
VS19 6 s19 0
L19 s19 16 47e-2
VS20 4 s20 0
C20 s20 9 15e-4
VS21 15 s21 0
R21 s21 14 12e-1
VS22 1 s22 0
C22 s22 9 56e-5
VS23 6 s23 0
R23 s23 5 12e2
VS24 0 s24 0
R24 s24 11 12e3
VS25 7 s25 0
C25 s25 4 10e-5
VS26 15 s26 0
R26 s26 13 22e2
VS27 17 s27 0
L27 s27 15 82e-5
VS28 4 s28 0
R28 s28 17 82e-1
VS29 8 s29 0
L29 s29 0 18e-5
VS30 19 s30 0
R30 s30 2 33e0
VS31 13 s31 0
R31 s31 15 33e-2
VS32 6 s32 0
L32 s32 3 68e-4
VS33 10 s33 0
C33 s33 15 47e-4
VS34 1 s34 0
V34 e34 s34 DC 0 AC 68e0 180
RI34 e34 8 18e-2
VS35 14 s35 0
R35 s35 5 56e-2
VS36 7 s36 0
C36 s36 12 10e-7
VS37 18 s37 0
R37 s37 4 39e3
.control
set numdgt=17
ac lin 1 60 60
print v(1) v(2) v(3) v(4) v(5) v(6) v(7) v(8) v(9) v(10)
print v(11) v(12) v(13) v(14) v(15) v(16) v(17) v(18) v(19)
print i(vs0) i(vs1) i(vs2) i(vs3) i(vs4) i(vs5) i(vs6) i(vs7) i(vs8) i(vs9)
print i(vs10) i(vs11) i(vs12) i(vs13) i(vs14) i(vs15) i(vs16) i(vs17) i(vs18) i(vs19)
print i(vs20) i(vs21) i(vs22) i(vs23) i(vs24) i(vs25) i(vs26) i(vs27) i(vs28) i(vs29)
print i(vs30) i(vs31) i(vs32) i(vs33) i(vs34) i(vs35) i(vs36) i(vs37)
.endc
.end
