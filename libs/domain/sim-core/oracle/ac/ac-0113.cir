controls oracle ac-0113
* Generated (plan F2.7, ADR 0012): do not edit; regenerate with `pnpm sim oracle regen`. ac seed 20261031 index 113 nodes 9 elements 13
.options sparse gmin=1e-12 noopac
RG1 1 0 1000000000000
RG2 2 0 1000000000000
RG3 3 0 1000000000000
RG4 4 0 1000000000000
RG5 5 0 1000000000000
RG6 6 0 1000000000000
RG7 7 0 1000000000000
RG8 8 0 1000000000000
VS0 2 s0 0
L0 s0 6 39e-2
VS1 0 s1 0
V1 e1 s1 DC 0 AC 12e1 0
RI1 e1 1 22e-1
VS2 2 s2 0
V2 e2 s2 DC 0 AC 10e1 0
RI2 e2 8 27e-2
VS3 8 s3 0
R3 s3 0 68e-2
VS4 2 s4 0
L4 s4 7 18e-3
VS5 1 s5 0
L5 s5 7 82e-5
VS6 5 s6 0
R6 s6 4 27e3
VS7 2 s7 0
L7 s7 0 22e-4
VS8 7 s8 0
R8 s8 2 33e2
VS9 0 s9 0
R9 s9 8 47e2
VS10 8 s10 0
V10 e10 s10 DC 0 AC 10e0 0
RI10 e10 5 68e-1
VS11 5 s11 0
R11 s11 1 39e1
VS12 8 s12 0
R12 s12 3 27e-2
.control
set numdgt=17
ac lin 1 60 60
print v(1) v(2) v(3) v(4) v(5) v(6) v(7) v(8)
print i(vs0) i(vs1) i(vs2) i(vs3) i(vs4) i(vs5) i(vs6) i(vs7) i(vs8) i(vs9)
print i(vs10) i(vs11) i(vs12)
.endc
.end
