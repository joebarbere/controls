controls oracle ac-0162
* Generated (plan F2.7, ADR 0012): do not edit; regenerate with `pnpm sim oracle regen`. ac seed 20261031 index 162 nodes 3 elements 3
.options sparse gmin=1e-12 noopac
RG1 1 0 1000000000000
RG2 2 0 1000000000000
VS0 0 s0 0
V0 e0 s0 DC 0 AC 27e0 -120
RI0 e0 1 68e-3
VS1 1 s1 0
C1 s1 2 22e-4
VS2 2 s2 0
R2 s2 0 15e1
.control
set numdgt=17
ac lin 1 60 60
print v(1) v(2)
print i(vs0) i(vs1) i(vs2)
.endc
.end
