controls oracle ac-0152
* Generated (plan F2.7, ADR 0012): do not edit; regenerate with `pnpm sim oracle regen`. ac seed 20261031 index 152 nodes 3 elements 5
.options sparse gmin=1e-12 noopac
RG1 1 0 1000000000000
RG2 2 0 1000000000000
VS0 0 s0 0
V0 e0 s0 DC 0 AC 33e0 120
RI0 e0 2 47e-2
VS1 0 s1 0
R1 s1 1 39e-1
VS2 2 s2 0
V2 e2 s2 DC 0 AC 33e1 120
RI2 e2 0 68e-1
VS3 2 s3 0
L3 s3 1 10e-2
VS4 0 s4 0
V4 e4 s4 DC 0 AC 39e1 120
RI4 e4 1 33e-2
.control
set numdgt=17
ac lin 1 60 60
print v(1) v(2)
print i(vs0) i(vs1) i(vs2) i(vs3) i(vs4)
.endc
.end
