controls oracle ac-0152
* Generated (plan F2.7, ADR 0012): do not edit; regenerate with `pnpm sim oracle regen`. ac seed 20261031 index 152 nodes 3 elements 6
.options sparse gmin=1e-12 noopac
RG1 1 0 1000000000000
RG2 2 0 1000000000000
VS0 0 s0 0
V0 e0 s0 DC 0 AC 12e-1 -120
RI0 e0 1 12e-1
VS1 2 s1 0
V1 e1 s1 DC 0 AC 10e-1 -120
RI1 e1 1 27e-3
VS2 2 s2 0
V2 e2 s2 DC 0 AC 33e0 120
RI2 e2 1 47e-2
VS3 0 s3 0
L3 s3 2 39e-4
VS4 0 s4 0
R4 s4 1 12e-1
VS5 1 s5 0
L5 s5 0 15e-3
.control
set numdgt=17
ac lin 1 60 60
print v(1) v(2)
print i(vs0) i(vs1) i(vs2) i(vs3) i(vs4) i(vs5)
.endc
.end
