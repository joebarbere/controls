controls oracle ac-0152
* Generated (plan F2.7, ADR 0012): do not edit; regenerate with `pnpm sim oracle regen`. ac seed 20261031 index 152 nodes 3 elements 4
.options sparse gmin=1e-12 noopac
RG1 1 0 1000000000000
RG2 2 0 1000000000000
VS0 2 s0 0
R0 s0 1 39e-1
VS1 0 s1 0
V1 e1 s1 DC 0 AC 33e1 120
RI1 e1 2 68e-1
VS2 2 s2 0
V2 e2 s2 DC 0 AC 39e1 120
RI2 e2 1 33e-2
VS3 2 s3 0
V3 e3 s3 DC 0 AC 33e0 120
RI3 e3 0 47e-2
.control
set numdgt=17
ac lin 1 60 60
print v(1) v(2)
print i(vs0) i(vs1) i(vs2) i(vs3)
.endc
.end
