controls oracle ac-0057
* Generated (plan F2.7, ADR 0012): do not edit; regenerate with `pnpm sim oracle regen`. ac seed 20261031 index 57 nodes 6 elements 7
.options sparse gmin=1e-12 noopac
RG1 1 0 1000000000000
RG2 2 0 1000000000000
RG3 3 0 1000000000000
RG4 4 0 1000000000000
RG5 5 0 1000000000000
VS0 0 s0 0
V0 e0 s0 DC 0 AC 18e0 120
RI0 e0 4 12e-1
VS1 3 s1 0
R1 s1 1 68e3
VS2 2 s2 0
R2 s2 0 56e2
VS3 3 s3 0
R3 s3 2 10e-1
VS4 2 s4 0
R4 s4 5 18e3
VS5 1 s5 0
R5 s5 5 15e3
VS6 1 s6 0
V6 e6 s6 DC 0 AC 18e-1 -120
RI6 e6 4 10e-3
.control
set numdgt=17
ac lin 1 60 60
print v(1) v(2) v(3) v(4) v(5)
print i(vs0) i(vs1) i(vs2) i(vs3) i(vs4) i(vs5) i(vs6)
.endc
.end
