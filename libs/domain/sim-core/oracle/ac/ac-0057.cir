controls oracle ac-0057
* Generated (plan F2.7, ADR 0012): do not edit; regenerate with `pnpm sim oracle regen`. ac seed 20261031 index 57 nodes 6 elements 7
.options sparse gmin=1e-12 noopac
RG1 1 0 1000000000000
RG2 2 0 1000000000000
RG3 3 0 1000000000000
RG4 4 0 1000000000000
RG5 5 0 1000000000000
VS0 0 s0 0
V0 e0 s0 DC 0 AC 18e0 120
RI0 e0 m0 12e-1
LI0 m0 n0 12e-7
H0 n0 h0 VS6 39e-4
ED0 h0 4 d0 0 -22e-5
F0 0 d0 VS6 1
LD0 d0 0 1
VS1 3 s1 0
R1 s1 1 68e3
VS2 2 s2 0
R2 s2 0 56e2
VS3 3 s3 0
R3 s3 2 10e-1
VS4 2 s4 0
R4 s4 5 18e3
VS5 1 s5 0
R5 s5 5 15e3
VS6 1 s6 0
V6 e6 s6 DC 0 AC 18e-1 -120
RI6 e6 m6 10e-3
LI6 m6 n6 56e-5
H6 n6 h6 VS0 39e-4
ED6 h6 4 d6 0 -22e-5
F6 0 d6 VS0 1
LD6 d6 0 1
.control
set numdgt=17
ac lin 1 60 60
print v(1) v(2) v(3) v(4) v(5)
print i(vs0) i(vs1) i(vs2) i(vs3) i(vs4) i(vs5) i(vs6)
.endc
.end
