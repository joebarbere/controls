controls oracle ac-0494
* Generated (plan F2.7, ADR 0012): do not edit; regenerate with `pnpm sim oracle regen`. ac seed 20261031 index 494 nodes 23 elements 35
.options sparse gmin=1e-12 noopac
RG1 1 0 1000000000000
RG2 2 0 1000000000000
RG3 3 0 1000000000000
RG4 4 0 1000000000000
RG5 5 0 1000000000000
RG6 6 0 1000000000000
RG7 7 0 1000000000000
RG8 8 0 1000000000000
RG9 9 0 1000000000000
RG10 10 0 1000000000000
RG11 11 0 1000000000000
RG12 12 0 1000000000000
RG13 13 0 1000000000000
RG14 14 0 1000000000000
RG15 15 0 1000000000000
RG16 16 0 1000000000000
RG17 17 0 1000000000000
RG18 18 0 1000000000000
RG19 19 0 1000000000000
RG20 20 0 1000000000000
RG21 21 0 1000000000000
RG22 22 0 1000000000000
VS0 8 s0 0
C0 s0 14 15e-5
VS1 7 s1 0
C1 s1 18 18e-6
VS2 0 s2 0
V2 e2 s2 DC 0 AC 22e0 0
RI2 e2 9 39e-3
VS3 4 s3 0
L3 s3 1 12e-3
VS4 18 s4 0
R4 s4 14 56e2
VS5 19 s5 0
L5 s5 17 18e-3
VS6 17 s6 0
C6 s6 7 18e-4
VS7 17 s7 0
R7 s7 6 27e3
VS8 19 s8 0
V8 e8 s8 DC 0 AC 12e1 120
RI8 e8 m8 33e-2
LI8 m8 16 33e-6
VS9 12 s9 0
R9 s9 13 18e1
VS10 19 s10 0
R10 s10 13 22e2
VS11 18 s11 0
L11 s11 21 15e-5
VS12 3 s12 0
L12 s12 19 82e-4
VS13 6 s13 0
C13 s13 15 33e-5
VS14 1 s14 0
V14 e14 s14 DC 0 AC 68e0 180
RI14 e14 m14 18e-3
LI14 m14 5 22e-6
VS15 17 s15 0
V15 e15 s15 DC 0 AC 56e-1 0
RI15 e15 6 12e-1
VS16 2 s16 0
R16 s16 3 10e1
VS17 17 s17 0
V17 e17 s17 DC 0 AC 56e1 120
RI17 e17 20 12e-3
VS18 13 s18 0
C18 s18 4 82e-4
VS19 22 s19 0
R19 s19 20 10e-2
VS20 8 s20 0
C20 s20 1 22e-6
VS21 5 s21 0
L21 s21 1 12e-3
VS22 19 s22 0
R22 s22 10 56e1
VS23 19 s23 0
C23 s23 22 39e-7
VS24 9 s24 0
R24 s24 5 15e-1
VS25 22 s25 0
V25 e25 s25 DC 0 AC 47e1 180
RI25 e25 0 27e-3
VS26 12 s26 0
R26 s26 8 47e3
VS27 9 s27 0
V27 e27 s27 DC 0 AC 10e0 0
RI27 e27 3 10e-3
VS28 21 s28 0
L28 s28 2 47e-5
VS29 11 s29 0
L29 s29 12 15e-5
VS30 0 s30 0
R30 s30 10 39e3
VS31 11 s31 0
L31 s31 15 39e-3
VS32 1 s32 0
R32 s32 16 10e3
VS33 7 s33 0
L33 s33 19 82e-3
VS34 22 s34 0
L34 s34 12 27e-4
.control
set numdgt=17
ac lin 1 60 60
print v(1) v(2) v(3) v(4) v(5) v(6) v(7) v(8) v(9) v(10)
print v(11) v(12) v(13) v(14) v(15) v(16) v(17) v(18) v(19) v(20)
print v(21) v(22)
print i(vs0) i(vs1) i(vs2) i(vs3) i(vs4) i(vs5) i(vs6) i(vs7) i(vs8) i(vs9)
print i(vs10) i(vs11) i(vs12) i(vs13) i(vs14) i(vs15) i(vs16) i(vs17) i(vs18) i(vs19)
print i(vs20) i(vs21) i(vs22) i(vs23) i(vs24) i(vs25) i(vs26) i(vs27) i(vs28) i(vs29)
print i(vs30) i(vs31) i(vs32) i(vs33) i(vs34)
.endc
.end
