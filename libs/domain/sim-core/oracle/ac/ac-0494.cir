controls oracle ac-0494
* Generated (plan F2.7, ADR 0012): do not edit; regenerate with `pnpm sim oracle regen`. ac seed 20261031 index 494 nodes 23 elements 41
.options sparse gmin=1e-12 noopac
RG1 1 0 1000000000000
RG2 2 0 1000000000000
RG3 3 0 1000000000000
RG4 4 0 1000000000000
RG5 5 0 1000000000000
RG6 6 0 1000000000000
RG7 7 0 1000000000000
RG8 8 0 1000000000000
RG9 9 0 1000000000000
RG10 10 0 1000000000000
RG11 11 0 1000000000000
RG12 12 0 1000000000000
RG13 13 0 1000000000000
RG14 14 0 1000000000000
RG15 15 0 1000000000000
RG16 16 0 1000000000000
RG17 17 0 1000000000000
RG18 18 0 1000000000000
RG19 19 0 1000000000000
RG20 20 0 1000000000000
RG21 21 0 1000000000000
RG22 22 0 1000000000000
VS0 21 s0 0
R0 s0 19 27e3
VS1 22 s1 0
L1 s1 0 22e-4
VS2 5 s2 0
C2 s2 20 12e-4
VS3 3 s3 0
C3 s3 0 39e-7
VS4 16 s4 0
R4 s4 8 12e1
VS5 9 s5 0
R5 s5 8 47e-2
VS6 20 s6 0
R6 s6 12 33e-1
VS7 0 s7 0
V7 e7 s7 DC 0 AC 33e-1 -120
RI7 e7 m7 18e-2
LI7 m7 20 10e-6
VS8 20 s8 0
V8 e8 s8 DC 0 AC 33e0 -120
RI8 e8 11 12e-1
VS9 9 s9 0
R9 s9 6 12e2
VS10 10 s10 0
R10 s10 2 18e1
VS11 6 s11 0
V11 e11 s11 DC 0 AC 27e1 180
RI11 e11 m11 39e-3
LI11 m11 5 15e-6
VS12 17 s12 0
L12 s12 0 18e-3
VS13 17 s13 0
V13 e13 s13 DC 0 AC 22e0 0
RI13 e13 6 82e-2
VS14 3 s14 0
L14 s14 17 82e-4
VS15 0 s15 0
L15 s15 4 33e-3
VS16 2 s16 0
V16 e16 s16 DC 0 AC 68e0 180
RI16 e16 1 18e-3
VS17 13 s17 0
R17 s17 0 39e0
VS18 7 s18 0
L18 s18 17 82e-3
VS19 12 s19 0
R19 s19 14 12e1
VS20 16 s20 0
V20 e20 s20 DC 0 AC 10e0 180
RI20 e20 18 15e-2
VS21 7 s21 0
C21 s21 18 18e-6
VS22 7 s22 0
L22 s22 14 12e-3
VS23 18 s23 0
L23 s23 2 18e-5
VS24 9 s24 0
V24 e24 s24 DC 0 AC 10e0 0
RI24 e24 3 10e-3
VS25 7 s25 0
R25 s25 12 39e3
VS26 7 s26 0
L26 s26 12 27e-2
VS27 6 s27 0
V27 e27 s27 DC 0 AC 12e-1 120
RI27 e27 12 47e-1
VS28 7 s28 0
V28 e28 s28 DC 0 AC 10e1 -120
RI28 e28 4 68e-3
VS29 18 s29 0
R29 s29 21 47e0
VS30 17 s30 0
R30 s30 13 22e-1
VS31 18 s31 0
R31 s31 10 10e0
VS32 1 s32 0
C32 s32 4 22e-4
VS33 12 s33 0
V33 e33 s33 DC 0 AC 12e1 0
RI33 e33 m33 56e-1
LI33 m33 9 22e-5
VS34 5 s34 0
L34 s34 16 47e-5
VS35 0 s35 0
L35 s35 13 33e-4
VS36 15 s36 0
V36 e36 s36 DC 0 AC 10e1 0
RI36 e36 m36 82e-3
LI36 m36 19 39e-6
VS37 15 s37 0
C37 s37 2 68e-6
VS38 18 s38 0
C38 s38 15 15e-5
VS39 22 s39 0
C39 s39 15 56e-5
VS40 10 s40 0
C40 s40 11 22e-6
.control
set numdgt=17
ac lin 1 60 60
print v(1) v(2) v(3) v(4) v(5) v(6) v(7) v(8) v(9) v(10)
print v(11) v(12) v(13) v(14) v(15) v(16) v(17) v(18) v(19) v(20)
print v(21) v(22)
print i(vs0) i(vs1) i(vs2) i(vs3) i(vs4) i(vs5) i(vs6) i(vs7) i(vs8) i(vs9)
print i(vs10) i(vs11) i(vs12) i(vs13) i(vs14) i(vs15) i(vs16) i(vs17) i(vs18) i(vs19)
print i(vs20) i(vs21) i(vs22) i(vs23) i(vs24) i(vs25) i(vs26) i(vs27) i(vs28) i(vs29)
print i(vs30) i(vs31) i(vs32) i(vs33) i(vs34) i(vs35) i(vs36) i(vs37) i(vs38) i(vs39)
print i(vs40)
.endc
.end
