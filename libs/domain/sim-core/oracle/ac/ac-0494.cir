controls oracle ac-0494
* Generated (plan F2.7, ADR 0012): do not edit; regenerate with `pnpm sim oracle regen`. ac seed 20261031 index 494 nodes 23 elements 29
.options sparse gmin=1e-12 noopac
RG1 1 0 1000000000000
RG2 2 0 1000000000000
RG3 3 0 1000000000000
RG4 4 0 1000000000000
RG5 5 0 1000000000000
RG6 6 0 1000000000000
RG7 7 0 1000000000000
RG8 8 0 1000000000000
RG9 9 0 1000000000000
RG10 10 0 1000000000000
RG11 11 0 1000000000000
RG12 12 0 1000000000000
RG13 13 0 1000000000000
RG14 14 0 1000000000000
RG15 15 0 1000000000000
RG16 16 0 1000000000000
RG17 17 0 1000000000000
RG18 18 0 1000000000000
RG19 19 0 1000000000000
RG20 20 0 1000000000000
RG21 21 0 1000000000000
RG22 22 0 1000000000000
VS0 22 s0 0
R0 s0 20 10e-2
VS1 11 s1 0
L1 s1 12 15e-5
VS2 7 s2 0
L2 s2 1 82e-3
VS3 6 s3 0
C3 s3 15 33e-5
VS4 17 s4 0
R4 s4 6 27e3
VS5 13 s5 0
C5 s5 4 82e-4
VS6 0 s6 0
V6 e6 s6 DC 0 AC 68e0 180
RI6 e6 5 18e-3
VS7 18 s7 0
R7 s7 14 56e2
VS8 22 s8 0
V8 e8 s8 DC 0 AC 47e1 180
RI8 e8 19 27e-3
VS9 3 s9 0
L9 s9 1 82e-4
VS10 17 s10 0
V10 e10 s10 DC 0 AC 56e-1 0
RI10 e10 6 12e-1
VS11 1 s11 0
L11 s11 17 18e-3
VS12 21 s12 0
L12 s12 2 47e-5
VS13 17 s13 0
C13 s13 7 18e-4
VS14 18 s14 0
L14 s14 21 15e-5
VS15 1 s15 0
R15 s15 10 56e1
VS16 22 s16 0
L16 s16 12 27e-4
VS17 1 s17 0
C17 s17 22 39e-7
VS18 12 s18 0
R18 s18 13 18e1
VS19 1 s19 0
V19 e19 s19 DC 0 AC 12e1 120
RI19 e19 16 33e-2
VS20 1 s20 0
R20 s20 13 22e2
VS21 2 s21 0
R21 s21 3 10e1
VS22 0 s22 0
R22 s22 16 10e3
VS23 17 s23 0
V23 e23 s23 DC 0 AC 56e1 120
RI23 e23 20 12e-3
VS24 9 s24 0
V24 e24 s24 DC 0 AC 10e0 0
RI24 e24 3 10e-3
VS25 7 s25 0
C25 s25 18 18e-6
VS26 8 s26 0
C26 s26 0 22e-6
VS27 5 s27 0
L27 s27 0 12e-3
VS28 4 s28 0
L28 s28 0 12e-3
.control
set numdgt=17
ac lin 1 60 60
print v(1) v(2) v(3) v(4) v(5) v(6) v(7) v(8) v(9) v(10)
print v(11) v(12) v(13) v(14) v(15) v(16) v(17) v(18) v(19) v(20)
print v(21) v(22)
print i(vs0) i(vs1) i(vs2) i(vs3) i(vs4) i(vs5) i(vs6) i(vs7) i(vs8) i(vs9)
print i(vs10) i(vs11) i(vs12) i(vs13) i(vs14) i(vs15) i(vs16) i(vs17) i(vs18) i(vs19)
print i(vs20) i(vs21) i(vs22) i(vs23) i(vs24) i(vs25) i(vs26) i(vs27) i(vs28)
.endc
.end
