controls oracle ac-0395
* Generated (plan F2.7, ADR 0012): do not edit; regenerate with `pnpm sim oracle regen`. ac seed 20261031 index 395 nodes 24 elements 33
.options sparse gmin=1e-12 noopac
RG1 1 0 1000000000000
RG2 2 0 1000000000000
RG3 3 0 1000000000000
RG4 4 0 1000000000000
RG5 5 0 1000000000000
RG6 6 0 1000000000000
RG7 7 0 1000000000000
RG8 8 0 1000000000000
RG9 9 0 1000000000000
RG10 10 0 1000000000000
RG11 11 0 1000000000000
RG12 12 0 1000000000000
RG13 13 0 1000000000000
RG14 14 0 1000000000000
RG15 15 0 1000000000000
RG16 16 0 1000000000000
RG17 17 0 1000000000000
RG18 18 0 1000000000000
RG19 19 0 1000000000000
RG20 20 0 1000000000000
RG21 21 0 1000000000000
RG22 22 0 1000000000000
RG23 23 0 1000000000000
VS0 23 s0 0
C0 s0 21 15e-5
VS1 8 s1 0
R1 s1 16 47e0
VS2 0 s2 0
V2 e2 s2 DC 0 AC 12e-1 120
RI2 e2 m2 10e-2
LI2 m2 11 27e-6
VS3 2 s3 0
R3 s3 13 15e-1
VS4 3 s4 0
L4 s4 8 82e-2
VS5 21 s5 0
L5 s5 2 12e-5
VS6 18 s6 0
V6 e6 s6 DC 0 AC 18e-1 120
RI6 e6 19 18e-2
VS7 1 s7 0
C7 s7 2 68e-5
VS8 3 s8 0
V8 e8 s8 DC 0 AC 18e0 120
RI8 e8 m8 27e-2
LI8 m8 7 12e-5
VS9 10 s9 0
L9 s9 16 47e-5
VS10 19 s10 0
R10 s10 1 47e3
VS11 20 s11 0
R11 s11 7 15e-1
VS12 20 s12 0
V12 e12 s12 DC 0 AC 12e-1 -120
RI12 e12 m12 56e-3
LI12 m12 17 22e-6
VS13 4 s13 0
V13 e13 s13 DC 0 AC 47e1 -120
RI13 e13 15 12e-3
VS14 20 s14 0
L14 s14 6 33e-5
VS15 15 s15 0
C15 s15 7 22e-4
VS16 9 s16 0
V16 e16 s16 DC 0 AC 82e0 0
RI16 e16 21 18e-3
VS17 2 s17 0
V17 e17 s17 DC 0 AC 47e-1 0
RI17 e17 m17 39e-2
LI17 m17 10 82e-5
VS18 12 s18 0
C18 s18 20 47e-6
VS19 21 s19 0
L19 s19 0 22e-5
VS20 2 s20 0
V20 e20 s20 DC 0 AC 56e1 120
RI20 e20 m20 56e-1
LI20 m20 7 10e-5
VS21 18 s21 0
C21 s21 22 56e-6
VS22 21 s22 0
V22 e22 s22 DC 0 AC 56e0 120
RI22 e22 11 33e-2
VS23 20 s23 0
R23 s23 0 18e3
VS24 22 s24 0
C24 s24 12 18e-4
VS25 22 s25 0
R25 s25 17 22e0
VS26 5 s26 0
C26 s26 18 18e-4
VS27 14 s27 0
V27 e27 s27 DC 0 AC 12e1 0
RI27 e27 1 22e-2
VS28 5 s28 0
L28 s28 22 12e-2
VS29 15 s29 0
C29 s29 23 39e-7
VS30 18 s30 0
R30 s30 13 47e2
VS31 4 s31 0
C31 s31 14 22e-7
VS32 9 s32 0
C32 s32 6 10e-5
.control
set numdgt=17
ac lin 1 60 60
print v(1) v(2) v(3) v(4) v(5) v(6) v(7) v(8) v(9) v(10)
print v(11) v(12) v(13) v(14) v(15) v(16) v(17) v(18) v(19) v(20)
print v(21) v(22) v(23)
print i(vs0) i(vs1) i(vs2) i(vs3) i(vs4) i(vs5) i(vs6) i(vs7) i(vs8) i(vs9)
print i(vs10) i(vs11) i(vs12) i(vs13) i(vs14) i(vs15) i(vs16) i(vs17) i(vs18) i(vs19)
print i(vs20) i(vs21) i(vs22) i(vs23) i(vs24) i(vs25) i(vs26) i(vs27) i(vs28) i(vs29)
print i(vs30) i(vs31) i(vs32)
.endc
.end
