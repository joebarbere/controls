controls oracle ac-0395
* Generated (plan F2.7, ADR 0012): do not edit; regenerate with `pnpm sim oracle regen`. ac seed 20261031 index 395 nodes 24 elements 35
.options sparse gmin=1e-12 noopac
RG1 1 0 1000000000000
RG2 2 0 1000000000000
RG3 3 0 1000000000000
RG4 4 0 1000000000000
RG5 5 0 1000000000000
RG6 6 0 1000000000000
RG7 7 0 1000000000000
RG8 8 0 1000000000000
RG9 9 0 1000000000000
RG10 10 0 1000000000000
RG11 11 0 1000000000000
RG12 12 0 1000000000000
RG13 13 0 1000000000000
RG14 14 0 1000000000000
RG15 15 0 1000000000000
RG16 16 0 1000000000000
RG17 17 0 1000000000000
RG18 18 0 1000000000000
RG19 19 0 1000000000000
RG20 20 0 1000000000000
RG21 21 0 1000000000000
RG22 22 0 1000000000000
RG23 23 0 1000000000000
VS0 11 s0 0
C0 s0 18 15e-5
VS1 23 s1 0
C1 s1 2 68e-5
VS2 0 s2 0
V2 e2 s2 DC 0 AC 18e-1 120
RI2 e2 19 18e-2
VS3 12 s3 0
R3 s3 15 39e-1
VS4 13 s4 0
V4 e4 s4 DC 0 AC 68e1 -120
RI4 e4 10 12e-1
VS5 18 s5 0
V5 e5 s5 DC 0 AC 12e-1 -120
RI5 e5 17 56e-3
VS6 21 s6 0
V6 e6 s6 DC 0 AC 27e0 180
RI6 e6 7 22e-2
VS7 9 s7 0
V7 e7 s7 DC 0 AC 33e-1 -120
RI7 e7 10 47e-2
VS8 21 s8 0
V8 e8 s8 DC 0 AC 22e1 0
RI8 e8 13 15e-1
VS9 7 s9 0
C9 s9 17 15e-7
VS10 19 s10 0
R10 s10 1 47e3
VS11 6 s11 0
V11 e11 s11 DC 0 AC 27e0 180
RI11 e11 8 12e-1
VS12 22 s12 0
C12 s12 12 18e-4
VS13 10 s13 0
R13 s13 19 47e-1
VS14 0 s14 0
V14 e14 s14 DC 0 AC 47e-1 -120
RI14 e14 1 12e-2
VS15 17 s15 0
V15 e15 s15 DC 0 AC 12e-1 120
RI15 e15 18 10e-2
VS16 6 s16 0
R16 s16 4 39e0
VS17 18 s17 0
R17 s17 7 15e-1
VS18 5 s18 0
L18 s18 20 39e-2
VS19 12 s19 0
C19 s19 18 47e-6
VS20 22 s20 0
R20 s20 17 22e0
VS21 14 s21 0
L21 s21 0 10e-4
VS22 7 s22 0
L22 s22 11 39e-5
VS23 13 s23 0
L23 s23 23 39e-2
VS24 12 s24 0
R24 s24 5 12e-2
VS25 6 s25 0
C25 s25 2 82e-6
VS26 11 s26 0
V26 e26 s26 DC 0 AC 47e1 -120
RI26 e26 3 12e-3
VS27 15 s27 0
R27 s27 16 10e3
VS28 8 s28 0
V28 e28 s28 DC 0 AC 18e0 120
RI28 e28 2 27e-2
VS29 16 s29 0
L29 s29 9 10e-4
VS30 18 s30 0
L30 s30 6 33e-5
VS31 18 s31 0
R31 s31 20 18e3
VS32 0 s32 0
C32 s32 22 56e-6
VS33 3 s33 0
C33 s33 1 22e-4
VS34 17 s34 0
L34 s34 0 47e-5
.control
set numdgt=17
ac lin 1 60 60
print v(1) v(2) v(3) v(4) v(5) v(6) v(7) v(8) v(9) v(10)
print v(11) v(12) v(13) v(14) v(15) v(16) v(17) v(18) v(19) v(20)
print v(21) v(22) v(23)
print i(vs0) i(vs1) i(vs2) i(vs3) i(vs4) i(vs5) i(vs6) i(vs7) i(vs8) i(vs9)
print i(vs10) i(vs11) i(vs12) i(vs13) i(vs14) i(vs15) i(vs16) i(vs17) i(vs18) i(vs19)
print i(vs20) i(vs21) i(vs22) i(vs23) i(vs24) i(vs25) i(vs26) i(vs27) i(vs28) i(vs29)
print i(vs30) i(vs31) i(vs32) i(vs33) i(vs34)
.endc
.end
