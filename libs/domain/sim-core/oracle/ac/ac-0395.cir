controls oracle ac-0395
* Generated (plan F2.7, ADR 0012): do not edit; regenerate with `pnpm sim oracle regen`. ac seed 20261031 index 395 nodes 24 elements 37
.options sparse gmin=1e-12 noopac
RG1 1 0 1000000000000
RG2 2 0 1000000000000
RG3 3 0 1000000000000
RG4 4 0 1000000000000
RG5 5 0 1000000000000
RG6 6 0 1000000000000
RG7 7 0 1000000000000
RG8 8 0 1000000000000
RG9 9 0 1000000000000
RG10 10 0 1000000000000
RG11 11 0 1000000000000
RG12 12 0 1000000000000
RG13 13 0 1000000000000
RG14 14 0 1000000000000
RG15 15 0 1000000000000
RG16 16 0 1000000000000
RG17 17 0 1000000000000
RG18 18 0 1000000000000
RG19 19 0 1000000000000
RG20 20 0 1000000000000
RG21 21 0 1000000000000
RG22 22 0 1000000000000
RG23 23 0 1000000000000
VS0 0 s0 0
V0 e0 s0 DC 0 AC 27e0 180
RI0 e0 m0 22e-2
LI0 m0 n0 18e-6
H0 n0 h0 VS1 -10e-3
ED0 h0 7 d0 0 15e-7
F0 0 d0 VS1 1
LD0 d0 0 1
VS1 6 s1 0
V1 e1 s1 DC 0 AC 27e0 180
RI1 e1 n1 12e-1
H1 n1 h1 VS0 -10e-3
ED1 h1 8 d1 0 15e-7
F1 0 d1 VS0 1
LD1 d1 0 1
VS2 11 s2 0
C2 s2 21 15e-5
VS3 12 s3 0
R3 s3 5 12e-2
VS4 21 s4 0
R4 s4 20 18e3
VS5 12 s5 0
C5 s5 21 47e-6
VS6 19 s6 0
R6 s6 1 47e3
VS7 21 s7 0
V7 e7 s7 DC 0 AC 12e-1 -120
RI7 e7 m7 56e-3
LI7 m7 17 10e-7
VS8 15 s8 0
R8 s8 16 10e3
VS9 14 s9 0
L9 s9 18 10e-4
VS10 16 s10 0
R10 s10 4 33e1
VS11 18 s11 0
V11 e11 s11 DC 0 AC 18e-1 120
RI11 e11 m11 18e-2
LI11 m11 19 33e-6
VS12 23 s12 0
C12 s12 2 68e-5
VS13 5 s13 0
L13 s13 20 39e-2
VS14 7 s14 0
C14 s14 17 15e-7
VS15 13 s15 0
L15 s15 23 39e-2
VS16 6 s16 0
C16 s16 2 82e-6
VS17 9 s17 0
V17 e17 s17 DC 0 AC 33e-1 -120
RI17 e17 10 47e-2
VS18 13 s18 0
V18 e18 s18 DC 0 AC 68e1 -120
RI18 e18 10 12e-1
VS19 14 s19 0
L19 s19 17 56e-3
VS20 12 s20 0
R20 s20 15 39e-1
VS21 18 s21 0
V21 e21 s21 DC 0 AC 47e-1 -120
RI21 e21 m21 12e-2
LI21 m21 1 33e-6
VS22 3 s22 0
C22 s22 1 22e-4
VS23 17 s23 0
V23 e23 s23 DC 0 AC 12e-1 120
RI23 e23 m23 10e-2
LI23 m23 21 22e-6
VS24 6 s24 0
R24 s24 4 39e0
VS25 22 s25 0
R25 s25 17 22e0
VS26 0 s26 0
V26 e26 s26 DC 0 AC 22e1 0
RI26 e26 m26 15e-1
LI26 m26 13 12e-5
VS27 10 s27 0
R27 s27 19 47e-1
VS28 7 s28 0
L28 s28 11 39e-5
VS29 11 s29 0
V29 e29 s29 DC 0 AC 47e1 -120
RI29 e29 m29 12e-3
LI29 m29 3 82e-6
VS30 17 s30 0
L30 s30 18 47e-5
VS31 21 s31 0
L31 s31 6 33e-5
VS32 18 s32 0
C32 s32 22 56e-6
VS33 16 s33 0
L33 s33 9 10e-4
VS34 8 s34 0
V34 e34 s34 DC 0 AC 18e0 120
RI34 e34 m34 27e-2
LI34 m34 2 22e-5
VS35 21 s35 0
R35 s35 7 15e-1
VS36 22 s36 0
C36 s36 12 18e-4
.control
set numdgt=17
ac lin 1 60 60
print v(1) v(2) v(3) v(4) v(5) v(6) v(7) v(8) v(9) v(10)
print v(11) v(12) v(13) v(14) v(15) v(16) v(17) v(18) v(19) v(20)
print v(21) v(22) v(23)
print i(vs0) i(vs1) i(vs2) i(vs3) i(vs4) i(vs5) i(vs6) i(vs7) i(vs8) i(vs9)
print i(vs10) i(vs11) i(vs12) i(vs13) i(vs14) i(vs15) i(vs16) i(vs17) i(vs18) i(vs19)
print i(vs20) i(vs21) i(vs22) i(vs23) i(vs24) i(vs25) i(vs26) i(vs27) i(vs28) i(vs29)
print i(vs30) i(vs31) i(vs32) i(vs33) i(vs34) i(vs35) i(vs36)
.endc
.end
