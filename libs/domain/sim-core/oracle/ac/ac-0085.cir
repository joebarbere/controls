controls oracle ac-0085
* Generated (plan F2.7, ADR 0012): do not edit; regenerate with `pnpm sim oracle regen`. ac seed 20261031 index 85 nodes 4 elements 6
.options sparse gmin=1e-12 noopac
RG1 1 0 1000000000000
RG2 2 0 1000000000000
RG3 3 0 1000000000000
VS0 1 s0 0
R0 s0 2 56e1
VS1 3 s1 0
L1 s1 0 56e-2
VS2 0 s2 0
V2 e2 s2 DC 0 AC 68e1 0
RI2 e2 2 10e-3
VS3 2 s3 0
R3 s3 3 68e1
VS4 3 s4 0
R4 s4 1 10e2
VS5 3 s5 0
V5 e5 s5 DC 0 AC 33e-1 120
RI5 e5 2 68e-1
.control
set numdgt=17
ac lin 1 60 60
print v(1) v(2) v(3)
print i(vs0) i(vs1) i(vs2) i(vs3) i(vs4) i(vs5)
.endc
.end
