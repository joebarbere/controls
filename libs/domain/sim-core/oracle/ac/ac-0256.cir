controls oracle ac-0256
* Generated (plan F2.7, ADR 0012): do not edit; regenerate with `pnpm sim oracle regen`. ac seed 20261031 index 256 nodes 19 elements 34
.options sparse gmin=1e-12 noopac
RG1 1 0 1000000000000
RG2 2 0 1000000000000
RG3 3 0 1000000000000
RG4 4 0 1000000000000
RG5 5 0 1000000000000
RG6 6 0 1000000000000
RG7 7 0 1000000000000
RG8 8 0 1000000000000
RG9 9 0 1000000000000
RG10 10 0 1000000000000
RG11 11 0 1000000000000
RG12 12 0 1000000000000
RG13 13 0 1000000000000
RG14 14 0 1000000000000
RG15 15 0 1000000000000
RG16 16 0 1000000000000
RG17 17 0 1000000000000
RG18 18 0 1000000000000
VS0 6 s0 0
C0 s0 2 15e-5
VS1 14 s1 0
C1 s1 10 56e-6
VS2 0 s2 0
V2 e2 s2 DC 0 AC 47e0 0
RI2 e2 m2 68e-2
LI2 m2 3 68e-7
VS3 1 s3 0
L3 s3 11 82e-3
VS4 15 s4 0
V4 e4 s4 DC 0 AC 18e1 120
RI4 e4 m4 33e-3
LI4 m4 14 33e-5
VS5 10 s5 0
L5 s5 0 82e-3
VS6 1 s6 0
L6 s6 4 10e-5
VS7 10 s7 0
C7 s7 13 22e-4
VS8 15 s8 0
L8 s8 2 18e-3
VS9 5 s9 0
V9 e9 s9 DC 0 AC 47e-1 0
RI9 e9 m9 33e-2
LI9 m9 15 22e-5
VS10 17 s10 0
L10 s10 5 22e-5
VS11 16 s11 0
L11 s11 6 22e-5
VS12 5 s12 0
V12 e12 s12 DC 0 AC 82e1 180
RI12 e12 0 82e-2
VS13 12 s13 0
V13 e13 s13 DC 0 AC 10e1 0
RI13 e13 m13 18e-1
LI13 m13 4 47e-5
VS14 1 s14 0
C14 s14 7 56e-5
VS15 15 s15 0
R15 s15 8 10e0
VS16 18 s16 0
L16 s16 8 68e-5
VS17 3 s17 0
V17 e17 s17 DC 0 AC 47e-1 180
RI17 e17 13 27e-3
VS18 4 s18 0
L18 s18 1 12e-4
VS19 10 s19 0
L19 s19 18 10e-5
VS20 14 s20 0
V20 e20 s20 DC 0 AC 68e0 0
RI20 e20 m20 27e-2
LI20 m20 2 22e-5
VS21 2 s21 0
R21 s21 7 12e3
VS22 9 s22 0
L22 s22 12 39e-2
VS23 9 s23 0
R23 s23 2 47e-1
VS24 2 s24 0
L24 s24 3 47e-5
VS25 1 s25 0
L25 s25 16 10e-3
VS26 15 s26 0
R26 s26 13 47e-2
VS27 1 s27 0
L27 s27 9 22e-2
VS28 1 s28 0
L28 s28 18 27e-2
VS29 17 s29 0
R29 s29 5 56e-1
VS30 6 s30 0
L30 s30 2 82e-2
VS31 2 s31 0
R31 s31 13 18e0
VS32 11 s32 0
C32 s32 12 56e-5
VS33 15 s33 0
L33 s33 17 33e-3
.control
set numdgt=17
ac lin 1 60 60
print v(1) v(2) v(3) v(4) v(5) v(6) v(7) v(8) v(9) v(10)
print v(11) v(12) v(13) v(14) v(15) v(16) v(17) v(18)
print i(vs0) i(vs1) i(vs2) i(vs3) i(vs4) i(vs5) i(vs6) i(vs7) i(vs8) i(vs9)
print i(vs10) i(vs11) i(vs12) i(vs13) i(vs14) i(vs15) i(vs16) i(vs17) i(vs18) i(vs19)
print i(vs20) i(vs21) i(vs22) i(vs23) i(vs24) i(vs25) i(vs26) i(vs27) i(vs28) i(vs29)
print i(vs30) i(vs31) i(vs32) i(vs33)
.endc
.end
