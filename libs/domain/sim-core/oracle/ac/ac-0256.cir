controls oracle ac-0256
* Generated (plan F2.7, ADR 0012): do not edit; regenerate with `pnpm sim oracle regen`. ac seed 20261031 index 256 nodes 19 elements 26
.options sparse gmin=1e-12 noopac
RG1 1 0 1000000000000
RG2 2 0 1000000000000
RG3 3 0 1000000000000
RG4 4 0 1000000000000
RG5 5 0 1000000000000
RG6 6 0 1000000000000
RG7 7 0 1000000000000
RG8 8 0 1000000000000
RG9 9 0 1000000000000
RG10 10 0 1000000000000
RG11 11 0 1000000000000
RG12 12 0 1000000000000
RG13 13 0 1000000000000
RG14 14 0 1000000000000
RG15 15 0 1000000000000
RG16 16 0 1000000000000
RG17 17 0 1000000000000
RG18 18 0 1000000000000
VS0 18 s0 0
R0 s0 5 39e2
VS1 0 s1 0
V1 e1 s1 DC 0 AC 47e-1 0
RI1 e1 3 27e-1
VS2 15 s2 0
R2 s2 13 47e-2
VS3 2 s3 0
R3 s3 13 18e0
VS4 6 s4 0
L4 s4 2 82e-2
VS5 15 s5 0
R5 s5 8 10e0
VS6 0 s6 0
C6 s6 10 56e-6
VS7 15 s7 0
L7 s7 2 18e-3
VS8 4 s8 0
L8 s8 1 12e-4
VS9 10 s9 0
C9 s9 13 22e-4
VS10 13 s10 0
L10 s10 6 22e-5
VS11 0 s11 0
V11 e11 s11 DC 0 AC 68e0 0
RI11 e11 2 27e-2
VS12 16 s12 0
L12 s12 6 22e-5
VS13 13 s13 0
R13 s13 12 27e0
VS14 11 s14 0
R14 s14 4 22e0
VS15 10 s15 0
L15 s15 17 33e-5
VS16 1 s16 0
L16 s16 4 10e-5
VS17 1 s17 0
C17 s17 14 56e-5
VS18 1 s18 0
L18 s18 18 27e-2
VS19 3 s19 0
V19 e19 s19 DC 0 AC 27e1 -120
RI19 e19 6 22e-1
VS20 5 s20 0
V20 e20 s20 DC 0 AC 82e1 180
RI20 e20 7 82e-2
VS21 2 s21 0
R21 s21 14 12e3
VS22 3 s22 0
L22 s22 16 39e-4
VS23 5 s23 0
V23 e23 s23 DC 0 AC 47e-1 0
RI23 e23 15 33e-2
VS24 10 s24 0
L24 s24 7 82e-3
VS25 9 s25 0
V25 e25 s25 DC 0 AC 12e0 120
RI25 e25 1 22e-2
.control
set numdgt=17
ac lin 1 60 60
print v(1) v(2) v(3) v(4) v(5) v(6) v(7) v(8) v(9) v(10)
print v(11) v(12) v(13) v(14) v(15) v(16) v(17) v(18)
print i(vs0) i(vs1) i(vs2) i(vs3) i(vs4) i(vs5) i(vs6) i(vs7) i(vs8) i(vs9)
print i(vs10) i(vs11) i(vs12) i(vs13) i(vs14) i(vs15) i(vs16) i(vs17) i(vs18) i(vs19)
print i(vs20) i(vs21) i(vs22) i(vs23) i(vs24) i(vs25)
.endc
.end
