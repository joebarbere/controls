controls oracle ac-0256
* Generated (plan F2.7, ADR 0012): do not edit; regenerate with `pnpm sim oracle regen`. ac seed 20261031 index 256 nodes 19 elements 31
.options sparse gmin=1e-12 noopac
RG1 1 0 1000000000000
RG2 2 0 1000000000000
RG3 3 0 1000000000000
RG4 4 0 1000000000000
RG5 5 0 1000000000000
RG6 6 0 1000000000000
RG7 7 0 1000000000000
RG8 8 0 1000000000000
RG9 9 0 1000000000000
RG10 10 0 1000000000000
RG11 11 0 1000000000000
RG12 12 0 1000000000000
RG13 13 0 1000000000000
RG14 14 0 1000000000000
RG15 15 0 1000000000000
RG16 16 0 1000000000000
RG17 17 0 1000000000000
RG18 18 0 1000000000000
VS0 6 s0 0
L0 s0 2 82e-2
VS1 16 s1 0
R1 s1 9 33e-2
VS2 18 s2 0
R2 s2 0 39e2
VS3 15 s3 0
R3 s3 8 10e0
VS4 0 s4 0
V4 e4 s4 DC 0 AC 82e1 180
RI4 e4 7 82e-2
VS5 11 s5 0
R5 s5 4 22e0
VS6 8 s6 0
R6 s6 1 56e3
VS7 16 s7 0
L7 s7 6 22e-5
VS8 1 s8 0
L8 s8 18 27e-2
VS9 13 s9 0
L9 s9 6 22e-5
VS10 2 s10 0
R10 s10 5 12e3
VS11 14 s11 0
C11 s11 10 56e-6
VS12 3 s12 0
V12 e12 s12 DC 0 AC 27e1 -120
RI12 e12 6 22e-1
VS13 18 s13 0
R13 s13 11 68e3
VS14 3 s14 0
L14 s14 16 39e-4
VS15 0 s15 0
V15 e15 s15 DC 0 AC 47e-1 0
RI15 e15 15 33e-2
VS16 15 s16 0
L16 s16 2 18e-3
VS17 4 s17 0
L17 s17 1 12e-4
VS18 15 s18 0
R18 s18 13 47e-2
VS19 1 s19 0
L19 s19 4 10e-5
VS20 10 s20 0
C20 s20 13 22e-4
VS21 10 s21 0
L21 s21 17 33e-5
VS22 1 s22 0
C22 s22 5 56e-5
VS23 2 s23 0
R23 s23 13 18e0
VS24 9 s24 0
V24 e24 s24 DC 0 AC 12e0 120
RI24 e24 1 22e-2
VS25 14 s25 0
V25 e25 s25 DC 0 AC 47e-1 0
RI25 e25 3 27e-1
VS26 4 s26 0
R26 s26 17 68e1
VS27 13 s27 0
R27 s27 12 27e0
VS28 14 s28 0
V28 e28 s28 DC 0 AC 68e0 0
RI28 e28 2 27e-2
VS29 10 s29 0
L29 s29 7 82e-3
VS30 3 s30 0
R30 s30 12 15e-1
.control
set numdgt=17
ac lin 1 60 60
print v(1) v(2) v(3) v(4) v(5) v(6) v(7) v(8) v(9) v(10)
print v(11) v(12) v(13) v(14) v(15) v(16) v(17) v(18)
print i(vs0) i(vs1) i(vs2) i(vs3) i(vs4) i(vs5) i(vs6) i(vs7) i(vs8) i(vs9)
print i(vs10) i(vs11) i(vs12) i(vs13) i(vs14) i(vs15) i(vs16) i(vs17) i(vs18) i(vs19)
print i(vs20) i(vs21) i(vs22) i(vs23) i(vs24) i(vs25) i(vs26) i(vs27) i(vs28) i(vs29)
print i(vs30)
.endc
.end
