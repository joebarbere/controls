controls oracle ac-0452
* Generated (plan F2.7, ADR 0012): do not edit; regenerate with `pnpm sim oracle regen`. ac seed 20261031 index 452 nodes 13 elements 24
.options sparse gmin=1e-12 noopac
RG1 1 0 1000000000000
RG2 2 0 1000000000000
RG3 3 0 1000000000000
RG4 4 0 1000000000000
RG5 5 0 1000000000000
RG6 6 0 1000000000000
RG7 7 0 1000000000000
RG8 8 0 1000000000000
RG9 9 0 1000000000000
RG10 10 0 1000000000000
RG11 11 0 1000000000000
RG12 12 0 1000000000000
VS0 7 s0 0
C0 s0 8 18e-4
VS1 6 s1 0
L1 s1 4 39e-4
VS2 0 s2 0
V2 e2 s2 DC 0 AC 39e1 0
RI2 e2 4 10e-2
VS3 4 s3 0
L3 s3 3 33e-3
VS4 4 s4 0
L4 s4 9 82e-4
VS5 2 s5 0
L5 s5 5 33e-4
VS6 7 s6 0
L6 s6 11 68e-4
VS7 5 s7 0
C7 s7 0 10e-5
VS8 8 s8 0
L8 s8 11 18e-3
VS9 1 s9 0
R9 s9 2 39e-1
VS10 12 s10 0
C10 s10 6 15e-6
VS11 7 s11 0
L11 s11 5 56e-3
VS12 0 s12 0
V12 e12 s12 DC 0 AC 10e0 120
RI12 e12 7 18e-2
VS13 4 s13 0
R13 s13 7 22e0
VS14 4 s14 0
L14 s14 2 56e-5
VS15 9 s15 0
C15 s15 0 18e-7
VS16 2 s16 0
L16 s16 1 33e-2
VS17 5 s17 0
C17 s17 10 18e-5
VS18 9 s18 0
V18 e18 s18 DC 0 AC 18e-1 0
RI18 e18 7 15e-3
VS19 2 s19 0
L19 s19 6 18e-2
VS20 11 s20 0
V20 e20 s20 DC 0 AC 22e1 120
RI20 e20 8 18e-1
VS21 4 s21 0
R21 s21 10 10e0
VS22 9 s22 0
C22 s22 6 27e-7
VS23 9 s23 0
C23 s23 3 15e-5
.control
set numdgt=17
ac lin 1 60 60
print v(1) v(2) v(3) v(4) v(5) v(6) v(7) v(8) v(9) v(10)
print v(11) v(12)
print i(vs0) i(vs1) i(vs2) i(vs3) i(vs4) i(vs5) i(vs6) i(vs7) i(vs8) i(vs9)
print i(vs10) i(vs11) i(vs12) i(vs13) i(vs14) i(vs15) i(vs16) i(vs17) i(vs18) i(vs19)
print i(vs20) i(vs21) i(vs22) i(vs23)
.endc
.end
