controls oracle ac-0497
* Generated (plan F2.7, ADR 0012): do not edit; regenerate with `pnpm sim oracle regen`. ac seed 20261031 index 497 nodes 18 elements 25
.options sparse gmin=1e-12 noopac
RG1 1 0 1000000000000
RG2 2 0 1000000000000
RG3 3 0 1000000000000
RG4 4 0 1000000000000
RG5 5 0 1000000000000
RG6 6 0 1000000000000
RG7 7 0 1000000000000
RG8 8 0 1000000000000
RG9 9 0 1000000000000
RG10 10 0 1000000000000
RG11 11 0 1000000000000
RG12 12 0 1000000000000
RG13 13 0 1000000000000
RG14 14 0 1000000000000
RG15 15 0 1000000000000
RG16 16 0 1000000000000
RG17 17 0 1000000000000
VS0 12 s0 0
L0 s0 17 18e-4
VS1 8 s1 0
R1 s1 10 82e0
VS2 11 s2 0
C2 s2 1 18e-7
VS3 13 s3 0
R3 s3 10 27e0
VS4 8 s4 0
L4 s4 17 39e-3
VS5 0 s5 0
V5 e5 s5 DC 0 AC 18e0 0
RI5 e5 16 22e-1
VS6 16 s6 0
R6 s6 6 68e2
VS7 9 s7 0
C7 s7 0 82e-4
VS8 6 s8 0
R8 s8 1 56e2
VS9 8 s9 0
L9 s9 15 47e-2
VS10 17 s10 0
C10 s10 2 47e-6
VS11 6 s11 0
R11 s11 10 18e2
VS12 1 s12 0
V12 e12 s12 DC 0 AC 33e0 180
RI12 e12 8 22e-3
VS13 5 s13 0
R13 s13 3 56e0
VS14 14 s14 0
V14 e14 s14 DC 0 AC 27e1 -120
RI14 e14 2 33e-1
VS15 0 s15 0
R15 s15 13 22e-1
VS16 4 s16 0
R16 s16 11 82e-2
VS17 6 s17 0
C17 s17 2 27e-7
VS18 14 s18 0
C18 s18 7 10e-5
VS19 7 s19 0
L19 s19 0 56e-4
VS20 3 s20 0
V20 e20 s20 DC 0 AC 15e-1 120
RI20 e20 17 39e-3
VS21 9 s21 0
R21 s21 8 10e0
VS22 1 s22 0
V22 e22 s22 DC 0 AC 47e-1 120
RI22 e22 15 27e-1
VS23 2 s23 0
L23 s23 17 18e-5
VS24 13 s24 0
C24 s24 1 10e-4
.control
set numdgt=17
ac lin 1 60 60
print v(1) v(2) v(3) v(4) v(5) v(6) v(7) v(8) v(9) v(10)
print v(11) v(12) v(13) v(14) v(15) v(16) v(17)
print i(vs0) i(vs1) i(vs2) i(vs3) i(vs4) i(vs5) i(vs6) i(vs7) i(vs8) i(vs9)
print i(vs10) i(vs11) i(vs12) i(vs13) i(vs14) i(vs15) i(vs16) i(vs17) i(vs18) i(vs19)
print i(vs20) i(vs21) i(vs22) i(vs23) i(vs24)
.endc
.end
