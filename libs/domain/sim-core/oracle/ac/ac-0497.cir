controls oracle ac-0497
* Generated (plan F2.7, ADR 0012): do not edit; regenerate with `pnpm sim oracle regen`. ac seed 20261031 index 497 nodes 18 elements 29
.options sparse gmin=1e-12 noopac
RG1 1 0 1000000000000
RG2 2 0 1000000000000
RG3 3 0 1000000000000
RG4 4 0 1000000000000
RG5 5 0 1000000000000
RG6 6 0 1000000000000
RG7 7 0 1000000000000
RG8 8 0 1000000000000
RG9 9 0 1000000000000
RG10 10 0 1000000000000
RG11 11 0 1000000000000
RG12 12 0 1000000000000
RG13 13 0 1000000000000
RG14 14 0 1000000000000
RG15 15 0 1000000000000
RG16 16 0 1000000000000
RG17 17 0 1000000000000
VS0 8 s0 0
L0 s0 15 47e-2
VS1 14 s1 0
C1 s1 2 27e-7
VS2 13 s2 0
C2 s2 1 10e-4
VS3 0 s3 0
V3 e3 s3 DC 0 AC 27e1 -120
RI3 e3 2 33e-1
VS4 16 s4 0
R4 s4 14 68e2
VS5 8 s5 0
L5 s5 17 39e-3
VS6 4 s6 0
R6 s6 11 82e-2
VS7 17 s7 0
C7 s7 2 47e-6
VS8 6 s8 0
V8 e8 s8 DC 0 AC 18e0 0
RI8 e8 16 22e-1
VS9 12 s9 0
C9 s9 6 18e-4
VS10 12 s10 0
L10 s10 17 18e-4
VS11 13 s11 0
R11 s11 3 56e2
VS12 5 s12 0
V12 e12 s12 DC 0 AC 15e1 -120
RI12 e12 17 56e-3
VS13 5 s13 0
R13 s13 3 56e0
VS14 2 s14 0
L14 s14 17 18e-5
VS15 3 s15 0
V15 e15 s15 DC 0 AC 15e-1 120
RI15 e15 17 39e-3
VS16 14 s16 0
R16 s16 10 18e2
VS17 4 s17 0
C17 s17 16 12e-7
VS18 11 s18 0
C18 s18 1 18e-7
VS19 9 s19 0
C19 s19 6 82e-4
VS20 8 s20 0
R20 s20 10 82e0
VS21 9 s21 0
R21 s21 8 10e0
VS22 13 s22 0
R22 s22 10 27e0
VS23 1 s23 0
V23 e23 s23 DC 0 AC 33e0 180
RI23 e23 8 22e-3
VS24 1 s24 0
V24 e24 s24 DC 0 AC 47e-1 120
RI24 e24 15 27e-1
VS25 6 s25 0
R25 s25 13 22e-1
VS26 14 s26 0
R26 s26 1 56e2
VS27 0 s27 0
C27 s27 7 10e-5
VS28 7 s28 0
L28 s28 6 56e-4
.control
set numdgt=17
ac lin 1 60 60
print v(1) v(2) v(3) v(4) v(5) v(6) v(7) v(8) v(9) v(10)
print v(11) v(12) v(13) v(14) v(15) v(16) v(17)
print i(vs0) i(vs1) i(vs2) i(vs3) i(vs4) i(vs5) i(vs6) i(vs7) i(vs8) i(vs9)
print i(vs10) i(vs11) i(vs12) i(vs13) i(vs14) i(vs15) i(vs16) i(vs17) i(vs18) i(vs19)
print i(vs20) i(vs21) i(vs22) i(vs23) i(vs24) i(vs25) i(vs26) i(vs27) i(vs28)
.endc
.end
