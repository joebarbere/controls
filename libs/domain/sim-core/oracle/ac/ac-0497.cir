controls oracle ac-0497
* Generated (plan F2.7, ADR 0012): do not edit; regenerate with `pnpm sim oracle regen`. ac seed 20261031 index 497 nodes 18 elements 32
.options sparse gmin=1e-12 noopac
RG1 1 0 1000000000000
RG2 2 0 1000000000000
RG3 3 0 1000000000000
RG4 4 0 1000000000000
RG5 5 0 1000000000000
RG6 6 0 1000000000000
RG7 7 0 1000000000000
RG8 8 0 1000000000000
RG9 9 0 1000000000000
RG10 10 0 1000000000000
RG11 11 0 1000000000000
RG12 12 0 1000000000000
RG13 13 0 1000000000000
RG14 14 0 1000000000000
RG15 15 0 1000000000000
RG16 16 0 1000000000000
RG17 17 0 1000000000000
VS0 3 s0 0
C0 s0 5 82e-4
VS1 4 s1 0
R1 s1 14 47e-1
VS2 0 s2 0
V2 e2 s2 DC 0 AC 15e0 180
RI2 e2 10 22e-3
VS3 12 s3 0
R3 s3 3 22e0
VS4 8 s4 0
V4 e4 s4 DC 0 AC 82e0 180
RI4 e4 11 22e-3
VS5 1 s5 0
C5 s5 15 10e-4
VS6 17 s6 0
L6 s6 15 22e-4
VS7 9 s7 0
R7 s7 1 12e1
VS8 7 s8 0
C8 s8 0 10e-7
VS9 0 s9 0
R9 s9 9 10e-1
VS10 16 s10 0
L10 s10 3 68e-5
VS11 12 s11 0
L11 s11 0 33e-5
VS12 5 s12 0
R12 s12 10 15e2
VS13 1 s13 0
R13 s13 13 10e1
VS14 16 s14 0
C14 s14 10 15e-7
VS15 11 s15 0
R15 s15 13 27e0
VS16 6 s16 0
V16 e16 s16 DC 0 AC 18e0 0
RI16 e16 m16 22e-1
LI16 m16 0 82e-7
VS17 13 s17 0
R17 s17 16 18e-2
VS18 6 s18 0
R18 s18 0 22e-2
VS19 3 s19 0
C19 s19 6 68e-4
VS20 14 s20 0
C20 s20 5 27e-5
VS21 16 s21 0
R21 s21 4 15e0
VS22 1 s22 0
V22 e22 s22 DC 0 AC 56e-1 180
RI22 e22 7 27e-3
VS23 15 s23 0
L23 s23 8 39e-2
VS24 1 s24 0
V24 e24 s24 DC 0 AC 27e1 -120
RI24 e24 14 82e-2
VS25 2 s25 0
V25 e25 s25 DC 0 AC 27e1 120
RI25 e25 m25 56e-3
LI25 m25 17 33e-7
VS26 0 s26 0
V26 e26 s26 DC 0 AC 33e0 180
RI26 e26 12 22e-3
VS27 11 s27 0
L27 s27 1 47e-4
VS28 5 s28 0
V28 e28 s28 DC 0 AC 27e1 -120
RI28 e28 m28 33e-1
LI28 m28 11 27e-7
VS29 8 s29 0
V29 e29 s29 DC 0 AC 15e0 120
RI29 e29 11 12e-2
VS30 2 s30 0
C30 s30 16 12e-6
VS31 0 s31 0
R31 s31 16 68e2
.control
set numdgt=17
ac lin 1 60 60
print v(1) v(2) v(3) v(4) v(5) v(6) v(7) v(8) v(9) v(10)
print v(11) v(12) v(13) v(14) v(15) v(16) v(17)
print i(vs0) i(vs1) i(vs2) i(vs3) i(vs4) i(vs5) i(vs6) i(vs7) i(vs8) i(vs9)
print i(vs10) i(vs11) i(vs12) i(vs13) i(vs14) i(vs15) i(vs16) i(vs17) i(vs18) i(vs19)
print i(vs20) i(vs21) i(vs22) i(vs23) i(vs24) i(vs25) i(vs26) i(vs27) i(vs28) i(vs29)
print i(vs30) i(vs31)
.endc
.end
