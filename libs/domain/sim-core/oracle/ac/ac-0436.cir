controls oracle ac-0436
* Generated (plan F2.7, ADR 0012): do not edit; regenerate with `pnpm sim oracle regen`. ac seed 20261031 index 436 nodes 29 elements 55
.options sparse gmin=1e-12 noopac
RG1 1 0 1000000000000
RG2 2 0 1000000000000
RG3 3 0 1000000000000
RG4 4 0 1000000000000
RG5 5 0 1000000000000
RG6 6 0 1000000000000
RG7 7 0 1000000000000
RG8 8 0 1000000000000
RG9 9 0 1000000000000
RG10 10 0 1000000000000
RG11 11 0 1000000000000
RG12 12 0 1000000000000
RG13 13 0 1000000000000
RG14 14 0 1000000000000
RG15 15 0 1000000000000
RG16 16 0 1000000000000
RG17 17 0 1000000000000
RG18 18 0 1000000000000
RG19 19 0 1000000000000
RG20 20 0 1000000000000
RG21 21 0 1000000000000
RG22 22 0 1000000000000
RG23 23 0 1000000000000
RG24 24 0 1000000000000
RG25 25 0 1000000000000
RG26 26 0 1000000000000
RG27 27 0 1000000000000
RG28 28 0 1000000000000
VS0 16 s0 0
C0 s0 21 39e-5
VS1 16 s1 0
L1 s1 8 12e-3
VS2 8 s2 0
L2 s2 0 47e-4
VS3 10 s3 0
R3 s3 28 15e1
VS4 0 s4 0
V4 e4 s4 DC 0 AC 18e-1 180
RI4 e4 m4 18e-1
LI4 m4 n4 12e-7
H4 n4 h4 VS6 -10e-2
ED4 h4 25 d4 0 12e-7
F4 0 d4 VS6 1
LD4 d4 0 1
VS5 20 s5 0
L5 s5 27 39e-4
VS6 0 s6 0
V6 e6 s6 DC 0 AC 82e0 -120
RI6 e6 m6 10e-1
LI6 m6 n6 33e-5
H6 n6 h6 VS4 -10e-2
ED6 h6 26 d6 0 12e-7
F6 0 d6 VS4 1
LD6 d6 0 1
VS7 1 s7 0
R7 s7 28 27e2
VS8 27 s8 0
R8 s8 3 15e2
VS9 1 s9 0
C9 s9 6 15e-6
VS10 6 s10 0
C10 s10 24 12e-4
VS11 8 s11 0
L11 s11 2 15e-5
VS12 4 s12 0
R12 s12 20 68e3
VS13 12 s13 0
R13 s13 2 33e0
VS14 26 s14 0
L14 s14 12 56e-4
VS15 27 s15 0
V15 e15 s15 DC 0 AC 56e1 180
RI15 e15 m15 33e-1
LI15 m15 18 12e-7
VS16 24 s16 0
L16 s16 17 47e-4
VS17 13 s17 0
L17 s17 14 47e-5
VS18 25 s18 0
C18 s18 5 12e-4
VS19 14 s19 0
R19 s19 15 12e2
VS20 22 s20 0
L20 s20 19 12e-3
VS21 5 s21 0
V21 e21 s21 DC 0 AC 33e1 -120
RI21 e21 m21 15e-1
LI21 m21 26 18e-5
VS22 15 s22 0
R22 s22 2 56e2
VS23 5 s23 0
L23 s23 25 33e-3
VS24 21 s24 0
R24 s24 25 39e1
VS25 24 s25 0
V25 e25 s25 DC 0 AC 82e0 180
RI25 e25 26 18e-3
VS26 28 s26 0
L26 s26 15 82e-3
VS27 8 s27 0
V27 e27 s27 DC 0 AC 68e0 -120
RI27 e27 24 47e-2
VS28 11 s28 0
L28 s28 27 33e-4
VS29 4 s29 0
V29 e29 s29 DC 0 AC 12e0 180
RI29 e29 15 33e-2
VS30 5 s30 0
L30 s30 23 68e-5
VS31 21 s31 0
R31 s31 12 22e3
VS32 26 s32 0
R32 s32 18 15e-1
VS33 3 s33 0
L33 s33 16 56e-4
VS34 21 s34 0
C34 s34 18 33e-6
VS35 9 s35 0
C35 s35 13 47e-7
VS36 11 s36 0
R36 s36 28 82e3
VS37 21 s37 0
R37 s37 19 15e3
VS38 10 s38 0
R38 s38 9 15e-1
VS39 20 s39 0
V39 e39 s39 DC 0 AC 10e0 0
RI39 e39 15 39e-3
VS40 17 s40 0
V40 e40 s40 DC 0 AC 33e0 0
RI40 e40 m40 10e-2
LI40 m40 22 68e-6
VS41 12 s41 0
R41 s41 14 12e-2
VS42 15 s42 0
V42 e42 s42 DC 0 AC 33e1 0
RI42 e42 m42 47e-1
LI42 m42 17 12e-6
VS43 13 s43 0
L43 s43 20 12e-3
VS44 7 s44 0
R44 s44 2 27e-2
VS45 24 s45 0
C45 s45 5 12e-4
VS46 13 s46 0
C46 s46 7 68e-6
VS47 15 s47 0
L47 s47 19 15e-5
VS48 10 s48 0
C48 s48 21 10e-6
VS49 27 s49 0
R49 s49 2 56e-2
VS50 2 s50 0
R50 s50 6 39e0
VS51 21 s51 0
L51 s51 13 39e-3
VS52 23 s52 0
R52 s52 15 47e1
VS53 21 s53 0
V53 e53 s53 DC 0 AC 68e0 0
RI53 e53 m53 27e-3
LI53 m53 2 22e-5
VS54 24 s54 0
R54 s54 21 68e2
.control
set numdgt=17
ac lin 1 60 60
print v(1) v(2) v(3) v(4) v(5) v(6) v(7) v(8) v(9) v(10)
print v(11) v(12) v(13) v(14) v(15) v(16) v(17) v(18) v(19) v(20)
print v(21) v(22) v(23) v(24) v(25) v(26) v(27) v(28)
print i(vs0) i(vs1) i(vs2) i(vs3) i(vs4) i(vs5) i(vs6) i(vs7) i(vs8) i(vs9)
print i(vs10) i(vs11) i(vs12) i(vs13) i(vs14) i(vs15) i(vs16) i(vs17) i(vs18) i(vs19)
print i(vs20) i(vs21) i(vs22) i(vs23) i(vs24) i(vs25) i(vs26) i(vs27) i(vs28) i(vs29)
print i(vs30) i(vs31) i(vs32) i(vs33) i(vs34) i(vs35) i(vs36) i(vs37) i(vs38) i(vs39)
print i(vs40) i(vs41) i(vs42) i(vs43) i(vs44) i(vs45) i(vs46) i(vs47) i(vs48) i(vs49)
print i(vs50) i(vs51) i(vs52) i(vs53) i(vs54)
.endc
.end
