controls oracle ac-0436
* Generated (plan F2.7, ADR 0012): do not edit; regenerate with `pnpm sim oracle regen`. ac seed 20261031 index 436 nodes 29 elements 52
.options sparse gmin=1e-12 noopac
RG1 1 0 1000000000000
RG2 2 0 1000000000000
RG3 3 0 1000000000000
RG4 4 0 1000000000000
RG5 5 0 1000000000000
RG6 6 0 1000000000000
RG7 7 0 1000000000000
RG8 8 0 1000000000000
RG9 9 0 1000000000000
RG10 10 0 1000000000000
RG11 11 0 1000000000000
RG12 12 0 1000000000000
RG13 13 0 1000000000000
RG14 14 0 1000000000000
RG15 15 0 1000000000000
RG16 16 0 1000000000000
RG17 17 0 1000000000000
RG18 18 0 1000000000000
RG19 19 0 1000000000000
RG20 20 0 1000000000000
RG21 21 0 1000000000000
RG22 22 0 1000000000000
RG23 23 0 1000000000000
RG24 24 0 1000000000000
RG25 25 0 1000000000000
RG26 26 0 1000000000000
RG27 27 0 1000000000000
RG28 28 0 1000000000000
VS0 26 s0 0
R0 s0 13 22e3
VS1 27 s1 0
R1 s1 16 56e-2
VS2 26 s2 0
R2 s2 3 10e0
VS3 26 s3 0
R3 s3 20 15e1
VS4 4 s4 0
L4 s4 22 39e-4
VS5 20 s5 0
C5 s5 16 47e-7
VS6 11 s6 0
C6 s6 13 10e-6
VS7 25 s7 0
L7 s7 3 68e-5
VS8 11 s8 0
R8 s8 21 27e3
VS9 24 s9 0
R9 s9 6 22e3
VS10 12 s10 0
R10 s10 16 33e0
VS11 15 s11 0
L11 s11 24 56e-4
VS12 8 s12 0
L12 s12 14 33e-4
VS13 5 s13 0
C13 s13 24 18e-5
VS14 20 s14 0
R14 s14 16 12e3
VS15 7 s15 0
C15 s15 17 33e-5
VS16 15 s16 0
C16 s16 28 12e-4
VS17 0 s17 0
V17 e17 s17 DC 0 AC 33e0 0
RI17 e17 m17 10e-2
LI17 m17 10 22e-7
VS18 3 s18 0
V18 e18 s18 DC 0 AC 22e-1 180
RI18 e18 m18 22e-1
LI18 m18 0 27e-7
VS19 23 s19 0
R19 s19 14 12e-2
VS20 13 s20 0
R20 s20 15 15e1
VS21 26 s21 0
R21 s21 14 68e1
VS22 25 s22 0
R22 s22 21 82e0
VS23 0 s23 0
L23 s23 12 10e-4
VS24 19 s24 0
R24 s24 21 27e2
VS25 0 s25 0
L25 s25 8 47e-4
VS26 1 s26 0
V26 e26 s26 DC 0 AC 39e1 180
RI26 e26 18 12e-2
VS27 6 s27 0
R27 s27 13 47e2
VS28 23 s28 0
R28 s28 10 10e-2
VS29 26 s29 0
R29 s29 5 15e-1
VS30 16 s30 0
R30 s30 19 22e0
VS31 12 s31 0
V31 e31 s31 DC 0 AC 12e0 120
RI31 e31 m31 15e-1
LI31 m31 16 39e-6
VS32 16 s32 0
R32 s32 24 22e-1
VS33 22 s33 0
L33 s33 2 18e-3
VS34 7 s34 0
L34 s34 16 33e-4
VS35 4 s35 0
V35 e35 s35 DC 0 AC 82e0 180
RI35 e35 17 39e-3
VS36 17 s36 0
C36 s36 21 22e-7
VS37 21 s37 0
V37 e37 s37 DC 0 AC 68e0 0
RI37 e37 16 27e-3
VS38 28 s38 0
V38 e38 s38 DC 0 AC 18e-1 180
RI38 e38 18 18e-1
VS39 22 s39 0
C39 s39 3 33e-6
VS40 22 s40 0
L40 s40 1 82e-4
VS41 8 s41 0
V41 e41 s41 DC 0 AC 68e-1 120
RI41 e41 27 10e-2
VS42 14 s42 0
L42 s42 27 27e-4
VS43 1 s43 0
C43 s43 7 47e-7
VS44 2 s44 0
V44 e44 s44 DC 0 AC 22e0 -120
RI44 e44 26 22e-3
VS45 19 s45 0
L45 s45 16 15e-3
VS46 19 s46 0
C46 s46 9 18e-5
VS47 1 s47 0
R47 s47 0 82e-1
VS48 2 s48 0
V48 e48 s48 DC 0 AC 15e-1 120
RI48 e48 3 33e-1
VS49 12 s49 0
L49 s49 9 15e-4
VS50 15 s50 0
C50 s50 21 22e-6
VS51 14 s51 0
C51 s51 13 68e-7
.control
set numdgt=17
ac lin 1 60 60
print v(1) v(2) v(3) v(4) v(5) v(6) v(7) v(8) v(9) v(10)
print v(11) v(12) v(13) v(14) v(15) v(16) v(17) v(18) v(19) v(20)
print v(21) v(22) v(23) v(24) v(25) v(26) v(27) v(28)
print i(vs0) i(vs1) i(vs2) i(vs3) i(vs4) i(vs5) i(vs6) i(vs7) i(vs8) i(vs9)
print i(vs10) i(vs11) i(vs12) i(vs13) i(vs14) i(vs15) i(vs16) i(vs17) i(vs18) i(vs19)
print i(vs20) i(vs21) i(vs22) i(vs23) i(vs24) i(vs25) i(vs26) i(vs27) i(vs28) i(vs29)
print i(vs30) i(vs31) i(vs32) i(vs33) i(vs34) i(vs35) i(vs36) i(vs37) i(vs38) i(vs39)
print i(vs40) i(vs41) i(vs42) i(vs43) i(vs44) i(vs45) i(vs46) i(vs47) i(vs48) i(vs49)
print i(vs50) i(vs51)
.endc
.end
