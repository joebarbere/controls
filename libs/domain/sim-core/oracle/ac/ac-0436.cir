controls oracle ac-0436
* Generated (plan F2.7, ADR 0012): do not edit; regenerate with `pnpm sim oracle regen`. ac seed 20261031 index 436 nodes 29 elements 53
.options sparse gmin=1e-12 noopac
RG1 1 0 1000000000000
RG2 2 0 1000000000000
RG3 3 0 1000000000000
RG4 4 0 1000000000000
RG5 5 0 1000000000000
RG6 6 0 1000000000000
RG7 7 0 1000000000000
RG8 8 0 1000000000000
RG9 9 0 1000000000000
RG10 10 0 1000000000000
RG11 11 0 1000000000000
RG12 12 0 1000000000000
RG13 13 0 1000000000000
RG14 14 0 1000000000000
RG15 15 0 1000000000000
RG16 16 0 1000000000000
RG17 17 0 1000000000000
RG18 18 0 1000000000000
RG19 19 0 1000000000000
RG20 20 0 1000000000000
RG21 21 0 1000000000000
RG22 22 0 1000000000000
RG23 23 0 1000000000000
RG24 24 0 1000000000000
RG25 25 0 1000000000000
RG26 26 0 1000000000000
RG27 27 0 1000000000000
RG28 28 0 1000000000000
VS0 0 s0 0
V0 e0 s0 DC 0 AC 56e1 180
RI0 e0 18 33e-1
VS1 13 s1 0
C1 s1 7 68e-6
VS2 24 s2 0
L2 s2 17 47e-4
VS3 5 s3 0
L3 s3 23 68e-5
VS4 25 s4 0
C4 s4 5 12e-4
VS5 10 s5 0
R5 s5 28 15e1
VS6 24 s6 0
R6 s6 21 68e2
VS7 4 s7 0
V7 e7 s7 DC 0 AC 12e0 180
RI7 e7 15 33e-2
VS8 2 s8 0
V8 e8 s8 DC 0 AC 82e0 -120
RI8 e8 26 10e-1
VS9 6 s9 0
C9 s9 24 12e-4
VS10 7 s10 0
R10 s10 27 27e-2
VS11 21 s11 0
C11 s11 18 33e-6
VS12 21 s12 0
R12 s12 19 15e3
VS13 28 s13 0
L13 s13 15 82e-3
VS14 8 s14 0
L14 s14 27 15e-5
VS15 1 s15 0
C15 s15 6 15e-6
VS16 21 s16 0
R16 s16 12 22e3
VS17 26 s17 0
R17 s17 18 15e-1
VS18 16 s18 0
L18 s18 8 12e-3
VS19 0 s19 0
R19 s19 27 56e-2
VS20 5 s20 0
V20 e20 s20 DC 0 AC 33e1 -120
RI20 e20 26 15e-1
VS21 23 s21 0
R21 s21 15 47e1
VS22 21 s22 0
L22 s22 13 39e-3
VS23 21 s23 0
V23 e23 s23 DC 0 AC 68e0 0
RI23 e23 27 27e-3
VS24 15 s24 0
L24 s24 19 15e-5
VS25 12 s25 0
R25 s25 27 33e0
VS26 1 s26 0
R26 s26 28 27e2
VS27 13 s27 0
L27 s27 14 47e-5
VS28 9 s28 0
C28 s28 13 47e-7
VS29 15 s29 0
R29 s29 27 56e2
VS30 24 s30 0
V30 e30 s30 DC 0 AC 82e0 180
RI30 e30 26 18e-3
VS31 0 s31 0
R31 s31 3 15e2
VS32 8 s32 0
L32 s32 2 47e-4
VS33 8 s33 0
V33 e33 s33 DC 0 AC 68e0 -120
RI33 e33 24 47e-2
VS34 10 s34 0
C34 s34 21 10e-6
VS35 15 s35 0
V35 e35 s35 DC 0 AC 33e1 0
RI35 e35 17 47e-1
VS36 16 s36 0
C36 s36 21 39e-5
VS37 11 s37 0
R37 s37 28 82e3
VS38 10 s38 0
R38 s38 9 15e-1
VS39 24 s39 0
C39 s39 5 12e-4
VS40 20 s40 0
L40 s40 0 39e-4
VS41 3 s41 0
L41 s41 16 56e-4
VS42 2 s42 0
V42 e42 s42 DC 0 AC 18e-1 180
RI42 e42 25 18e-1
VS43 26 s43 0
L43 s43 12 56e-4
VS44 27 s44 0
R44 s44 6 39e0
VS45 11 s45 0
L45 s45 0 33e-4
VS46 13 s46 0
L46 s46 20 12e-3
VS47 20 s47 0
V47 e47 s47 DC 0 AC 10e0 0
RI47 e47 15 39e-3
VS48 14 s48 0
R48 s48 15 12e2
VS49 5 s49 0
L49 s49 25 33e-3
VS50 21 s50 0
R50 s50 25 39e1
VS51 17 s51 0
V51 e51 s51 DC 0 AC 33e0 0
RI51 e51 22 10e-2
VS52 12 s52 0
R52 s52 14 12e-2
.control
set numdgt=17
ac lin 1 60 60
print v(1) v(2) v(3) v(4) v(5) v(6) v(7) v(8) v(9) v(10)
print v(11) v(12) v(13) v(14) v(15) v(16) v(17) v(18) v(19) v(20)
print v(21) v(22) v(23) v(24) v(25) v(26) v(27) v(28)
print i(vs0) i(vs1) i(vs2) i(vs3) i(vs4) i(vs5) i(vs6) i(vs7) i(vs8) i(vs9)
print i(vs10) i(vs11) i(vs12) i(vs13) i(vs14) i(vs15) i(vs16) i(vs17) i(vs18) i(vs19)
print i(vs20) i(vs21) i(vs22) i(vs23) i(vs24) i(vs25) i(vs26) i(vs27) i(vs28) i(vs29)
print i(vs30) i(vs31) i(vs32) i(vs33) i(vs34) i(vs35) i(vs36) i(vs37) i(vs38) i(vs39)
print i(vs40) i(vs41) i(vs42) i(vs43) i(vs44) i(vs45) i(vs46) i(vs47) i(vs48) i(vs49)
print i(vs50) i(vs51) i(vs52)
.endc
.end
