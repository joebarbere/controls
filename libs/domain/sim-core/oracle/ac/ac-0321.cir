controls oracle ac-0321
* Generated (plan F2.7, ADR 0012): do not edit; regenerate with `pnpm sim oracle regen`. ac seed 20261031 index 321 nodes 8 elements 15
.options sparse gmin=1e-12 noopac
RG1 1 0 1000000000000
RG2 2 0 1000000000000
RG3 3 0 1000000000000
RG4 4 0 1000000000000
RG5 5 0 1000000000000
RG6 6 0 1000000000000
RG7 7 0 1000000000000
VS0 4 s0 0
C0 s0 6 82e-6
VS1 0 s1 0
V1 e1 s1 DC 0 AC 10e1 180
RI1 e1 m1 22e-3
LI1 m1 2 15e-5
VS2 2 s2 0
R2 s2 4 18e1
VS3 1 s3 0
C3 s3 7 47e-5
VS4 7 s4 0
R4 s4 0 82e0
VS5 1 s5 0
C5 s5 5 47e-4
VS6 2 s6 0
C6 s6 3 39e-5
VS7 5 s7 0
R7 s7 3 56e1
VS8 4 s8 0
V8 e8 s8 DC 0 AC 39e0 180
RI8 e8 2 47e-2
VS9 0 s9 0
R9 s9 5 82e2
VS10 4 s10 0
R10 s10 6 27e1
VS11 6 s11 0
V11 e11 s11 DC 0 AC 18e-1 -120
RI11 e11 m11 68e-1
LI11 m11 1 82e-5
VS12 6 s12 0
R12 s12 2 27e-1
VS13 1 s13 0
R13 s13 2 22e-2
VS14 1 s14 0
C14 s14 6 82e-5
.control
set numdgt=17
ac lin 1 60 60
print v(1) v(2) v(3) v(4) v(5) v(6) v(7)
print i(vs0) i(vs1) i(vs2) i(vs3) i(vs4) i(vs5) i(vs6) i(vs7) i(vs8) i(vs9)
print i(vs10) i(vs11) i(vs12) i(vs13) i(vs14)
.endc
.end
