controls oracle ac-0321
* Generated (plan F2.7, ADR 0012): do not edit; regenerate with `pnpm sim oracle regen`. ac seed 20261031 index 321 nodes 8 elements 14
.options sparse gmin=1e-12 noopac
RG1 1 0 1000000000000
RG2 2 0 1000000000000
RG3 3 0 1000000000000
RG4 4 0 1000000000000
RG5 5 0 1000000000000
RG6 6 0 1000000000000
RG7 7 0 1000000000000
VS0 0 s0 0
R0 s0 6 27e1
VS1 2 s1 0
C1 s1 3 18e-4
VS2 0 s2 0
C2 s2 6 82e-6
VS3 1 s3 0
R3 s3 2 22e-2
VS4 3 s4 0
R4 s4 5 82e2
VS5 1 s5 0
C5 s5 7 47e-5
VS6 0 s6 0
C6 s6 3 33e-4
VS7 6 s7 0
L7 s7 7 18e-2
VS8 1 s8 0
C8 s8 5 47e-4
VS9 1 s9 0
C9 s9 6 82e-5
VS10 0 s10 0
V10 e10 s10 DC 0 AC 39e0 180
RI10 e10 2 47e-2
VS11 5 s11 0
R11 s11 4 56e1
VS12 2 s12 0
C12 s12 5 15e-4
VS13 5 s13 0
V13 e13 s13 DC 0 AC 12e1 180
RI13 e13 6 15e-2
.control
set numdgt=17
ac lin 1 60 60
print v(1) v(2) v(3) v(4) v(5) v(6) v(7)
print i(vs0) i(vs1) i(vs2) i(vs3) i(vs4) i(vs5) i(vs6) i(vs7) i(vs8) i(vs9)
print i(vs10) i(vs11) i(vs12) i(vs13)
.endc
.end
