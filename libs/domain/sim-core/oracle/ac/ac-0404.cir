controls oracle ac-0404
* Generated (plan F2.7, ADR 0012): do not edit; regenerate with `pnpm sim oracle regen`. ac seed 20261031 index 404 nodes 15 elements 16
.options sparse gmin=1e-12 noopac
RG1 1 0 1000000000000
RG2 2 0 1000000000000
RG3 3 0 1000000000000
RG4 4 0 1000000000000
RG5 5 0 1000000000000
RG6 6 0 1000000000000
RG7 7 0 1000000000000
RG8 8 0 1000000000000
RG9 9 0 1000000000000
RG10 10 0 1000000000000
RG11 11 0 1000000000000
RG12 12 0 1000000000000
RG13 13 0 1000000000000
RG14 14 0 1000000000000
VS0 0 s0 0
V0 e0 s0 DC 0 AC 15e1 0
RI0 e0 7 18e-2
VS1 3 s1 0
R1 s1 14 18e2
VS2 6 s2 0
R2 s2 0 12e-1
VS3 7 s3 0
L3 s3 8 56e-2
VS4 10 s4 0
R4 s4 9 27e3
VS5 2 s5 0
L5 s5 10 39e-2
VS6 8 s6 0
R6 s6 1 82e-1
VS7 1 s7 0
C7 s7 3 68e-7
VS8 2 s8 0
C8 s8 14 33e-6
VS9 11 s9 0
R9 s9 2 15e0
VS10 6 s10 0
R10 s10 14 18e2
VS11 13 s11 0
L11 s11 6 15e-3
VS12 2 s12 0
R12 s12 7 15e1
VS13 11 s13 0
V13 e13 s13 DC 0 AC 56e0 -120
RI13 e13 4 56e-3
VS14 7 s14 0
L14 s14 12 12e-4
VS15 5 s15 0
L15 s15 14 12e-5
.control
set numdgt=17
ac lin 1 60 60
print v(1) v(2) v(3) v(4) v(5) v(6) v(7) v(8) v(9) v(10)
print v(11) v(12) v(13) v(14)
print i(vs0) i(vs1) i(vs2) i(vs3) i(vs4) i(vs5) i(vs6) i(vs7) i(vs8) i(vs9)
print i(vs10) i(vs11) i(vs12) i(vs13) i(vs14) i(vs15)
.endc
.end
