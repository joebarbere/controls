controls oracle ac-0404
* Generated (plan F2.7, ADR 0012): do not edit; regenerate with `pnpm sim oracle regen`. ac seed 20261031 index 404 nodes 15 elements 23
.options sparse gmin=1e-12 noopac
RG1 1 0 1000000000000
RG2 2 0 1000000000000
RG3 3 0 1000000000000
RG4 4 0 1000000000000
RG5 5 0 1000000000000
RG6 6 0 1000000000000
RG7 7 0 1000000000000
RG8 8 0 1000000000000
RG9 9 0 1000000000000
RG10 10 0 1000000000000
RG11 11 0 1000000000000
RG12 12 0 1000000000000
RG13 13 0 1000000000000
RG14 14 0 1000000000000
VS0 0 s0 0
V0 e0 s0 DC 0 AC 15e1 120
RI0 e0 m0 39e-1
LI0 m0 1 27e-5
VS1 0 s1 0
R1 s1 10 27e1
VS2 8 s2 0
R2 s2 1 82e-1
VS3 10 s3 0
V3 e3 s3 DC 0 AC 68e1 -120
RI3 e3 m3 33e-2
LI3 m3 13 22e-5
VS4 1 s4 0
R4 s4 14 10e-2
VS5 11 s5 0
R5 s5 0 68e-1
VS6 6 s6 0
R6 s6 7 15e1
VS7 7 s7 0
R7 s7 4 47e2
VS8 9 s8 0
V8 e8 s8 DC 0 AC 56e0 180
RI8 e8 4 18e-2
VS9 5 s9 0
R9 s9 0 18e-2
VS10 9 s10 0
L10 s10 11 27e-2
VS11 6 s11 0
V11 e11 s11 DC 0 AC 33e-1 120
RI11 e11 m11 15e-3
LI11 m11 0 33e-5
VS12 8 s12 0
R12 s12 0 22e1
VS13 3 s13 0
R13 s13 14 33e1
VS14 6 s14 0
C14 s14 14 33e-6
VS15 2 s15 0
V15 e15 s15 DC 0 AC 27e-1 -120
RI15 e15 14 18e-1
VS16 2 s16 0
V16 e16 s16 DC 0 AC 15e1 0
RI16 e16 m16 18e-2
LI16 m16 7 12e-7
VS17 6 s17 0
L17 s17 10 39e-2
VS18 13 s18 0
C18 s18 9 10e-4
VS19 12 s19 0
R19 s19 14 56e0
VS20 12 s20 0
R20 s20 4 56e3
VS21 5 s21 0
L21 s21 7 18e-2
VS22 7 s22 0
C22 s22 3 10e-6
.control
set numdgt=17
ac lin 1 60 60
print v(1) v(2) v(3) v(4) v(5) v(6) v(7) v(8) v(9) v(10)
print v(11) v(12) v(13) v(14)
print i(vs0) i(vs1) i(vs2) i(vs3) i(vs4) i(vs5) i(vs6) i(vs7) i(vs8) i(vs9)
print i(vs10) i(vs11) i(vs12) i(vs13) i(vs14) i(vs15) i(vs16) i(vs17) i(vs18) i(vs19)
print i(vs20) i(vs21) i(vs22)
.endc
.end
