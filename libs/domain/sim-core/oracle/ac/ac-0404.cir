controls oracle ac-0404
* Generated (plan F2.7, ADR 0012): do not edit; regenerate with `pnpm sim oracle regen`. ac seed 20261031 index 404 nodes 15 elements 21
.options sparse gmin=1e-12 noopac
RG1 1 0 1000000000000
RG2 2 0 1000000000000
RG3 3 0 1000000000000
RG4 4 0 1000000000000
RG5 5 0 1000000000000
RG6 6 0 1000000000000
RG7 7 0 1000000000000
RG8 8 0 1000000000000
RG9 9 0 1000000000000
RG10 10 0 1000000000000
RG11 11 0 1000000000000
RG12 12 0 1000000000000
RG13 13 0 1000000000000
RG14 14 0 1000000000000
VS0 0 s0 0
V0 e0 s0 DC 0 AC 56e0 180
RI0 e0 m0 18e-2
LI0 m0 n0 12e-7
H0 n0 h0 VS12 82e-4
ED0 h0 13 d0 0 47e-5
F0 0 d0 VS12 1
LD0 d0 0 1
VS1 8 s1 0
C1 s1 14 33e-6
VS2 8 s2 0
L2 s2 10 39e-2
VS3 11 s3 0
R3 s3 8 15e0
VS4 10 s4 0
R4 s4 9 27e3
VS5 1 s5 0
C5 s5 3 68e-7
VS6 7 s6 0
L6 s6 12 12e-4
VS7 8 s7 0
R7 s7 7 15e1
VS8 5 s8 0
L8 s8 14 12e-5
VS9 13 s9 0
L9 s9 6 15e-3
VS10 0 s10 0
R10 s10 1 82e-1
VS11 4 s11 0
L11 s11 9 12e-4
VS12 11 s12 0
V12 e12 s12 DC 0 AC 56e0 -120
RI12 e12 m12 56e-3
LI12 m12 n12 33e-5
H12 n12 h12 VS0 82e-4
ED12 h12 4 d12 0 47e-5
F12 0 d12 VS0 1
LD12 d12 0 1
VS13 3 s13 0
C13 s13 11 12e-6
VS14 2 s14 0
V14 e14 s14 DC 0 AC 15e1 0
RI14 e14 7 18e-2
VS15 12 s15 0
R15 s15 1 27e0
VS16 6 s16 0
R16 s16 2 12e-1
VS17 7 s17 0
L17 s17 0 56e-2
VS18 3 s18 0
R18 s18 14 18e2
VS19 1 s19 0
L19 s19 5 12e-4
VS20 6 s20 0
R20 s20 14 18e2
.control
set numdgt=17
ac lin 1 60 60
print v(1) v(2) v(3) v(4) v(5) v(6) v(7) v(8) v(9) v(10)
print v(11) v(12) v(13) v(14)
print i(vs0) i(vs1) i(vs2) i(vs3) i(vs4) i(vs5) i(vs6) i(vs7) i(vs8) i(vs9)
print i(vs10) i(vs11) i(vs12) i(vs13) i(vs14) i(vs15) i(vs16) i(vs17) i(vs18) i(vs19)
print i(vs20)
.endc
.end
