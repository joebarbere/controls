controls oracle ac-0402
* Generated (plan F2.7, ADR 0012): do not edit; regenerate with `pnpm sim oracle regen`. ac seed 20261031 index 402 nodes 24 elements 39
.options sparse gmin=1e-12 noopac
RG1 1 0 1000000000000
RG2 2 0 1000000000000
RG3 3 0 1000000000000
RG4 4 0 1000000000000
RG5 5 0 1000000000000
RG6 6 0 1000000000000
RG7 7 0 1000000000000
RG8 8 0 1000000000000
RG9 9 0 1000000000000
RG10 10 0 1000000000000
RG11 11 0 1000000000000
RG12 12 0 1000000000000
RG13 13 0 1000000000000
RG14 14 0 1000000000000
RG15 15 0 1000000000000
RG16 16 0 1000000000000
RG17 17 0 1000000000000
RG18 18 0 1000000000000
RG19 19 0 1000000000000
RG20 20 0 1000000000000
RG21 21 0 1000000000000
RG22 22 0 1000000000000
RG23 23 0 1000000000000
VS0 1 s0 0
C0 s0 7 39e-7
VS1 3 s1 0
L1 s1 9 39e-4
VS2 2 s2 0
C2 s2 0 18e-5
VS3 0 s3 0
V3 e3 s3 DC 0 AC 22e-1 -120
RI3 e3 19 39e-1
VS4 12 s4 0
V4 e4 s4 DC 0 AC 39e0 120
RI4 e4 m4 22e-3
LI4 m4 1 56e-7
VS5 19 s5 0
C5 s5 13 47e-7
VS6 10 s6 0
L6 s6 22 56e-5
VS7 3 s7 0
V7 e7 s7 DC 0 AC 56e-1 -120
RI7 e7 23 39e-2
VS8 11 s8 0
V8 e8 s8 DC 0 AC 82e1 120
RI8 e8 17 18e-2
VS9 5 s9 0
L9 s9 18 22e-5
VS10 13 s10 0
V10 e10 s10 DC 0 AC 39e1 0
RI10 e10 1 39e-1
VS11 22 s11 0
V11 e11 s11 DC 0 AC 82e-1 -120
RI11 e11 m11 47e-2
LI11 m11 12 56e-5
VS12 10 s12 0
V12 e12 s12 DC 0 AC 39e1 0
RI12 e12 m12 33e-2
LI12 m12 15 33e-7
VS13 4 s13 0
C13 s13 19 56e-7
VS14 17 s14 0
C14 s14 0 56e-7
VS15 18 s15 0
R15 s15 2 68e0
VS16 16 s16 0
R16 s16 14 68e-2
VS17 3 s17 0
V17 e17 s17 DC 0 AC 47e0 120
RI17 e17 10 47e-1
VS18 8 s18 0
R18 s18 17 47e3
VS19 15 s19 0
L19 s19 19 68e-5
VS20 4 s20 0
L20 s20 20 27e-5
VS21 23 s21 0
L21 s21 6 12e-4
VS22 15 s22 0
L22 s22 6 33e-3
VS23 5 s23 0
C23 s23 10 39e-5
VS24 14 s24 0
C24 s24 23 10e-7
VS25 18 s25 0
R25 s25 20 22e2
VS26 19 s26 0
L26 s26 20 12e-3
VS27 5 s27 0
R27 s27 12 39e-1
VS28 4 s28 0
C28 s28 21 27e-4
VS29 18 s29 0
V29 e29 s29 DC 0 AC 56e0 0
RI29 e29 m29 33e-2
LI29 m29 16 82e-5
VS30 8 s30 0
R30 s30 1 33e2
VS31 21 s31 0
V31 e31 s31 DC 0 AC 33e1 120
RI31 e31 23 27e-2
VS32 10 s32 0
L32 s32 1 27e-5
VS33 20 s33 0
L33 s33 19 15e-5
VS34 21 s34 0
V34 e34 s34 DC 0 AC 22e-1 -120
RI34 e34 18 82e-1
VS35 7 s35 0
V35 e35 s35 DC 0 AC 68e0 120
RI35 e35 9 39e-3
VS36 11 s36 0
L36 s36 12 68e-2
VS37 2 s37 0
V37 e37 s37 DC 0 AC 33e0 0
RI37 e37 5 15e-1
VS38 4 s38 0
C38 s38 1 27e-4
.control
set numdgt=17
ac lin 1 60 60
print v(1) v(2) v(3) v(4) v(5) v(6) v(7) v(8) v(9) v(10)
print v(11) v(12) v(13) v(14) v(15) v(16) v(17) v(18) v(19) v(20)
print v(21) v(22) v(23)
print i(vs0) i(vs1) i(vs2) i(vs3) i(vs4) i(vs5) i(vs6) i(vs7) i(vs8) i(vs9)
print i(vs10) i(vs11) i(vs12) i(vs13) i(vs14) i(vs15) i(vs16) i(vs17) i(vs18) i(vs19)
print i(vs20) i(vs21) i(vs22) i(vs23) i(vs24) i(vs25) i(vs26) i(vs27) i(vs28) i(vs29)
print i(vs30) i(vs31) i(vs32) i(vs33) i(vs34) i(vs35) i(vs36) i(vs37) i(vs38)
.endc
.end
