controls oracle ac-0484
* Generated (plan F2.7, ADR 0012): do not edit; regenerate with `pnpm sim oracle regen`. ac seed 20261031 index 484 nodes 12 elements 17
.options sparse gmin=1e-12 noopac
RG1 1 0 1000000000000
RG2 2 0 1000000000000
RG3 3 0 1000000000000
RG4 4 0 1000000000000
RG5 5 0 1000000000000
RG6 6 0 1000000000000
RG7 7 0 1000000000000
RG8 8 0 1000000000000
RG9 9 0 1000000000000
RG10 10 0 1000000000000
RG11 11 0 1000000000000
VS0 0 s0 0
V0 e0 s0 DC 0 AC 27e1 180
RI0 e0 n0 68e-3
H0 n0 h0 VS1 -27e-4
ED0 h0 5 d0 0 -68e-7
F0 0 d0 VS1 1
LD0 d0 0 1
VS1 7 s1 0
V1 e1 s1 DC 0 AC 39e0 -120
RI1 e1 n1 18e-2
H1 n1 h1 VS0 -27e-4
ED1 h1 5 d1 0 -68e-7
F1 0 d1 VS0 1
LD1 d1 0 1
VS2 8 s2 0
V2 e2 s2 DC 0 AC 18e1 120
RI2 e2 6 10e-2
VS3 9 s3 0
V3 e3 s3 DC 0 AC 18e1 -120
RI3 e3 11 27e-2
VS4 11 s4 0
V4 e4 s4 DC 0 AC 47e-1 120
RI4 e4 m4 15e-3
LI4 m4 0 47e-5
VS5 4 s5 0
L5 s5 7 47e-5
VS6 1 s6 0
L6 s6 6 10e-2
VS7 5 s7 0
V7 e7 s7 DC 0 AC 39e1 0
RI7 e7 m7 18e-3
LI7 m7 10 10e-5
VS8 2 s8 0
V8 e8 s8 DC 0 AC 39e1 120
RI8 e8 8 56e-2
VS9 5 s9 0
R9 s9 4 12e2
VS10 3 s10 0
V10 e10 s10 DC 0 AC 27e1 0
RI10 e10 4 39e-3
VS11 11 s11 0
C11 s11 3 15e-5
VS12 10 s12 0
R12 s12 9 10e-2
VS13 10 s13 0
R13 s13 3 33e3
VS14 10 s14 0
L14 s14 8 47e-5
VS15 1 s15 0
V15 e15 s15 DC 0 AC 39e1 0
RI15 e15 5 33e-1
VS16 2 s16 0
L16 s16 5 68e-4
.control
set numdgt=17
ac lin 1 60 60
print v(1) v(2) v(3) v(4) v(5) v(6) v(7) v(8) v(9) v(10)
print v(11)
print i(vs0) i(vs1) i(vs2) i(vs3) i(vs4) i(vs5) i(vs6) i(vs7) i(vs8) i(vs9)
print i(vs10) i(vs11) i(vs12) i(vs13) i(vs14) i(vs15) i(vs16)
.endc
.end
