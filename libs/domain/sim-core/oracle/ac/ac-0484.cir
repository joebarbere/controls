controls oracle ac-0484
* Generated (plan F2.7, ADR 0012): do not edit; regenerate with `pnpm sim oracle regen`. ac seed 20261031 index 484 nodes 12 elements 17
.options sparse gmin=1e-12 noopac
RG1 1 0 1000000000000
RG2 2 0 1000000000000
RG3 3 0 1000000000000
RG4 4 0 1000000000000
RG5 5 0 1000000000000
RG6 6 0 1000000000000
RG7 7 0 1000000000000
RG8 8 0 1000000000000
RG9 9 0 1000000000000
RG10 10 0 1000000000000
RG11 11 0 1000000000000
VS0 0 s0 0
V0 e0 s0 DC 0 AC 39e1 0
RI0 e0 m0 18e-3
LI0 m0 5 15e-5
VS1 5 s1 0
L1 s1 8 47e-5
VS2 9 s2 0
L2 s2 11 33e-2
VS3 7 s3 0
R3 s3 1 47e2
VS4 10 s4 0
V4 e4 s4 DC 0 AC 68e-1 0
RI4 e4 0 68e-2
VS5 7 s5 0
R5 s5 3 33e1
VS6 4 s6 0
L6 s6 11 68e-3
VS7 1 s7 0
V7 e7 s7 DC 0 AC 15e1 180
RI7 e7 m7 82e-1
LI7 m7 4 10e-6
VS8 6 s8 0
R8 s8 2 82e2
VS9 3 s9 0
V9 e9 s9 DC 0 AC 82e1 120
RI9 e9 m9 15e-1
LI9 m9 2 39e-6
VS10 4 s10 0
L10 s10 7 39e-4
VS11 9 s11 0
L11 s11 0 18e-5
VS12 2 s12 0
R12 s12 0 82e2
VS13 0 s13 0
C13 s13 7 68e-4
VS14 2 s14 0
C14 s14 8 10e-5
VS15 0 s15 0
V15 e15 s15 DC 0 AC 68e-1 120
RI15 e15 m15 39e-3
LI15 m15 6 12e-7
VS16 10 s16 0
L16 s16 11 47e-3
.control
set numdgt=17
ac lin 1 60 60
print v(1) v(2) v(3) v(4) v(5) v(6) v(7) v(8) v(9) v(10)
print v(11)
print i(vs0) i(vs1) i(vs2) i(vs3) i(vs4) i(vs5) i(vs6) i(vs7) i(vs8) i(vs9)
print i(vs10) i(vs11) i(vs12) i(vs13) i(vs14) i(vs15) i(vs16)
.endc
.end
