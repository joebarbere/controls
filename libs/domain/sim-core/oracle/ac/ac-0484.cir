controls oracle ac-0484
* Generated (plan F2.7, ADR 0012): do not edit; regenerate with `pnpm sim oracle regen`. ac seed 20261031 index 484 nodes 12 elements 12
.options sparse gmin=1e-12 noopac
RG1 1 0 1000000000000
RG2 2 0 1000000000000
RG3 3 0 1000000000000
RG4 4 0 1000000000000
RG5 5 0 1000000000000
RG6 6 0 1000000000000
RG7 7 0 1000000000000
RG8 8 0 1000000000000
RG9 9 0 1000000000000
RG10 10 0 1000000000000
RG11 11 0 1000000000000
VS0 0 s0 0
V0 e0 s0 DC 0 AC 27e1 180
RI0 e0 5 68e-3
VS1 9 s1 0
V1 e1 s1 DC 0 AC 18e1 -120
RI1 e1 11 27e-2
VS2 8 s2 0
V2 e2 s2 DC 0 AC 18e1 120
RI2 e2 6 10e-2
VS3 10 s3 0
L3 s3 8 47e-5
VS4 5 s4 0
V4 e4 s4 DC 0 AC 39e1 0
RI4 e4 10 18e-3
VS5 10 s5 0
R5 s5 3 33e3
VS6 1 s6 0
L6 s6 6 10e-2
VS7 2 s7 0
L7 s7 5 68e-4
VS8 5 s8 0
R8 s8 4 12e2
VS9 4 s9 0
L9 s9 7 47e-5
VS10 11 s10 0
C10 s10 3 15e-5
VS11 7 s11 0
V11 e11 s11 DC 0 AC 39e0 -120
RI11 e11 5 18e-2
.control
set numdgt=17
ac lin 1 60 60
print v(1) v(2) v(3) v(4) v(5) v(6) v(7) v(8) v(9) v(10)
print v(11)
print i(vs0) i(vs1) i(vs2) i(vs3) i(vs4) i(vs5) i(vs6) i(vs7) i(vs8) i(vs9)
print i(vs10) i(vs11)
.endc
.end
