controls oracle ac-0253
* Generated (plan F2.7, ADR 0012): do not edit; regenerate with `pnpm sim oracle regen`. ac seed 20261031 index 253 nodes 20 elements 29
.options sparse gmin=1e-12 noopac
RG1 1 0 1000000000000
RG2 2 0 1000000000000
RG3 3 0 1000000000000
RG4 4 0 1000000000000
RG5 5 0 1000000000000
RG6 6 0 1000000000000
RG7 7 0 1000000000000
RG8 8 0 1000000000000
RG9 9 0 1000000000000
RG10 10 0 1000000000000
RG11 11 0 1000000000000
RG12 12 0 1000000000000
RG13 13 0 1000000000000
RG14 14 0 1000000000000
RG15 15 0 1000000000000
RG16 16 0 1000000000000
RG17 17 0 1000000000000
RG18 18 0 1000000000000
RG19 19 0 1000000000000
VS0 0 s0 0
C0 s0 18 39e-5
VS1 18 s1 0
L1 s1 17 68e-5
VS2 0 s2 0
V2 e2 s2 DC 0 AC 68e-1 0
RI2 e2 m2 82e-1
LI2 m2 15 22e-7
VS3 6 s3 0
L3 s3 11 15e-5
VS4 5 s4 0
L4 s4 11 15e-2
VS5 7 s5 0
R5 s5 5 39e0
VS6 16 s6 0
L6 s6 6 82e-4
VS7 4 s7 0
L7 s7 17 18e-4
VS8 5 s8 0
R8 s8 8 39e1
VS9 17 s9 0
C9 s9 12 22e-5
VS10 13 s10 0
R10 s10 6 15e1
VS11 3 s11 0
L11 s11 16 82e-4
VS12 9 s12 0
V12 e12 s12 DC 0 AC 15e-1 -120
RI12 e12 m12 15e-2
LI12 m12 1 27e-7
VS13 9 s13 0
V13 e13 s13 DC 0 AC 47e1 120
RI13 e13 m13 10e-1
LI13 m13 14 68e-6
VS14 6 s14 0
C14 s14 16 22e-4
VS15 6 s15 0
L15 s15 17 39e-5
VS16 5 s16 0
R16 s16 8 68e1
VS17 8 s17 0
R17 s17 10 82e1
VS18 2 s18 0
V18 e18 s18 DC 0 AC 15e1 0
RI18 e18 m18 39e-2
LI18 m18 4 27e-6
VS19 15 s19 0
V19 e19 s19 DC 0 AC 15e1 180
RI19 e19 m19 56e-1
LI19 m19 7 27e-5
VS20 5 s20 0
C20 s20 19 56e-7
VS21 13 s21 0
V21 e21 s21 DC 0 AC 27e0 180
RI21 e21 m21 18e-2
LI21 m21 1 33e-7
VS22 14 s22 0
C22 s22 7 39e-7
VS23 10 s23 0
R23 s23 16 47e3
VS24 12 s24 0
C24 s24 14 12e-4
VS25 11 s25 0
R25 s25 2 10e2
VS26 7 s26 0
C26 s26 19 22e-5
VS27 4 s27 0
C27 s27 13 68e-5
VS28 3 s28 0
R28 s28 12 82e-1
.control
set numdgt=17
ac lin 1 60 60
print v(1) v(2) v(3) v(4) v(5) v(6) v(7) v(8) v(9) v(10)
print v(11) v(12) v(13) v(14) v(15) v(16) v(17) v(18) v(19)
print i(vs0) i(vs1) i(vs2) i(vs3) i(vs4) i(vs5) i(vs6) i(vs7) i(vs8) i(vs9)
print i(vs10) i(vs11) i(vs12) i(vs13) i(vs14) i(vs15) i(vs16) i(vs17) i(vs18) i(vs19)
print i(vs20) i(vs21) i(vs22) i(vs23) i(vs24) i(vs25) i(vs26) i(vs27) i(vs28)
.endc
.end
