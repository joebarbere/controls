controls oracle ac-0253
* Generated (plan F2.7, ADR 0012): do not edit; regenerate with `pnpm sim oracle regen`. ac seed 20261031 index 253 nodes 20 elements 30
.options sparse gmin=1e-12 noopac
RG1 1 0 1000000000000
RG2 2 0 1000000000000
RG3 3 0 1000000000000
RG4 4 0 1000000000000
RG5 5 0 1000000000000
RG6 6 0 1000000000000
RG7 7 0 1000000000000
RG8 8 0 1000000000000
RG9 9 0 1000000000000
RG10 10 0 1000000000000
RG11 11 0 1000000000000
RG12 12 0 1000000000000
RG13 13 0 1000000000000
RG14 14 0 1000000000000
RG15 15 0 1000000000000
RG16 16 0 1000000000000
RG17 17 0 1000000000000
RG18 18 0 1000000000000
RG19 19 0 1000000000000
VS0 4 s0 0
L0 s0 17 18e-4
VS1 16 s1 0
L1 s1 6 82e-4
VS2 0 s2 0
V2 e2 s2 DC 0 AC 27e0 180
RI2 e2 m2 18e-2
LI2 m2 1 22e-6
VS3 5 s3 0
L3 s3 8 68e-4
VS4 8 s4 0
R4 s4 6 47e3
VS5 0 s5 0
V5 e5 s5 DC 0 AC 82e-1 0
RI5 e5 m5 18e-1
LI5 m5 14 22e-6
VS6 5 s6 0
L6 s6 13 15e-2
VS7 11 s7 0
V7 e7 s7 DC 0 AC 15e-1 -120
RI7 e7 m7 15e-2
LI7 m7 19 10e-5
VS8 7 s8 0
R8 s8 5 39e0
VS9 3 s9 0
L9 s9 16 82e-4
VS10 17 s10 0
C10 s10 12 22e-5
VS11 2 s11 0
C11 s11 15 39e-7
VS12 4 s12 0
C12 s12 2 27e-7
VS13 10 s13 0
R13 s13 0 82e1
VS14 9 s14 0
V14 e14 s14 DC 0 AC 47e1 120
RI14 e14 m14 10e-1
LI14 m14 14 10e-6
VS15 10 s15 0
R15 s15 16 47e3
VS16 11 s16 0
C16 s16 1 68e-5
VS17 7 s17 0
C17 s17 14 22e-4
VS18 18 s18 0
R18 s18 11 82e-1
VS19 4 s19 0
R19 s19 15 10e1
VS20 16 s20 0
R20 s20 11 39e-2
VS21 6 s21 0
L21 s21 17 39e-5
VS22 12 s22 0
C22 s22 14 12e-4
VS23 18 s23 0
L23 s23 17 68e-5
VS24 6 s24 0
R24 s24 3 39e1
VS25 3 s25 0
V25 e25 s25 DC 0 AC 27e0 0
RI25 e25 m25 56e-3
LI25 m25 2 68e-7
VS26 6 s26 0
L26 s26 13 15e-5
VS27 0 s27 0
R27 s27 6 15e1
VS28 9 s28 0
V28 e28 s28 DC 0 AC 15e1 180
RI28 e28 m28 56e-1
LI28 m28 7 22e-5
VS29 19 s29 0
V29 e29 s29 DC 0 AC 56e-1 120
RI29 e29 4 22e-3
.control
set numdgt=17
ac lin 1 60 60
print v(1) v(2) v(3) v(4) v(5) v(6) v(7) v(8) v(9) v(10)
print v(11) v(12) v(13) v(14) v(15) v(16) v(17) v(18) v(19)
print i(vs0) i(vs1) i(vs2) i(vs3) i(vs4) i(vs5) i(vs6) i(vs7) i(vs8) i(vs9)
print i(vs10) i(vs11) i(vs12) i(vs13) i(vs14) i(vs15) i(vs16) i(vs17) i(vs18) i(vs19)
print i(vs20) i(vs21) i(vs22) i(vs23) i(vs24) i(vs25) i(vs26) i(vs27) i(vs28) i(vs29)
.endc
.end
