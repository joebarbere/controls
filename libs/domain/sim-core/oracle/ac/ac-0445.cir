controls oracle ac-0445
* Generated (plan F2.7, ADR 0012): do not edit; regenerate with `pnpm sim oracle regen`. ac seed 20261031 index 445 nodes 16 elements 22
.options sparse gmin=1e-12 noopac
RG1 1 0 1000000000000
RG2 2 0 1000000000000
RG3 3 0 1000000000000
RG4 4 0 1000000000000
RG5 5 0 1000000000000
RG6 6 0 1000000000000
RG7 7 0 1000000000000
RG8 8 0 1000000000000
RG9 9 0 1000000000000
RG10 10 0 1000000000000
RG11 11 0 1000000000000
RG12 12 0 1000000000000
RG13 13 0 1000000000000
RG14 14 0 1000000000000
RG15 15 0 1000000000000
VS0 9 s0 0
C0 s0 2 56e-7
VS1 0 s1 0
C1 s1 8 22e-4
VS2 6 s2 0
L2 s2 7 33e-4
VS3 5 s3 0
C3 s3 10 12e-6
VS4 0 s4 0
V4 e4 s4 DC 0 AC 27e-1 -120
RI4 e4 14 10e-3
VS5 14 s5 0
V5 e5 s5 DC 0 AC 82e1 120
RI5 e5 13 27e-2
VS6 1 s6 0
C6 s6 15 22e-6
VS7 1 s7 0
R7 s7 0 68e2
VS8 1 s8 0
L8 s8 2 15e-4
VS9 4 s9 0
V9 e9 s9 DC 0 AC 47e0 0
RI9 e9 3 18e-2
VS10 12 s10 0
L10 s10 9 82e-5
VS11 13 s11 0
L11 s11 4 22e-4
VS12 11 s12 0
L12 s12 6 56e-2
VS13 11 s13 0
C13 s13 12 15e-6
VS14 14 s14 0
C14 s14 8 47e-5
VS15 15 s15 0
R15 s15 10 18e0
VS16 5 s16 0
V16 e16 s16 DC 0 AC 12e1 -120
RI16 e16 m16 12e-1
LI16 m16 14 18e-5
VS17 1 s17 0
V17 e17 s17 DC 0 AC 56e1 120
RI17 e17 m17 82e-3
LI17 m17 3 56e-5
VS18 14 s18 0
V18 e18 s18 DC 0 AC 22e0 0
RI18 e18 m18 10e-2
LI18 m18 4 82e-5
VS19 11 s19 0
C19 s19 0 27e-4
VS20 11 s20 0
C20 s20 6 12e-5
VS21 7 s21 0
R21 s21 15 82e-1
.control
set numdgt=17
ac lin 1 60 60
print v(1) v(2) v(3) v(4) v(5) v(6) v(7) v(8) v(9) v(10)
print v(11) v(12) v(13) v(14) v(15)
print i(vs0) i(vs1) i(vs2) i(vs3) i(vs4) i(vs5) i(vs6) i(vs7) i(vs8) i(vs9)
print i(vs10) i(vs11) i(vs12) i(vs13) i(vs14) i(vs15) i(vs16) i(vs17) i(vs18) i(vs19)
print i(vs20) i(vs21)
.endc
.end
