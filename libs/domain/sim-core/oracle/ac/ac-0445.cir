controls oracle ac-0445
* Generated (plan F2.7, ADR 0012): do not edit; regenerate with `pnpm sim oracle regen`. ac seed 20261031 index 445 nodes 16 elements 30
.options sparse gmin=1e-12 noopac
RG1 1 0 1000000000000
RG2 2 0 1000000000000
RG3 3 0 1000000000000
RG4 4 0 1000000000000
RG5 5 0 1000000000000
RG6 6 0 1000000000000
RG7 7 0 1000000000000
RG8 8 0 1000000000000
RG9 9 0 1000000000000
RG10 10 0 1000000000000
RG11 11 0 1000000000000
RG12 12 0 1000000000000
RG13 13 0 1000000000000
RG14 14 0 1000000000000
RG15 15 0 1000000000000
VS0 13 s0 0
R0 s0 9 27e3
VS1 0 s1 0
V1 e1 s1 DC 0 AC 68e0 -120
RI1 e1 m1 22e-3
LI1 m1 n1 39e-7
H1 n1 h1 VS7 10e-4
ED1 h1 8 d1 0 82e-6
F1 0 d1 VS7 1
LD1 d1 0 1
VS2 2 s2 0
R2 s2 5 27e-1
VS3 4 s3 0
R3 s3 13 10e0
VS4 11 s4 0
L4 s4 1 10e-5
VS5 14 s5 0
R5 s5 5 18e-1
VS6 6 s6 0
C6 s6 10 47e-5
VS7 1 s7 0
V7 e7 s7 DC 0 AC 68e-1 180
RI7 e7 n7 39e-2
H7 n7 h7 VS1 10e-4
ED7 h7 13 d7 0 82e-6
F7 0 d7 VS1 1
LD7 d7 0 1
VS8 6 s8 0
C8 s8 4 12e-5
VS9 7 s9 0
L9 s9 9 22e-4
VS10 10 s10 0
V10 e10 s10 DC 0 AC 27e0 180
RI10 e10 m10 39e-2
LI10 m10 14 18e-5
VS11 5 s11 0
L11 s11 8 22e-4
VS12 12 s12 0
C12 s12 2 33e-7
VS13 10 s13 0
R13 s13 7 27e3
VS14 13 s14 0
C14 s14 0 12e-6
VS15 8 s15 0
R15 s15 3 15e0
VS16 2 s16 0
C16 s16 7 39e-4
VS17 1 s17 0
V17 e17 s17 DC 0 AC 68e0 -120
RI17 e17 m17 82e-1
LI17 m17 0 39e-5
VS18 13 s18 0
V18 e18 s18 DC 0 AC 82e1 0
RI18 e18 m18 56e-3
LI18 m18 2 68e-5
VS19 11 s19 0
C19 s19 3 47e-5
VS20 12 s20 0
C20 s20 15 68e-4
VS21 2 s21 0
V21 e21 s21 DC 0 AC 56e1 120
RI21 e21 m21 82e-3
LI21 m21 7 27e-5
VS22 12 s22 0
R22 s22 1 68e2
VS23 0 s23 0
C23 s23 9 15e-6
VS24 2 s24 0
R24 s24 7 33e0
VS25 1 s25 0
V25 e25 s25 DC 0 AC 27e-1 -120
RI25 e25 m25 10e-3
LI25 m25 14 39e-7
VS26 10 s26 0
R26 s26 1 12e0
VS27 1 s27 0
C27 s27 6 22e-6
VS28 1 s28 0
C28 s28 4 68e-5
VS29 15 s29 0
C29 s29 10 56e-7
.control
set numdgt=17
ac lin 1 60 60
print v(1) v(2) v(3) v(4) v(5) v(6) v(7) v(8) v(9) v(10)
print v(11) v(12) v(13) v(14) v(15)
print i(vs0) i(vs1) i(vs2) i(vs3) i(vs4) i(vs5) i(vs6) i(vs7) i(vs8) i(vs9)
print i(vs10) i(vs11) i(vs12) i(vs13) i(vs14) i(vs15) i(vs16) i(vs17) i(vs18) i(vs19)
print i(vs20) i(vs21) i(vs22) i(vs23) i(vs24) i(vs25) i(vs26) i(vs27) i(vs28) i(vs29)
.endc
.end
