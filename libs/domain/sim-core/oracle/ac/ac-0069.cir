controls oracle ac-0069
* Generated (plan F2.7, ADR 0012): do not edit; regenerate with `pnpm sim oracle regen`. ac seed 20261031 index 69 nodes 25 elements 46
.options sparse gmin=1e-12 noopac
RG1 1 0 1000000000000
RG2 2 0 1000000000000
RG3 3 0 1000000000000
RG4 4 0 1000000000000
RG5 5 0 1000000000000
RG6 6 0 1000000000000
RG7 7 0 1000000000000
RG8 8 0 1000000000000
RG9 9 0 1000000000000
RG10 10 0 1000000000000
RG11 11 0 1000000000000
RG12 12 0 1000000000000
RG13 13 0 1000000000000
RG14 14 0 1000000000000
RG15 15 0 1000000000000
RG16 16 0 1000000000000
RG17 17 0 1000000000000
RG18 18 0 1000000000000
RG19 19 0 1000000000000
RG20 20 0 1000000000000
RG21 21 0 1000000000000
RG22 22 0 1000000000000
RG23 23 0 1000000000000
RG24 24 0 1000000000000
VS0 0 s0 0
V0 e0 s0 DC 0 AC 22e-1 120
RI0 e0 m0 82e-1
LI0 m0 2 22e-5
VS1 6 s1 0
R1 s1 11 33e-2
VS2 2 s2 0
R2 s2 23 18e1
VS3 0 s3 0
R3 s3 16 22e0
VS4 9 s4 0
R4 s4 19 33e2
VS5 23 s5 0
V5 e5 s5 DC 0 AC 10e0 -120
RI5 e5 0 47e-1
VS6 9 s6 0
L6 s6 17 82e-3
VS7 10 s7 0
C7 s7 13 27e-4
VS8 22 s8 0
R8 s8 0 22e3
VS9 2 s9 0
V9 e9 s9 DC 0 AC 15e0 180
RI9 e9 m9 56e-2
LI9 m9 24 82e-7
VS10 13 s10 0
C10 s10 15 27e-7
VS11 21 s11 0
R11 s11 18 56e3
VS12 2 s12 0
C12 s12 15 68e-5
VS13 3 s13 0
V13 e13 s13 DC 0 AC 39e1 120
RI13 e13 9 10e-1
VS14 19 s14 0
R14 s14 10 33e2
VS15 19 s15 0
C15 s15 0 47e-6
VS16 1 s16 0
L16 s16 7 33e-4
VS17 23 s17 0
L17 s17 5 82e-2
VS18 16 s18 0
C18 s18 8 82e-6
VS19 12 s19 0
C19 s19 24 68e-7
VS20 5 s20 0
C20 s20 4 39e-7
VS21 1 s21 0
C21 s21 7 15e-4
VS22 8 s22 0
R22 s22 22 82e2
VS23 3 s23 0
V23 e23 s23 DC 0 AC 27e1 120
RI23 e23 m23 12e-3
LI23 m23 22 39e-7
VS24 1 s24 0
V24 e24 s24 DC 0 AC 12e-1 120
RI24 e24 m24 33e-3
LI24 m24 14 12e-7
VS25 3 s25 0
L25 s25 15 27e-5
VS26 19 s26 0
C26 s26 2 18e-4
VS27 9 s27 0
R27 s27 21 22e-1
VS28 6 s28 0
L28 s28 15 68e-5
VS29 11 s29 0
R29 s29 7 39e2
VS30 3 s30 0
R30 s30 1 56e0
VS31 17 s31 0
L31 s31 8 82e-5
VS32 19 s32 0
C32 s32 21 33e-6
VS33 11 s33 0
V33 e33 s33 DC 0 AC 33e0 180
RI33 e33 m33 27e-3
LI33 m33 13 82e-6
VS34 18 s34 0
L34 s34 17 22e-3
VS35 13 s35 0
L35 s35 22 82e-3
VS36 23 s36 0
L36 s36 12 39e-3
VS37 11 s37 0
V37 e37 s37 DC 0 AC 10e1 -120
RI37 e37 2 22e-2
VS38 1 s38 0
R38 s38 21 27e0
VS39 14 s39 0
C39 s39 15 47e-4
VS40 24 s40 0
R40 s40 3 22e3
VS41 0 s41 0
R41 s41 20 27e2
VS42 4 s42 0
L42 s42 21 27e-3
VS43 24 s43 0
V43 e43 s43 DC 0 AC 82e-1 0
RI43 e43 16 47e-1
VS44 20 s44 0
R44 s44 12 10e0
VS45 6 s45 0
R45 s45 13 15e-2
.control
set numdgt=17
ac lin 1 60 60
print v(1) v(2) v(3) v(4) v(5) v(6) v(7) v(8) v(9) v(10)
print v(11) v(12) v(13) v(14) v(15) v(16) v(17) v(18) v(19) v(20)
print v(21) v(22) v(23) v(24)
print i(vs0) i(vs1) i(vs2) i(vs3) i(vs4) i(vs5) i(vs6) i(vs7) i(vs8) i(vs9)
print i(vs10) i(vs11) i(vs12) i(vs13) i(vs14) i(vs15) i(vs16) i(vs17) i(vs18) i(vs19)
print i(vs20) i(vs21) i(vs22) i(vs23) i(vs24) i(vs25) i(vs26) i(vs27) i(vs28) i(vs29)
print i(vs30) i(vs31) i(vs32) i(vs33) i(vs34) i(vs35) i(vs36) i(vs37) i(vs38) i(vs39)
print i(vs40) i(vs41) i(vs42) i(vs43) i(vs44) i(vs45)
.endc
.end
