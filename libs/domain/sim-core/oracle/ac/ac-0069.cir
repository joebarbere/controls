controls oracle ac-0069
* Generated (plan F2.7, ADR 0012): do not edit; regenerate with `pnpm sim oracle regen`. ac seed 20261031 index 69 nodes 25 elements 36
.options sparse gmin=1e-12 noopac
RG1 1 0 1000000000000
RG2 2 0 1000000000000
RG3 3 0 1000000000000
RG4 4 0 1000000000000
RG5 5 0 1000000000000
RG6 6 0 1000000000000
RG7 7 0 1000000000000
RG8 8 0 1000000000000
RG9 9 0 1000000000000
RG10 10 0 1000000000000
RG11 11 0 1000000000000
RG12 12 0 1000000000000
RG13 13 0 1000000000000
RG14 14 0 1000000000000
RG15 15 0 1000000000000
RG16 16 0 1000000000000
RG17 17 0 1000000000000
RG18 18 0 1000000000000
RG19 19 0 1000000000000
RG20 20 0 1000000000000
RG21 21 0 1000000000000
RG22 22 0 1000000000000
RG23 23 0 1000000000000
RG24 24 0 1000000000000
VS0 21 s0 0
L0 s0 20 27e-3
VS1 24 s1 0
R1 s1 21 15e2
VS2 0 s2 0
R2 s2 1 56e0
VS3 14 s3 0
C3 s3 15 47e-4
VS4 0 s4 0
V4 e4 s4 DC 0 AC 39e1 120
RI4 e4 9 10e-1
VS5 11 s5 0
V5 e5 s5 DC 0 AC 33e0 180
RI5 e5 13 27e-3
VS6 18 s6 0
V6 e6 s6 DC 0 AC 39e0 120
RI6 e6 19 56e-1
VS7 23 s7 0
L7 s7 11 10e-3
VS8 7 s8 0
L8 s8 16 22e-3
VS9 16 s9 0
C9 s9 6 22e-7
VS10 13 s10 0
R10 s10 12 15e3
VS11 1 s11 0
V11 e11 s11 DC 0 AC 12e-1 120
RI11 e11 14 33e-3
VS12 3 s12 0
V12 e12 s12 DC 0 AC 22e1 -120
RI12 e12 4 22e-2
VS13 18 s13 0
R13 s13 8 27e-2
VS14 14 s14 0
L14 s14 4 39e-3
VS15 19 s15 0
C15 s15 2 18e-4
VS16 19 s16 0
C16 s16 6 47e-6
VS17 15 s17 0
R17 s17 10 33e-1
VS18 0 s18 0
L18 s18 15 27e-5
VS19 8 s19 0
R19 s19 7 22e0
VS20 22 s20 0
V20 e20 s20 DC 0 AC 33e0 0
RI20 e20 10 12e-2
VS21 16 s21 0
L21 s21 11 82e-4
VS22 4 s22 0
V22 e22 s22 DC 0 AC 10e0 120
RI22 e22 20 68e-2
VS23 2 s23 0
V23 e23 s23 DC 0 AC 12e-1 -120
RI23 e23 3 22e-2
VS24 11 s24 0
R24 s24 5 18e3
VS25 3 s25 0
R25 s25 11 33e-2
VS26 1 s26 0
C26 s26 5 12e-6
VS27 3 s27 0
L27 s27 15 68e-5
VS28 23 s28 0
C28 s28 7 22e-5
VS29 1 s29 0
R29 s29 21 27e0
VS30 11 s30 0
R30 s30 7 39e2
VS31 10 s31 0
R31 s31 6 12e2
VS32 19 s32 0
L32 s32 13 18e-5
VS33 8 s33 0
C33 s33 16 15e-4
VS34 17 s34 0
L34 s34 21 33e-2
VS35 8 s35 0
R35 s35 1 18e3
.control
set numdgt=17
ac lin 1 60 60
print v(1) v(2) v(3) v(4) v(5) v(6) v(7) v(8) v(9) v(10)
print v(11) v(12) v(13) v(14) v(15) v(16) v(17) v(18) v(19) v(20)
print v(21) v(22) v(23) v(24)
print i(vs0) i(vs1) i(vs2) i(vs3) i(vs4) i(vs5) i(vs6) i(vs7) i(vs8) i(vs9)
print i(vs10) i(vs11) i(vs12) i(vs13) i(vs14) i(vs15) i(vs16) i(vs17) i(vs18) i(vs19)
print i(vs20) i(vs21) i(vs22) i(vs23) i(vs24) i(vs25) i(vs26) i(vs27) i(vs28) i(vs29)
print i(vs30) i(vs31) i(vs32) i(vs33) i(vs34) i(vs35)
.endc
.end
