controls oracle ac-0415
* Generated (plan F2.7, ADR 0012): do not edit; regenerate with `pnpm sim oracle regen`. ac seed 20261031 index 415 nodes 24 elements 47
.options sparse gmin=1e-12 noopac
RG1 1 0 1000000000000
RG2 2 0 1000000000000
RG3 3 0 1000000000000
RG4 4 0 1000000000000
RG5 5 0 1000000000000
RG6 6 0 1000000000000
RG7 7 0 1000000000000
RG8 8 0 1000000000000
RG9 9 0 1000000000000
RG10 10 0 1000000000000
RG11 11 0 1000000000000
RG12 12 0 1000000000000
RG13 13 0 1000000000000
RG14 14 0 1000000000000
RG15 15 0 1000000000000
RG16 16 0 1000000000000
RG17 17 0 1000000000000
RG18 18 0 1000000000000
RG19 19 0 1000000000000
RG20 20 0 1000000000000
RG21 21 0 1000000000000
RG22 22 0 1000000000000
RG23 23 0 1000000000000
VS0 17 s0 0
L0 s0 9 18e-3
VS1 8 s1 0
C1 s1 2 15e-4
VS2 5 s2 0
C2 s2 8 68e-7
VS3 18 s3 0
C3 s3 11 82e-5
VS4 21 s4 0
C4 s4 14 12e-7
VS5 0 s5 0
V5 e5 s5 DC 0 AC 82e1 120
RI5 e5 12 15e-1
VS6 11 s6 0
L6 s6 16 47e-5
VS7 2 s7 0
C7 s7 22 22e-7
VS8 4 s8 0
V8 e8 s8 DC 0 AC 10e1 0
RI8 e8 23 68e-2
VS9 8 s9 0
L9 s9 12 27e-2
VS10 11 s10 0
V10 e10 s10 DC 0 AC 22e-1 120
RI10 e10 m10 15e-2
LI10 m10 22 22e-6
VS11 17 s11 0
R11 s11 10 39e-1
VS12 1 s12 0
L12 s12 11 12e-3
VS13 19 s13 0
L13 s13 2 56e-5
VS14 3 s14 0
C14 s14 12 12e-7
VS15 14 s15 0
V15 e15 s15 DC 0 AC 33e1 120
RI15 e15 m15 10e-1
LI15 m15 0 12e-7
VS16 5 s16 0
C16 s16 4 68e-6
VS17 18 s17 0
C17 s17 4 10e-4
VS18 11 s18 0
C18 s18 0 22e-4
VS19 22 s19 0
L19 s19 17 27e-2
VS20 11 s20 0
R20 s20 2 33e1
VS21 1 s21 0
L21 s21 0 33e-2
VS22 23 s22 0
L22 s22 5 27e-5
VS23 22 s23 0
C23 s23 8 22e-5
VS24 18 s24 0
C24 s24 7 22e-6
VS25 15 s25 0
V25 e25 s25 DC 0 AC 10e1 0
RI25 e25 m25 10e-2
LI25 m25 0 27e-7
VS26 18 s26 0
L26 s26 22 10e-4
VS27 1 s27 0
L27 s27 7 33e-3
VS28 2 s28 0
C28 s28 10 33e-4
VS29 11 s29 0
L29 s29 16 12e-2
VS30 5 s30 0
V30 e30 s30 DC 0 AC 27e1 120
RI30 e30 17 10e-1
VS31 12 s31 0
C31 s31 6 22e-4
VS32 19 s32 0
L32 s32 20 10e-2
VS33 13 s33 0
L33 s33 12 10e-2
VS34 13 s34 0
R34 s34 9 10e-1
VS35 1 s35 0
L35 s35 4 39e-4
VS36 6 s36 0
L36 s36 3 22e-2
VS37 5 s37 0
V37 e37 s37 DC 0 AC 15e-1 0
RI37 e37 21 18e-1
VS38 18 s38 0
L38 s38 2 47e-5
VS39 18 s39 0
C39 s39 4 47e-7
VS40 14 s40 0
R40 s40 4 56e3
VS41 14 s41 0
L41 s41 16 18e-2
VS42 16 s42 0
V42 e42 s42 DC 0 AC 56e-1 180
RI42 e42 12 39e-2
VS43 20 s43 0
C43 s43 23 47e-6
VS44 6 s44 0
R44 s44 19 39e-1
VS45 15 s45 0
V45 e45 s45 DC 0 AC 47e-1 0
RI45 e45 m45 47e-1
LI45 m45 12 39e-7
VS46 5 s46 0
R46 s46 13 22e-1
.control
set numdgt=17
ac lin 1 60 60
print v(1) v(2) v(3) v(4) v(5) v(6) v(7) v(8) v(9) v(10)
print v(11) v(12) v(13) v(14) v(15) v(16) v(17) v(18) v(19) v(20)
print v(21) v(22) v(23)
print i(vs0) i(vs1) i(vs2) i(vs3) i(vs4) i(vs5) i(vs6) i(vs7) i(vs8) i(vs9)
print i(vs10) i(vs11) i(vs12) i(vs13) i(vs14) i(vs15) i(vs16) i(vs17) i(vs18) i(vs19)
print i(vs20) i(vs21) i(vs22) i(vs23) i(vs24) i(vs25) i(vs26) i(vs27) i(vs28) i(vs29)
print i(vs30) i(vs31) i(vs32) i(vs33) i(vs34) i(vs35) i(vs36) i(vs37) i(vs38) i(vs39)
print i(vs40) i(vs41) i(vs42) i(vs43) i(vs44) i(vs45) i(vs46)
.endc
.end
