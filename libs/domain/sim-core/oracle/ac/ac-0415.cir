controls oracle ac-0415
* Generated (plan F2.7, ADR 0012): do not edit; regenerate with `pnpm sim oracle regen`. ac seed 20261031 index 415 nodes 24 elements 38
.options sparse gmin=1e-12 noopac
RG1 1 0 1000000000000
RG2 2 0 1000000000000
RG3 3 0 1000000000000
RG4 4 0 1000000000000
RG5 5 0 1000000000000
RG6 6 0 1000000000000
RG7 7 0 1000000000000
RG8 8 0 1000000000000
RG9 9 0 1000000000000
RG10 10 0 1000000000000
RG11 11 0 1000000000000
RG12 12 0 1000000000000
RG13 13 0 1000000000000
RG14 14 0 1000000000000
RG15 15 0 1000000000000
RG16 16 0 1000000000000
RG17 17 0 1000000000000
RG18 18 0 1000000000000
RG19 19 0 1000000000000
RG20 20 0 1000000000000
RG21 21 0 1000000000000
RG22 22 0 1000000000000
RG23 23 0 1000000000000
VS0 14 s0 0
R0 s0 6 82e-2
VS1 0 s1 0
V1 e1 s1 DC 0 AC 39e0 0
RI1 e1 23 82e-2
VS2 14 s2 0
L2 s2 8 27e-2
VS3 12 s3 0
V3 e3 s3 DC 0 AC 33e-1 0
RI3 e3 10 39e-1
VS4 2 s4 0
V4 e4 s4 DC 0 AC 68e0 -120
RI4 e4 5 47e-1
VS5 22 s5 0
C5 s5 8 33e-7
VS6 1 s6 0
R6 s6 9 47e1
VS7 18 s7 0
V7 e7 s7 DC 0 AC 22e-1 -120
RI7 e7 14 33e-1
VS8 7 s8 0
L8 s8 16 10e-2
VS9 3 s9 0
C9 s9 7 39e-7
VS10 5 s10 0
L10 s10 8 39e-5
VS11 5 s11 0
R11 s11 6 27e2
VS12 13 s12 0
V12 e12 s12 DC 0 AC 47e0 120
RI12 e12 m12 22e-2
LI12 m12 0 47e-5
VS13 5 s13 0
R13 s13 1 82e0
VS14 21 s14 0
C14 s14 19 27e-6
VS15 4 s15 0
C15 s15 17 18e-5
VS16 6 s16 0
R16 s16 20 22e-2
VS17 4 s17 0
C17 s17 0 10e-7
VS18 8 s18 0
L18 s18 1 22e-4
VS19 22 s19 0
L19 s19 9 18e-5
VS20 12 s20 0
R20 s20 7 47e-2
VS21 22 s21 0
V21 e21 s21 DC 0 AC 15e0 180
RI21 e21 13 22e-1
VS22 16 s22 0
L22 s22 12 10e-4
VS23 12 s23 0
C23 s23 7 47e-6
VS24 20 s24 0
C24 s24 2 47e-7
VS25 14 s25 0
R25 s25 23 39e-2
VS26 17 s26 0
C26 s26 11 82e-7
VS27 19 s27 0
L27 s27 13 22e-5
VS28 3 s28 0
R28 s28 15 39e1
VS29 17 s29 0
V29 e29 s29 DC 0 AC 10e1 -120
RI29 e29 m29 10e-1
LI29 m29 15 47e-5
VS30 10 s30 0
V30 e30 s30 DC 0 AC 47e0 180
RI30 e30 23 33e-2
VS31 8 s31 0
C31 s31 21 15e-4
VS32 17 s32 0
V32 e32 s32 DC 0 AC 56e0 120
RI32 e32 7 15e-1
VS33 17 s33 0
L33 s33 12 39e-3
VS34 22 s34 0
R34 s34 18 12e0
VS35 12 s35 0
V35 e35 s35 DC 0 AC 82e1 120
RI35 e35 23 15e-1
VS36 0 s36 0
V36 e36 s36 DC 0 AC 27e1 0
RI36 e36 7 18e-1
VS37 11 s37 0
V37 e37 s37 DC 0 AC 39e-1 0
RI37 e37 m37 10e-2
LI37 m37 1 12e-5
.control
set numdgt=17
ac lin 1 60 60
print v(1) v(2) v(3) v(4) v(5) v(6) v(7) v(8) v(9) v(10)
print v(11) v(12) v(13) v(14) v(15) v(16) v(17) v(18) v(19) v(20)
print v(21) v(22) v(23)
print i(vs0) i(vs1) i(vs2) i(vs3) i(vs4) i(vs5) i(vs6) i(vs7) i(vs8) i(vs9)
print i(vs10) i(vs11) i(vs12) i(vs13) i(vs14) i(vs15) i(vs16) i(vs17) i(vs18) i(vs19)
print i(vs20) i(vs21) i(vs22) i(vs23) i(vs24) i(vs25) i(vs26) i(vs27) i(vs28) i(vs29)
print i(vs30) i(vs31) i(vs32) i(vs33) i(vs34) i(vs35) i(vs36) i(vs37)
.endc
.end
