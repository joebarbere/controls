controls oracle ac-0415
* Generated (plan F2.7, ADR 0012): do not edit; regenerate with `pnpm sim oracle regen`. ac seed 20261031 index 415 nodes 24 elements 34
.options sparse gmin=1e-12 noopac
RG1 1 0 1000000000000
RG2 2 0 1000000000000
RG3 3 0 1000000000000
RG4 4 0 1000000000000
RG5 5 0 1000000000000
RG6 6 0 1000000000000
RG7 7 0 1000000000000
RG8 8 0 1000000000000
RG9 9 0 1000000000000
RG10 10 0 1000000000000
RG11 11 0 1000000000000
RG12 12 0 1000000000000
RG13 13 0 1000000000000
RG14 14 0 1000000000000
RG15 15 0 1000000000000
RG16 16 0 1000000000000
RG17 17 0 1000000000000
RG18 18 0 1000000000000
RG19 19 0 1000000000000
RG20 20 0 1000000000000
RG21 21 0 1000000000000
RG22 22 0 1000000000000
RG23 23 0 1000000000000
VS0 6 s0 0
R0 s0 20 22e-2
VS1 12 s1 0
C1 s1 7 47e-6
VS2 21 s2 0
C2 s2 19 27e-6
VS3 0 s3 0
V3 e3 s3 DC 0 AC 47e0 180
RI3 e3 10 33e-2
VS4 12 s4 0
V4 e4 s4 DC 0 AC 82e1 120
RI4 e4 10 15e-1
VS5 7 s5 0
L5 s5 16 10e-2
VS6 3 s6 0
R6 s6 15 39e1
VS7 3 s7 0
C7 s7 7 39e-7
VS8 17 s8 0
V8 e8 s8 DC 0 AC 56e0 120
RI8 e8 7 15e-1
VS9 17 s9 0
L9 s9 12 39e-3
VS10 17 s10 0
V10 e10 s10 DC 0 AC 10e1 -120
RI10 e10 15 10e-1
VS11 5 s11 0
R11 s11 6 27e2
VS12 23 s12 0
V12 e12 s12 DC 0 AC 27e1 0
RI12 e12 7 18e-1
VS13 12 s13 0
R13 s13 7 47e-2
VS14 23 s14 0
V14 e14 s14 DC 0 AC 39e0 0
RI14 e14 10 82e-2
VS15 16 s15 0
L15 s15 12 10e-4
VS16 19 s16 0
L16 s16 13 22e-5
VS17 11 s17 0
V17 e17 s17 DC 0 AC 39e-1 0
RI17 e17 1 10e-2
VS18 8 s18 0
L18 s18 1 22e-4
VS19 22 s19 0
C19 s19 8 33e-7
VS20 12 s20 0
V20 e20 s20 DC 0 AC 33e-1 0
RI20 e20 0 39e-1
VS21 14 s21 0
R21 s21 10 39e-2
VS22 17 s22 0
C22 s22 11 82e-7
VS23 4 s23 0
C23 s23 23 10e-7
VS24 8 s24 0
C24 s24 21 15e-4
VS25 13 s25 0
V25 e25 s25 DC 0 AC 47e0 120
RI25 e25 23 22e-2
VS26 22 s26 0
L26 s26 9 18e-5
VS27 14 s27 0
R27 s27 6 82e-2
VS28 22 s28 0
R28 s28 18 12e0
VS29 2 s29 0
V29 e29 s29 DC 0 AC 68e0 -120
RI29 e29 5 47e-1
VS30 5 s30 0
R30 s30 1 82e0
VS31 14 s31 0
L31 s31 8 27e-2
VS32 22 s32 0
V32 e32 s32 DC 0 AC 15e0 180
RI32 e32 13 22e-1
VS33 5 s33 0
L33 s33 8 39e-5
.control
set numdgt=17
ac lin 1 60 60
print v(1) v(2) v(3) v(4) v(5) v(6) v(7) v(8) v(9) v(10)
print v(11) v(12) v(13) v(14) v(15) v(16) v(17) v(18) v(19) v(20)
print v(21) v(22) v(23)
print i(vs0) i(vs1) i(vs2) i(vs3) i(vs4) i(vs5) i(vs6) i(vs7) i(vs8) i(vs9)
print i(vs10) i(vs11) i(vs12) i(vs13) i(vs14) i(vs15) i(vs16) i(vs17) i(vs18) i(vs19)
print i(vs20) i(vs21) i(vs22) i(vs23) i(vs24) i(vs25) i(vs26) i(vs27) i(vs28) i(vs29)
print i(vs30) i(vs31) i(vs32) i(vs33)
.endc
.end
