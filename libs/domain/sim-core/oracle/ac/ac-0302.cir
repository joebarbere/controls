controls oracle ac-0302
* Generated (plan F2.7, ADR 0012): do not edit; regenerate with `pnpm sim oracle regen`. ac seed 20261031 index 302 nodes 13 elements 17
.options sparse gmin=1e-12 noopac
RG1 1 0 1000000000000
RG2 2 0 1000000000000
RG3 3 0 1000000000000
RG4 4 0 1000000000000
RG5 5 0 1000000000000
RG6 6 0 1000000000000
RG7 7 0 1000000000000
RG8 8 0 1000000000000
RG9 9 0 1000000000000
RG10 10 0 1000000000000
RG11 11 0 1000000000000
RG12 12 0 1000000000000
VS0 4 s0 0
C0 s0 6 18e-7
VS1 8 s1 0
R1 s1 2 22e-1
VS2 3 s2 0
R2 s2 9 68e2
VS3 10 s3 0
R3 s3 2 15e3
VS4 0 s4 0
L4 s4 11 39e-3
VS5 7 s5 0
R5 s5 9 82e-1
VS6 10 s6 0
R6 s6 1 68e1
VS7 12 s7 0
R7 s7 5 68e-1
VS8 12 s8 0
R8 s8 9 12e-2
VS9 8 s9 0
L9 s9 3 33e-2
VS10 7 s10 0
R10 s10 5 27e-1
VS11 10 s11 0
L11 s11 6 39e-3
VS12 5 s12 0
R12 s12 0 33e0
VS13 3 s13 0
L13 s13 6 22e-2
VS14 0 s14 0
V14 e14 s14 DC 0 AC 68e1 180
RI14 e14 1 10e-2
VS15 3 s15 0
R15 s15 11 68e-2
VS16 9 s16 0
R16 s16 4 12e3
.control
set numdgt=17
ac lin 1 60 60
print v(1) v(2) v(3) v(4) v(5) v(6) v(7) v(8) v(9) v(10)
print v(11) v(12)
print i(vs0) i(vs1) i(vs2) i(vs3) i(vs4) i(vs5) i(vs6) i(vs7) i(vs8) i(vs9)
print i(vs10) i(vs11) i(vs12) i(vs13) i(vs14) i(vs15) i(vs16)
.endc
.end
