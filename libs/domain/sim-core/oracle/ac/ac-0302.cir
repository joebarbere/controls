controls oracle ac-0302
* Generated (plan F2.7, ADR 0012): do not edit; regenerate with `pnpm sim oracle regen`. ac seed 20261031 index 302 nodes 13 elements 14
.options sparse gmin=1e-12 noopac
RG1 1 0 1000000000000
RG2 2 0 1000000000000
RG3 3 0 1000000000000
RG4 4 0 1000000000000
RG5 5 0 1000000000000
RG6 6 0 1000000000000
RG7 7 0 1000000000000
RG8 8 0 1000000000000
RG9 9 0 1000000000000
RG10 10 0 1000000000000
RG11 11 0 1000000000000
RG12 12 0 1000000000000
VS0 5 s0 0
R0 s0 0 33e0
VS1 8 s1 0
R1 s1 2 22e-1
VS2 0 s2 0
V2 e2 s2 DC 0 AC 68e1 180
RI2 e2 1 10e-2
VS3 3 s3 0
R3 s3 11 68e-2
VS4 9 s4 0
R4 s4 4 12e3
VS5 3 s5 0
R5 s5 9 68e2
VS6 1 s6 0
L6 s6 0 33e-5
VS7 10 s7 0
L7 s7 6 39e-3
VS8 7 s8 0
R8 s8 9 82e-1
VS9 4 s9 0
C9 s9 6 18e-7
VS10 8 s10 0
L10 s10 3 33e-2
VS11 12 s11 0
R11 s11 5 68e-1
VS12 3 s12 0
L12 s12 6 22e-2
VS13 7 s13 0
R13 s13 5 27e-1
.control
set numdgt=17
ac lin 1 60 60
print v(1) v(2) v(3) v(4) v(5) v(6) v(7) v(8) v(9) v(10)
print v(11) v(12)
print i(vs0) i(vs1) i(vs2) i(vs3) i(vs4) i(vs5) i(vs6) i(vs7) i(vs8) i(vs9)
print i(vs10) i(vs11) i(vs12) i(vs13)
.endc
.end
