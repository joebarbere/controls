controls oracle ac-0302
* Generated (plan F2.7, ADR 0012): do not edit; regenerate with `pnpm sim oracle regen`. ac seed 20261031 index 302 nodes 13 elements 23
.options sparse gmin=1e-12 noopac
RG1 1 0 1000000000000
RG2 2 0 1000000000000
RG3 3 0 1000000000000
RG4 4 0 1000000000000
RG5 5 0 1000000000000
RG6 6 0 1000000000000
RG7 7 0 1000000000000
RG8 8 0 1000000000000
RG9 9 0 1000000000000
RG10 10 0 1000000000000
RG11 11 0 1000000000000
RG12 12 0 1000000000000
VS0 7 s0 0
R0 s0 5 27e-1
VS1 3 s1 0
R1 s1 2 12e3
VS2 4 s2 0
C2 s2 6 18e-7
VS3 2 s3 0
R3 s3 1 33e-1
VS4 0 s4 0
R4 s4 5 39e0
VS5 0 s5 0
V5 e5 s5 DC 0 AC 10e-1 0
RI5 e5 m5 12e-3
LI5 m5 7 68e-7
VS6 5 s6 0
R6 s6 9 33e0
VS7 4 s7 0
R7 s7 5 56e3
VS8 10 s8 0
C8 s8 9 33e-5
VS9 7 s9 0
R9 s9 8 82e-1
VS10 3 s10 0
L10 s10 6 22e-2
VS11 1 s11 0
R11 s11 8 18e3
VS12 5 s12 0
C12 s12 7 27e-6
VS13 3 s13 0
L13 s13 12 27e-2
VS14 9 s14 0
V14 e14 s14 DC 0 AC 68e1 180
RI14 e14 1 10e-2
VS15 3 s15 0
R15 s15 8 68e2
VS16 10 s16 0
C16 s16 6 33e-5
VS17 10 s17 0
L17 s17 11 10e-5
VS18 9 s18 0
L18 s18 8 27e-4
VS19 1 s19 0
L19 s19 11 10e-4
VS20 12 s20 0
R20 s20 5 68e-1
VS21 8 s21 0
R21 s21 0 82e-2
VS22 0 s22 0
L22 s22 3 68e-5
.control
set numdgt=17
ac lin 1 60 60
print v(1) v(2) v(3) v(4) v(5) v(6) v(7) v(8) v(9) v(10)
print v(11) v(12)
print i(vs0) i(vs1) i(vs2) i(vs3) i(vs4) i(vs5) i(vs6) i(vs7) i(vs8) i(vs9)
print i(vs10) i(vs11) i(vs12) i(vs13) i(vs14) i(vs15) i(vs16) i(vs17) i(vs18) i(vs19)
print i(vs20) i(vs21) i(vs22)
.endc
.end
