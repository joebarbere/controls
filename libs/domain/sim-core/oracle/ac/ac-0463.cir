controls oracle ac-0463
* Generated (plan F2.7, ADR 0012): do not edit; regenerate with `pnpm sim oracle regen`. ac seed 20261031 index 463 nodes 6 elements 11
.options sparse gmin=1e-12 noopac
RG1 1 0 1000000000000
RG2 2 0 1000000000000
RG3 3 0 1000000000000
RG4 4 0 1000000000000
RG5 5 0 1000000000000
VS0 4 s0 0
R0 s0 5 33e3
VS1 0 s1 0
V1 e1 s1 DC 0 AC 22e0 0
RI1 e1 n1 15e-1
H1 n1 h1 VS2 39e-3
ED1 h1 3 d1 0 -12e-5
F1 0 d1 VS2 1
LD1 d1 0 1
VS2 0 s2 0
V2 e2 s2 DC 0 AC 56e0 -120
RI2 e2 m2 47e-2
LI2 m2 n2 68e-7
H2 n2 h2 VS1 39e-3
ED2 h2 3 d2 0 -12e-5
F2 0 d2 VS1 1
LD2 d2 0 1
VS3 5 s3 0
L3 s3 1 68e-2
VS4 3 s4 0
C4 s4 2 15e-7
VS5 2 s5 0
R5 s5 0 22e3
VS6 3 s6 0
L6 s6 1 10e-3
VS7 0 s7 0
L7 s7 5 47e-2
VS8 4 s8 0
V8 e8 s8 DC 0 AC 56e1 120
RI8 e8 m8 68e-3
LI8 m8 3 82e-5
VS9 0 s9 0
R9 s9 2 56e-2
VS10 4 s10 0
R10 s10 3 33e-1
.control
set numdgt=17
ac lin 1 60 60
print v(1) v(2) v(3) v(4) v(5)
print i(vs0) i(vs1) i(vs2) i(vs3) i(vs4) i(vs5) i(vs6) i(vs7) i(vs8) i(vs9)
print i(vs10)
.endc
.end
