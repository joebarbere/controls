controls oracle ac-0463
* Generated (plan F2.7, ADR 0012): do not edit; regenerate with `pnpm sim oracle regen`. ac seed 20261031 index 463 nodes 6 elements 10
.options sparse gmin=1e-12 noopac
RG1 1 0 1000000000000
RG2 2 0 1000000000000
RG3 3 0 1000000000000
RG4 4 0 1000000000000
RG5 5 0 1000000000000
VS0 0 s0 0
V0 e0 s0 DC 0 AC 56e1 120
RI0 e0 3 68e-3
VS1 5 s1 0
L1 s1 1 68e-2
VS2 4 s2 0
V2 e2 s2 DC 0 AC 56e0 -120
RI2 e2 3 47e-2
VS3 0 s3 0
R3 s3 5 33e3
VS4 0 s4 0
R4 s4 3 33e-1
VS5 3 s5 0
L5 s5 1 10e-3
VS6 4 s6 0
V6 e6 s6 DC 0 AC 22e0 0
RI6 e6 3 15e-1
VS7 4 s7 0
R7 s7 2 56e-2
VS8 2 s8 0
R8 s8 4 22e3
VS9 4 s9 0
L9 s9 5 47e-2
.control
set numdgt=17
ac lin 1 60 60
print v(1) v(2) v(3) v(4) v(5)
print i(vs0) i(vs1) i(vs2) i(vs3) i(vs4) i(vs5) i(vs6) i(vs7) i(vs8) i(vs9)
.endc
.end
