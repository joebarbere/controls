controls oracle ac-0463
* Generated (plan F2.7, ADR 0012): do not edit; regenerate with `pnpm sim oracle regen`. ac seed 20261031 index 463 nodes 6 elements 11
.options sparse gmin=1e-12 noopac
RG1 1 0 1000000000000
RG2 2 0 1000000000000
RG3 3 0 1000000000000
RG4 4 0 1000000000000
RG5 5 0 1000000000000
VS0 1 s0 0
R0 s0 5 18e0
VS1 3 s1 0
C1 s1 5 82e-6
VS2 0 s2 0
V2 e2 s2 DC 0 AC 22e0 0
RI2 e2 m2 15e-1
LI2 m2 3 22e-6
VS3 2 s3 0
R3 s3 0 68e0
VS4 5 s4 0
C4 s4 0 10e-6
VS5 0 s5 0
R5 s5 5 82e0
VS6 2 s6 0
C6 s6 1 33e-5
VS7 5 s7 0
L7 s7 2 12e-5
VS8 2 s8 0
R8 s8 4 56e0
VS9 4 s9 0
V9 e9 s9 DC 0 AC 56e0 -120
RI9 e9 0 15e-3
VS10 1 s10 0
V10 e10 s10 DC 0 AC 56e0 180
RI10 e10 3 47e-3
.control
set numdgt=17
ac lin 1 60 60
print v(1) v(2) v(3) v(4) v(5)
print i(vs0) i(vs1) i(vs2) i(vs3) i(vs4) i(vs5) i(vs6) i(vs7) i(vs8) i(vs9)
print i(vs10)
.endc
.end
