controls oracle ac-0480
* Generated (plan F2.7, ADR 0012): do not edit; regenerate with `pnpm sim oracle regen`. ac seed 20261031 index 480 nodes 4 elements 4
.options sparse gmin=1e-12 noopac
RG1 1 0 1000000000000
RG2 2 0 1000000000000
RG3 3 0 1000000000000
VS0 2 s0 0
C0 s0 0 27e-4
VS1 0 s1 0
V1 e1 s1 DC 0 AC 47e-1 120
RI1 e1 1 39e-3
VS2 2 s2 0
V2 e2 s2 DC 0 AC 10e-1 120
RI2 e2 1 82e-1
VS3 3 s3 0
V3 e3 s3 DC 0 AC 22e1 180
RI3 e3 2 56e-1
.control
set numdgt=17
ac lin 1 60 60
print v(1) v(2) v(3)
print i(vs0) i(vs1) i(vs2) i(vs3)
.endc
.end
