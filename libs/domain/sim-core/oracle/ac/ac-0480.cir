controls oracle ac-0480
* Generated (plan F2.7, ADR 0012): do not edit; regenerate with `pnpm sim oracle regen`. ac seed 20261031 index 480 nodes 4 elements 7
.options sparse gmin=1e-12 noopac
RG1 1 0 1000000000000
RG2 2 0 1000000000000
RG3 3 0 1000000000000
VS0 0 s0 0
V0 e0 s0 DC 0 AC 22e1 180
RI0 e0 2 56e-1
VS1 3 s1 0
L1 s1 1 82e-3
VS2 0 s2 0
L2 s2 2 33e-3
VS3 3 s3 0
V3 e3 s3 DC 0 AC 39e0 0
RI3 e3 0 15e-1
VS4 3 s4 0
L4 s4 0 15e-2
VS5 1 s5 0
R5 s5 2 47e3
VS6 0 s6 0
R6 s6 1 68e-2
.control
set numdgt=17
ac lin 1 60 60
print v(1) v(2) v(3)
print i(vs0) i(vs1) i(vs2) i(vs3) i(vs4) i(vs5) i(vs6)
.endc
.end
