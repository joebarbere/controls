controls oracle ac-0312
* Generated (plan F2.7, ADR 0012): do not edit; regenerate with `pnpm sim oracle regen`. ac seed 20261031 index 312 nodes 21 elements 33
.options sparse gmin=1e-12 noopac
RG1 1 0 1000000000000
RG2 2 0 1000000000000
RG3 3 0 1000000000000
RG4 4 0 1000000000000
RG5 5 0 1000000000000
RG6 6 0 1000000000000
RG7 7 0 1000000000000
RG8 8 0 1000000000000
RG9 9 0 1000000000000
RG10 10 0 1000000000000
RG11 11 0 1000000000000
RG12 12 0 1000000000000
RG13 13 0 1000000000000
RG14 14 0 1000000000000
RG15 15 0 1000000000000
RG16 16 0 1000000000000
RG17 17 0 1000000000000
RG18 18 0 1000000000000
RG19 19 0 1000000000000
RG20 20 0 1000000000000
VS0 17 s0 0
C0 s0 13 12e-4
VS1 18 s1 0
R1 s1 19 27e3
VS2 10 s2 0
C2 s2 7 68e-5
VS3 13 s3 0
C3 s3 1 47e-6
VS4 9 s4 0
R4 s4 10 47e-2
VS5 10 s5 0
C5 s5 11 12e-6
VS6 8 s6 0
R6 s6 13 18e0
VS7 6 s7 0
C7 s7 12 82e-6
VS8 13 s8 0
L8 s8 20 12e-4
VS9 15 s9 0
C9 s9 16 82e-5
VS10 1 s10 0
C10 s10 18 27e-4
VS11 14 s11 0
R11 s11 20 47e-1
VS12 11 s12 0
L12 s12 3 18e-4
VS13 7 s13 0
L13 s13 3 47e-2
VS14 0 s14 0
V14 e14 s14 DC 0 AC 33e0 180
RI14 e14 13 12e-1
VS15 4 s15 0
C15 s15 13 33e-4
VS16 12 s16 0
R16 s16 13 22e-2
VS17 1 s17 0
L17 s17 6 12e-2
VS18 18 s18 0
R18 s18 11 39e3
VS19 18 s19 0
R19 s19 0 56e-2
VS20 15 s20 0
V20 e20 s20 DC 0 AC 10e-1 -120
RI20 e20 9 15e-2
VS21 4 s21 0
R21 s21 19 39e1
VS22 17 s22 0
L22 s22 11 47e-5
VS23 12 s23 0
L23 s23 13 39e-5
VS24 5 s24 0
C24 s24 19 47e-6
VS25 19 s25 0
R25 s25 10 39e0
VS26 11 s26 0
L26 s26 16 10e-4
VS27 8 s27 0
C27 s27 2 27e-6
VS28 11 s28 0
C28 s28 5 47e-6
VS29 2 s29 0
L29 s29 20 39e-3
VS30 11 s30 0
L30 s30 16 12e-4
VS31 15 s31 0
C31 s31 14 12e-6
VS32 20 s32 0
C32 s32 7 47e-7
.control
set numdgt=17
ac lin 1 60 60
print v(1) v(2) v(3) v(4) v(5) v(6) v(7) v(8) v(9) v(10)
print v(11) v(12) v(13) v(14) v(15) v(16) v(17) v(18) v(19) v(20)
print i(vs0) i(vs1) i(vs2) i(vs3) i(vs4) i(vs5) i(vs6) i(vs7) i(vs8) i(vs9)
print i(vs10) i(vs11) i(vs12) i(vs13) i(vs14) i(vs15) i(vs16) i(vs17) i(vs18) i(vs19)
print i(vs20) i(vs21) i(vs22) i(vs23) i(vs24) i(vs25) i(vs26) i(vs27) i(vs28) i(vs29)
print i(vs30) i(vs31) i(vs32)
.endc
.end
