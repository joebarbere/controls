controls oracle ac-0312
* Generated (plan F2.7, ADR 0012): do not edit; regenerate with `pnpm sim oracle regen`. ac seed 20261031 index 312 nodes 21 elements 26
.options sparse gmin=1e-12 noopac
RG1 1 0 1000000000000
RG2 2 0 1000000000000
RG3 3 0 1000000000000
RG4 4 0 1000000000000
RG5 5 0 1000000000000
RG6 6 0 1000000000000
RG7 7 0 1000000000000
RG8 8 0 1000000000000
RG9 9 0 1000000000000
RG10 10 0 1000000000000
RG11 11 0 1000000000000
RG12 12 0 1000000000000
RG13 13 0 1000000000000
RG14 14 0 1000000000000
RG15 15 0 1000000000000
RG16 16 0 1000000000000
RG17 17 0 1000000000000
RG18 18 0 1000000000000
RG19 19 0 1000000000000
RG20 20 0 1000000000000
VS0 6 s0 0
C0 s0 12 82e-6
VS1 11 s1 0
C1 s1 5 47e-6
VS2 20 s2 0
C2 s2 15 47e-7
VS3 9 s3 0
R3 s3 10 47e-2
VS4 11 s4 0
L4 s4 16 12e-4
VS5 8 s5 0
R5 s5 13 18e0
VS6 10 s6 0
C6 s6 15 68e-5
VS7 14 s7 0
R7 s7 20 47e-1
VS8 12 s8 0
L8 s8 13 39e-5
VS9 2 s9 0
L9 s9 20 39e-3
VS10 12 s10 0
R10 s10 13 22e-2
VS11 19 s11 0
R11 s11 10 39e0
VS12 17 s12 0
L12 s12 11 47e-5
VS13 0 s13 0
C13 s13 16 82e-5
VS14 4 s14 0
C14 s14 13 33e-4
VS15 11 s15 0
L15 s15 16 10e-4
VS16 0 s16 0
V16 e16 s16 DC 0 AC 10e-1 -120
RI16 e16 9 15e-2
VS17 11 s17 0
L17 s17 3 18e-4
VS18 1 s18 0
C18 s18 18 27e-4
VS19 18 s19 0
R19 s19 7 56e-2
VS20 13 s20 0
L20 s20 20 12e-4
VS21 10 s21 0
C21 s21 11 12e-6
VS22 13 s22 0
C22 s22 1 47e-6
VS23 16 s23 0
V23 e23 s23 DC 0 AC 15e1 180
RI23 e23 14 22e-1
VS24 18 s24 0
R24 s24 11 39e3
VS25 19 s25 0
V25 e25 s25 DC 0 AC 47e-1 0
RI25 e25 18 10e-2
.control
set numdgt=17
ac lin 1 60 60
print v(1) v(2) v(3) v(4) v(5) v(6) v(7) v(8) v(9) v(10)
print v(11) v(12) v(13) v(14) v(15) v(16) v(17) v(18) v(19) v(20)
print i(vs0) i(vs1) i(vs2) i(vs3) i(vs4) i(vs5) i(vs6) i(vs7) i(vs8) i(vs9)
print i(vs10) i(vs11) i(vs12) i(vs13) i(vs14) i(vs15) i(vs16) i(vs17) i(vs18) i(vs19)
print i(vs20) i(vs21) i(vs22) i(vs23) i(vs24) i(vs25)
.endc
.end
