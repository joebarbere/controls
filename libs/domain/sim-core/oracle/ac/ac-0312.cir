controls oracle ac-0312
* Generated (plan F2.7, ADR 0012): do not edit; regenerate with `pnpm sim oracle regen`. ac seed 20261031 index 312 nodes 21 elements 34
.options sparse gmin=1e-12 noopac
RG1 1 0 1000000000000
RG2 2 0 1000000000000
RG3 3 0 1000000000000
RG4 4 0 1000000000000
RG5 5 0 1000000000000
RG6 6 0 1000000000000
RG7 7 0 1000000000000
RG8 8 0 1000000000000
RG9 9 0 1000000000000
RG10 10 0 1000000000000
RG11 11 0 1000000000000
RG12 12 0 1000000000000
RG13 13 0 1000000000000
RG14 14 0 1000000000000
RG15 15 0 1000000000000
RG16 16 0 1000000000000
RG17 17 0 1000000000000
RG18 18 0 1000000000000
RG19 19 0 1000000000000
RG20 20 0 1000000000000
VS0 11 s0 0
L0 s0 16 10e-4
VS1 10 s1 0
R1 s1 2 68e1
VS2 10 s2 0
R2 s2 4 56e2
VS3 0 s3 0
V3 e3 s3 DC 0 AC 10e-1 -120
RI3 e3 9 15e-2
VS4 6 s4 0
C4 s4 12 82e-6
VS5 1 s5 0
C5 s5 18 27e-4
VS6 10 s6 0
C6 s6 11 12e-6
VS7 13 s7 0
L7 s7 20 12e-4
VS8 17 s8 0
L8 s8 11 47e-5
VS9 4 s9 0
C9 s9 13 33e-4
VS10 11 s10 0
L10 s10 16 12e-4
VS11 11 s11 0
C11 s11 5 47e-6
VS12 20 s12 0
C12 s12 15 47e-7
VS13 10 s13 0
C13 s13 15 68e-5
VS14 9 s14 0
R14 s14 10 47e-2
VS15 18 s15 0
R15 s15 11 39e3
VS16 16 s16 0
V16 e16 s16 DC 0 AC 15e1 180
RI16 e16 m16 22e-1
LI16 m16 14 68e-5
VS17 6 s17 0
L17 s17 13 27e-5
VS18 19 s18 0
V18 e18 s18 DC 0 AC 47e-1 0
RI18 e18 18 10e-2
VS19 18 s19 0
R19 s19 7 56e-2
VS20 5 s20 0
V20 e20 s20 DC 0 AC 68e1 -120
RI20 e20 8 82e-2
VS21 12 s21 0
L21 s21 13 39e-5
VS22 13 s22 0
C22 s22 1 47e-6
VS23 0 s23 0
C23 s23 16 82e-5
VS24 8 s24 0
R24 s24 13 18e0
VS25 14 s25 0
R25 s25 20 47e-1
VS26 3 s26 0
R26 s26 0 18e2
VS27 2 s27 0
L27 s27 20 39e-3
VS28 11 s28 0
L28 s28 3 18e-4
VS29 7 s29 0
L29 s29 9 56e-5
VS30 12 s30 0
C30 s30 18 18e-6
VS31 17 s31 0
V31 e31 s31 DC 0 AC 27e0 120
RI31 e31 m31 33e-1
LI31 m31 0 12e-7
VS32 12 s32 0
R32 s32 13 22e-2
VS33 19 s33 0
R33 s33 10 39e0
.control
set numdgt=17
ac lin 1 60 60
print v(1) v(2) v(3) v(4) v(5) v(6) v(7) v(8) v(9) v(10)
print v(11) v(12) v(13) v(14) v(15) v(16) v(17) v(18) v(19) v(20)
print i(vs0) i(vs1) i(vs2) i(vs3) i(vs4) i(vs5) i(vs6) i(vs7) i(vs8) i(vs9)
print i(vs10) i(vs11) i(vs12) i(vs13) i(vs14) i(vs15) i(vs16) i(vs17) i(vs18) i(vs19)
print i(vs20) i(vs21) i(vs22) i(vs23) i(vs24) i(vs25) i(vs26) i(vs27) i(vs28) i(vs29)
print i(vs30) i(vs31) i(vs32) i(vs33)
.endc
.end
