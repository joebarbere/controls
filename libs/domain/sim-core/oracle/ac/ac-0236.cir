controls oracle ac-0236
* Generated (plan F2.7, ADR 0012): do not edit; regenerate with `pnpm sim oracle regen`. ac seed 20261031 index 236 nodes 16 elements 23
.options sparse gmin=1e-12 noopac
RG1 1 0 1000000000000
RG2 2 0 1000000000000
RG3 3 0 1000000000000
RG4 4 0 1000000000000
RG5 5 0 1000000000000
RG6 6 0 1000000000000
RG7 7 0 1000000000000
RG8 8 0 1000000000000
RG9 9 0 1000000000000
RG10 10 0 1000000000000
RG11 11 0 1000000000000
RG12 12 0 1000000000000
RG13 13 0 1000000000000
RG14 14 0 1000000000000
RG15 15 0 1000000000000
VS0 13 s0 0
C0 s0 5 15e-6
VS1 6 s1 0
R1 s1 8 39e-2
VS2 3 s2 0
R2 s2 2 18e1
VS3 10 s3 0
R3 s3 3 68e0
VS4 0 s4 0
V4 e4 s4 DC 0 AC 15e1 0
RI4 e4 m4 22e-1
LI4 m4 2 12e-6
VS5 8 s5 0
C5 s5 0 82e-6
VS6 5 s6 0
R6 s6 7 15e-2
VS7 6 s7 0
C7 s7 5 18e-4
VS8 14 s8 0
R8 s8 13 18e0
VS9 11 s9 0
C9 s9 13 18e-5
VS10 12 s10 0
R10 s10 6 27e-1
VS11 6 s11 0
R11 s11 12 15e1
VS12 1 s12 0
L12 s12 7 82e-4
VS13 11 s13 0
V13 e13 s13 DC 0 AC 39e1 120
RI13 e13 m13 56e-1
LI13 m13 7 56e-7
VS14 14 s14 0
V14 e14 s14 DC 0 AC 39e-1 180
RI14 e14 m14 27e-3
LI14 m14 4 47e-5
VS15 14 s15 0
C15 s15 3 27e-4
VS16 6 s16 0
L16 s16 3 12e-5
VS17 15 s17 0
R17 s17 12 10e1
VS18 1 s18 0
R18 s18 12 22e2
VS19 3 s19 0
C19 s19 9 22e-5
VS20 9 s20 0
C20 s20 15 12e-7
VS21 2 s21 0
R21 s21 4 68e-2
VS22 10 s22 0
L22 s22 0 15e-3
.control
set numdgt=17
ac lin 1 60 60
print v(1) v(2) v(3) v(4) v(5) v(6) v(7) v(8) v(9) v(10)
print v(11) v(12) v(13) v(14) v(15)
print i(vs0) i(vs1) i(vs2) i(vs3) i(vs4) i(vs5) i(vs6) i(vs7) i(vs8) i(vs9)
print i(vs10) i(vs11) i(vs12) i(vs13) i(vs14) i(vs15) i(vs16) i(vs17) i(vs18) i(vs19)
print i(vs20) i(vs21) i(vs22)
.endc
.end
