controls oracle ac-0236
* Generated (plan F2.7, ADR 0012): do not edit; regenerate with `pnpm sim oracle regen`. ac seed 20261031 index 236 nodes 16 elements 22
.options sparse gmin=1e-12 noopac
RG1 1 0 1000000000000
RG2 2 0 1000000000000
RG3 3 0 1000000000000
RG4 4 0 1000000000000
RG5 5 0 1000000000000
RG6 6 0 1000000000000
RG7 7 0 1000000000000
RG8 8 0 1000000000000
RG9 9 0 1000000000000
RG10 10 0 1000000000000
RG11 11 0 1000000000000
RG12 12 0 1000000000000
RG13 13 0 1000000000000
RG14 14 0 1000000000000
RG15 15 0 1000000000000
VS0 5 s0 0
L0 s0 3 12e-5
VS1 7 s1 0
R1 s1 14 33e1
VS2 5 s2 0
C2 s2 0 18e-4
VS3 3 s3 0
R3 s3 2 18e1
VS4 0 s4 0
V4 e4 s4 DC 0 AC 47e1 -120
RI4 e4 m4 82e-2
LI4 m4 n4 12e-6
H4 n4 h4 VS7 27e-4
ED4 h4 8 d4 0 56e-7
F4 0 d4 VS7 1
LD4 d4 0 1
VS5 10 s5 0
R5 s5 3 82e3
VS6 13 s6 0
C6 s6 0 15e-6
VS7 13 s7 0
V7 e7 s7 DC 0 AC 68e-1 120
RI7 e7 n7 39e-3
H7 n7 h7 VS4 27e-4
ED7 h7 1 d7 0 56e-7
F7 0 d7 VS4 1
LD7 d7 0 1
VS8 5 s8 0
R8 s8 12 15e1
VS9 15 s9 0
R9 s9 12 10e1
VS10 14 s10 0
V10 e10 s10 DC 0 AC 39e-1 180
RI10 e10 m10 27e-3
LI10 m10 4 68e-7
VS11 8 s11 0
C11 s11 15 22e-5
VS12 11 s12 0
L12 s12 4 18e-5
VS13 0 s13 0
R13 s13 10 18e-1
VS14 14 s14 0
C14 s14 3 27e-4
VS15 6 s15 0
V15 e15 s15 DC 0 AC 15e1 0
RI15 e15 2 22e-1
VS16 14 s16 0
R16 s16 1 27e-1
VS17 2 s17 0
L17 s17 9 12e-3
VS18 6 s18 0
R18 s18 12 22e1
VS19 7 s19 0
L19 s19 5 56e-2
VS20 12 s20 0
R20 s20 5 27e-1
VS21 9 s21 0
R21 s21 11 33e0
.control
set numdgt=17
ac lin 1 60 60
print v(1) v(2) v(3) v(4) v(5) v(6) v(7) v(8) v(9) v(10)
print v(11) v(12) v(13) v(14) v(15)
print i(vs0) i(vs1) i(vs2) i(vs3) i(vs4) i(vs5) i(vs6) i(vs7) i(vs8) i(vs9)
print i(vs10) i(vs11) i(vs12) i(vs13) i(vs14) i(vs15) i(vs16) i(vs17) i(vs18) i(vs19)
print i(vs20) i(vs21)
.endc
.end
