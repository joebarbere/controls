controls oracle ac-0236
* Generated (plan F2.7, ADR 0012): do not edit; regenerate with `pnpm sim oracle regen`. ac seed 20261031 index 236 nodes 16 elements 20
.options sparse gmin=1e-12 noopac
RG1 1 0 1000000000000
RG2 2 0 1000000000000
RG3 3 0 1000000000000
RG4 4 0 1000000000000
RG5 5 0 1000000000000
RG6 6 0 1000000000000
RG7 7 0 1000000000000
RG8 8 0 1000000000000
RG9 9 0 1000000000000
RG10 10 0 1000000000000
RG11 11 0 1000000000000
RG12 12 0 1000000000000
RG13 13 0 1000000000000
RG14 14 0 1000000000000
RG15 15 0 1000000000000
VS0 12 s0 0
R0 s0 6 27e-1
VS1 6 s1 0
C1 s1 5 18e-4
VS2 6 s2 0
R2 s2 12 15e1
VS3 0 s3 0
R3 s3 12 22e1
VS4 0 s4 0
V4 e4 s4 DC 0 AC 15e1 0
RI4 e4 2 22e-1
VS5 13 s5 0
C5 s5 5 15e-6
VS6 14 s6 0
V6 e6 s6 DC 0 AC 39e-1 180
RI6 e6 4 27e-3
VS7 10 s7 0
R7 s7 3 82e3
VS8 15 s8 0
R8 s8 12 10e1
VS9 6 s9 0
L9 s9 3 12e-5
VS10 3 s10 0
R10 s10 2 18e1
VS11 2 s11 0
L11 s11 9 12e-3
VS12 14 s12 0
R12 s12 1 27e-1
VS13 14 s13 0
C13 s13 3 27e-4
VS14 8 s14 0
C14 s14 15 22e-5
VS15 7 s15 0
R15 s15 14 33e1
VS16 5 s16 0
R16 s16 10 18e-1
VS17 13 s17 0
V17 e17 s17 DC 0 AC 68e-1 120
RI17 e17 1 39e-3
VS18 9 s18 0
R18 s18 11 33e0
VS19 7 s19 0
L19 s19 6 56e-2
.control
set numdgt=17
ac lin 1 60 60
print v(1) v(2) v(3) v(4) v(5) v(6) v(7) v(8) v(9) v(10)
print v(11) v(12) v(13) v(14) v(15)
print i(vs0) i(vs1) i(vs2) i(vs3) i(vs4) i(vs5) i(vs6) i(vs7) i(vs8) i(vs9)
print i(vs10) i(vs11) i(vs12) i(vs13) i(vs14) i(vs15) i(vs16) i(vs17) i(vs18) i(vs19)
.endc
.end
