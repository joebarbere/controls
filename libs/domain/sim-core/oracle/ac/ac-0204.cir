controls oracle ac-0204
* Generated (plan F2.7, ADR 0012): do not edit; regenerate with `pnpm sim oracle regen`. ac seed 20261031 index 204 nodes 27 elements 34
.options sparse gmin=1e-12 noopac
RG1 1 0 1000000000000
RG2 2 0 1000000000000
RG3 3 0 1000000000000
RG4 4 0 1000000000000
RG5 5 0 1000000000000
RG6 6 0 1000000000000
RG7 7 0 1000000000000
RG8 8 0 1000000000000
RG9 9 0 1000000000000
RG10 10 0 1000000000000
RG11 11 0 1000000000000
RG12 12 0 1000000000000
RG13 13 0 1000000000000
RG14 14 0 1000000000000
RG15 15 0 1000000000000
RG16 16 0 1000000000000
RG17 17 0 1000000000000
RG18 18 0 1000000000000
RG19 19 0 1000000000000
RG20 20 0 1000000000000
RG21 21 0 1000000000000
RG22 22 0 1000000000000
RG23 23 0 1000000000000
RG24 24 0 1000000000000
RG25 25 0 1000000000000
RG26 26 0 1000000000000
VS0 2 s0 0
C0 s0 11 18e-4
VS1 8 s1 0
L1 s1 2 27e-5
VS2 22 s2 0
R2 s2 17 82e-1
VS3 0 s3 0
V3 e3 s3 DC 0 AC 18e0 120
RI3 e3 9 15e-2
VS4 18 s4 0
L4 s4 7 10e-3
VS5 16 s5 0
V5 e5 s5 DC 0 AC 22e1 -120
RI5 e5 9 68e-3
VS6 20 s6 0
V6 e6 s6 DC 0 AC 47e0 120
RI6 e6 2 33e-1
VS7 23 s7 0
R7 s7 21 15e3
VS8 14 s8 0
V8 e8 s8 DC 0 AC 22e1 -120
RI8 e8 2 22e-2
VS9 5 s9 0
L9 s9 0 22e-5
VS10 1 s10 0
C10 s10 5 22e-5
VS11 7 s11 0
V11 e11 s11 DC 0 AC 39e1 0
RI11 e11 25 39e-2
VS12 22 s12 0
L12 s12 11 68e-2
VS13 23 s13 0
R13 s13 12 47e0
VS14 26 s14 0
V14 e14 s14 DC 0 AC 68e1 120
RI14 e14 15 22e-3
VS15 21 s15 0
C15 s15 16 15e-7
VS16 10 s16 0
V16 e16 s16 DC 0 AC 27e-1 0
RI16 e16 12 33e-2
VS17 24 s17 0
C17 s17 20 39e-7
VS18 2 s18 0
V18 e18 s18 DC 0 AC 56e0 0
RI18 e18 16 82e-3
VS19 18 s19 0
L19 s19 9 33e-2
VS20 16 s20 0
C20 s20 12 22e-5
VS21 1 s21 0
V21 e21 s21 DC 0 AC 39e0 0
RI21 e21 18 10e-2
VS22 11 s22 0
V22 e22 s22 DC 0 AC 56e0 -120
RI22 e22 3 68e-2
VS23 1 s23 0
L23 s23 12 12e-3
VS24 16 s24 0
L24 s24 22 10e-2
VS25 19 s25 0
C25 s25 2 56e-5
VS26 26 s26 0
C26 s26 16 33e-6
VS27 7 s27 0
C27 s27 14 22e-6
VS28 4 s28 0
L28 s28 15 27e-3
VS29 16 s29 0
L29 s29 24 47e-5
VS30 21 s30 0
C30 s30 13 15e-6
VS31 15 s31 0
L31 s31 16 82e-4
VS32 2 s32 0
L32 s32 23 47e-2
VS33 0 s33 0
V33 e33 s33 DC 0 AC 27e0 0
RI33 e33 6 12e-3
.control
set numdgt=17
ac lin 1 60 60
print v(1) v(2) v(3) v(4) v(5) v(6) v(7) v(8) v(9) v(10)
print v(11) v(12) v(13) v(14) v(15) v(16) v(17) v(18) v(19) v(20)
print v(21) v(22) v(23) v(24) v(25) v(26)
print i(vs0) i(vs1) i(vs2) i(vs3) i(vs4) i(vs5) i(vs6) i(vs7) i(vs8) i(vs9)
print i(vs10) i(vs11) i(vs12) i(vs13) i(vs14) i(vs15) i(vs16) i(vs17) i(vs18) i(vs19)
print i(vs20) i(vs21) i(vs22) i(vs23) i(vs24) i(vs25) i(vs26) i(vs27) i(vs28) i(vs29)
print i(vs30) i(vs31) i(vs32) i(vs33)
.endc
.end
