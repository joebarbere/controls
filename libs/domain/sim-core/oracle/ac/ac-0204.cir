controls oracle ac-0204
* Generated (plan F2.7, ADR 0012): do not edit; regenerate with `pnpm sim oracle regen`. ac seed 20261031 index 204 nodes 27 elements 42
.options sparse gmin=1e-12 noopac
RG1 1 0 1000000000000
RG2 2 0 1000000000000
RG3 3 0 1000000000000
RG4 4 0 1000000000000
RG5 5 0 1000000000000
RG6 6 0 1000000000000
RG7 7 0 1000000000000
RG8 8 0 1000000000000
RG9 9 0 1000000000000
RG10 10 0 1000000000000
RG11 11 0 1000000000000
RG12 12 0 1000000000000
RG13 13 0 1000000000000
RG14 14 0 1000000000000
RG15 15 0 1000000000000
RG16 16 0 1000000000000
RG17 17 0 1000000000000
RG18 18 0 1000000000000
RG19 19 0 1000000000000
RG20 20 0 1000000000000
RG21 21 0 1000000000000
RG22 22 0 1000000000000
RG23 23 0 1000000000000
RG24 24 0 1000000000000
RG25 25 0 1000000000000
RG26 26 0 1000000000000
VS0 23 s0 0
R0 s0 12 47e0
VS1 8 s1 0
R1 s1 18 68e0
VS2 7 s2 0
L2 s2 23 47e-2
VS3 17 s3 0
L3 s3 2 82e-2
VS4 16 s4 0
L4 s4 22 10e-2
VS5 13 s5 0
R5 s5 3 68e-2
VS6 21 s6 0
C6 s6 13 15e-6
VS7 5 s7 0
L7 s7 2 22e-5
VS8 3 s8 0
R8 s8 10 47e3
VS9 0 s9 0
V9 e9 s9 DC 0 AC 39e1 0
RI9 e9 m9 39e-2
LI9 m9 n9 68e-5
H9 n9 h9 VS13 12e-3
ED9 h9 25 d9 0 -22e-5
F9 0 d9 VS13 1
LD9 d9 0 1
VS10 8 s10 0
L10 s10 7 27e-5
VS11 1 s11 0
C11 s11 5 22e-5
VS12 12 s12 0
L12 s12 6 39e-5
VS13 14 s13 0
V13 e13 s13 DC 0 AC 22e1 -120
RI13 e13 m13 22e-2
LI13 m13 n13 12e-7
H13 n13 h13 VS9 12e-3
ED13 h13 7 d13 0 -22e-5
F13 0 d13 VS9 1
LD13 d13 0 1
VS14 10 s14 0
C14 s14 19 22e-6
VS15 4 s15 0
L15 s15 15 27e-3
VS16 0 s16 0
C16 s16 14 22e-6
VS17 15 s17 0
L17 s17 16 82e-4
VS18 16 s18 0
V18 e18 s18 DC 0 AC 22e1 -120
RI18 e18 9 68e-3
VS19 18 s19 0
L19 s19 0 10e-3
VS20 9 s20 0
R20 s20 4 15e-1
VS21 20 s21 0
V21 e21 s21 DC 0 AC 47e0 120
RI21 e21 7 33e-1
VS22 24 s22 0
C22 s22 20 39e-7
VS23 21 s23 0
C23 s23 16 15e-7
VS24 24 s24 0
R24 s24 25 33e-1
VS25 22 s25 0
R25 s25 17 82e-1
VS26 2 s26 0
V26 e26 s26 DC 0 AC 27e0 0
RI26 e26 m26 12e-3
LI26 m26 6 12e-7
VS27 11 s27 0
V27 e27 s27 DC 0 AC 56e0 -120
RI27 e27 3 68e-2
VS28 7 s28 0
C28 s28 11 18e-4
VS29 22 s29 0
L29 s29 11 68e-2
VS30 16 s30 0
L30 s30 24 47e-5
VS31 1 s31 0
L31 s31 12 12e-3
VS32 23 s32 0
R32 s32 21 15e3
VS33 2 s33 0
V33 e33 s33 DC 0 AC 18e0 120
RI33 e33 9 15e-2
VS34 26 s34 0
C34 s34 16 33e-6
VS35 18 s35 0
L35 s35 9 33e-2
VS36 16 s36 0
C36 s36 12 22e-5
VS37 1 s37 0
V37 e37 s37 DC 0 AC 39e0 0
RI37 e37 18 10e-2
VS38 7 s38 0
V38 e38 s38 DC 0 AC 56e0 0
RI38 e38 16 82e-3
VS39 19 s39 0
C39 s39 7 56e-5
VS40 10 s40 0
V40 e40 s40 DC 0 AC 27e-1 0
RI40 e40 m40 33e-2
LI40 m40 12 68e-6
VS41 26 s41 0
V41 e41 s41 DC 0 AC 68e1 120
RI41 e41 m41 22e-3
LI41 m41 15 56e-7
.control
set numdgt=17
ac lin 1 60 60
print v(1) v(2) v(3) v(4) v(5) v(6) v(7) v(8) v(9) v(10)
print v(11) v(12) v(13) v(14) v(15) v(16) v(17) v(18) v(19) v(20)
print v(21) v(22) v(23) v(24) v(25) v(26)
print i(vs0) i(vs1) i(vs2) i(vs3) i(vs4) i(vs5) i(vs6) i(vs7) i(vs8) i(vs9)
print i(vs10) i(vs11) i(vs12) i(vs13) i(vs14) i(vs15) i(vs16) i(vs17) i(vs18) i(vs19)
print i(vs20) i(vs21) i(vs22) i(vs23) i(vs24) i(vs25) i(vs26) i(vs27) i(vs28) i(vs29)
print i(vs30) i(vs31) i(vs32) i(vs33) i(vs34) i(vs35) i(vs36) i(vs37) i(vs38) i(vs39)
print i(vs40) i(vs41)
.endc
.end
