controls oracle ac-0398
* Generated (plan F2.7, ADR 0012): do not edit; regenerate with `pnpm sim oracle regen`. ac seed 20261031 index 398 nodes 21 elements 41
.options sparse gmin=1e-12 noopac
RG1 1 0 1000000000000
RG2 2 0 1000000000000
RG3 3 0 1000000000000
RG4 4 0 1000000000000
RG5 5 0 1000000000000
RG6 6 0 1000000000000
RG7 7 0 1000000000000
RG8 8 0 1000000000000
RG9 9 0 1000000000000
RG10 10 0 1000000000000
RG11 11 0 1000000000000
RG12 12 0 1000000000000
RG13 13 0 1000000000000
RG14 14 0 1000000000000
RG15 15 0 1000000000000
RG16 16 0 1000000000000
RG17 17 0 1000000000000
RG18 18 0 1000000000000
RG19 19 0 1000000000000
RG20 20 0 1000000000000
VS0 3 s0 0
R0 s0 13 27e3
VS1 1 s1 0
C1 s1 2 82e-4
VS2 6 s2 0
L2 s2 11 22e-3
VS3 2 s3 0
L3 s3 5 56e-3
VS4 8 s4 0
C4 s4 15 22e-7
VS5 18 s5 0
R5 s5 19 12e3
VS6 20 s6 0
R6 s6 17 33e0
VS7 11 s7 0
C7 s7 14 56e-4
VS8 11 s8 0
L8 s8 18 68e-4
VS9 4 s9 0
R9 s9 12 47e-1
VS10 1 s10 0
R10 s10 13 10e2
VS11 0 s11 0
V11 e11 s11 DC 0 AC 22e1 -120
RI11 e11 10 10e-3
VS12 7 s12 0
C12 s12 16 82e-4
VS13 3 s13 0
C13 s13 18 10e-6
VS14 15 s14 0
L14 s14 1 15e-2
VS15 19 s15 0
C15 s15 9 56e-5
VS16 6 s16 0
C16 s16 5 22e-7
VS17 18 s17 0
R17 s17 6 15e2
VS18 14 s18 0
L18 s18 17 10e-3
VS19 16 s19 0
V19 e19 s19 DC 0 AC 47e1 120
RI19 e19 15 56e-3
VS20 10 s20 0
R20 s20 9 33e-2
VS21 4 s21 0
R21 s21 15 15e-2
VS22 10 s22 0
R22 s22 11 33e1
VS23 10 s23 0
L23 s23 5 68e-2
VS24 12 s24 0
L24 s24 1 27e-5
VS25 10 s25 0
L25 s25 15 82e-5
VS26 13 s26 0
L26 s26 12 12e-2
VS27 0 s27 0
L27 s27 16 68e-4
VS28 5 s28 0
C28 s28 14 15e-6
VS29 9 s29 0
V29 e29 s29 DC 0 AC 68e0 0
RI29 e29 8 27e-3
VS30 17 s30 0
C30 s30 4 47e-7
VS31 17 s31 0
R31 s31 18 82e3
VS32 15 s32 0
C32 s32 20 47e-5
VS33 6 s33 0
R33 s33 9 15e3
VS34 6 s34 0
R34 s34 3 33e-2
VS35 16 s35 0
R35 s35 14 10e0
VS36 2 s36 0
R36 s36 4 82e1
VS37 18 s37 0
L37 s37 7 27e-3
VS38 16 s38 0
L38 s38 4 15e-4
VS39 3 s39 0
L39 s39 14 68e-4
VS40 12 s40 0
C40 s40 4 15e-7
.control
set numdgt=17
ac lin 1 60 60
print v(1) v(2) v(3) v(4) v(5) v(6) v(7) v(8) v(9) v(10)
print v(11) v(12) v(13) v(14) v(15) v(16) v(17) v(18) v(19) v(20)
print i(vs0) i(vs1) i(vs2) i(vs3) i(vs4) i(vs5) i(vs6) i(vs7) i(vs8) i(vs9)
print i(vs10) i(vs11) i(vs12) i(vs13) i(vs14) i(vs15) i(vs16) i(vs17) i(vs18) i(vs19)
print i(vs20) i(vs21) i(vs22) i(vs23) i(vs24) i(vs25) i(vs26) i(vs27) i(vs28) i(vs29)
print i(vs30) i(vs31) i(vs32) i(vs33) i(vs34) i(vs35) i(vs36) i(vs37) i(vs38) i(vs39)
print i(vs40)
.endc
.end
