controls oracle ac-0398
* Generated (plan F2.7, ADR 0012): do not edit; regenerate with `pnpm sim oracle regen`. ac seed 20261031 index 398 nodes 21 elements 32
.options sparse gmin=1e-12 noopac
RG1 1 0 1000000000000
RG2 2 0 1000000000000
RG3 3 0 1000000000000
RG4 4 0 1000000000000
RG5 5 0 1000000000000
RG6 6 0 1000000000000
RG7 7 0 1000000000000
RG8 8 0 1000000000000
RG9 9 0 1000000000000
RG10 10 0 1000000000000
RG11 11 0 1000000000000
RG12 12 0 1000000000000
RG13 13 0 1000000000000
RG14 14 0 1000000000000
RG15 15 0 1000000000000
RG16 16 0 1000000000000
RG17 17 0 1000000000000
RG18 18 0 1000000000000
RG19 19 0 1000000000000
RG20 20 0 1000000000000
VS0 0 s0 0
C0 s0 17 47e-7
VS1 3 s1 0
R1 s1 8 10e2
VS2 0 s2 0
V2 e2 s2 DC 0 AC 68e0 0
RI2 e2 m2 27e-3
LI2 m2 7 33e-6
VS3 3 s3 0
R3 s3 13 27e3
VS4 16 s4 0
V4 e4 s4 DC 0 AC 47e1 120
RI4 e4 m4 56e-3
LI4 m4 15 68e-7
VS5 13 s5 0
C5 s5 11 47e-6
VS6 10 s6 0
R6 s6 11 33e1
VS7 18 s7 0
C7 s7 7 15e-4
VS8 2 s8 0
R8 s8 17 82e1
VS9 0 s9 0
R9 s9 18 82e3
VS10 20 s10 0
R10 s10 16 47e-1
VS11 10 s11 0
L11 s11 16 22e-5
VS12 11 s12 0
L12 s12 18 68e-4
VS13 14 s13 0
L13 s13 6 10e-5
VS14 6 s14 0
R14 s14 8 56e3
VS15 15 s15 0
C15 s15 10 10e-4
VS16 17 s16 0
R16 s16 15 15e-2
VS17 4 s17 0
R17 s17 3 27e-1
VS18 4 s18 0
L18 s18 20 15e-2
VS19 19 s19 0
C19 s19 4 22e-7
VS20 0 s20 0
R20 s20 11 15e-2
VS21 18 s21 0
R21 s21 6 15e2
VS22 6 s22 0
R22 s22 9 15e3
VS23 2 s23 0
L23 s23 5 56e-3
VS24 12 s24 0
L24 s24 1 27e-5
VS25 3 s25 0
C25 s25 18 56e-7
VS26 9 s26 0
L26 s26 11 10e-4
VS27 17 s27 0
R27 s27 12 47e-1
VS28 12 s28 0
R28 s28 2 47e3
VS29 19 s29 0
R29 s29 1 27e1
VS30 5 s30 0
C30 s30 14 15e-6
VS31 0 s31 0
L31 s31 5 22e-5
.control
set numdgt=17
ac lin 1 60 60
print v(1) v(2) v(3) v(4) v(5) v(6) v(7) v(8) v(9) v(10)
print v(11) v(12) v(13) v(14) v(15) v(16) v(17) v(18) v(19) v(20)
print i(vs0) i(vs1) i(vs2) i(vs3) i(vs4) i(vs5) i(vs6) i(vs7) i(vs8) i(vs9)
print i(vs10) i(vs11) i(vs12) i(vs13) i(vs14) i(vs15) i(vs16) i(vs17) i(vs18) i(vs19)
print i(vs20) i(vs21) i(vs22) i(vs23) i(vs24) i(vs25) i(vs26) i(vs27) i(vs28) i(vs29)
print i(vs30) i(vs31)
.endc
.end
