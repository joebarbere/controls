controls oracle ac-0398
* Generated (plan F2.7, ADR 0012): do not edit; regenerate with `pnpm sim oracle regen`. ac seed 20261031 index 398 nodes 21 elements 39
.options sparse gmin=1e-12 noopac
RG1 1 0 1000000000000
RG2 2 0 1000000000000
RG3 3 0 1000000000000
RG4 4 0 1000000000000
RG5 5 0 1000000000000
RG6 6 0 1000000000000
RG7 7 0 1000000000000
RG8 8 0 1000000000000
RG9 9 0 1000000000000
RG10 10 0 1000000000000
RG11 11 0 1000000000000
RG12 12 0 1000000000000
RG13 13 0 1000000000000
RG14 14 0 1000000000000
RG15 15 0 1000000000000
RG16 16 0 1000000000000
RG17 17 0 1000000000000
RG18 18 0 1000000000000
RG19 19 0 1000000000000
RG20 20 0 1000000000000
VS0 18 s0 0
R0 s0 6 15e2
VS1 6 s1 0
C1 s1 5 22e-7
VS2 2 s2 0
R2 s2 4 82e1
VS3 10 s3 0
R3 s3 11 33e1
VS4 6 s4 0
R4 s4 9 15e3
VS5 0 s5 0
V5 e5 s5 DC 0 AC 22e1 -120
RI5 e5 10 10e-3
VS6 8 s6 0
C6 s6 15 22e-7
VS7 10 s7 0
L7 s7 15 82e-5
VS8 4 s8 0
R8 s8 15 15e-2
VS9 15 s9 0
C9 s9 20 47e-5
VS10 12 s10 0
C10 s10 4 15e-7
VS11 2 s11 0
L11 s11 5 56e-3
VS12 3 s12 0
C12 s12 18 10e-6
VS13 11 s13 0
L13 s13 18 68e-4
VS14 3 s14 0
R14 s14 13 27e3
VS15 11 s15 0
C15 s15 14 56e-4
VS16 16 s16 0
L16 s16 4 15e-4
VS17 16 s17 0
V17 e17 s17 DC 0 AC 47e1 120
RI17 e17 15 56e-3
VS18 14 s18 0
L18 s18 17 10e-3
VS19 17 s19 0
C19 s19 4 47e-7
VS20 10 s20 0
L20 s20 5 68e-2
VS21 6 s21 0
L21 s21 11 22e-3
VS22 0 s22 0
L22 s22 16 68e-4
VS23 6 s23 0
R23 s23 3 33e-2
VS24 17 s24 0
R24 s24 18 82e3
VS25 1 s25 0
R25 s25 13 10e2
VS26 20 s26 0
R26 s26 17 33e0
VS27 18 s27 0
L27 s27 7 27e-3
VS28 19 s28 0
C28 s28 9 56e-5
VS29 3 s29 0
L29 s29 14 68e-4
VS30 15 s30 0
L30 s30 1 15e-2
VS31 13 s31 0
L31 s31 12 12e-2
VS32 10 s32 0
R32 s32 9 33e-2
VS33 9 s33 0
V33 e33 s33 DC 0 AC 68e0 0
RI33 e33 8 27e-3
VS34 16 s34 0
R34 s34 14 10e0
VS35 4 s35 0
R35 s35 12 47e-1
VS36 5 s36 0
C36 s36 14 15e-6
VS37 1 s37 0
C37 s37 2 82e-4
VS38 12 s38 0
L38 s38 1 27e-5
.control
set numdgt=17
ac lin 1 60 60
print v(1) v(2) v(3) v(4) v(5) v(6) v(7) v(8) v(9) v(10)
print v(11) v(12) v(13) v(14) v(15) v(16) v(17) v(18) v(19) v(20)
print i(vs0) i(vs1) i(vs2) i(vs3) i(vs4) i(vs5) i(vs6) i(vs7) i(vs8) i(vs9)
print i(vs10) i(vs11) i(vs12) i(vs13) i(vs14) i(vs15) i(vs16) i(vs17) i(vs18) i(vs19)
print i(vs20) i(vs21) i(vs22) i(vs23) i(vs24) i(vs25) i(vs26) i(vs27) i(vs28) i(vs29)
print i(vs30) i(vs31) i(vs32) i(vs33) i(vs34) i(vs35) i(vs36) i(vs37) i(vs38)
.endc
.end
