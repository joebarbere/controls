controls oracle ac-0358
* Generated (plan F2.7, ADR 0012): do not edit; regenerate with `pnpm sim oracle regen`. ac seed 20261031 index 358 nodes 14 elements 18
.options sparse gmin=1e-12 noopac
RG1 1 0 1000000000000
RG2 2 0 1000000000000
RG3 3 0 1000000000000
RG4 4 0 1000000000000
RG5 5 0 1000000000000
RG6 6 0 1000000000000
RG7 7 0 1000000000000
RG8 8 0 1000000000000
RG9 9 0 1000000000000
RG10 10 0 1000000000000
RG11 11 0 1000000000000
RG12 12 0 1000000000000
RG13 13 0 1000000000000
VS0 0 s0 0
V0 e0 s0 DC 0 AC 18e0 0
RI0 e0 13 82e-2
VS1 4 s1 0
C1 s1 5 18e-5
VS2 12 s2 0
V2 e2 s2 DC 0 AC 12e-1 -120
RI2 e2 13 47e-2
VS3 1 s3 0
R3 s3 2 56e2
VS4 8 s4 0
R4 s4 11 68e1
VS5 11 s5 0
R5 s5 0 27e-2
VS6 0 s6 0
R6 s6 6 18e2
VS7 3 s7 0
C7 s7 8 15e-6
VS8 5 s8 0
R8 s8 8 68e-2
VS9 8 s9 0
L9 s9 1 12e-5
VS10 10 s10 0
V10 e10 s10 DC 0 AC 10e-1 180
RI10 e10 1 10e-1
VS11 1 s11 0
L11 s11 6 10e-3
VS12 7 s12 0
V12 e12 s12 DC 0 AC 27e0 120
RI12 e12 5 33e-2
VS13 13 s13 0
R13 s13 9 22e-2
VS14 6 s14 0
C14 s14 9 56e-4
VS15 9 s15 0
C15 s15 11 39e-7
VS16 7 s16 0
L16 s16 13 33e-2
VS17 8 s17 0
V17 e17 s17 DC 0 AC 33e0 -120
RI17 e17 4 12e-2
.control
set numdgt=17
ac lin 1 60 60
print v(1) v(2) v(3) v(4) v(5) v(6) v(7) v(8) v(9) v(10)
print v(11) v(12) v(13)
print i(vs0) i(vs1) i(vs2) i(vs3) i(vs4) i(vs5) i(vs6) i(vs7) i(vs8) i(vs9)
print i(vs10) i(vs11) i(vs12) i(vs13) i(vs14) i(vs15) i(vs16) i(vs17)
.endc
.end
