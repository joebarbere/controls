controls oracle ac-0374
* Generated (plan F2.7, ADR 0012): do not edit; regenerate with `pnpm sim oracle regen`. ac seed 20261031 index 374 nodes 20 elements 34
.options sparse gmin=1e-12 noopac
RG1 1 0 1000000000000
RG2 2 0 1000000000000
RG3 3 0 1000000000000
RG4 4 0 1000000000000
RG5 5 0 1000000000000
RG6 6 0 1000000000000
RG7 7 0 1000000000000
RG8 8 0 1000000000000
RG9 9 0 1000000000000
RG10 10 0 1000000000000
RG11 11 0 1000000000000
RG12 12 0 1000000000000
RG13 13 0 1000000000000
RG14 14 0 1000000000000
RG15 15 0 1000000000000
RG16 16 0 1000000000000
RG17 17 0 1000000000000
RG18 18 0 1000000000000
RG19 19 0 1000000000000
VS0 8 s0 0
R0 s0 1 82e2
VS1 0 s1 0
V1 e1 s1 DC 0 AC 27e0 180
RI1 e1 m1 18e-2
LI1 m1 7 18e-7
VS2 9 s2 0
L2 s2 12 12e-2
VS3 2 s3 0
L3 s3 9 33e-2
VS4 8 s4 0
R4 s4 15 68e1
VS5 12 s5 0
V5 e5 s5 DC 0 AC 12e0 120
RI5 e5 m5 18e-2
LI5 m5 15 15e-7
VS6 18 s6 0
R6 s6 13 39e-2
VS7 19 s7 0
R7 s7 16 22e-1
VS8 17 s8 0
C8 s8 1 18e-7
VS9 6 s9 0
C9 s9 0 82e-7
VS10 13 s10 0
C10 s10 8 56e-7
VS11 6 s11 0
R11 s11 8 56e1
VS12 10 s12 0
V12 e12 s12 DC 0 AC 68e1 120
RI12 e12 19 56e-3
VS13 3 s13 0
L13 s13 6 18e-3
VS14 12 s14 0
R14 s14 4 18e1
VS15 15 s15 0
R15 s15 1 56e1
VS16 17 s16 0
R16 s16 2 82e-1
VS17 17 s17 0
V17 e17 s17 DC 0 AC 33e1 0
RI17 e17 m17 22e-2
LI17 m17 11 12e-6
VS18 4 s18 0
R18 s18 13 33e1
VS19 6 s19 0
R19 s19 16 15e-2
VS20 12 s20 0
R20 s20 2 12e3
VS21 11 s21 0
R21 s21 7 22e-1
VS22 2 s22 0
V22 e22 s22 DC 0 AC 68e-1 0
RI22 e22 10 68e-3
VS23 14 s23 0
L23 s23 19 10e-5
VS24 5 s24 0
V24 e24 s24 DC 0 AC 15e1 180
RI24 e24 m24 47e-3
LI24 m24 2 82e-7
VS25 8 s25 0
L25 s25 6 18e-5
VS26 19 s26 0
R26 s26 11 15e1
VS27 18 s27 0
R27 s27 9 33e-2
VS28 8 s28 0
V28 e28 s28 DC 0 AC 15e0 180
RI28 e28 m28 82e-1
LI28 m28 19 15e-5
VS29 0 s29 0
R29 s29 5 22e-2
VS30 13 s30 0
R30 s30 14 22e-2
VS31 2 s31 0
C31 s31 19 12e-7
VS32 4 s32 0
C32 s32 11 10e-5
VS33 13 s33 0
V33 e33 s33 DC 0 AC 39e0 180
RI33 e33 m33 27e-3
LI33 m33 3 15e-7
.control
set numdgt=17
ac lin 1 60 60
print v(1) v(2) v(3) v(4) v(5) v(6) v(7) v(8) v(9) v(10)
print v(11) v(12) v(13) v(14) v(15) v(16) v(17) v(18) v(19)
print i(vs0) i(vs1) i(vs2) i(vs3) i(vs4) i(vs5) i(vs6) i(vs7) i(vs8) i(vs9)
print i(vs10) i(vs11) i(vs12) i(vs13) i(vs14) i(vs15) i(vs16) i(vs17) i(vs18) i(vs19)
print i(vs20) i(vs21) i(vs22) i(vs23) i(vs24) i(vs25) i(vs26) i(vs27) i(vs28) i(vs29)
print i(vs30) i(vs31) i(vs32) i(vs33)
.endc
.end
