controls oracle ac-0374
* Generated (plan F2.7, ADR 0012): do not edit; regenerate with `pnpm sim oracle regen`. ac seed 20261031 index 374 nodes 20 elements 31
.options sparse gmin=1e-12 noopac
RG1 1 0 1000000000000
RG2 2 0 1000000000000
RG3 3 0 1000000000000
RG4 4 0 1000000000000
RG5 5 0 1000000000000
RG6 6 0 1000000000000
RG7 7 0 1000000000000
RG8 8 0 1000000000000
RG9 9 0 1000000000000
RG10 10 0 1000000000000
RG11 11 0 1000000000000
RG12 12 0 1000000000000
RG13 13 0 1000000000000
RG14 14 0 1000000000000
RG15 15 0 1000000000000
RG16 16 0 1000000000000
RG17 17 0 1000000000000
RG18 18 0 1000000000000
RG19 19 0 1000000000000
VS0 0 s0 0
V0 e0 s0 DC 0 AC 33e1 0
RI0 e0 11 22e-2
VS1 13 s1 0
V1 e1 s1 DC 0 AC 39e0 180
RI1 e1 3 27e-3
VS2 9 s2 0
L2 s2 12 12e-2
VS3 19 s3 0
R3 s3 11 15e1
VS4 4 s4 0
R4 s4 13 33e1
VS5 12 s5 0
R5 s5 2 12e3
VS6 12 s6 0
R6 s6 4 18e1
VS7 18 s7 0
R7 s7 9 33e-2
VS8 2 s8 0
L8 s8 9 33e-2
VS9 12 s9 0
V9 e9 s9 DC 0 AC 12e0 120
RI9 e9 15 18e-2
VS10 4 s10 0
C10 s10 11 10e-5
VS11 15 s11 0
R11 s11 1 56e1
VS12 6 s12 0
C12 s12 8 82e-7
VS13 6 s13 0
R13 s13 16 15e-2
VS14 5 s14 0
V14 e14 s14 DC 0 AC 15e1 180
RI14 e14 2 47e-3
VS15 17 s15 0
R15 s15 15 68e1
VS16 13 s16 0
C16 s16 17 56e-7
VS17 17 s17 0
V17 e17 s17 DC 0 AC 15e0 180
RI17 e17 19 82e-1
VS18 0 s18 0
C18 s18 1 18e-7
VS19 17 s19 0
L19 s19 6 18e-5
VS20 19 s20 0
R20 s20 16 22e-1
VS21 0 s21 0
R21 s21 2 82e-1
VS22 2 s22 0
C22 s22 19 12e-7
VS23 18 s23 0
R23 s23 13 39e-2
VS24 17 s24 0
R24 s24 1 82e2
VS25 11 s25 0
R25 s25 7 22e-1
VS26 14 s26 0
L26 s26 19 10e-5
VS27 3 s27 0
L27 s27 6 18e-3
VS28 6 s28 0
R28 s28 17 56e1
VS29 8 s29 0
R29 s29 5 22e-2
VS30 10 s30 0
V30 e30 s30 DC 0 AC 68e1 120
RI30 e30 19 56e-3
.control
set numdgt=17
ac lin 1 60 60
print v(1) v(2) v(3) v(4) v(5) v(6) v(7) v(8) v(9) v(10)
print v(11) v(12) v(13) v(14) v(15) v(16) v(17) v(18) v(19)
print i(vs0) i(vs1) i(vs2) i(vs3) i(vs4) i(vs5) i(vs6) i(vs7) i(vs8) i(vs9)
print i(vs10) i(vs11) i(vs12) i(vs13) i(vs14) i(vs15) i(vs16) i(vs17) i(vs18) i(vs19)
print i(vs20) i(vs21) i(vs22) i(vs23) i(vs24) i(vs25) i(vs26) i(vs27) i(vs28) i(vs29)
print i(vs30)
.endc
.end
