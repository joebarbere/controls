controls oracle ac-0374
* Generated (plan F2.7, ADR 0012): do not edit; regenerate with `pnpm sim oracle regen`. ac seed 20261031 index 374 nodes 20 elements 33
.options sparse gmin=1e-12 noopac
RG1 1 0 1000000000000
RG2 2 0 1000000000000
RG3 3 0 1000000000000
RG4 4 0 1000000000000
RG5 5 0 1000000000000
RG6 6 0 1000000000000
RG7 7 0 1000000000000
RG8 8 0 1000000000000
RG9 9 0 1000000000000
RG10 10 0 1000000000000
RG11 11 0 1000000000000
RG12 12 0 1000000000000
RG13 13 0 1000000000000
RG14 14 0 1000000000000
RG15 15 0 1000000000000
RG16 16 0 1000000000000
RG17 17 0 1000000000000
RG18 18 0 1000000000000
RG19 19 0 1000000000000
VS0 9 s0 0
L0 s0 12 12e-2
VS1 17 s1 0
R1 s1 1 82e2
VS2 6 s2 0
C2 s2 8 82e-7
VS3 18 s3 0
R3 s3 9 33e-2
VS4 14 s4 0
L4 s4 19 10e-5
VS5 18 s5 0
L5 s5 8 39e-5
VS6 17 s6 0
L6 s6 18 22e-3
VS7 13 s7 0
C7 s7 17 56e-7
VS8 0 s8 0
V8 e8 s8 DC 0 AC 12e1 0
RI8 e8 m8 18e-2
LI8 m8 19 33e-6
VS9 13 s9 0
V9 e9 s9 DC 0 AC 39e0 180
RI9 e9 m9 27e-3
LI9 m9 3 56e-6
VS10 14 s10 0
V10 e10 s10 DC 0 AC 10e0 0
RI10 e10 4 33e-2
VS11 6 s11 0
R11 s11 17 56e1
VS12 19 s12 0
R12 s12 11 15e1
VS13 2 s13 0
L13 s13 9 33e-2
VS14 15 s14 0
R14 s14 7 15e-2
VS15 5 s15 0
L15 s15 18 47e-4
VS16 14 s16 0
L16 s16 17 22e-3
VS17 12 s17 0
R17 s17 4 18e1
VS18 0 s18 0
R18 s18 2 82e-1
VS19 3 s19 0
C19 s19 16 47e-7
VS20 13 s20 0
R20 s20 6 18e-2
VS21 12 s21 0
V21 e21 s21 DC 0 AC 12e-1 0
RI21 e21 m21 68e-1
LI21 m21 5 15e-6
VS22 5 s22 0
R22 s22 18 56e1
VS23 6 s23 0
R23 s23 16 15e-2
VS24 0 s24 0
R24 s24 5 22e1
VS25 14 s25 0
V25 e25 s25 DC 0 AC 10e0 180
RI25 e25 9 68e-3
VS26 19 s26 0
L26 s26 13 82e-4
VS27 12 s27 0
V27 e27 s27 DC 0 AC 12e0 120
RI27 e27 15 18e-2
VS28 11 s28 0
R28 s28 7 22e-1
VS29 6 s29 0
L29 s29 14 12e-5
VS30 12 s30 0
C30 s30 1 82e-5
VS31 10 s31 0
V31 e31 s31 DC 0 AC 68e1 120
RI31 e31 m31 56e-3
LI31 m31 19 22e-5
VS32 11 s32 0
L32 s32 10 39e-4
.control
set numdgt=17
ac lin 1 60 60
print v(1) v(2) v(3) v(4) v(5) v(6) v(7) v(8) v(9) v(10)
print v(11) v(12) v(13) v(14) v(15) v(16) v(17) v(18) v(19)
print i(vs0) i(vs1) i(vs2) i(vs3) i(vs4) i(vs5) i(vs6) i(vs7) i(vs8) i(vs9)
print i(vs10) i(vs11) i(vs12) i(vs13) i(vs14) i(vs15) i(vs16) i(vs17) i(vs18) i(vs19)
print i(vs20) i(vs21) i(vs22) i(vs23) i(vs24) i(vs25) i(vs26) i(vs27) i(vs28) i(vs29)
print i(vs30) i(vs31) i(vs32)
.endc
.end
