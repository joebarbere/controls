controls oracle ac-0294
* Generated (plan F2.7, ADR 0012): do not edit; regenerate with `pnpm sim oracle regen`. ac seed 20261031 index 294 nodes 14 elements 16
.options sparse gmin=1e-12 noopac
RG1 1 0 1000000000000
RG2 2 0 1000000000000
RG3 3 0 1000000000000
RG4 4 0 1000000000000
RG5 5 0 1000000000000
RG6 6 0 1000000000000
RG7 7 0 1000000000000
RG8 8 0 1000000000000
RG9 9 0 1000000000000
RG10 10 0 1000000000000
RG11 11 0 1000000000000
RG12 12 0 1000000000000
RG13 13 0 1000000000000
VS0 7 s0 0
R0 s0 8 39e2
VS1 6 s1 0
L1 s1 11 15e-3
VS2 13 s2 0
C2 s2 12 15e-4
VS3 10 s3 0
R3 s3 4 82e-2
VS4 0 s4 0
V4 e4 s4 DC 0 AC 56e0 120
RI4 e4 1 27e-1
VS5 5 s5 0
R5 s5 3 15e0
VS6 9 s6 0
R6 s6 1 56e-2
VS7 0 s7 0
R7 s7 7 22e2
VS8 12 s8 0
C8 s8 10 15e-6
VS9 5 s9 0
R9 s9 7 12e-2
VS10 9 s10 0
C10 s10 5 33e-4
VS11 5 s11 0
R11 s11 2 22e3
VS12 5 s12 0
V12 e12 s12 DC 0 AC 12e1 120
RI12 e12 6 39e-2
VS13 5 s13 0
C13 s13 13 82e-6
VS14 1 s14 0
R14 s14 13 10e2
VS15 6 s15 0
V15 e15 s15 DC 0 AC 56e-1 0
RI15 e15 8 12e-2
.control
set numdgt=17
ac lin 1 60 60
print v(1) v(2) v(3) v(4) v(5) v(6) v(7) v(8) v(9) v(10)
print v(11) v(12) v(13)
print i(vs0) i(vs1) i(vs2) i(vs3) i(vs4) i(vs5) i(vs6) i(vs7) i(vs8) i(vs9)
print i(vs10) i(vs11) i(vs12) i(vs13) i(vs14) i(vs15)
.endc
.end
