controls oracle ac-0294
* Generated (plan F2.7, ADR 0012): do not edit; regenerate with `pnpm sim oracle regen`. ac seed 20261031 index 294 nodes 14 elements 23
.options sparse gmin=1e-12 noopac
RG1 1 0 1000000000000
RG2 2 0 1000000000000
RG3 3 0 1000000000000
RG4 4 0 1000000000000
RG5 5 0 1000000000000
RG6 6 0 1000000000000
RG7 7 0 1000000000000
RG8 8 0 1000000000000
RG9 9 0 1000000000000
RG10 10 0 1000000000000
RG11 11 0 1000000000000
RG12 12 0 1000000000000
RG13 13 0 1000000000000
VS0 0 s0 0
V0 e0 s0 DC 0 AC 12e1 120
RI0 e0 6 39e-2
VS1 11 s1 0
R1 s1 6 33e1
VS2 4 s2 0
C2 s2 9 33e-7
VS3 12 s3 0
C3 s3 10 15e-6
VS4 6 s4 0
L4 s4 10 12e-5
VS5 8 s5 0
C5 s5 7 12e-5
VS6 8 s6 0
V6 e6 s6 DC 0 AC 10e-1 180
RI6 e6 9 39e-1
VS7 5 s7 0
C7 s7 12 15e-4
VS8 13 s8 0
R8 s8 1 33e3
VS9 9 s9 0
C9 s9 0 33e-4
VS10 7 s10 0
V10 e10 s10 DC 0 AC 18e0 0
RI10 e10 m10 56e-2
LI10 m10 4 10e-7
VS11 1 s11 0
R11 s11 5 33e3
VS12 0 s12 0
C12 s12 13 18e-4
VS13 9 s13 0
L13 s13 13 82e-5
VS14 6 s14 0
C14 s14 3 10e-4
VS15 2 s15 0
C15 s15 9 15e-7
VS16 5 s16 0
C16 s16 8 47e-7
VS17 11 s17 0
C17 s17 10 15e-5
VS18 1 s18 0
L18 s18 2 82e-4
VS19 0 s19 0
R19 s19 5 68e-2
VS20 3 s20 0
R20 s20 12 18e2
VS21 0 s21 0
C21 s21 5 82e-6
VS22 13 s22 0
L22 s22 8 56e-5
.control
set numdgt=17
ac lin 1 60 60
print v(1) v(2) v(3) v(4) v(5) v(6) v(7) v(8) v(9) v(10)
print v(11) v(12) v(13)
print i(vs0) i(vs1) i(vs2) i(vs3) i(vs4) i(vs5) i(vs6) i(vs7) i(vs8) i(vs9)
print i(vs10) i(vs11) i(vs12) i(vs13) i(vs14) i(vs15) i(vs16) i(vs17) i(vs18) i(vs19)
print i(vs20) i(vs21) i(vs22)
.endc
.end
