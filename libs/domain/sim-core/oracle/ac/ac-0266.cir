controls oracle ac-0266
* Generated (plan F2.7, ADR 0012): do not edit; regenerate with `pnpm sim oracle regen`. ac seed 20261031 index 266 nodes 8 elements 11
.options sparse gmin=1e-12 noopac
RG1 1 0 1000000000000
RG2 2 0 1000000000000
RG3 3 0 1000000000000
RG4 4 0 1000000000000
RG5 5 0 1000000000000
RG6 6 0 1000000000000
RG7 7 0 1000000000000
VS0 0 s0 0
R0 s0 4 56e1
VS1 6 s1 0
C1 s1 1 39e-5
VS2 0 s2 0
V2 e2 s2 DC 0 AC 39e1 0
RI2 e2 m2 47e-2
LI2 m2 6 56e-6
VS3 3 s3 0
C3 s3 4 56e-5
VS4 5 s4 0
R4 s4 1 18e-2
VS5 5 s5 0
V5 e5 s5 DC 0 AC 33e1 180
RI5 e5 m5 27e-3
LI5 m5 2 22e-6
VS6 3 s6 0
C6 s6 0 27e-5
VS7 3 s7 0
V7 e7 s7 DC 0 AC 12e0 0
RI7 e7 m7 39e-2
LI7 m7 2 33e-5
VS8 5 s8 0
L8 s8 1 15e-4
VS9 1 s9 0
L9 s9 7 10e-3
VS10 7 s10 0
V10 e10 s10 DC 0 AC 18e1 0
RI10 e10 m10 56e-2
LI10 m10 3 39e-7
.control
set numdgt=17
ac lin 1 60 60
print v(1) v(2) v(3) v(4) v(5) v(6) v(7)
print i(vs0) i(vs1) i(vs2) i(vs3) i(vs4) i(vs5) i(vs6) i(vs7) i(vs8) i(vs9)
print i(vs10)
.endc
.end
