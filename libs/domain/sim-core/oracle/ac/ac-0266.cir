controls oracle ac-0266
* Generated (plan F2.7, ADR 0012): do not edit; regenerate with `pnpm sim oracle regen`. ac seed 20261031 index 266 nodes 8 elements 14
.options sparse gmin=1e-12 noopac
RG1 1 0 1000000000000
RG2 2 0 1000000000000
RG3 3 0 1000000000000
RG4 4 0 1000000000000
RG5 5 0 1000000000000
RG6 6 0 1000000000000
RG7 7 0 1000000000000
VS0 0 s0 0
R0 s0 4 27e1
VS1 7 s1 0
R1 s1 1 15e-2
VS2 4 s2 0
L2 s2 3 22e-2
VS3 4 s3 0
R3 s3 0 27e2
VS4 1 s4 0
R4 s4 3 18e2
VS5 7 s5 0
R5 s5 2 56e0
VS6 0 s6 0
R6 s6 3 18e3
VS7 3 s7 0
L7 s7 2 56e-5
VS8 5 s8 0
R8 s8 2 39e1
VS9 6 s9 0
L9 s9 5 12e-4
VS10 0 s10 0
R10 s10 6 27e0
VS11 0 s11 0
C11 s11 7 47e-4
VS12 7 s12 0
R12 s12 1 82e3
VS13 0 s13 0
V13 e13 s13 DC 0 AC 39e1 0
RI13 e13 6 47e-2
.control
set numdgt=17
ac lin 1 60 60
print v(1) v(2) v(3) v(4) v(5) v(6) v(7)
print i(vs0) i(vs1) i(vs2) i(vs3) i(vs4) i(vs5) i(vs6) i(vs7) i(vs8) i(vs9)
print i(vs10) i(vs11) i(vs12) i(vs13)
.endc
.end
