controls oracle ac-0266
* Generated (plan F2.7, ADR 0012): do not edit; regenerate with `pnpm sim oracle regen`. ac seed 20261031 index 266 nodes 8 elements 12
.options sparse gmin=1e-12 noopac
RG1 1 0 1000000000000
RG2 2 0 1000000000000
RG3 3 0 1000000000000
RG4 4 0 1000000000000
RG5 5 0 1000000000000
RG6 6 0 1000000000000
RG7 7 0 1000000000000
VS0 0 s0 0
R0 s0 3 18e3
VS1 3 s1 0
L1 s1 2 56e-5
VS2 7 s2 0
R2 s2 2 56e0
VS3 0 s3 0
R3 s3 6 27e0
VS4 7 s4 0
R4 s4 1 15e-2
VS5 0 s5 0
C5 s5 7 47e-4
VS6 0 s6 0
R6 s6 4 27e1
VS7 1 s7 0
R7 s7 3 18e2
VS8 4 s8 0
R8 s8 0 27e2
VS9 7 s9 0
R9 s9 1 82e3
VS10 5 s10 0
R10 s10 2 39e1
VS11 0 s11 0
V11 e11 s11 DC 0 AC 39e1 0
RI11 e11 6 47e-2
.control
set numdgt=17
ac lin 1 60 60
print v(1) v(2) v(3) v(4) v(5) v(6) v(7)
print i(vs0) i(vs1) i(vs2) i(vs3) i(vs4) i(vs5) i(vs6) i(vs7) i(vs8) i(vs9)
print i(vs10) i(vs11)
.endc
.end
