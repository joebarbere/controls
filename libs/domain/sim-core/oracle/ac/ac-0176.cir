controls oracle ac-0176
* Generated (plan F2.7, ADR 0012): do not edit; regenerate with `pnpm sim oracle regen`. ac seed 20261031 index 176 nodes 11 elements 17
.options sparse gmin=1e-12 noopac
RG1 1 0 1000000000000
RG2 2 0 1000000000000
RG3 3 0 1000000000000
RG4 4 0 1000000000000
RG5 5 0 1000000000000
RG6 6 0 1000000000000
RG7 7 0 1000000000000
RG8 8 0 1000000000000
RG9 9 0 1000000000000
RG10 10 0 1000000000000
VS0 3 s0 0
C0 s0 7 33e-7
VS1 4 s1 0
L1 s1 5 15e-4
VS2 0 s2 0
V2 e2 s2 DC 0 AC 10e-1 -120
RI2 e2 m2 10e-3
LI2 m2 2 18e-7
VS3 6 s3 0
R3 s3 5 68e2
VS4 1 s4 0
L4 s4 7 27e-4
VS5 9 s5 0
L5 s5 0 12e-2
VS6 9 s6 0
L6 s6 1 15e-5
VS7 5 s7 0
V7 e7 s7 DC 0 AC 56e-1 180
RI7 e7 m7 18e-2
LI7 m7 6 12e-6
VS8 4 s8 0
V8 e8 s8 DC 0 AC 33e1 -120
RI8 e8 m8 33e-3
LI8 m8 9 18e-7
VS9 6 s9 0
R9 s9 4 68e-1
VS10 5 s10 0
R10 s10 10 33e0
VS11 8 s11 0
V11 e11 s11 DC 0 AC 12e1 0
RI11 e11 6 22e-1
VS12 8 s12 0
V12 e12 s12 DC 0 AC 12e1 180
RI12 e12 9 56e-1
VS13 3 s13 0
R13 s13 0 39e0
VS14 7 s14 0
V14 e14 s14 DC 0 AC 15e-1 0
RI14 e14 0 56e-3
VS15 3 s15 0
C15 s15 1 27e-7
VS16 10 s16 0
R16 s16 2 39e0
.control
set numdgt=17
ac lin 1 60 60
print v(1) v(2) v(3) v(4) v(5) v(6) v(7) v(8) v(9) v(10)
print i(vs0) i(vs1) i(vs2) i(vs3) i(vs4) i(vs5) i(vs6) i(vs7) i(vs8) i(vs9)
print i(vs10) i(vs11) i(vs12) i(vs13) i(vs14) i(vs15) i(vs16)
.endc
.end
