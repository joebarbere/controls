controls oracle ac-0176
* Generated (plan F2.7, ADR 0012): do not edit; regenerate with `pnpm sim oracle regen`. ac seed 20261031 index 176 nodes 11 elements 19
.options sparse gmin=1e-12 noopac
RG1 1 0 1000000000000
RG2 2 0 1000000000000
RG3 3 0 1000000000000
RG4 4 0 1000000000000
RG5 5 0 1000000000000
RG6 6 0 1000000000000
RG7 7 0 1000000000000
RG8 8 0 1000000000000
RG9 9 0 1000000000000
RG10 10 0 1000000000000
VS0 5 s0 0
C0 s0 10 27e-5
VS1 2 s1 0
L1 s1 4 10e-5
VS2 7 s2 0
C2 s2 5 68e-4
VS3 0 s3 0
V3 e3 s3 DC 0 AC 22e-1 -120
RI3 e3 n3 82e-3
H3 n3 h3 VS11 68e-4
ED3 h3 9 d3 0 -10e-7
F3 0 d3 VS11 1
LD3 d3 0 1
VS4 2 s4 0
R4 s4 3 10e0
VS5 5 s5 0
L5 s5 4 18e-3
VS6 8 s6 0
L6 s6 2 10e-4
VS7 9 s7 0
L7 s7 7 47e-5
VS8 0 s8 0
C8 s8 1 12e-6
VS9 6 s9 0
R9 s9 9 33e0
VS10 1 s10 0
R10 s10 7 15e0
VS11 2 s11 0
V11 e11 s11 DC 0 AC 12e1 180
RI11 e11 n11 56e-1
H11 n11 h11 VS3 68e-4
ED11 h11 9 d11 0 -10e-7
F11 0 d11 VS3 1
LD11 d11 0 1
VS12 10 s12 0
C12 s12 8 27e-7
VS13 6 s13 0
V13 e13 s13 DC 0 AC 15e0 -120
RI13 e13 m13 82e-3
LI13 m13 3 82e-6
VS14 6 s14 0
V14 e14 s14 DC 0 AC 27e1 0
RI14 e14 2 10e-3
VS15 4 s15 0
V15 e15 s15 DC 0 AC 15e-1 180
RI15 e15 m15 22e-2
LI15 m15 9 33e-5
VS16 9 s16 0
R16 s16 4 10e2
VS17 3 s17 0
V17 e17 s17 DC 0 AC 27e-1 -120
RI17 e17 10 47e-3
VS18 7 s18 0
L18 s18 9 18e-3
.control
set numdgt=17
ac lin 1 60 60
print v(1) v(2) v(3) v(4) v(5) v(6) v(7) v(8) v(9) v(10)
print i(vs0) i(vs1) i(vs2) i(vs3) i(vs4) i(vs5) i(vs6) i(vs7) i(vs8) i(vs9)
print i(vs10) i(vs11) i(vs12) i(vs13) i(vs14) i(vs15) i(vs16) i(vs17) i(vs18)
.endc
.end
