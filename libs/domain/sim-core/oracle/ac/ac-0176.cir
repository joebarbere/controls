controls oracle ac-0176
* Generated (plan F2.7, ADR 0012): do not edit; regenerate with `pnpm sim oracle regen`. ac seed 20261031 index 176 nodes 11 elements 16
.options sparse gmin=1e-12 noopac
RG1 1 0 1000000000000
RG2 2 0 1000000000000
RG3 3 0 1000000000000
RG4 4 0 1000000000000
RG5 5 0 1000000000000
RG6 6 0 1000000000000
RG7 7 0 1000000000000
RG8 8 0 1000000000000
RG9 9 0 1000000000000
RG10 10 0 1000000000000
VS0 0 s0 0
R0 s0 9 33e0
VS1 0 s1 0
V1 e1 s1 DC 0 AC 27e1 0
RI1 e1 6 10e-3
VS2 6 s2 0
L2 s2 4 10e-5
VS3 1 s3 0
R3 s3 7 15e0
VS4 9 s4 0
L4 s4 7 47e-5
VS5 4 s5 0
V5 e5 s5 DC 0 AC 15e-1 180
RI5 e5 9 22e-2
VS6 2 s6 0
V6 e6 s6 DC 0 AC 22e-1 -120
RI6 e6 9 82e-3
VS7 7 s7 0
L7 s7 9 18e-3
VS8 3 s8 0
V8 e8 s8 DC 0 AC 27e-1 -120
RI8 e8 10 47e-3
VS9 9 s9 0
R9 s9 4 10e2
VS10 5 s10 0
L10 s10 4 18e-3
VS11 2 s11 0
C11 s11 1 12e-6
VS12 6 s12 0
V12 e12 s12 DC 0 AC 12e1 180
RI12 e12 9 56e-1
VS13 6 s13 0
R13 s13 3 10e0
VS14 8 s14 0
L14 s14 6 10e-4
VS15 0 s15 0
V15 e15 s15 DC 0 AC 15e0 -120
RI15 e15 3 82e-3
.control
set numdgt=17
ac lin 1 60 60
print v(1) v(2) v(3) v(4) v(5) v(6) v(7) v(8) v(9) v(10)
print i(vs0) i(vs1) i(vs2) i(vs3) i(vs4) i(vs5) i(vs6) i(vs7) i(vs8) i(vs9)
print i(vs10) i(vs11) i(vs12) i(vs13) i(vs14) i(vs15)
.endc
.end
