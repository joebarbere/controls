controls oracle ac-0350
* Generated (plan F2.7, ADR 0012): do not edit; regenerate with `pnpm sim oracle regen`. ac seed 20261031 index 350 nodes 13 elements 18
.options sparse gmin=1e-12 noopac
RG1 1 0 1000000000000
RG2 2 0 1000000000000
RG3 3 0 1000000000000
RG4 4 0 1000000000000
RG5 5 0 1000000000000
RG6 6 0 1000000000000
RG7 7 0 1000000000000
RG8 8 0 1000000000000
RG9 9 0 1000000000000
RG10 10 0 1000000000000
RG11 11 0 1000000000000
RG12 12 0 1000000000000
VS0 0 s0 0
V0 e0 s0 DC 0 AC 22e1 0
RI0 e0 m0 68e-3
LI0 m0 7 33e-6
VS1 3 s1 0
R1 s1 7 82e-2
VS2 7 s2 0
V2 e2 s2 DC 0 AC 82e0 0
RI2 e2 m2 39e-3
LI2 m2 11 22e-5
VS3 2 s3 0
L3 s3 4 47e-4
VS4 3 s4 0
V4 e4 s4 DC 0 AC 47e-1 180
RI4 e4 m4 68e-2
LI4 m4 6 15e-6
VS5 12 s5 0
L5 s5 10 39e-5
VS6 9 s6 0
V6 e6 s6 DC 0 AC 27e-1 -120
RI6 e6 6 15e-2
VS7 12 s7 0
C7 s7 9 82e-5
VS8 1 s8 0
R8 s8 11 68e2
VS9 5 s9 0
C9 s9 11 82e-4
VS10 10 s10 0
C10 s10 8 22e-5
VS11 8 s11 0
R11 s11 10 33e0
VS12 4 s12 0
C12 s12 6 10e-7
VS13 8 s13 0
C13 s13 7 18e-5
VS14 5 s14 0
V14 e14 s14 DC 0 AC 39e0 180
RI14 e14 m14 27e-2
LI14 m14 4 68e-6
VS15 7 s15 0
C15 s15 2 33e-5
VS16 1 s16 0
R16 s16 12 15e-1
VS17 0 s17 0
V17 e17 s17 DC 0 AC 56e-1 120
RI17 e17 4 22e-2
.control
set numdgt=17
ac lin 1 60 60
print v(1) v(2) v(3) v(4) v(5) v(6) v(7) v(8) v(9) v(10)
print v(11) v(12)
print i(vs0) i(vs1) i(vs2) i(vs3) i(vs4) i(vs5) i(vs6) i(vs7) i(vs8) i(vs9)
print i(vs10) i(vs11) i(vs12) i(vs13) i(vs14) i(vs15) i(vs16) i(vs17)
.endc
.end
