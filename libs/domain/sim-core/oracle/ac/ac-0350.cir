controls oracle ac-0350
* Generated (plan F2.7, ADR 0012): do not edit; regenerate with `pnpm sim oracle regen`. ac seed 20261031 index 350 nodes 13 elements 14
.options sparse gmin=1e-12 noopac
RG1 1 0 1000000000000
RG2 2 0 1000000000000
RG3 3 0 1000000000000
RG4 4 0 1000000000000
RG5 5 0 1000000000000
RG6 6 0 1000000000000
RG7 7 0 1000000000000
RG8 8 0 1000000000000
RG9 9 0 1000000000000
RG10 10 0 1000000000000
RG11 11 0 1000000000000
RG12 12 0 1000000000000
VS0 4 s0 0
C0 s0 10 10e-7
VS1 0 s1 0
V1 e1 s1 DC 0 AC 27e-1 -120
RI1 e1 6 15e-2
VS2 11 s2 0
L2 s2 3 68e-4
VS3 7 s3 0
V3 e3 s3 DC 0 AC 15e0 0
RI3 e3 8 18e-1
VS4 7 s4 0
V4 e4 s4 DC 0 AC 82e0 0
RI4 e4 3 39e-3
VS5 7 s5 0
L5 s5 4 47e-3
VS6 1 s6 0
C6 s6 10 18e-5
VS7 4 s7 0
V7 e7 s7 DC 0 AC 22e1 120
RI7 e7 6 47e-3
VS8 11 s8 0
C8 s8 8 39e-7
VS9 0 s9 0
L9 s9 5 12e-5
VS10 12 s10 0
R10 s10 3 68e2
VS11 7 s11 0
C11 s11 2 18e-4
VS12 7 s12 0
R12 s12 9 33e0
VS13 2 s13 0
V13 e13 s13 DC 0 AC 27e0 0
RI13 e13 8 56e-1
.control
set numdgt=17
ac lin 1 60 60
print v(1) v(2) v(3) v(4) v(5) v(6) v(7) v(8) v(9) v(10)
print v(11) v(12)
print i(vs0) i(vs1) i(vs2) i(vs3) i(vs4) i(vs5) i(vs6) i(vs7) i(vs8) i(vs9)
print i(vs10) i(vs11) i(vs12) i(vs13)
.endc
.end
