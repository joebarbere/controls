controls oracle ac-0136
* Generated (plan F2.7, ADR 0012): do not edit; regenerate with `pnpm sim oracle regen`. ac seed 20261031 index 136 nodes 16 elements 32
.options sparse gmin=1e-12 noopac
RG1 1 0 1000000000000
RG2 2 0 1000000000000
RG3 3 0 1000000000000
RG4 4 0 1000000000000
RG5 5 0 1000000000000
RG6 6 0 1000000000000
RG7 7 0 1000000000000
RG8 8 0 1000000000000
RG9 9 0 1000000000000
RG10 10 0 1000000000000
RG11 11 0 1000000000000
RG12 12 0 1000000000000
RG13 13 0 1000000000000
RG14 14 0 1000000000000
RG15 15 0 1000000000000
VS0 0 s0 0
V0 e0 s0 DC 0 AC 18e0 180
RI0 e0 10 18e-1
VS1 0 s1 0
R1 s1 7 27e-2
VS2 5 s2 0
L2 s2 13 22e-3
VS3 8 s3 0
C3 s3 7 27e-5
VS4 1 s4 0
L4 s4 4 82e-4
VS5 12 s5 0
C5 s5 4 39e-4
VS6 1 s6 0
R6 s6 5 68e-1
VS7 6 s7 0
L7 s7 5 12e-3
VS8 9 s8 0
R8 s8 11 15e-2
VS9 8 s9 0
V9 e9 s9 DC 0 AC 68e1 -120
RI9 e9 9 12e-1
VS10 4 s10 0
V10 e10 s10 DC 0 AC 68e1 180
RI10 e10 10 10e-1
VS11 1 s11 0
L11 s11 15 68e-2
VS12 8 s12 0
V12 e12 s12 DC 0 AC 10e1 120
RI12 e12 m12 33e-1
LI12 m12 14 47e-6
VS13 8 s13 0
L13 s13 14 47e-5
VS14 3 s14 0
R14 s14 7 15e-1
VS15 2 s15 0
R15 s15 3 47e-2
VS16 11 s16 0
L16 s16 12 39e-5
VS17 14 s17 0
L17 s17 0 18e-4
VS18 15 s18 0
R18 s18 5 47e0
VS19 1 s19 0
L19 s19 9 22e-4
VS20 13 s20 0
L20 s20 12 18e-3
VS21 2 s21 0
V21 e21 s21 DC 0 AC 22e0 120
RI21 e21 m21 10e-2
LI21 m21 13 12e-7
VS22 10 s22 0
L22 s22 5 56e-3
VS23 1 s23 0
L23 s23 14 68e-2
VS24 8 s24 0
R24 s24 6 10e2
VS25 11 s25 0
R25 s25 5 68e2
VS26 7 s26 0
L26 s26 0 22e-5
VS27 6 s27 0
C27 s27 12 68e-6
VS28 4 s28 0
V28 e28 s28 DC 0 AC 27e1 -120
RI28 e28 0 39e-1
VS29 12 s29 0
L29 s29 14 15e-3
VS30 10 s30 0
R30 s30 6 12e-2
VS31 9 s31 0
C31 s31 13 47e-7
.control
set numdgt=17
ac lin 1 60 60
print v(1) v(2) v(3) v(4) v(5) v(6) v(7) v(8) v(9) v(10)
print v(11) v(12) v(13) v(14) v(15)
print i(vs0) i(vs1) i(vs2) i(vs3) i(vs4) i(vs5) i(vs6) i(vs7) i(vs8) i(vs9)
print i(vs10) i(vs11) i(vs12) i(vs13) i(vs14) i(vs15) i(vs16) i(vs17) i(vs18) i(vs19)
print i(vs20) i(vs21) i(vs22) i(vs23) i(vs24) i(vs25) i(vs26) i(vs27) i(vs28) i(vs29)
print i(vs30) i(vs31)
.endc
.end
