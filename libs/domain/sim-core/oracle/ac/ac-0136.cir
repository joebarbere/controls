controls oracle ac-0136
* Generated (plan F2.7, ADR 0012): do not edit; regenerate with `pnpm sim oracle regen`. ac seed 20261031 index 136 nodes 16 elements 30
.options sparse gmin=1e-12 noopac
RG1 1 0 1000000000000
RG2 2 0 1000000000000
RG3 3 0 1000000000000
RG4 4 0 1000000000000
RG5 5 0 1000000000000
RG6 6 0 1000000000000
RG7 7 0 1000000000000
RG8 8 0 1000000000000
RG9 9 0 1000000000000
RG10 10 0 1000000000000
RG11 11 0 1000000000000
RG12 12 0 1000000000000
RG13 13 0 1000000000000
RG14 14 0 1000000000000
RG15 15 0 1000000000000
VS0 0 s0 0
V0 e0 s0 DC 0 AC 68e1 180
RI0 e0 1 18e-3
VS1 0 s1 0
R1 s1 9 39e2
VS2 8 s2 0
V2 e2 s2 DC 0 AC 47e-1 0
RI2 e2 3 10e-2
VS3 13 s3 0
L3 s3 11 47e-5
VS4 11 s4 0
R4 s4 6 12e-1
VS5 10 s5 0
L5 s5 5 56e-3
VS6 11 s6 0
R6 s6 10 22e-1
VS7 11 s7 0
L7 s7 12 12e-5
VS8 2 s8 0
C8 s8 7 27e-7
VS9 9 s9 0
R9 s9 8 22e2
VS10 5 s10 0
V10 e10 s10 DC 0 AC 68e0 120
RI10 e10 2 39e-2
VS11 8 s11 0
C11 s11 1 15e-7
VS12 14 s12 0
R12 s12 3 33e1
VS13 6 s13 0
V13 e13 s13 DC 0 AC 27e1 -120
RI13 e13 12 39e-1
VS14 9 s14 0
R14 s14 1 15e-1
VS15 6 s15 0
R15 s15 2 56e-1
VS16 12 s16 0
C16 s16 7 27e-5
VS17 11 s17 0
R17 s17 5 68e2
VS18 1 s18 0
L18 s18 9 22e-4
VS19 15 s19 0
R19 s19 3 39e0
VS20 8 s20 0
V20 e20 s20 DC 0 AC 18e0 180
RI20 e20 10 18e-1
VS21 7 s21 0
C21 s21 4 47e-5
VS22 13 s22 0
R22 s22 5 33e3
VS23 6 s23 0
R23 s23 4 22e0
VS24 12 s24 0
L24 s24 3 27e-3
VS25 8 s25 0
C25 s25 12 33e-5
VS26 10 s26 0
C26 s26 15 27e-4
VS27 12 s27 0
V27 e27 s27 DC 0 AC 68e1 -120
RI27 e27 9 12e-1
VS28 12 s28 0
V28 e28 s28 DC 0 AC 15e1 0
RI28 e28 14 56e-1
VS29 14 s29 0
L29 s29 0 82e-5
.control
set numdgt=17
ac lin 1 60 60
print v(1) v(2) v(3) v(4) v(5) v(6) v(7) v(8) v(9) v(10)
print v(11) v(12) v(13) v(14) v(15)
print i(vs0) i(vs1) i(vs2) i(vs3) i(vs4) i(vs5) i(vs6) i(vs7) i(vs8) i(vs9)
print i(vs10) i(vs11) i(vs12) i(vs13) i(vs14) i(vs15) i(vs16) i(vs17) i(vs18) i(vs19)
print i(vs20) i(vs21) i(vs22) i(vs23) i(vs24) i(vs25) i(vs26) i(vs27) i(vs28) i(vs29)
.endc
.end
