controls oracle ac-0136
* Generated (plan F2.7, ADR 0012): do not edit; regenerate with `pnpm sim oracle regen`. ac seed 20261031 index 136 nodes 16 elements 29
.options sparse gmin=1e-12 noopac
RG1 1 0 1000000000000
RG2 2 0 1000000000000
RG3 3 0 1000000000000
RG4 4 0 1000000000000
RG5 5 0 1000000000000
RG6 6 0 1000000000000
RG7 7 0 1000000000000
RG8 8 0 1000000000000
RG9 9 0 1000000000000
RG10 10 0 1000000000000
RG11 11 0 1000000000000
RG12 12 0 1000000000000
RG13 13 0 1000000000000
RG14 14 0 1000000000000
RG15 15 0 1000000000000
VS0 13 s0 0
L0 s0 11 47e-5
VS1 6 s1 0
L1 s1 3 27e-3
VS2 15 s2 0
R2 s2 3 39e0
VS3 11 s3 0
L3 s3 6 12e-5
VS4 12 s4 0
R4 s4 9 39e2
VS5 11 s5 0
R5 s5 5 68e2
VS6 0 s6 0
V6 e6 s6 DC 0 AC 27e1 -120
RI6 e6 6 39e-1
VS7 9 s7 0
R7 s7 8 22e2
VS8 11 s8 0
R8 s8 0 12e-1
VS9 1 s9 0
L9 s9 9 22e-4
VS10 12 s10 0
V10 e10 s10 DC 0 AC 68e1 180
RI10 e10 1 18e-3
VS11 10 s11 0
C11 s11 15 27e-4
VS12 2 s12 0
C12 s12 7 27e-7
VS13 8 s13 0
C13 s13 1 15e-7
VS14 10 s14 0
L14 s14 5 56e-3
VS15 9 s15 0
R15 s15 1 15e-1
VS16 14 s16 0
R16 s16 3 33e1
VS17 13 s17 0
R17 s17 5 33e3
VS18 6 s18 0
C18 s18 7 27e-5
VS19 8 s19 0
C19 s19 6 33e-5
VS20 0 s20 0
R20 s20 2 56e-1
VS21 11 s21 0
R21 s21 10 22e-1
VS22 6 s22 0
V22 e22 s22 DC 0 AC 15e1 0
RI22 e22 14 56e-1
VS23 5 s23 0
V23 e23 s23 DC 0 AC 68e0 120
RI23 e23 2 39e-2
VS24 14 s24 0
L24 s24 12 82e-5
VS25 0 s25 0
R25 s25 4 22e0
VS26 8 s26 0
V26 e26 s26 DC 0 AC 47e-1 0
RI26 e26 3 10e-2
VS27 8 s27 0
V27 e27 s27 DC 0 AC 18e0 180
RI27 e27 10 18e-1
VS28 6 s28 0
V28 e28 s28 DC 0 AC 68e1 -120
RI28 e28 9 12e-1
.control
set numdgt=17
ac lin 1 60 60
print v(1) v(2) v(3) v(4) v(5) v(6) v(7) v(8) v(9) v(10)
print v(11) v(12) v(13) v(14) v(15)
print i(vs0) i(vs1) i(vs2) i(vs3) i(vs4) i(vs5) i(vs6) i(vs7) i(vs8) i(vs9)
print i(vs10) i(vs11) i(vs12) i(vs13) i(vs14) i(vs15) i(vs16) i(vs17) i(vs18) i(vs19)
print i(vs20) i(vs21) i(vs22) i(vs23) i(vs24) i(vs25) i(vs26) i(vs27) i(vs28)
.endc
.end
