controls oracle ac-0264
* Generated (plan F2.7, ADR 0012): do not edit; regenerate with `pnpm sim oracle regen`. ac seed 20261031 index 264 nodes 4 elements 5
.options sparse gmin=1e-12 noopac
RG1 1 0 1000000000000
RG2 2 0 1000000000000
RG3 3 0 1000000000000
VS0 0 s0 0
V0 e0 s0 DC 0 AC 22e1 -120
RI0 e0 3 22e-3
VS1 0 s1 0
L1 s1 1 39e-4
VS2 1 s2 0
R2 s2 2 33e3
VS3 3 s3 0
R3 s3 1 39e0
VS4 2 s4 0
V4 e4 s4 DC 0 AC 27e-1 0
RI4 e4 0 39e-3
.control
set numdgt=17
ac lin 1 60 60
print v(1) v(2) v(3)
print i(vs0) i(vs1) i(vs2) i(vs3) i(vs4)
.endc
.end
