controls oracle ac-0264
* Generated (plan F2.7, ADR 0012): do not edit; regenerate with `pnpm sim oracle regen`. ac seed 20261031 index 264 nodes 4 elements 6
.options sparse gmin=1e-12 noopac
RG1 1 0 1000000000000
RG2 2 0 1000000000000
RG3 3 0 1000000000000
VS0 0 s0 0
V0 e0 s0 DC 0 AC 27e-1 0
RI0 e0 2 39e-3
VS1 2 s1 0
R1 s1 1 82e-1
VS2 0 s2 0
L2 s2 1 15e-5
VS3 0 s3 0
L3 s3 2 39e-5
VS4 1 s4 0
R4 s4 2 15e-1
VS5 3 s5 0
R5 s5 0 68e2
.control
set numdgt=17
ac lin 1 60 60
print v(1) v(2) v(3)
print i(vs0) i(vs1) i(vs2) i(vs3) i(vs4) i(vs5)
.endc
.end
