controls oracle ac-0421
* Generated (plan F2.7, ADR 0012): do not edit; regenerate with `pnpm sim oracle regen`. ac seed 20261031 index 421 nodes 26 elements 53
.options sparse gmin=1e-12 noopac
RG1 1 0 1000000000000
RG2 2 0 1000000000000
RG3 3 0 1000000000000
RG4 4 0 1000000000000
RG5 5 0 1000000000000
RG6 6 0 1000000000000
RG7 7 0 1000000000000
RG8 8 0 1000000000000
RG9 9 0 1000000000000
RG10 10 0 1000000000000
RG11 11 0 1000000000000
RG12 12 0 1000000000000
RG13 13 0 1000000000000
RG14 14 0 1000000000000
RG15 15 0 1000000000000
RG16 16 0 1000000000000
RG17 17 0 1000000000000
RG18 18 0 1000000000000
RG19 19 0 1000000000000
RG20 20 0 1000000000000
RG21 21 0 1000000000000
RG22 22 0 1000000000000
RG23 23 0 1000000000000
RG24 24 0 1000000000000
RG25 25 0 1000000000000
VS0 17 s0 0
C0 s0 9 82e-6
VS1 22 s1 0
C1 s1 7 68e-4
VS2 22 s2 0
L2 s2 17 47e-3
VS3 14 s3 0
R3 s3 7 56e0
VS4 18 s4 0
R4 s4 1 39e3
VS5 21 s5 0
L5 s5 20 39e-5
VS6 13 s6 0
R6 s6 21 47e2
VS7 3 s7 0
R7 s7 14 12e1
VS8 9 s8 0
C8 s8 24 18e-5
VS9 22 s9 0
R9 s9 7 22e-2
VS10 19 s10 0
L10 s10 11 39e-3
VS11 12 s11 0
R11 s11 18 39e-1
VS12 6 s12 0
L12 s12 17 15e-3
VS13 4 s13 0
R13 s13 21 68e2
VS14 4 s14 0
R14 s14 11 68e-2
VS15 0 s15 0
V15 e15 s15 DC 0 AC 15e-1 120
RI15 e15 m15 56e-1
LI15 m15 2 68e-6
VS16 11 s16 0
V16 e16 s16 DC 0 AC 27e0 120
RI16 e16 m16 56e-2
LI16 m16 22 22e-7
VS17 15 s17 0
V17 e17 s17 DC 0 AC 12e-1 120
RI17 e17 m17 47e-2
LI17 m17 25 10e-7
VS18 12 s18 0
R18 s18 23 68e0
VS19 14 s19 0
V19 e19 s19 DC 0 AC 12e-1 120
RI19 e19 6 27e-2
VS20 24 s20 0
R20 s20 4 22e2
VS21 11 s21 0
C21 s21 21 56e-4
VS22 13 s22 0
L22 s22 9 39e-3
VS23 9 s23 0
C23 s23 2 10e-7
VS24 14 s24 0
C24 s24 22 18e-5
VS25 12 s25 0
L25 s25 22 10e-5
VS26 14 s26 0
R26 s26 13 10e-2
VS27 10 s27 0
L27 s27 7 15e-2
VS28 4 s28 0
R28 s28 22 15e0
VS29 15 s29 0
V29 e29 s29 DC 0 AC 12e1 0
RI29 e29 m29 27e-1
LI29 m29 4 27e-6
VS30 22 s30 0
C30 s30 1 27e-7
VS31 9 s31 0
R31 s31 10 12e-1
VS32 16 s32 0
C32 s32 13 39e-7
VS33 15 s33 0
R33 s33 23 33e3
VS34 17 s34 0
V34 e34 s34 DC 0 AC 33e-1 180
RI34 e34 m34 68e-3
LI34 m34 0 56e-7
VS35 3 s35 0
C35 s35 2 39e-6
VS36 8 s36 0
C36 s36 20 12e-4
VS37 5 s37 0
R37 s37 1 33e2
VS38 9 s38 0
R38 s38 0 47e-2
VS39 17 s39 0
L39 s39 9 15e-4
VS40 2 s40 0
C40 s40 5 22e-5
VS41 19 s41 0
L41 s41 15 33e-4
VS42 9 s42 0
R42 s42 19 47e0
VS43 12 s43 0
V43 e43 s43 DC 0 AC 10e1 -120
RI43 e43 m43 10e-3
LI43 m43 2 39e-7
VS44 17 s44 0
R44 s44 23 22e-1
VS45 8 s45 0
L45 s45 21 12e-5
VS46 20 s46 0
R46 s46 16 82e3
VS47 22 s47 0
V47 e47 s47 DC 0 AC 68e1 0
RI47 e47 17 68e-2
VS48 17 s48 0
C48 s48 3 10e-6
VS49 6 s49 0
V49 e49 s49 DC 0 AC 39e1 -120
RI49 e49 23 82e-3
VS50 18 s50 0
C50 s50 25 68e-5
VS51 19 s51 0
V51 e51 s51 DC 0 AC 15e0 0
RI51 e51 10 15e-3
VS52 10 s52 0
V52 e52 s52 DC 0 AC 18e0 180
RI52 e52 m52 10e-3
LI52 m52 9 68e-6
.control
set numdgt=17
ac lin 1 60 60
print v(1) v(2) v(3) v(4) v(5) v(6) v(7) v(8) v(9) v(10)
print v(11) v(12) v(13) v(14) v(15) v(16) v(17) v(18) v(19) v(20)
print v(21) v(22) v(23) v(24) v(25)
print i(vs0) i(vs1) i(vs2) i(vs3) i(vs4) i(vs5) i(vs6) i(vs7) i(vs8) i(vs9)
print i(vs10) i(vs11) i(vs12) i(vs13) i(vs14) i(vs15) i(vs16) i(vs17) i(vs18) i(vs19)
print i(vs20) i(vs21) i(vs22) i(vs23) i(vs24) i(vs25) i(vs26) i(vs27) i(vs28) i(vs29)
print i(vs30) i(vs31) i(vs32) i(vs33) i(vs34) i(vs35) i(vs36) i(vs37) i(vs38) i(vs39)
print i(vs40) i(vs41) i(vs42) i(vs43) i(vs44) i(vs45) i(vs46) i(vs47) i(vs48) i(vs49)
print i(vs50) i(vs51) i(vs52)
.endc
.end
