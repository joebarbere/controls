controls oracle ac-0421
* Generated (plan F2.7, ADR 0012): do not edit; regenerate with `pnpm sim oracle regen`. ac seed 20261031 index 421 nodes 26 elements 39
.options sparse gmin=1e-12 noopac
RG1 1 0 1000000000000
RG2 2 0 1000000000000
RG3 3 0 1000000000000
RG4 4 0 1000000000000
RG5 5 0 1000000000000
RG6 6 0 1000000000000
RG7 7 0 1000000000000
RG8 8 0 1000000000000
RG9 9 0 1000000000000
RG10 10 0 1000000000000
RG11 11 0 1000000000000
RG12 12 0 1000000000000
RG13 13 0 1000000000000
RG14 14 0 1000000000000
RG15 15 0 1000000000000
RG16 16 0 1000000000000
RG17 17 0 1000000000000
RG18 18 0 1000000000000
RG19 19 0 1000000000000
RG20 20 0 1000000000000
RG21 21 0 1000000000000
RG22 22 0 1000000000000
RG23 23 0 1000000000000
RG24 24 0 1000000000000
RG25 25 0 1000000000000
VS0 12 s0 0
R0 s0 14 39e-2
VS1 6 s1 0
L1 s1 22 33e-4
VS2 15 s2 0
L2 s2 10 47e-5
VS3 8 s3 0
C3 s3 10 22e-5
VS4 23 s4 0
R4 s4 2 33e2
VS5 22 s5 0
C5 s5 5 56e-5
VS6 24 s6 0
L6 s6 4 56e-3
VS7 3 s7 0
R7 s7 14 15e-2
VS8 0 s8 0
V8 e8 s8 DC 0 AC 22e-1 -120
RI8 e8 22 15e-1
VS9 10 s9 0
L9 s9 14 56e-5
VS10 21 s10 0
R10 s10 15 33e0
VS11 20 s11 0
C11 s11 11 18e-5
VS12 1 s12 0
R12 s12 19 68e2
VS13 9 s13 0
V13 e13 s13 DC 0 AC 10e-1 120
RI13 e13 m13 68e-1
LI13 m13 13 39e-6
VS14 14 s14 0
R14 s14 7 56e0
VS15 12 s15 0
R15 s15 13 68e0
VS16 23 s16 0
V16 e16 s16 DC 0 AC 47e1 0
RI16 e16 m16 68e-2
LI16 m16 0 12e-6
VS17 13 s17 0
L17 s17 9 39e-3
VS18 16 s18 0
V18 e18 s18 DC 0 AC 22e0 180
RI18 e18 12 15e-3
VS19 17 s19 0
R19 s19 4 56e3
VS20 11 s20 0
V20 e20 s20 DC 0 AC 27e0 120
RI20 e20 m20 56e-2
LI20 m20 12 10e-6
VS21 10 s21 0
L21 s21 18 82e-2
VS22 22 s22 0
C22 s22 24 33e-4
VS23 7 s23 0
C23 s23 3 15e-4
VS24 21 s24 0
V24 e24 s24 DC 0 AC 12e1 0
RI24 e24 22 27e-1
VS25 19 s25 0
R25 s25 18 33e0
VS26 17 s26 0
V26 e26 s26 DC 0 AC 33e0 -120
RI26 e26 23 47e-2
VS27 22 s27 0
R27 s27 17 22e0
VS28 16 s28 0
L28 s28 7 10e-3
VS29 6 s29 0
R29 s29 14 22e-2
VS30 12 s30 0
L30 s30 1 10e-4
VS31 25 s31 0
L31 s31 2 33e-3
VS32 24 s32 0
V32 e32 s32 DC 0 AC 15e-1 120
RI32 e32 m32 56e-1
LI32 m32 13 68e-6
VS33 20 s33 0
R33 s33 25 82e-2
VS34 7 s34 0
C34 s34 5 27e-4
VS35 17 s35 0
C35 s35 9 82e-6
VS36 3 s36 0
R36 s36 14 12e1
VS37 12 s37 0
R37 s37 17 33e0
VS38 8 s38 0
C38 s38 12 18e-4
.control
set numdgt=17
ac lin 1 60 60
print v(1) v(2) v(3) v(4) v(5) v(6) v(7) v(8) v(9) v(10)
print v(11) v(12) v(13) v(14) v(15) v(16) v(17) v(18) v(19) v(20)
print v(21) v(22) v(23) v(24) v(25)
print i(vs0) i(vs1) i(vs2) i(vs3) i(vs4) i(vs5) i(vs6) i(vs7) i(vs8) i(vs9)
print i(vs10) i(vs11) i(vs12) i(vs13) i(vs14) i(vs15) i(vs16) i(vs17) i(vs18) i(vs19)
print i(vs20) i(vs21) i(vs22) i(vs23) i(vs24) i(vs25) i(vs26) i(vs27) i(vs28) i(vs29)
print i(vs30) i(vs31) i(vs32) i(vs33) i(vs34) i(vs35) i(vs36) i(vs37) i(vs38)
.endc
.end
