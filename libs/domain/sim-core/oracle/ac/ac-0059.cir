controls oracle ac-0059
* Generated (plan F2.7, ADR 0012): do not edit; regenerate with `pnpm sim oracle regen`. ac seed 20261031 index 59 nodes 19 elements 20
.options sparse gmin=1e-12 noopac
RG1 1 0 1000000000000
RG2 2 0 1000000000000
RG3 3 0 1000000000000
RG4 4 0 1000000000000
RG5 5 0 1000000000000
RG6 6 0 1000000000000
RG7 7 0 1000000000000
RG8 8 0 1000000000000
RG9 9 0 1000000000000
RG10 10 0 1000000000000
RG11 11 0 1000000000000
RG12 12 0 1000000000000
RG13 13 0 1000000000000
RG14 14 0 1000000000000
RG15 15 0 1000000000000
RG16 16 0 1000000000000
RG17 17 0 1000000000000
RG18 18 0 1000000000000
VS0 7 s0 0
R0 s0 9 22e-1
VS1 0 s1 0
L1 s1 16 18e-4
VS2 0 s2 0
V2 e2 s2 DC 0 AC 27e1 120
RI2 e2 14 12e-1
VS3 1 s3 0
C3 s3 14 82e-5
VS4 15 s4 0
R4 s4 4 39e0
VS5 0 s5 0
C5 s5 18 68e-6
VS6 5 s6 0
L6 s6 9 27e-5
VS7 13 s7 0
C7 s7 7 27e-4
VS8 15 s8 0
L8 s8 12 15e-2
VS9 0 s9 0
R9 s9 12 22e3
VS10 8 s10 0
R10 s10 3 47e-1
VS11 8 s11 0
L11 s11 10 82e-5
VS12 8 s12 0
V12 e12 s12 DC 0 AC 33e-1 180
RI12 e12 6 39e-2
VS13 15 s13 0
C13 s13 17 47e-7
VS14 0 s14 0
L14 s14 14 15e-4
VS15 11 s15 0
C15 s15 15 47e-7
VS16 16 s16 0
R16 s16 8 33e0
VS17 0 s17 0
L17 s17 9 82e-2
VS18 5 s18 0
L18 s18 2 39e-2
VS19 9 s19 0
L19 s19 15 47e-5
.control
set numdgt=17
ac lin 1 60 60
print v(1) v(2) v(3) v(4) v(5) v(6) v(7) v(8) v(9) v(10)
print v(11) v(12) v(13) v(14) v(15) v(16) v(17) v(18)
print i(vs0) i(vs1) i(vs2) i(vs3) i(vs4) i(vs5) i(vs6) i(vs7) i(vs8) i(vs9)
print i(vs10) i(vs11) i(vs12) i(vs13) i(vs14) i(vs15) i(vs16) i(vs17) i(vs18) i(vs19)
.endc
.end
