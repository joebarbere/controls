controls oracle ac-0059
* Generated (plan F2.7, ADR 0012): do not edit; regenerate with `pnpm sim oracle regen`. ac seed 20261031 index 59 nodes 19 elements 37
.options sparse gmin=1e-12 noopac
RG1 1 0 1000000000000
RG2 2 0 1000000000000
RG3 3 0 1000000000000
RG4 4 0 1000000000000
RG5 5 0 1000000000000
RG6 6 0 1000000000000
RG7 7 0 1000000000000
RG8 8 0 1000000000000
RG9 9 0 1000000000000
RG10 10 0 1000000000000
RG11 11 0 1000000000000
RG12 12 0 1000000000000
RG13 13 0 1000000000000
RG14 14 0 1000000000000
RG15 15 0 1000000000000
RG16 16 0 1000000000000
RG17 17 0 1000000000000
RG18 18 0 1000000000000
VS0 7 s0 0
R0 s0 17 68e2
VS1 0 s1 0
V1 e1 s1 DC 0 AC 56e1 120
RI1 e1 7 27e-1
VS2 9 s2 0
L2 s2 0 12e-3
VS3 4 s3 0
V3 e3 s3 DC 0 AC 47e1 120
RI3 e3 m3 47e-2
LI3 m3 13 22e-5
VS4 0 s4 0
R4 s4 12 18e0
VS5 3 s5 0
L5 s5 6 47e-3
VS6 11 s6 0
V6 e6 s6 DC 0 AC 39e-1 0
RI6 e6 1 47e-2
VS7 9 s7 0
V7 e7 s7 DC 0 AC 27e1 120
RI7 e7 14 12e-1
VS8 18 s8 0
R8 s8 15 82e3
VS9 9 s9 0
V9 e9 s9 DC 0 AC 82e-1 180
RI9 e9 m9 18e-2
LI9 m9 5 47e-6
VS10 18 s10 0
L10 s10 8 33e-4
VS11 3 s11 0
C11 s11 12 33e-4
VS12 0 s12 0
L12 s12 11 10e-3
VS13 16 s13 0
V13 e13 s13 DC 0 AC 56e-1 120
RI13 e13 m13 22e-3
LI13 m13 14 68e-6
VS14 5 s14 0
C14 s14 2 47e-6
VS15 9 s15 0
L15 s15 18 82e-2
VS16 3 s16 0
V16 e16 s16 DC 0 AC 22e0 -120
RI16 e16 2 47e-1
VS17 4 s17 0
V17 e17 s17 DC 0 AC 18e1 -120
RI17 e17 m17 39e-1
LI17 m17 12 47e-7
VS18 16 s18 0
L18 s18 2 27e-3
VS19 6 s19 0
R19 s19 7 15e1
VS20 17 s20 0
L20 s20 6 82e-5
VS21 8 s21 0
V21 e21 s21 DC 0 AC 56e1 -120
RI21 e21 5 39e-1
VS22 8 s22 0
L22 s22 16 68e-4
VS23 9 s23 0
C23 s23 16 22e-4
VS24 13 s24 0
C24 s24 4 27e-7
VS25 1 s25 0
V25 e25 s25 DC 0 AC 68e1 120
RI25 e25 5 56e-2
VS26 4 s26 0
R26 s26 16 15e1
VS27 18 s27 0
L27 s27 15 47e-5
VS28 5 s28 0
R28 s28 10 15e-1
VS29 9 s29 0
R29 s29 13 12e2
VS30 8 s30 0
L30 s30 11 12e-5
VS31 18 s31 0
L31 s31 7 39e-3
VS32 10 s32 0
V32 e32 s32 DC 0 AC 22e1 120
RI32 e32 m32 33e-1
LI32 m32 7 15e-5
VS33 15 s33 0
V33 e33 s33 DC 0 AC 39e-1 -120
RI33 e33 2 12e-1
VS34 8 s34 0
C34 s34 2 12e-7
VS35 1 s35 0
V35 e35 s35 DC 0 AC 12e1 -120
RI35 e35 14 10e-3
VS36 9 s36 0
L36 s36 16 18e-4
.control
set numdgt=17
ac lin 1 60 60
print v(1) v(2) v(3) v(4) v(5) v(6) v(7) v(8) v(9) v(10)
print v(11) v(12) v(13) v(14) v(15) v(16) v(17) v(18)
print i(vs0) i(vs1) i(vs2) i(vs3) i(vs4) i(vs5) i(vs6) i(vs7) i(vs8) i(vs9)
print i(vs10) i(vs11) i(vs12) i(vs13) i(vs14) i(vs15) i(vs16) i(vs17) i(vs18) i(vs19)
print i(vs20) i(vs21) i(vs22) i(vs23) i(vs24) i(vs25) i(vs26) i(vs27) i(vs28) i(vs29)
print i(vs30) i(vs31) i(vs32) i(vs33) i(vs34) i(vs35) i(vs36)
.endc
.end
