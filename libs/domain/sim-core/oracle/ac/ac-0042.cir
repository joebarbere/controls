controls oracle ac-0042
* Generated (plan F2.7, ADR 0012): do not edit; regenerate with `pnpm sim oracle regen`. ac seed 20261031 index 42 nodes 25 elements 47
.options sparse gmin=1e-12 noopac
RG1 1 0 1000000000000
RG2 2 0 1000000000000
RG3 3 0 1000000000000
RG4 4 0 1000000000000
RG5 5 0 1000000000000
RG6 6 0 1000000000000
RG7 7 0 1000000000000
RG8 8 0 1000000000000
RG9 9 0 1000000000000
RG10 10 0 1000000000000
RG11 11 0 1000000000000
RG12 12 0 1000000000000
RG13 13 0 1000000000000
RG14 14 0 1000000000000
RG15 15 0 1000000000000
RG16 16 0 1000000000000
RG17 17 0 1000000000000
RG18 18 0 1000000000000
RG19 19 0 1000000000000
RG20 20 0 1000000000000
RG21 21 0 1000000000000
RG22 22 0 1000000000000
RG23 23 0 1000000000000
RG24 24 0 1000000000000
VS0 7 s0 0
L0 s0 17 33e-2
VS1 0 s1 0
V1 e1 s1 DC 0 AC 33e1 -120
RI1 e1 2 10e-3
VS2 21 s2 0
L2 s2 1 27e-4
VS3 5 s3 0
R3 s3 21 56e-1
VS4 6 s4 0
L4 s4 12 12e-3
VS5 20 s5 0
V5 e5 s5 DC 0 AC 33e1 180
RI5 e5 13 39e-2
VS6 15 s6 0
C6 s6 2 10e-4
VS7 13 s7 0
R7 s7 16 39e1
VS8 17 s8 0
R8 s8 5 15e0
VS9 22 s9 0
R9 s9 19 18e2
VS10 15 s10 0
C10 s10 0 10e-4
VS11 13 s11 0
R11 s11 21 18e-1
VS12 2 s12 0
V12 e12 s12 DC 0 AC 82e1 0
RI12 e12 10 82e-3
VS13 4 s13 0
C13 s13 11 27e-7
VS14 21 s14 0
R14 s14 4 39e-2
VS15 24 s15 0
R15 s15 6 56e1
VS16 20 s16 0
R16 s16 21 10e2
VS17 11 s17 0
L17 s17 18 39e-5
VS18 8 s18 0
L18 s18 16 22e-2
VS19 10 s19 0
R19 s19 23 15e1
VS20 21 s20 0
C20 s20 23 27e-4
VS21 22 s21 0
R21 s21 1 27e-2
VS22 14 s22 0
L22 s22 12 22e-4
VS23 12 s23 0
L23 s23 2 18e-5
VS24 18 s24 0
R24 s24 7 39e-2
VS25 20 s25 0
V25 e25 s25 DC 0 AC 18e-1 120
RI25 e25 0 18e-2
VS26 12 s26 0
V26 e26 s26 DC 0 AC 15e0 0
RI26 e26 23 82e-1
VS27 21 s27 0
R27 s27 9 47e-1
VS28 21 s28 0
L28 s28 14 47e-3
VS29 9 s29 0
C29 s29 3 15e-7
VS30 19 s30 0
R30 s30 1 33e-1
VS31 4 s31 0
R31 s31 5 33e1
VS32 13 s32 0
C32 s32 7 18e-5
VS33 18 s33 0
L33 s33 19 12e-3
VS34 22 s34 0
V34 e34 s34 DC 0 AC 39e0 120
RI34 e34 10 27e-3
VS35 22 s35 0
L35 s35 5 18e-4
VS36 21 s36 0
C36 s36 17 22e-4
VS37 3 s37 0
C37 s37 8 33e-7
VS38 21 s38 0
L38 s38 8 56e-2
VS39 10 s39 0
V39 e39 s39 DC 0 AC 22e-1 180
RI39 e39 21 82e-3
VS40 24 s40 0
L40 s40 3 68e-3
VS41 0 s41 0
C41 s41 16 27e-7
VS42 3 s42 0
L42 s42 12 68e-4
VS43 23 s43 0
R43 s43 1 68e1
VS44 8 s44 0
R44 s44 16 33e0
VS45 19 s45 0
C45 s45 5 27e-4
VS46 17 s46 0
V46 e46 s46 DC 0 AC 68e0 -120
RI46 e46 11 18e-1
.control
set numdgt=17
ac lin 1 60 60
print v(1) v(2) v(3) v(4) v(5) v(6) v(7) v(8) v(9) v(10)
print v(11) v(12) v(13) v(14) v(15) v(16) v(17) v(18) v(19) v(20)
print v(21) v(22) v(23) v(24)
print i(vs0) i(vs1) i(vs2) i(vs3) i(vs4) i(vs5) i(vs6) i(vs7) i(vs8) i(vs9)
print i(vs10) i(vs11) i(vs12) i(vs13) i(vs14) i(vs15) i(vs16) i(vs17) i(vs18) i(vs19)
print i(vs20) i(vs21) i(vs22) i(vs23) i(vs24) i(vs25) i(vs26) i(vs27) i(vs28) i(vs29)
print i(vs30) i(vs31) i(vs32) i(vs33) i(vs34) i(vs35) i(vs36) i(vs37) i(vs38) i(vs39)
print i(vs40) i(vs41) i(vs42) i(vs43) i(vs44) i(vs45) i(vs46)
.endc
.end
