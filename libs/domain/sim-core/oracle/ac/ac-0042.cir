controls oracle ac-0042
* Generated (plan F2.7, ADR 0012): do not edit; regenerate with `pnpm sim oracle regen`. ac seed 20261031 index 42 nodes 25 elements 40
.options sparse gmin=1e-12 noopac
RG1 1 0 1000000000000
RG2 2 0 1000000000000
RG3 3 0 1000000000000
RG4 4 0 1000000000000
RG5 5 0 1000000000000
RG6 6 0 1000000000000
RG7 7 0 1000000000000
RG8 8 0 1000000000000
RG9 9 0 1000000000000
RG10 10 0 1000000000000
RG11 11 0 1000000000000
RG12 12 0 1000000000000
RG13 13 0 1000000000000
RG14 14 0 1000000000000
RG15 15 0 1000000000000
RG16 16 0 1000000000000
RG17 17 0 1000000000000
RG18 18 0 1000000000000
RG19 19 0 1000000000000
RG20 20 0 1000000000000
RG21 21 0 1000000000000
RG22 22 0 1000000000000
RG23 23 0 1000000000000
RG24 24 0 1000000000000
VS0 0 s0 0
V0 e0 s0 DC 0 AC 33e1 -120
RI0 e0 15 10e-3
VS1 18 s1 0
L1 s1 4 27e-4
VS2 14 s2 0
R2 s2 4 10e0
VS3 19 s3 0
C3 s3 17 10e-4
VS4 16 s4 0
L4 s4 20 56e-2
VS5 4 s5 0
V5 e5 s5 DC 0 AC 82e-1 120
RI5 e5 m5 22e-3
LI5 m5 2 82e-5
VS6 22 s6 0
C6 s6 2 10e-5
VS7 3 s7 0
C7 s7 8 33e-7
VS8 2 s8 0
C8 s8 6 82e-7
VS9 8 s9 0
L9 s9 7 18e-5
VS10 20 s10 0
R10 s10 21 33e-1
VS11 13 s11 0
C11 s11 17 22e-4
VS12 17 s12 0
R12 s12 23 68e-1
VS13 5 s13 0
R13 s13 13 56e-1
VS14 4 s14 0
C14 s14 5 15e-7
VS15 1 s15 0
R15 s15 11 22e-1
VS16 13 s16 0
C16 s16 23 27e-4
VS17 8 s17 0
R17 s17 16 33e0
VS18 21 s18 0
R18 s18 9 47e-1
VS19 24 s19 0
L19 s19 3 68e-3
VS20 0 s20 0
C20 s20 6 15e-6
VS21 22 s21 0
R21 s21 9 39e-1
VS22 10 s22 0
V22 e22 s22 DC 0 AC 22e-1 180
RI22 e22 13 82e-3
VS23 24 s23 0
R23 s23 12 82e-2
VS24 16 s24 0
R24 s24 13 33e2
VS25 13 s25 0
R25 s25 11 10e2
VS26 15 s26 0
L26 s26 18 33e-2
VS27 24 s27 0
L27 s27 17 10e-4
VS28 12 s28 0
V28 e28 s28 DC 0 AC 15e0 0
RI28 e28 m28 82e-1
LI28 m28 23 33e-5
VS29 14 s29 0
L29 s29 22 10e-4
VS30 0 s30 0
V30 e30 s30 DC 0 AC 22e0 0
RI30 e30 3 10e-3
VS31 18 s31 0
R31 s31 7 39e-2
VS32 0 s32 0
V32 e32 s32 DC 0 AC 33e1 0
RI32 e32 10 68e-3
VS33 19 s33 0
C33 s33 2 10e-7
VS34 13 s34 0
L34 s34 8 56e-2
VS35 10 s35 0
R35 s35 23 15e1
VS36 9 s36 0
L36 s36 8 12e-5
VS37 21 s37 0
R37 s37 11 18e-1
VS38 1 s38 0
V38 e38 s38 DC 0 AC 27e1 -120
RI38 e38 m38 82e-3
LI38 m38 17 10e-5
VS39 13 s39 0
L39 s39 14 47e-3
.control
set numdgt=17
ac lin 1 60 60
print v(1) v(2) v(3) v(4) v(5) v(6) v(7) v(8) v(9) v(10)
print v(11) v(12) v(13) v(14) v(15) v(16) v(17) v(18) v(19) v(20)
print v(21) v(22) v(23) v(24)
print i(vs0) i(vs1) i(vs2) i(vs3) i(vs4) i(vs5) i(vs6) i(vs7) i(vs8) i(vs9)
print i(vs10) i(vs11) i(vs12) i(vs13) i(vs14) i(vs15) i(vs16) i(vs17) i(vs18) i(vs19)
print i(vs20) i(vs21) i(vs22) i(vs23) i(vs24) i(vs25) i(vs26) i(vs27) i(vs28) i(vs29)
print i(vs30) i(vs31) i(vs32) i(vs33) i(vs34) i(vs35) i(vs36) i(vs37) i(vs38) i(vs39)
.endc
.end
