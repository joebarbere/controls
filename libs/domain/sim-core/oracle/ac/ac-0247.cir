controls oracle ac-0247
* Generated (plan F2.7, ADR 0012): do not edit; regenerate with `pnpm sim oracle regen`. ac seed 20261031 index 247 nodes 20 elements 31
.options sparse gmin=1e-12 noopac
RG1 1 0 1000000000000
RG2 2 0 1000000000000
RG3 3 0 1000000000000
RG4 4 0 1000000000000
RG5 5 0 1000000000000
RG6 6 0 1000000000000
RG7 7 0 1000000000000
RG8 8 0 1000000000000
RG9 9 0 1000000000000
RG10 10 0 1000000000000
RG11 11 0 1000000000000
RG12 12 0 1000000000000
RG13 13 0 1000000000000
RG14 14 0 1000000000000
RG15 15 0 1000000000000
RG16 16 0 1000000000000
RG17 17 0 1000000000000
RG18 18 0 1000000000000
RG19 19 0 1000000000000
VS0 17 s0 0
R0 s0 18 22e3
VS1 0 s1 0
V1 e1 s1 DC 0 AC 68e-1 180
RI1 e1 15 10e-3
VS2 3 s2 0
C2 s2 12 33e-5
VS3 9 s3 0
L3 s3 14 33e-5
VS4 8 s4 0
C4 s4 0 10e-5
VS5 17 s5 0
C5 s5 13 27e-5
VS6 12 s6 0
R6 s6 7 22e2
VS7 19 s7 0
V7 e7 s7 DC 0 AC 56e-1 -120
RI7 e7 8 12e-2
VS8 15 s8 0
R8 s8 5 22e-2
VS9 11 s9 0
R9 s9 4 39e2
VS10 11 s10 0
L10 s10 10 47e-2
VS11 15 s11 0
L11 s11 6 10e-3
VS12 9 s12 0
C12 s12 3 12e-7
VS13 18 s13 0
R13 s13 6 56e1
VS14 15 s14 0
R14 s14 1 33e2
VS15 7 s15 0
R15 s15 9 33e0
VS16 11 s16 0
V16 e16 s16 DC 0 AC 10e-1 -120
RI16 e16 7 10e-3
VS17 17 s17 0
V17 e17 s17 DC 0 AC 33e-1 0
RI17 e17 7 22e-2
VS18 17 s18 0
V18 e18 s18 DC 0 AC 33e0 120
RI18 e18 10 33e-2
VS19 12 s19 0
R19 s19 2 18e3
VS20 7 s20 0
V20 e20 s20 DC 0 AC 56e-1 120
RI20 e20 6 33e-3
VS21 7 s21 0
C21 s21 19 15e-5
VS22 17 s22 0
V22 e22 s22 DC 0 AC 39e-1 -120
RI22 e22 18 47e-1
VS23 10 s23 0
R23 s23 6 47e1
VS24 18 s24 0
L24 s24 2 15e-3
VS25 17 s25 0
C25 s25 9 18e-6
VS26 11 s26 0
L26 s26 15 56e-5
VS27 19 s27 0
L27 s27 2 22e-5
VS28 16 s28 0
C28 s28 0 22e-6
VS29 13 s29 0
R29 s29 7 68e2
VS30 17 s30 0
C30 s30 15 47e-4
.control
set numdgt=17
ac lin 1 60 60
print v(1) v(2) v(3) v(4) v(5) v(6) v(7) v(8) v(9) v(10)
print v(11) v(12) v(13) v(14) v(15) v(16) v(17) v(18) v(19)
print i(vs0) i(vs1) i(vs2) i(vs3) i(vs4) i(vs5) i(vs6) i(vs7) i(vs8) i(vs9)
print i(vs10) i(vs11) i(vs12) i(vs13) i(vs14) i(vs15) i(vs16) i(vs17) i(vs18) i(vs19)
print i(vs20) i(vs21) i(vs22) i(vs23) i(vs24) i(vs25) i(vs26) i(vs27) i(vs28) i(vs29)
print i(vs30)
.endc
.end
