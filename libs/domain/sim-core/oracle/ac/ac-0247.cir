controls oracle ac-0247
* Generated (plan F2.7, ADR 0012): do not edit; regenerate with `pnpm sim oracle regen`. ac seed 20261031 index 247 nodes 20 elements 35
.options sparse gmin=1e-12 noopac
RG1 1 0 1000000000000
RG2 2 0 1000000000000
RG3 3 0 1000000000000
RG4 4 0 1000000000000
RG5 5 0 1000000000000
RG6 6 0 1000000000000
RG7 7 0 1000000000000
RG8 8 0 1000000000000
RG9 9 0 1000000000000
RG10 10 0 1000000000000
RG11 11 0 1000000000000
RG12 12 0 1000000000000
RG13 13 0 1000000000000
RG14 14 0 1000000000000
RG15 15 0 1000000000000
RG16 16 0 1000000000000
RG17 17 0 1000000000000
RG18 18 0 1000000000000
RG19 19 0 1000000000000
VS0 15 s0 0
R0 s0 18 47e2
VS1 11 s1 0
L1 s1 15 56e-5
VS2 0 s2 0
V2 e2 s2 DC 0 AC 15e-1 0
RI2 e2 m2 22e-1
LI2 m2 8 33e-6
VS3 17 s3 0
R3 s3 12 56e-2
VS4 17 s4 0
R4 s4 3 82e1
VS5 16 s5 0
V5 e5 s5 DC 0 AC 82e-1 120
RI5 e5 13 22e-2
VS6 7 s6 0
R6 s6 14 33e1
VS7 14 s7 0
V7 e7 s7 DC 0 AC 68e0 -120
RI7 e7 1 68e-3
VS8 10 s8 0
V8 e8 s8 DC 0 AC 22e1 120
RI8 e8 12 10e-3
VS9 15 s9 0
R9 s9 8 68e-1
VS10 15 s10 0
R10 s10 19 47e2
VS11 10 s11 0
L11 s11 15 56e-5
VS12 4 s12 0
C12 s12 16 33e-4
VS13 5 s13 0
L13 s13 2 10e-3
VS14 2 s14 0
R14 s14 17 27e1
VS15 4 s15 0
L15 s15 3 27e-2
VS16 17 s16 0
L16 s16 19 27e-2
VS17 3 s17 0
R17 s17 18 47e1
VS18 4 s18 0
V18 e18 s18 DC 0 AC 12e-1 180
RI18 e18 7 39e-2
VS19 15 s19 0
L19 s19 17 18e-4
VS20 16 s20 0
C20 s20 7 33e-4
VS21 6 s21 0
V21 e21 s21 DC 0 AC 82e1 180
RI21 e21 7 10e-2
VS22 9 s22 0
C22 s22 13 18e-6
VS23 17 s23 0
R23 s23 16 10e3
VS24 1 s24 0
V24 e24 s24 DC 0 AC 33e-1 0
RI24 e24 7 18e-1
VS25 6 s25 0
R25 s25 3 15e3
VS26 9 s26 0
C26 s26 1 27e-5
VS27 1 s27 0
V27 e27 s27 DC 0 AC 82e0 180
RI27 e27 6 12e-3
VS28 4 s28 0
L28 s28 15 22e-4
VS29 13 s29 0
C29 s29 0 56e-4
VS30 0 s30 0
V30 e30 s30 DC 0 AC 68e-1 180
RI30 e30 15 10e-3
VS31 9 s31 0
R31 s31 7 15e2
VS32 5 s32 0
L32 s32 7 10e-5
VS33 0 s33 0
L33 s33 7 56e-5
VS34 11 s34 0
R34 s34 12 15e3
.control
set numdgt=17
ac lin 1 60 60
print v(1) v(2) v(3) v(4) v(5) v(6) v(7) v(8) v(9) v(10)
print v(11) v(12) v(13) v(14) v(15) v(16) v(17) v(18) v(19)
print i(vs0) i(vs1) i(vs2) i(vs3) i(vs4) i(vs5) i(vs6) i(vs7) i(vs8) i(vs9)
print i(vs10) i(vs11) i(vs12) i(vs13) i(vs14) i(vs15) i(vs16) i(vs17) i(vs18) i(vs19)
print i(vs20) i(vs21) i(vs22) i(vs23) i(vs24) i(vs25) i(vs26) i(vs27) i(vs28) i(vs29)
print i(vs30) i(vs31) i(vs32) i(vs33) i(vs34)
.endc
.end
