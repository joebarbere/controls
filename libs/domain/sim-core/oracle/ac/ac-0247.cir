controls oracle ac-0247
* Generated (plan F2.7, ADR 0012): do not edit; regenerate with `pnpm sim oracle regen`. ac seed 20261031 index 247 nodes 20 elements 36
.options sparse gmin=1e-12 noopac
RG1 1 0 1000000000000
RG2 2 0 1000000000000
RG3 3 0 1000000000000
RG4 4 0 1000000000000
RG5 5 0 1000000000000
RG6 6 0 1000000000000
RG7 7 0 1000000000000
RG8 8 0 1000000000000
RG9 9 0 1000000000000
RG10 10 0 1000000000000
RG11 11 0 1000000000000
RG12 12 0 1000000000000
RG13 13 0 1000000000000
RG14 14 0 1000000000000
RG15 15 0 1000000000000
RG16 16 0 1000000000000
RG17 17 0 1000000000000
RG18 18 0 1000000000000
RG19 19 0 1000000000000
VS0 15 s0 0
R0 s0 5 22e-2
VS1 13 s1 0
R1 s1 7 68e2
VS2 0 s2 0
V2 e2 s2 DC 0 AC 22e1 120
RI2 e2 m2 22e-1
LI2 m2 n2 56e-7
H2 n2 h2 VS7 -10e-4
ED2 h2 4 d2 0 15e-5
F2 0 d2 VS7 1
LD2 d2 0 1
VS3 18 s3 0
L3 s3 2 15e-3
VS4 0 s4 0
C4 s4 15 47e-4
VS5 11 s5 0
L5 s5 10 47e-2
VS6 11 s6 0
R6 s6 4 39e2
VS7 7 s7 0
V7 e7 s7 DC 0 AC 47e0 180
RI7 e7 n7 56e-3
H7 n7 h7 VS2 -10e-4
ED7 h7 5 d7 0 15e-5
F7 0 d7 VS2 1
LD7 d7 0 1
VS8 10 s8 0
R8 s8 6 47e1
VS9 19 s9 0
V9 e9 s9 DC 0 AC 56e-1 -120
RI9 e9 m9 12e-2
LI9 m9 8 12e-5
VS10 15 s10 0
L10 s10 6 10e-3
VS11 0 s11 0
C11 s11 9 18e-6
VS12 19 s12 0
L12 s12 2 22e-5
VS13 1 s13 0
R13 s13 2 27e2
VS14 3 s14 0
C14 s14 12 33e-5
VS15 0 s15 0
V15 e15 s15 DC 0 AC 39e-1 -120
RI15 e15 m15 47e-1
LI15 m15 18 56e-6
VS16 18 s16 0
R16 s16 6 56e1
VS17 0 s17 0
R17 s17 18 22e3
VS18 11 s18 0
L18 s18 15 56e-5
VS19 7 s19 0
C19 s19 19 15e-5
VS20 11 s20 0
V20 e20 s20 DC 0 AC 10e-1 -120
RI20 e20 7 10e-3
VS21 7 s21 0
R21 s21 9 33e0
VS22 7 s22 0
V22 e22 s22 DC 0 AC 56e-1 120
RI22 e22 6 33e-3
VS23 12 s23 0
R23 s23 2 18e3
VS24 16 s24 0
R24 s24 9 47e0
VS25 8 s25 0
C25 s25 17 10e-5
VS26 0 s26 0
V26 e26 s26 DC 0 AC 33e-1 0
RI26 e26 7 22e-2
VS27 17 s27 0
V27 e27 s27 DC 0 AC 68e-1 180
RI27 e27 15 10e-3
VS28 9 s28 0
C28 s28 3 12e-7
VS29 12 s29 0
R29 s29 7 22e2
VS30 15 s30 0
R30 s30 1 33e2
VS31 16 s31 0
C31 s31 17 22e-6
VS32 14 s32 0
R32 s32 17 15e-1
VS33 0 s33 0
V33 e33 s33 DC 0 AC 33e0 120
RI33 e33 m33 33e-2
LI33 m33 10 56e-5
VS34 9 s34 0
L34 s34 14 33e-5
VS35 0 s35 0
C35 s35 13 27e-5
.control
set numdgt=17
ac lin 1 60 60
print v(1) v(2) v(3) v(4) v(5) v(6) v(7) v(8) v(9) v(10)
print v(11) v(12) v(13) v(14) v(15) v(16) v(17) v(18) v(19)
print i(vs0) i(vs1) i(vs2) i(vs3) i(vs4) i(vs5) i(vs6) i(vs7) i(vs8) i(vs9)
print i(vs10) i(vs11) i(vs12) i(vs13) i(vs14) i(vs15) i(vs16) i(vs17) i(vs18) i(vs19)
print i(vs20) i(vs21) i(vs22) i(vs23) i(vs24) i(vs25) i(vs26) i(vs27) i(vs28) i(vs29)
print i(vs30) i(vs31) i(vs32) i(vs33) i(vs34) i(vs35)
.endc
.end
