controls oracle ac-0333
* Generated (plan F2.7, ADR 0012): do not edit; regenerate with `pnpm sim oracle regen`. ac seed 20261031 index 333 nodes 7 elements 10
.options sparse gmin=1e-12 noopac
RG1 1 0 1000000000000
RG2 2 0 1000000000000
RG3 3 0 1000000000000
RG4 4 0 1000000000000
RG5 5 0 1000000000000
RG6 6 0 1000000000000
VS0 0 s0 0
V0 e0 s0 DC 0 AC 10e-1 -120
RI0 e0 m0 27e-2
LI0 m0 1 56e-6
VS1 3 s1 0
C1 s1 6 56e-6
VS2 4 s2 0
V2 e2 s2 DC 0 AC 27e1 180
RI2 e2 m2 68e-3
LI2 m2 2 18e-7
VS3 2 s3 0
L3 s3 4 47e-5
VS4 2 s4 0
R4 s4 3 27e-2
VS5 5 s5 0
C5 s5 0 39e-6
VS6 4 s6 0
L6 s6 1 68e-5
VS7 0 s7 0
L7 s7 3 56e-2
VS8 6 s8 0
R8 s8 4 82e0
VS9 4 s9 0
C9 s9 5 15e-4
.control
set numdgt=17
ac lin 1 60 60
print v(1) v(2) v(3) v(4) v(5) v(6)
print i(vs0) i(vs1) i(vs2) i(vs3) i(vs4) i(vs5) i(vs6) i(vs7) i(vs8) i(vs9)
.endc
.end
