controls oracle ac-0333
* Generated (plan F2.7, ADR 0012): do not edit; regenerate with `pnpm sim oracle regen`. ac seed 20261031 index 333 nodes 7 elements 11
.options sparse gmin=1e-12 noopac
RG1 1 0 1000000000000
RG2 2 0 1000000000000
RG3 3 0 1000000000000
RG4 4 0 1000000000000
RG5 5 0 1000000000000
RG6 6 0 1000000000000
VS0 3 s0 0
C0 s0 1 56e-6
VS1 0 s1 0
C1 s1 4 47e-5
VS2 6 s2 0
R2 s2 0 82e0
VS3 0 s3 0
C3 s3 5 15e-4
VS4 3 s4 0
C4 s4 6 56e-6
VS5 4 s5 0
L5 s5 3 56e-2
VS6 3 s6 0
C6 s6 2 27e-6
VS7 0 s7 0
V7 e7 s7 DC 0 AC 27e1 180
RI7 e7 2 68e-3
VS8 2 s8 0
L8 s8 0 47e-5
VS9 0 s9 0
L9 s9 1 68e-5
VS10 5 s10 0
R10 s10 6 12e3
.control
set numdgt=17
ac lin 1 60 60
print v(1) v(2) v(3) v(4) v(5) v(6)
print i(vs0) i(vs1) i(vs2) i(vs3) i(vs4) i(vs5) i(vs6) i(vs7) i(vs8) i(vs9)
print i(vs10)
.endc
.end
