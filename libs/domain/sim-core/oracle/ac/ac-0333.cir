controls oracle ac-0333
* Generated (plan F2.7, ADR 0012): do not edit; regenerate with `pnpm sim oracle regen`. ac seed 20261031 index 333 nodes 7 elements 7
.options sparse gmin=1e-12 noopac
RG1 1 0 1000000000000
RG2 2 0 1000000000000
RG3 3 0 1000000000000
RG4 4 0 1000000000000
RG5 5 0 1000000000000
RG6 6 0 1000000000000
VS0 6 s0 0
R0 s0 0 82e0
VS1 4 s1 0
L1 s1 3 56e-2
VS2 0 s2 0
C2 s2 5 15e-4
VS3 2 s3 0
L3 s3 0 47e-5
VS4 3 s4 0
C4 s4 6 56e-6
VS5 0 s5 0
L5 s5 1 68e-5
VS6 0 s6 0
V6 e6 s6 DC 0 AC 27e1 180
RI6 e6 2 68e-3
.control
set numdgt=17
ac lin 1 60 60
print v(1) v(2) v(3) v(4) v(5) v(6)
print i(vs0) i(vs1) i(vs2) i(vs3) i(vs4) i(vs5) i(vs6)
.endc
.end
