controls oracle ac-0364
* Generated (plan F2.7, ADR 0012): do not edit; regenerate with `pnpm sim oracle regen`. ac seed 20261031 index 364 nodes 17 elements 28
.options sparse gmin=1e-12 noopac
RG1 1 0 1000000000000
RG2 2 0 1000000000000
RG3 3 0 1000000000000
RG4 4 0 1000000000000
RG5 5 0 1000000000000
RG6 6 0 1000000000000
RG7 7 0 1000000000000
RG8 8 0 1000000000000
RG9 9 0 1000000000000
RG10 10 0 1000000000000
RG11 11 0 1000000000000
RG12 12 0 1000000000000
RG13 13 0 1000000000000
RG14 14 0 1000000000000
RG15 15 0 1000000000000
RG16 16 0 1000000000000
VS0 2 s0 0
R0 s0 9 12e2
VS1 0 s1 0
V1 e1 s1 DC 0 AC 33e1 180
RI1 e1 m1 27e-2
LI1 m1 8 12e-5
VS2 15 s2 0
V2 e2 s2 DC 0 AC 22e-1 180
RI2 e2 9 12e-1
VS3 7 s3 0
L3 s3 1 39e-4
VS4 3 s4 0
V4 e4 s4 DC 0 AC 47e-1 0
RI4 e4 m4 27e-2
LI4 m4 9 33e-5
VS5 3 s5 0
C5 s5 10 15e-4
VS6 3 s6 0
V6 e6 s6 DC 0 AC 15e0 0
RI6 e6 m6 39e-2
LI6 m6 11 82e-5
VS7 16 s7 0
L7 s7 6 27e-4
VS8 7 s8 0
L8 s8 11 15e-3
VS9 12 s9 0
V9 e9 s9 DC 0 AC 10e1 0
RI9 e9 m9 82e-3
LI9 m9 0 22e-6
VS10 8 s10 0
L10 s10 6 12e-5
VS11 13 s11 0
V11 e11 s11 DC 0 AC 22e-1 0
RI11 e11 6 15e-3
VS12 16 s12 0
L12 s12 14 56e-3
VS13 8 s13 0
L13 s13 3 12e-5
VS14 2 s14 0
V14 e14 s14 DC 0 AC 12e-1 -120
RI14 e14 9 18e-1
VS15 3 s15 0
R15 s15 16 82e-1
VS16 2 s16 0
L16 s16 1 18e-2
VS17 4 s17 0
C17 s17 0 82e-4
VS18 5 s18 0
L18 s18 2 56e-5
VS19 9 s19 0
L19 s19 0 10e-4
VS20 13 s20 0
V20 e20 s20 DC 0 AC 33e0 180
RI20 e20 m20 56e-2
LI20 m20 8 27e-7
VS21 15 s21 0
C21 s21 12 15e-7
VS22 6 s22 0
V22 e22 s22 DC 0 AC 10e0 120
RI22 e22 m22 15e-3
LI22 m22 2 47e-7
VS23 4 s23 0
R23 s23 16 82e2
VS24 10 s24 0
C24 s24 16 68e-5
VS25 14 s25 0
C25 s25 7 12e-4
VS26 16 s26 0
L26 s26 5 15e-2
VS27 5 s27 0
V27 e27 s27 DC 0 AC 12e-1 180
RI27 e27 m27 15e-1
LI27 m27 9 82e-6
.control
set numdgt=17
ac lin 1 60 60
print v(1) v(2) v(3) v(4) v(5) v(6) v(7) v(8) v(9) v(10)
print v(11) v(12) v(13) v(14) v(15) v(16)
print i(vs0) i(vs1) i(vs2) i(vs3) i(vs4) i(vs5) i(vs6) i(vs7) i(vs8) i(vs9)
print i(vs10) i(vs11) i(vs12) i(vs13) i(vs14) i(vs15) i(vs16) i(vs17) i(vs18) i(vs19)
print i(vs20) i(vs21) i(vs22) i(vs23) i(vs24) i(vs25) i(vs26) i(vs27)
.endc
.end
