controls oracle ac-0364
* Generated (plan F2.7, ADR 0012): do not edit; regenerate with `pnpm sim oracle regen`. ac seed 20261031 index 364 nodes 17 elements 26
.options sparse gmin=1e-12 noopac
RG1 1 0 1000000000000
RG2 2 0 1000000000000
RG3 3 0 1000000000000
RG4 4 0 1000000000000
RG5 5 0 1000000000000
RG6 6 0 1000000000000
RG7 7 0 1000000000000
RG8 8 0 1000000000000
RG9 9 0 1000000000000
RG10 10 0 1000000000000
RG11 11 0 1000000000000
RG12 12 0 1000000000000
RG13 13 0 1000000000000
RG14 14 0 1000000000000
RG15 15 0 1000000000000
RG16 16 0 1000000000000
VS0 0 s0 0
V0 e0 s0 DC 0 AC 56e0 0
RI0 e0 3 15e-2
VS1 12 s1 0
L1 s1 9 82e-2
VS2 0 s2 0
V2 e2 s2 DC 0 AC 12e-1 -120
RI2 e2 7 18e-1
VS3 7 s3 0
L3 s3 3 12e-3
VS4 9 s4 0
V4 e4 s4 DC 0 AC 22e-1 180
RI4 e4 3 12e-1
VS5 5 s5 0
L5 s5 6 39e-3
VS6 10 s6 0
L6 s6 9 10e-3
VS7 3 s7 0
V7 e7 s7 DC 0 AC 47e-1 0
RI7 e7 12 27e-2
VS8 3 s8 0
C8 s8 16 82e-4
VS9 2 s9 0
L9 s9 0 10e-3
VS10 3 s10 0
C10 s10 4 56e-7
VS11 13 s11 0
R11 s11 3 22e-2
VS12 15 s12 0
R12 s12 11 82e2
VS13 12 s13 0
R13 s13 11 68e2
VS14 5 s14 0
V14 e14 s14 DC 0 AC 68e1 0
RI14 e14 2 18e-1
VS15 10 s15 0
L15 s15 13 56e-2
VS16 8 s16 0
R16 s16 3 10e1
VS17 2 s17 0
R17 s17 7 10e-2
VS18 4 s18 0
V18 e18 s18 DC 0 AC 10e1 180
RI18 e18 3 27e-1
VS19 8 s19 0
L19 s19 0 12e-2
VS20 11 s20 0
V20 e20 s20 DC 0 AC 39e0 -120
RI20 e20 6 82e-1
VS21 1 s21 0
V21 e21 s21 DC 0 AC 18e1 120
RI21 e21 0 56e-1
VS22 6 s22 0
R22 s22 12 12e3
VS23 15 s23 0
L23 s23 16 22e-2
VS24 16 s24 0
L24 s24 14 27e-4
VS25 12 s25 0
L25 s25 2 12e-3
.control
set numdgt=17
ac lin 1 60 60
print v(1) v(2) v(3) v(4) v(5) v(6) v(7) v(8) v(9) v(10)
print v(11) v(12) v(13) v(14) v(15) v(16)
print i(vs0) i(vs1) i(vs2) i(vs3) i(vs4) i(vs5) i(vs6) i(vs7) i(vs8) i(vs9)
print i(vs10) i(vs11) i(vs12) i(vs13) i(vs14) i(vs15) i(vs16) i(vs17) i(vs18) i(vs19)
print i(vs20) i(vs21) i(vs22) i(vs23) i(vs24) i(vs25)
.endc
.end
