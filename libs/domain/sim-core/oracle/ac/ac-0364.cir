controls oracle ac-0364
* Generated (plan F2.7, ADR 0012): do not edit; regenerate with `pnpm sim oracle regen`. ac seed 20261031 index 364 nodes 17 elements 29
.options sparse gmin=1e-12 noopac
RG1 1 0 1000000000000
RG2 2 0 1000000000000
RG3 3 0 1000000000000
RG4 4 0 1000000000000
RG5 5 0 1000000000000
RG6 6 0 1000000000000
RG7 7 0 1000000000000
RG8 8 0 1000000000000
RG9 9 0 1000000000000
RG10 10 0 1000000000000
RG11 11 0 1000000000000
RG12 12 0 1000000000000
RG13 13 0 1000000000000
RG14 14 0 1000000000000
RG15 15 0 1000000000000
RG16 16 0 1000000000000
VS0 10 s0 0
L0 s0 13 56e-2
VS1 5 s1 0
L1 s1 6 39e-3
VS2 10 s2 0
R2 s2 1 12e3
VS3 14 s3 0
R3 s3 7 22e3
VS4 3 s4 0
C4 s4 0 56e-7
VS5 4 s5 0
R5 s5 11 68e2
VS6 0 s6 0
V6 e6 s6 DC 0 AC 10e1 180
RI6 e6 n6 27e-1
H6 n6 h6 VS9 -39e-2
ED6 h6 3 d6 0 10e-5
F6 0 d6 VS9 1
LD6 d6 0 1
VS7 8 s7 0
L7 s7 12 12e-2
VS8 8 s8 0
R8 s8 3 10e1
VS9 11 s9 0
V9 e9 s9 DC 0 AC 39e0 -120
RI9 e9 m9 82e-1
LI9 m9 n9 15e-5
H9 n9 h9 VS6 -39e-2
ED9 h9 6 d9 0 10e-5
F9 0 d9 VS6 1
LD9 d9 0 1
VS10 12 s10 0
V10 e10 s10 DC 0 AC 56e0 0
RI10 e10 m10 15e-2
LI10 m10 3 15e-5
VS11 2 s11 0
R11 s11 7 10e-2
VS12 3 s12 0
V12 e12 s12 DC 0 AC 47e-1 0
RI12 e12 4 27e-2
VS13 9 s13 0
V13 e13 s13 DC 0 AC 22e-1 180
RI13 e13 3 12e-1
VS14 1 s14 0
V14 e14 s14 DC 0 AC 18e1 120
RI14 e14 m14 56e-1
LI14 m14 12 10e-6
VS15 4 s15 0
L15 s15 2 12e-3
VS16 12 s16 0
V16 e16 s16 DC 0 AC 12e-1 -120
RI16 e16 m16 18e-1
LI16 m16 7 82e-6
VS17 10 s17 0
L17 s17 9 10e-3
VS18 4 s18 0
L18 s18 9 82e-2
VS19 7 s19 0
L19 s19 3 12e-3
VS20 6 s20 0
R20 s20 4 12e3
VS21 15 s21 0
R21 s21 11 82e2
VS22 15 s22 0
L22 s22 16 22e-2
VS23 16 s23 0
L23 s23 14 27e-4
VS24 3 s24 0
C24 s24 16 82e-4
VS25 2 s25 0
L25 s25 12 10e-3
VS26 5 s26 0
V26 e26 s26 DC 0 AC 68e1 0
RI26 e26 m26 18e-1
LI26 m26 2 12e-7
VS27 13 s27 0
R27 s27 3 22e-2
VS28 0 s28 0
R28 s28 8 12e0
.control
set numdgt=17
ac lin 1 60 60
print v(1) v(2) v(3) v(4) v(5) v(6) v(7) v(8) v(9) v(10)
print v(11) v(12) v(13) v(14) v(15) v(16)
print i(vs0) i(vs1) i(vs2) i(vs3) i(vs4) i(vs5) i(vs6) i(vs7) i(vs8) i(vs9)
print i(vs10) i(vs11) i(vs12) i(vs13) i(vs14) i(vs15) i(vs16) i(vs17) i(vs18) i(vs19)
print i(vs20) i(vs21) i(vs22) i(vs23) i(vs24) i(vs25) i(vs26) i(vs27) i(vs28)
.endc
.end
