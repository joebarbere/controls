controls oracle ac-0293
* Generated (plan F2.7, ADR 0012): do not edit; regenerate with `pnpm sim oracle regen`. ac seed 20261031 index 293 nodes 14 elements 14
.options sparse gmin=1e-12 noopac
RG1 1 0 1000000000000
RG2 2 0 1000000000000
RG3 3 0 1000000000000
RG4 4 0 1000000000000
RG5 5 0 1000000000000
RG6 6 0 1000000000000
RG7 7 0 1000000000000
RG8 8 0 1000000000000
RG9 9 0 1000000000000
RG10 10 0 1000000000000
RG11 11 0 1000000000000
RG12 12 0 1000000000000
RG13 13 0 1000000000000
VS0 0 s0 0
V0 e0 s0 DC 0 AC 33e-1 -120
RI0 e0 8 10e-1
VS1 7 s1 0
V1 e1 s1 DC 0 AC 18e0 180
RI1 e1 4 12e-1
VS2 11 s2 0
C2 s2 8 56e-6
VS3 2 s3 0
V3 e3 s3 DC 0 AC 18e1 -120
RI3 e3 6 33e-3
VS4 8 s4 0
V4 e4 s4 DC 0 AC 82e-1 -120
RI4 e4 5 18e-3
VS5 12 s5 0
C5 s5 9 15e-6
VS6 10 s6 0
R6 s6 4 33e-1
VS7 5 s7 0
C7 s7 1 56e-5
VS8 12 s8 0
R8 s8 4 47e2
VS9 4 s9 0
L9 s9 2 18e-5
VS10 8 s10 0
R10 s10 12 10e-2
VS11 13 s11 0
C11 s11 2 39e-4
VS12 4 s12 0
R12 s12 3 56e0
VS13 4 s13 0
V13 e13 s13 DC 0 AC 10e1 -120
RI13 e13 12 18e-2
.control
set numdgt=17
ac lin 1 60 60
print v(1) v(2) v(3) v(4) v(5) v(6) v(7) v(8) v(9) v(10)
print v(11) v(12) v(13)
print i(vs0) i(vs1) i(vs2) i(vs3) i(vs4) i(vs5) i(vs6) i(vs7) i(vs8) i(vs9)
print i(vs10) i(vs11) i(vs12) i(vs13)
.endc
.end
