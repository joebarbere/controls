controls oracle ac-0293
* Generated (plan F2.7, ADR 0012): do not edit; regenerate with `pnpm sim oracle regen`. ac seed 20261031 index 293 nodes 14 elements 20
.options sparse gmin=1e-12 noopac
RG1 1 0 1000000000000
RG2 2 0 1000000000000
RG3 3 0 1000000000000
RG4 4 0 1000000000000
RG5 5 0 1000000000000
RG6 6 0 1000000000000
RG7 7 0 1000000000000
RG8 8 0 1000000000000
RG9 9 0 1000000000000
RG10 10 0 1000000000000
RG11 11 0 1000000000000
RG12 12 0 1000000000000
RG13 13 0 1000000000000
VS0 10 s0 0
C0 s0 9 56e-6
VS1 0 s1 0
V1 e1 s1 DC 0 AC 18e-1 -120
RI1 e1 m1 33e-2
LI1 m1 4 82e-5
VS2 4 s2 0
V2 e2 s2 DC 0 AC 10e1 -120
RI2 e2 12 18e-2
VS3 6 s3 0
V3 e3 s3 DC 0 AC 27e1 120
RI3 e3 12 10e-3
VS4 9 s4 0
R4 s4 13 10e-1
VS5 5 s5 0
V5 e5 s5 DC 0 AC 82e0 0
RI5 e5 8 12e-1
VS6 13 s6 0
L6 s6 4 10e-4
VS7 1 s7 0
L7 s7 10 27e-3
VS8 13 s8 0
V8 e8 s8 DC 0 AC 82e-1 120
RI8 e8 5 22e-2
VS9 1 s9 0
V9 e9 s9 DC 0 AC 56e0 180
RI9 e9 3 18e-1
VS10 7 s10 0
R10 s10 5 12e3
VS11 1 s11 0
R11 s11 7 68e-2
VS12 4 s12 0
L12 s12 2 18e-5
VS13 12 s13 0
R13 s13 2 33e2
VS14 0 s14 0
V14 e14 s14 DC 0 AC 33e-1 -120
RI14 e14 8 10e-1
VS15 6 s15 0
V15 e15 s15 DC 0 AC 39e0 180
RI15 e15 m15 68e-3
LI15 m15 11 33e-5
VS16 3 s16 0
C16 s16 13 27e-4
VS17 2 s17 0
R17 s17 8 33e-1
VS18 5 s18 0
C18 s18 10 39e-7
VS19 11 s19 0
C19 s19 8 56e-6
.control
set numdgt=17
ac lin 1 60 60
print v(1) v(2) v(3) v(4) v(5) v(6) v(7) v(8) v(9) v(10)
print v(11) v(12) v(13)
print i(vs0) i(vs1) i(vs2) i(vs3) i(vs4) i(vs5) i(vs6) i(vs7) i(vs8) i(vs9)
print i(vs10) i(vs11) i(vs12) i(vs13) i(vs14) i(vs15) i(vs16) i(vs17) i(vs18) i(vs19)
.endc
.end
