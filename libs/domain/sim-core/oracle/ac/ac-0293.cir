controls oracle ac-0293
* Generated (plan F2.7, ADR 0012): do not edit; regenerate with `pnpm sim oracle regen`. ac seed 20261031 index 293 nodes 14 elements 20
.options sparse gmin=1e-12 noopac
RG1 1 0 1000000000000
RG2 2 0 1000000000000
RG3 3 0 1000000000000
RG4 4 0 1000000000000
RG5 5 0 1000000000000
RG6 6 0 1000000000000
RG7 7 0 1000000000000
RG8 8 0 1000000000000
RG9 9 0 1000000000000
RG10 10 0 1000000000000
RG11 11 0 1000000000000
RG12 12 0 1000000000000
RG13 13 0 1000000000000
VS0 4 s0 0
L0 s0 8 18e-5
VS1 9 s1 0
R1 s1 1 82e-2
VS2 11 s2 0
C2 s2 2 12e-4
VS3 7 s3 0
R3 s3 2 82e3
VS4 12 s4 0
C4 s4 9 15e-6
VS5 0 s5 0
V5 e5 s5 DC 0 AC 82e-1 -120
RI5 e5 5 18e-3
VS6 10 s6 0
C6 s6 1 27e-5
VS7 4 s7 0
V7 e7 s7 DC 0 AC 10e1 -120
RI7 e7 12 18e-2
VS8 8 s8 0
V8 e8 s8 DC 0 AC 18e1 -120
RI8 e8 6 33e-3
VS9 10 s9 0
R9 s9 4 33e-1
VS10 11 s10 0
C10 s10 0 56e-6
VS11 11 s11 0
R11 s11 3 10e3
VS12 4 s12 0
R12 s12 3 56e0
VS13 7 s13 0
V13 e13 s13 DC 0 AC 18e0 180
RI13 e13 4 12e-1
VS14 13 s14 0
C14 s14 8 39e-4
VS15 0 s15 0
R15 s15 12 10e-2
VS16 13 s16 0
V16 e16 s16 DC 0 AC 15e-1 -120
RI16 e16 2 27e-1
VS17 5 s17 0
C17 s17 1 56e-5
VS18 5 s18 0
V18 e18 s18 DC 0 AC 18e-1 -120
RI18 e18 6 33e-2
VS19 2 s19 0
V19 e19 s19 DC 0 AC 33e-1 -120
RI19 e19 0 10e-1
.control
set numdgt=17
ac lin 1 60 60
print v(1) v(2) v(3) v(4) v(5) v(6) v(7) v(8) v(9) v(10)
print v(11) v(12) v(13)
print i(vs0) i(vs1) i(vs2) i(vs3) i(vs4) i(vs5) i(vs6) i(vs7) i(vs8) i(vs9)
print i(vs10) i(vs11) i(vs12) i(vs13) i(vs14) i(vs15) i(vs16) i(vs17) i(vs18) i(vs19)
.endc
.end
