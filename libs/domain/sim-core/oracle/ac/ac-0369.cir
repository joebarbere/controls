controls oracle ac-0369
* Generated (plan F2.7, ADR 0012): do not edit; regenerate with `pnpm sim oracle regen`. ac seed 20261031 index 369 nodes 3 elements 4
.options sparse gmin=1e-12 noopac
RG1 1 0 1000000000000
RG2 2 0 1000000000000
VS0 0 s0 0
L0 s0 2 82e-2
VS1 1 s1 0
R1 s1 0 22e-2
VS2 1 s2 0
R2 s2 2 12e0
VS3 0 s3 0
V3 e3 s3 DC 0 AC 68e1 0
RI3 e3 m3 27e-1
LI3 m3 1 10e-7
.control
set numdgt=17
ac lin 1 60 60
print v(1) v(2)
print i(vs0) i(vs1) i(vs2) i(vs3)
.endc
.end
