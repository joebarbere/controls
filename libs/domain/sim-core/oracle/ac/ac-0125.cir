controls oracle ac-0125
* Generated (plan F2.7, ADR 0012): do not edit; regenerate with `pnpm sim oracle regen`. ac seed 20261031 index 125 nodes 4 elements 6
.options sparse gmin=1e-12 noopac
RG1 1 0 1000000000000
RG2 2 0 1000000000000
RG3 3 0 1000000000000
VS0 0 s0 0
V0 e0 s0 DC 0 AC 22e0 -120
RI0 e0 m0 39e-3
LI0 m0 3 18e-5
VS1 2 s1 0
C1 s1 0 15e-7
VS2 1 s2 0
L2 s2 2 22e-5
VS3 3 s3 0
L3 s3 1 47e-3
VS4 3 s4 0
R4 s4 0 33e2
VS5 1 s5 0
C5 s5 3 33e-6
.control
set numdgt=17
ac lin 1 60 60
print v(1) v(2) v(3)
print i(vs0) i(vs1) i(vs2) i(vs3) i(vs4) i(vs5)
.endc
.end
