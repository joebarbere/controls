controls oracle ac-0049
* Generated (plan F2.7, ADR 0012): do not edit; regenerate with `pnpm sim oracle regen`. ac seed 20261031 index 49 nodes 27 elements 29
.options sparse gmin=1e-12 noopac
RG1 1 0 1000000000000
RG2 2 0 1000000000000
RG3 3 0 1000000000000
RG4 4 0 1000000000000
RG5 5 0 1000000000000
RG6 6 0 1000000000000
RG7 7 0 1000000000000
RG8 8 0 1000000000000
RG9 9 0 1000000000000
RG10 10 0 1000000000000
RG11 11 0 1000000000000
RG12 12 0 1000000000000
RG13 13 0 1000000000000
RG14 14 0 1000000000000
RG15 15 0 1000000000000
RG16 16 0 1000000000000
RG17 17 0 1000000000000
RG18 18 0 1000000000000
RG19 19 0 1000000000000
RG20 20 0 1000000000000
RG21 21 0 1000000000000
RG22 22 0 1000000000000
RG23 23 0 1000000000000
RG24 24 0 1000000000000
RG25 25 0 1000000000000
RG26 26 0 1000000000000
VS0 19 s0 0
R0 s0 14 56e2
VS1 26 s1 0
C1 s1 16 27e-6
VS2 0 s2 0
V2 e2 s2 DC 0 AC 39e1 120
RI2 e2 21 12e-3
VS3 24 s3 0
V3 e3 s3 DC 0 AC 68e0 -120
RI3 e3 14 18e-2
VS4 0 s4 0
R4 s4 22 27e-2
VS5 18 s5 0
C5 s5 11 12e-5
VS6 9 s6 0
L6 s6 22 82e-2
VS7 17 s7 0
C7 s7 20 33e-7
VS8 9 s8 0
L8 s8 6 27e-5
VS9 6 s9 0
R9 s9 4 56e2
VS10 3 s10 0
R10 s10 5 15e-2
VS11 7 s11 0
R11 s11 9 15e0
VS12 17 s12 0
R12 s12 13 39e0
VS13 5 s13 0
C13 s13 9 68e-4
VS14 22 s14 0
R14 s14 23 68e1
VS15 6 s15 0
L15 s15 12 18e-2
VS16 17 s16 0
L16 s16 0 27e-3
VS17 8 s17 0
R17 s17 19 10e1
VS18 25 s18 0
L18 s18 9 47e-3
VS19 22 s19 0
R19 s19 24 18e-2
VS20 8 s20 0
R20 s20 2 33e3
VS21 15 s21 0
R21 s21 9 22e0
VS22 11 s22 0
C22 s22 21 68e-4
VS23 2 s23 0
R23 s23 24 22e0
VS24 25 s24 0
R24 s24 18 56e0
VS25 26 s25 0
R25 s25 24 33e-1
VS26 4 s26 0
R26 s26 0 47e-1
VS27 10 s27 0
V27 e27 s27 DC 0 AC 10e-1 0
RI27 e27 18 33e-3
VS28 22 s28 0
R28 s28 1 18e3
.control
set numdgt=17
ac lin 1 60 60
print v(1) v(2) v(3) v(4) v(5) v(6) v(7) v(8) v(9) v(10)
print v(11) v(12) v(13) v(14) v(15) v(16) v(17) v(18) v(19) v(20)
print v(21) v(22) v(23) v(24) v(25) v(26)
print i(vs0) i(vs1) i(vs2) i(vs3) i(vs4) i(vs5) i(vs6) i(vs7) i(vs8) i(vs9)
print i(vs10) i(vs11) i(vs12) i(vs13) i(vs14) i(vs15) i(vs16) i(vs17) i(vs18) i(vs19)
print i(vs20) i(vs21) i(vs22) i(vs23) i(vs24) i(vs25) i(vs26) i(vs27) i(vs28)
.endc
.end
