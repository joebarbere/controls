controls oracle ac-0049
* Generated (plan F2.7, ADR 0012): do not edit; regenerate with `pnpm sim oracle regen`. ac seed 20261031 index 49 nodes 27 elements 38
.options sparse gmin=1e-12 noopac
RG1 1 0 1000000000000
RG2 2 0 1000000000000
RG3 3 0 1000000000000
RG4 4 0 1000000000000
RG5 5 0 1000000000000
RG6 6 0 1000000000000
RG7 7 0 1000000000000
RG8 8 0 1000000000000
RG9 9 0 1000000000000
RG10 10 0 1000000000000
RG11 11 0 1000000000000
RG12 12 0 1000000000000
RG13 13 0 1000000000000
RG14 14 0 1000000000000
RG15 15 0 1000000000000
RG16 16 0 1000000000000
RG17 17 0 1000000000000
RG18 18 0 1000000000000
RG19 19 0 1000000000000
RG20 20 0 1000000000000
RG21 21 0 1000000000000
RG22 22 0 1000000000000
RG23 23 0 1000000000000
RG24 24 0 1000000000000
RG25 25 0 1000000000000
RG26 26 0 1000000000000
VS0 19 s0 0
R0 s0 14 56e2
VS1 26 s1 0
C1 s1 16 27e-6
VS2 15 s2 0
R2 s2 9 22e0
VS3 3 s3 0
R3 s3 5 15e-2
VS4 26 s4 0
L4 s4 1 33e-5
VS5 0 s5 0
V5 e5 s5 DC 0 AC 39e1 120
RI5 e5 n5 12e-3
H5 n5 h5 VS9 10e-4
ED5 h5 21 d5 0 -22e-5
F5 0 d5 VS9 1
LD5 d5 0 1
VS6 5 s6 0
C6 s6 9 68e-4
VS7 26 s7 0
R7 s7 24 33e-1
VS8 8 s8 0
R8 s8 2 33e3
VS9 26 s9 0
V9 e9 s9 DC 0 AC 10e-1 120
RI9 e9 n9 10e-2
H9 n9 h9 VS5 10e-4
ED9 h9 20 d9 0 -22e-5
F9 0 d9 VS5 1
LD9 d9 0 1
VS10 17 s10 0
R10 s10 13 39e0
VS11 11 s11 0
C11 s11 21 68e-4
VS12 15 s12 0
V12 e12 s12 DC 0 AC 10e0 -120
RI12 e12 m12 18e-3
LI12 m12 5 18e-7
VS13 6 s13 0
R13 s13 4 56e2
VS14 13 s14 0
L14 s14 5 18e-4
VS15 0 s15 0
R15 s15 22 27e-2
VS16 25 s16 0
L16 s16 9 47e-3
VS17 8 s17 0
C17 s17 3 82e-5
VS18 18 s18 0
C18 s18 11 12e-5
VS19 23 s19 0
V19 e19 s19 DC 0 AC 10e0 0
RI19 e19 m19 10e-3
LI19 m19 25 18e-6
VS20 10 s20 0
C20 s20 21 22e-5
VS21 7 s21 0
R21 s21 9 15e0
VS22 6 s22 0
L22 s22 12 18e-2
VS23 22 s23 0
R23 s23 1 18e3
VS24 9 s24 0
L24 s24 6 27e-5
VS25 16 s25 0
R25 s25 7 82e1
VS26 25 s26 0
R26 s26 18 56e0
VS27 22 s27 0
R27 s27 24 18e-2
VS28 24 s28 0
V28 e28 s28 DC 0 AC 68e0 -120
RI28 e28 m28 18e-2
LI28 m28 14 47e-6
VS29 9 s29 0
L29 s29 22 82e-2
VS30 10 s30 0
V30 e30 s30 DC 0 AC 10e-1 0
RI30 e30 18 33e-3
VS31 17 s31 0
L31 s31 0 27e-3
VS32 17 s32 0
C32 s32 20 33e-7
VS33 4 s33 0
R33 s33 0 47e-1
VS34 8 s34 0
R34 s34 19 10e1
VS35 2 s35 0
R35 s35 24 22e0
VS36 12 s36 0
R36 s36 16 47e1
VS37 22 s37 0
R37 s37 23 68e1
.control
set numdgt=17
ac lin 1 60 60
print v(1) v(2) v(3) v(4) v(5) v(6) v(7) v(8) v(9) v(10)
print v(11) v(12) v(13) v(14) v(15) v(16) v(17) v(18) v(19) v(20)
print v(21) v(22) v(23) v(24) v(25) v(26)
print i(vs0) i(vs1) i(vs2) i(vs3) i(vs4) i(vs5) i(vs6) i(vs7) i(vs8) i(vs9)
print i(vs10) i(vs11) i(vs12) i(vs13) i(vs14) i(vs15) i(vs16) i(vs17) i(vs18) i(vs19)
print i(vs20) i(vs21) i(vs22) i(vs23) i(vs24) i(vs25) i(vs26) i(vs27) i(vs28) i(vs29)
print i(vs30) i(vs31) i(vs32) i(vs33) i(vs34) i(vs35) i(vs36) i(vs37)
.endc
.end
