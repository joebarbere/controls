controls oracle ac-0049
* Generated (plan F2.7, ADR 0012): do not edit; regenerate with `pnpm sim oracle regen`. ac seed 20261031 index 49 nodes 27 elements 46
.options sparse gmin=1e-12 noopac
RG1 1 0 1000000000000
RG2 2 0 1000000000000
RG3 3 0 1000000000000
RG4 4 0 1000000000000
RG5 5 0 1000000000000
RG6 6 0 1000000000000
RG7 7 0 1000000000000
RG8 8 0 1000000000000
RG9 9 0 1000000000000
RG10 10 0 1000000000000
RG11 11 0 1000000000000
RG12 12 0 1000000000000
RG13 13 0 1000000000000
RG14 14 0 1000000000000
RG15 15 0 1000000000000
RG16 16 0 1000000000000
RG17 17 0 1000000000000
RG18 18 0 1000000000000
RG19 19 0 1000000000000
RG20 20 0 1000000000000
RG21 21 0 1000000000000
RG22 22 0 1000000000000
RG23 23 0 1000000000000
RG24 24 0 1000000000000
RG25 25 0 1000000000000
RG26 26 0 1000000000000
VS0 13 s0 0
R0 s0 26 47e1
VS1 12 s1 0
L1 s1 5 82e-5
VS2 26 s2 0
R2 s2 24 33e-1
VS3 2 s3 0
R3 s3 19 18e3
VS4 9 s4 0
L4 s4 6 27e-5
VS5 10 s5 0
R5 s5 18 68e0
VS6 9 s6 0
L6 s6 22 82e-2
VS7 0 s7 0
V7 e7 s7 DC 0 AC 39e1 120
RI7 e7 m7 12e-3
LI7 m7 20 47e-5
VS8 25 s8 0
L8 s8 9 47e-3
VS9 10 s9 0
R9 s9 12 18e2
VS10 22 s10 0
L10 s10 6 18e-2
VS11 26 s11 0
V11 e11 s11 DC 0 AC 15e0 -120
RI11 e11 22 39e-1
VS12 15 s12 0
R12 s12 16 82e2
VS13 24 s13 0
V13 e13 s13 DC 0 AC 68e0 -120
RI13 e13 14 18e-2
VS14 26 s14 0
C14 s14 20 56e-5
VS15 17 s15 0
C15 s15 11 18e-6
VS16 10 s16 0
L16 s16 21 27e-5
VS17 25 s17 0
R17 s17 23 56e2
VS18 7 s18 0
R18 s18 9 15e0
VS19 13 s19 0
L19 s19 18 68e-5
VS20 0 s20 0
V20 e20 s20 DC 0 AC 33e-1 0
RI20 e20 21 47e-1
VS21 8 s21 0
L21 s21 24 33e-5
VS22 25 s22 0
R22 s22 18 56e0
VS23 15 s23 0
L23 s23 5 82e-5
VS24 5 s24 0
C24 s24 9 68e-4
VS25 0 s25 0
R25 s25 22 27e-2
VS26 3 s26 0
R26 s26 5 15e-2
VS27 22 s27 0
R27 s27 21 10e2
VS28 8 s28 0
R28 s28 0 39e1
VS29 11 s29 0
V29 e29 s29 DC 0 AC 82e1 -120
RI29 e29 2 18e-2
VS30 6 s30 0
R30 s30 4 56e2
VS31 24 s31 0
V31 e31 s31 DC 0 AC 47e0 180
RI31 e31 2 18e-3
VS32 9 s32 0
R32 s32 7 18e-2
VS33 4 s33 0
C33 s33 10 33e-7
VS34 11 s34 0
L34 s34 17 82e-5
VS35 17 s35 0
L35 s35 0 27e-3
VS36 15 s36 0
L36 s36 19 68e-3
VS37 7 s37 0
R37 s37 0 27e3
VS38 18 s38 0
L38 s38 10 10e-4
VS39 26 s39 0
C39 s39 16 47e-7
VS40 1 s40 0
L40 s40 25 15e-5
VS41 9 s41 0
L41 s41 17 33e-4
VS42 3 s42 0
C42 s42 1 33e-7
VS43 14 s43 0
C43 s43 23 22e-6
VS44 14 s44 0
C44 s44 23 33e-4
VS45 22 s45 0
R45 s45 24 18e-2
.control
set numdgt=17
ac lin 1 60 60
print v(1) v(2) v(3) v(4) v(5) v(6) v(7) v(8) v(9) v(10)
print v(11) v(12) v(13) v(14) v(15) v(16) v(17) v(18) v(19) v(20)
print v(21) v(22) v(23) v(24) v(25) v(26)
print i(vs0) i(vs1) i(vs2) i(vs3) i(vs4) i(vs5) i(vs6) i(vs7) i(vs8) i(vs9)
print i(vs10) i(vs11) i(vs12) i(vs13) i(vs14) i(vs15) i(vs16) i(vs17) i(vs18) i(vs19)
print i(vs20) i(vs21) i(vs22) i(vs23) i(vs24) i(vs25) i(vs26) i(vs27) i(vs28) i(vs29)
print i(vs30) i(vs31) i(vs32) i(vs33) i(vs34) i(vs35) i(vs36) i(vs37) i(vs38) i(vs39)
print i(vs40) i(vs41) i(vs42) i(vs43) i(vs44) i(vs45)
.endc
.end
