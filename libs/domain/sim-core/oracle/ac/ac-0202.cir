controls oracle ac-0202
* Generated (plan F2.7, ADR 0012): do not edit; regenerate with `pnpm sim oracle regen`. ac seed 20261031 index 202 nodes 17 elements 29
.options sparse gmin=1e-12 noopac
RG1 1 0 1000000000000
RG2 2 0 1000000000000
RG3 3 0 1000000000000
RG4 4 0 1000000000000
RG5 5 0 1000000000000
RG6 6 0 1000000000000
RG7 7 0 1000000000000
RG8 8 0 1000000000000
RG9 9 0 1000000000000
RG10 10 0 1000000000000
RG11 11 0 1000000000000
RG12 12 0 1000000000000
RG13 13 0 1000000000000
RG14 14 0 1000000000000
RG15 15 0 1000000000000
RG16 16 0 1000000000000
VS0 3 s0 0
R0 s0 12 82e1
VS1 7 s1 0
L1 s1 6 47e-4
VS2 7 s2 0
L2 s2 12 47e-3
VS3 0 s3 0
V3 e3 s3 DC 0 AC 68e0 -120
RI3 e3 m3 22e-3
LI3 m3 4 22e-6
VS4 14 s4 0
R4 s4 5 18e2
VS5 0 s5 0
V5 e5 s5 DC 0 AC 27e-1 120
RI5 e5 m5 10e-1
LI5 m5 1 15e-7
VS6 10 s6 0
R6 s6 16 82e-1
VS7 9 s7 0
R7 s7 1 47e2
VS8 15 s8 0
L8 s8 14 15e-4
VS9 2 s9 0
L9 s9 8 39e-4
VS10 11 s10 0
L10 s10 8 82e-2
VS11 15 s11 0
R11 s11 12 82e1
VS12 1 s12 0
R12 s12 3 82e2
VS13 4 s13 0
L13 s13 13 33e-5
VS14 13 s14 0
C14 s14 16 39e-6
VS15 7 s15 0
C15 s15 12 22e-4
VS16 14 s16 0
L16 s16 7 22e-2
VS17 2 s17 0
C17 s17 3 33e-4
VS18 3 s18 0
R18 s18 16 47e1
VS19 8 s19 0
V19 e19 s19 DC 0 AC 82e0 0
RI19 e19 m19 82e-2
LI19 m19 7 27e-6
VS20 14 s20 0
R20 s20 10 47e3
VS21 7 s21 0
R21 s21 11 82e1
VS22 11 s22 0
R22 s22 16 56e2
VS23 0 s23 0
L23 s23 5 15e-4
VS24 11 s24 0
L24 s24 6 27e-4
VS25 9 s25 0
R25 s25 2 12e1
VS26 4 s26 0
L26 s26 7 27e-2
VS27 1 s27 0
L27 s27 12 39e-5
VS28 5 s28 0
V28 e28 s28 DC 0 AC 33e1 0
RI28 e28 m28 82e-3
LI28 m28 14 33e-6
.control
set numdgt=17
ac lin 1 60 60
print v(1) v(2) v(3) v(4) v(5) v(6) v(7) v(8) v(9) v(10)
print v(11) v(12) v(13) v(14) v(15) v(16)
print i(vs0) i(vs1) i(vs2) i(vs3) i(vs4) i(vs5) i(vs6) i(vs7) i(vs8) i(vs9)
print i(vs10) i(vs11) i(vs12) i(vs13) i(vs14) i(vs15) i(vs16) i(vs17) i(vs18) i(vs19)
print i(vs20) i(vs21) i(vs22) i(vs23) i(vs24) i(vs25) i(vs26) i(vs27) i(vs28)
.endc
.end
