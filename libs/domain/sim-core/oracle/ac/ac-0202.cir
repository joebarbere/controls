controls oracle ac-0202
* Generated (plan F2.7, ADR 0012): do not edit; regenerate with `pnpm sim oracle regen`. ac seed 20261031 index 202 nodes 17 elements 24
.options sparse gmin=1e-12 noopac
RG1 1 0 1000000000000
RG2 2 0 1000000000000
RG3 3 0 1000000000000
RG4 4 0 1000000000000
RG5 5 0 1000000000000
RG6 6 0 1000000000000
RG7 7 0 1000000000000
RG8 8 0 1000000000000
RG9 9 0 1000000000000
RG10 10 0 1000000000000
RG11 11 0 1000000000000
RG12 12 0 1000000000000
RG13 13 0 1000000000000
RG14 14 0 1000000000000
RG15 15 0 1000000000000
RG16 16 0 1000000000000
VS0 9 s0 0
R0 s0 2 12e1
VS1 3 s1 0
R1 s1 16 47e1
VS2 8 s2 0
L2 s2 6 27e-4
VS3 0 s3 0
V3 e3 s3 DC 0 AC 82e0 0
RI3 e3 7 82e-2
VS4 14 s4 0
R4 s4 5 18e2
VS5 11 s5 0
V5 e5 s5 DC 0 AC 68e0 -120
RI5 e5 4 22e-3
VS6 7 s6 0
C6 s6 12 22e-4
VS7 1 s7 0
L7 s7 12 39e-5
VS8 5 s8 0
V8 e8 s8 DC 0 AC 33e1 0
RI8 e8 14 82e-3
VS9 15 s9 0
R9 s9 12 82e1
VS10 2 s10 0
C10 s10 3 33e-4
VS11 2 s11 0
L11 s11 0 39e-4
VS12 3 s12 0
R12 s12 12 82e1
VS13 4 s13 0
L13 s13 13 33e-5
VS14 9 s14 0
R14 s14 1 47e2
VS15 4 s15 0
L15 s15 7 27e-2
VS16 8 s16 0
R16 s16 16 56e2
VS17 10 s17 0
R17 s17 16 82e-1
VS18 1 s18 0
R18 s18 3 82e2
VS19 7 s19 0
L19 s19 12 47e-3
VS20 8 s20 0
L20 s20 0 82e-2
VS21 14 s21 0
L21 s21 7 22e-2
VS22 7 s22 0
R22 s22 8 82e1
VS23 14 s23 0
R23 s23 10 47e3
.control
set numdgt=17
ac lin 1 60 60
print v(1) v(2) v(3) v(4) v(5) v(6) v(7) v(8) v(9) v(10)
print v(11) v(12) v(13) v(14) v(15) v(16)
print i(vs0) i(vs1) i(vs2) i(vs3) i(vs4) i(vs5) i(vs6) i(vs7) i(vs8) i(vs9)
print i(vs10) i(vs11) i(vs12) i(vs13) i(vs14) i(vs15) i(vs16) i(vs17) i(vs18) i(vs19)
print i(vs20) i(vs21) i(vs22) i(vs23)
.endc
.end
