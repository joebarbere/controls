controls oracle ac-0202
* Generated (plan F2.7, ADR 0012): do not edit; regenerate with `pnpm sim oracle regen`. ac seed 20261031 index 202 nodes 17 elements 23
.options sparse gmin=1e-12 noopac
RG1 1 0 1000000000000
RG2 2 0 1000000000000
RG3 3 0 1000000000000
RG4 4 0 1000000000000
RG5 5 0 1000000000000
RG6 6 0 1000000000000
RG7 7 0 1000000000000
RG8 8 0 1000000000000
RG9 9 0 1000000000000
RG10 10 0 1000000000000
RG11 11 0 1000000000000
RG12 12 0 1000000000000
RG13 13 0 1000000000000
RG14 14 0 1000000000000
RG15 15 0 1000000000000
RG16 16 0 1000000000000
VS0 10 s0 0
R0 s0 16 82e-1
VS1 3 s1 0
R1 s1 16 47e1
VS2 0 s2 0
V2 e2 s2 DC 0 AC 12e1 -120
RI2 e2 m2 27e-1
LI2 m2 6 15e-6
VS3 11 s3 0
V3 e3 s3 DC 0 AC 68e0 -120
RI3 e3 m3 22e-3
LI3 m3 4 12e-7
VS4 9 s4 0
R4 s4 2 12e1
VS5 4 s5 0
L5 s5 13 33e-5
VS6 2 s6 0
C6 s6 3 33e-4
VS7 0 s7 0
L7 s7 1 56e-2
VS8 7 s8 0
L8 s8 12 47e-3
VS9 4 s9 0
L9 s9 7 27e-2
VS10 7 s10 0
C10 s10 8 82e-5
VS11 9 s11 0
L11 s11 0 56e-2
VS12 11 s12 0
L12 s12 5 12e-2
VS13 8 s13 0
L13 s13 10 18e-4
VS14 14 s14 0
R14 s14 10 47e3
VS15 13 s15 0
L15 s15 11 68e-5
VS16 1 s16 0
R16 s16 3 82e2
VS17 3 s17 0
V17 e17 s17 DC 0 AC 47e1 -120
RI17 e17 15 27e-1
VS18 7 s18 0
R18 s18 15 82e1
VS19 15 s19 0
R19 s19 16 56e2
VS20 5 s20 0
V20 e20 s20 DC 0 AC 33e1 0
RI20 e20 14 82e-3
VS21 15 s21 0
L21 s21 6 27e-4
VS22 0 s22 0
R22 s22 12 82e1
.control
set numdgt=17
ac lin 1 60 60
print v(1) v(2) v(3) v(4) v(5) v(6) v(7) v(8) v(9) v(10)
print v(11) v(12) v(13) v(14) v(15) v(16)
print i(vs0) i(vs1) i(vs2) i(vs3) i(vs4) i(vs5) i(vs6) i(vs7) i(vs8) i(vs9)
print i(vs10) i(vs11) i(vs12) i(vs13) i(vs14) i(vs15) i(vs16) i(vs17) i(vs18) i(vs19)
print i(vs20) i(vs21) i(vs22)
.endc
.end
