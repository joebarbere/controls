controls oracle ac-0367
* Generated (plan F2.7, ADR 0012): do not edit; regenerate with `pnpm sim oracle regen`. ac seed 20261031 index 367 nodes 17 elements 29
.options sparse gmin=1e-12 noopac
RG1 1 0 1000000000000
RG2 2 0 1000000000000
RG3 3 0 1000000000000
RG4 4 0 1000000000000
RG5 5 0 1000000000000
RG6 6 0 1000000000000
RG7 7 0 1000000000000
RG8 8 0 1000000000000
RG9 9 0 1000000000000
RG10 10 0 1000000000000
RG11 11 0 1000000000000
RG12 12 0 1000000000000
RG13 13 0 1000000000000
RG14 14 0 1000000000000
RG15 15 0 1000000000000
RG16 16 0 1000000000000
VS0 0 s0 0
V0 e0 s0 DC 0 AC 56e0 180
RI0 e0 11 39e-1
VS1 1 s1 0
V1 e1 s1 DC 0 AC 33e-1 180
RI1 e1 m1 39e-2
LI1 m1 14 68e-7
VS2 10 s2 0
L2 s2 4 47e-5
VS3 5 s3 0
R3 s3 15 12e-2
VS4 9 s4 0
R4 s4 5 10e1
VS5 11 s5 0
V5 e5 s5 DC 0 AC 39e0 180
RI5 e5 m5 82e-3
LI5 m5 9 82e-5
VS6 0 s6 0
V6 e6 s6 DC 0 AC 68e0 0
RI6 e6 m6 33e-1
LI6 m6 13 18e-6
VS7 7 s7 0
C7 s7 0 18e-6
VS8 4 s8 0
L8 s8 13 22e-3
VS9 9 s9 0
C9 s9 3 82e-5
VS10 9 s10 0
R10 s10 0 56e0
VS11 2 s11 0
R11 s11 8 27e-2
VS12 2 s12 0
L12 s12 15 15e-5
VS13 8 s13 0
R13 s13 3 18e-2
VS14 12 s14 0
C14 s14 6 82e-4
VS15 14 s15 0
R15 s15 9 12e-1
VS16 16 s16 0
R16 s16 8 33e-1
VS17 4 s17 0
R17 s17 7 10e0
VS18 2 s18 0
R18 s18 11 33e2
VS19 0 s19 0
V19 e19 s19 DC 0 AC 68e1 120
RI19 e19 2 47e-2
VS20 14 s20 0
L20 s20 15 68e-4
VS21 11 s21 0
V21 e21 s21 DC 0 AC 68e0 0
RI21 e21 m21 22e-1
LI21 m21 14 12e-7
VS22 16 s22 0
C22 s22 4 22e-6
VS23 7 s23 0
L23 s23 11 56e-4
VS24 15 s24 0
R24 s24 1 82e2
VS25 14 s25 0
V25 e25 s25 DC 0 AC 12e1 180
RI25 e25 m25 22e-2
LI25 m25 10 27e-7
VS26 5 s26 0
R26 s26 0 18e-1
VS27 12 s27 0
R27 s27 9 12e-2
VS28 16 s28 0
R28 s28 6 33e-1
.control
set numdgt=17
ac lin 1 60 60
print v(1) v(2) v(3) v(4) v(5) v(6) v(7) v(8) v(9) v(10)
print v(11) v(12) v(13) v(14) v(15) v(16)
print i(vs0) i(vs1) i(vs2) i(vs3) i(vs4) i(vs5) i(vs6) i(vs7) i(vs8) i(vs9)
print i(vs10) i(vs11) i(vs12) i(vs13) i(vs14) i(vs15) i(vs16) i(vs17) i(vs18) i(vs19)
print i(vs20) i(vs21) i(vs22) i(vs23) i(vs24) i(vs25) i(vs26) i(vs27) i(vs28)
.endc
.end
