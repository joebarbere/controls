controls oracle ac-0367
* Generated (plan F2.7, ADR 0012): do not edit; regenerate with `pnpm sim oracle regen`. ac seed 20261031 index 367 nodes 17 elements 29
.options sparse gmin=1e-12 noopac
RG1 1 0 1000000000000
RG2 2 0 1000000000000
RG3 3 0 1000000000000
RG4 4 0 1000000000000
RG5 5 0 1000000000000
RG6 6 0 1000000000000
RG7 7 0 1000000000000
RG8 8 0 1000000000000
RG9 9 0 1000000000000
RG10 10 0 1000000000000
RG11 11 0 1000000000000
RG12 12 0 1000000000000
RG13 13 0 1000000000000
RG14 14 0 1000000000000
RG15 15 0 1000000000000
RG16 16 0 1000000000000
VS0 2 s0 0
C0 s0 8 56e-6
VS1 0 s1 0
V1 e1 s1 DC 0 AC 27e1 0
RI1 e1 m1 22e-3
LI1 m1 n1 39e-5
H1 n1 h1 VS12 27e-4
ED1 h1 8 d1 0 33e-7
F1 0 d1 VS12 1
LD1 d1 0 1
VS2 0 s2 0
R2 s2 6 15e0
VS3 14 s3 0
C3 s3 2 18e-6
VS4 14 s4 0
L4 s4 15 33e-5
VS5 10 s5 0
R5 s5 7 15e0
VS6 15 s6 0
L6 s6 3 47e-2
VS7 2 s7 0
L7 s7 6 15e-5
VS8 16 s8 0
L8 s8 8 33e-4
VS9 16 s9 0
L9 s9 3 39e-3
VS10 2 s10 0
L10 s10 11 56e-4
VS11 5 s11 0
C11 s11 3 68e-5
VS12 11 s12 0
V12 e12 s12 DC 0 AC 39e0 180
RI12 e12 n12 82e-3
H12 n12 h12 VS1 27e-4
ED12 h12 9 d12 0 33e-7
F12 0 d12 VS1 1
LD12 d12 0 1
VS13 4 s13 0
R13 s13 2 10e0
VS14 15 s14 0
R14 s14 11 18e-1
VS15 13 s15 0
C15 s15 0 56e-4
VS16 13 s16 0
R16 s16 16 22e-2
VS17 4 s17 0
R17 s17 5 12e-2
VS18 11 s18 0
R18 s18 14 56e0
VS19 1 s19 0
V19 e19 s19 DC 0 AC 56e1 -120
RI19 e19 12 15e-3
VS20 2 s20 0
V20 e20 s20 DC 0 AC 47e1 120
RI20 e20 m20 12e-3
LI20 m20 9 82e-7
VS21 1 s21 0
L21 s21 0 15e-3
VS22 12 s22 0
C22 s22 9 68e-4
VS23 12 s23 0
R23 s23 10 15e0
VS24 3 s24 0
L24 s24 7 56e-5
VS25 11 s25 0
C25 s25 5 27e-6
VS26 4 s26 0
V26 e26 s26 DC 0 AC 56e0 180
RI26 e26 m26 47e-2
LI26 m26 11 15e-7
VS27 6 s27 0
V27 e27 s27 DC 0 AC 22e1 0
RI27 e27 1 15e-2
VS28 5 s28 0
R28 s28 13 18e0
.control
set numdgt=17
ac lin 1 60 60
print v(1) v(2) v(3) v(4) v(5) v(6) v(7) v(8) v(9) v(10)
print v(11) v(12) v(13) v(14) v(15) v(16)
print i(vs0) i(vs1) i(vs2) i(vs3) i(vs4) i(vs5) i(vs6) i(vs7) i(vs8) i(vs9)
print i(vs10) i(vs11) i(vs12) i(vs13) i(vs14) i(vs15) i(vs16) i(vs17) i(vs18) i(vs19)
print i(vs20) i(vs21) i(vs22) i(vs23) i(vs24) i(vs25) i(vs26) i(vs27) i(vs28)
.endc
.end
