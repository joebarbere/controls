controls oracle ac-0034
* Generated (plan F2.7, ADR 0012): do not edit; regenerate with `pnpm sim oracle regen`. ac seed 20261031 index 34 nodes 10 elements 15
.options sparse gmin=1e-12 noopac
RG1 1 0 1000000000000
RG2 2 0 1000000000000
RG3 3 0 1000000000000
RG4 4 0 1000000000000
RG5 5 0 1000000000000
RG6 6 0 1000000000000
RG7 7 0 1000000000000
RG8 8 0 1000000000000
RG9 9 0 1000000000000
VS0 0 s0 0
V0 e0 s0 DC 0 AC 27e0 120
RI0 e0 7 33e-2
VS1 9 s1 0
R1 s1 0 68e0
VS2 4 s2 0
C2 s2 5 15e-6
VS3 4 s3 0
R3 s3 9 10e-1
VS4 2 s4 0
C4 s4 3 27e-7
VS5 2 s5 0
L5 s5 1 56e-5
VS6 3 s6 0
L6 s6 0 39e-4
VS7 6 s7 0
C7 s7 8 27e-5
VS8 6 s8 0
C8 s8 7 27e-4
VS9 9 s9 0
L9 s9 2 47e-4
VS10 9 s10 0
L10 s10 8 56e-3
VS11 5 s11 0
R11 s11 2 18e1
VS12 4 s12 0
L12 s12 6 56e-5
VS13 5 s13 0
L13 s13 8 27e-5
VS14 1 s14 0
C14 s14 7 12e-4
.control
set numdgt=17
ac lin 1 60 60
print v(1) v(2) v(3) v(4) v(5) v(6) v(7) v(8) v(9)
print i(vs0) i(vs1) i(vs2) i(vs3) i(vs4) i(vs5) i(vs6) i(vs7) i(vs8) i(vs9)
print i(vs10) i(vs11) i(vs12) i(vs13) i(vs14)
.endc
.end
