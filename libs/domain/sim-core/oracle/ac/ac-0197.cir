controls oracle ac-0197
* Generated (plan F2.7, ADR 0012): do not edit; regenerate with `pnpm sim oracle regen`. ac seed 20261031 index 197 nodes 16 elements 20
.options sparse gmin=1e-12 noopac
RG1 1 0 1000000000000
RG2 2 0 1000000000000
RG3 3 0 1000000000000
RG4 4 0 1000000000000
RG5 5 0 1000000000000
RG6 6 0 1000000000000
RG7 7 0 1000000000000
RG8 8 0 1000000000000
RG9 9 0 1000000000000
RG10 10 0 1000000000000
RG11 11 0 1000000000000
RG12 12 0 1000000000000
RG13 13 0 1000000000000
RG14 14 0 1000000000000
RG15 15 0 1000000000000
VS0 0 s0 0
V0 e0 s0 DC 0 AC 10e1 120
RI0 e0 10 22e-1
VS1 2 s1 0
C1 s1 7 15e-7
VS2 12 s2 0
R2 s2 11 39e2
VS3 1 s3 0
V3 e3 s3 DC 0 AC 56e0 120
RI3 e3 11 33e-2
VS4 15 s4 0
C4 s4 5 33e-4
VS5 0 s5 0
R5 s5 1 39e2
VS6 14 s6 0
C6 s6 1 47e-6
VS7 8 s7 0
C7 s7 7 22e-6
VS8 13 s8 0
R8 s8 5 82e-2
VS9 4 s9 0
R9 s9 10 22e1
VS10 9 s10 0
C10 s10 3 56e-6
VS11 12 s11 0
C11 s11 0 22e-4
VS12 11 s12 0
L12 s12 15 12e-3
VS13 14 s13 0
R13 s13 2 56e0
VS14 9 s14 0
C14 s14 6 27e-6
VS15 9 s15 0
R15 s15 13 33e1
VS16 3 s16 0
L16 s16 2 27e-4
VS17 11 s17 0
V17 e17 s17 DC 0 AC 82e0 180
RI17 e17 7 82e-3
VS18 7 s18 0
L18 s18 8 39e-4
VS19 6 s19 0
C19 s19 10 56e-7
.control
set numdgt=17
ac lin 1 60 60
print v(1) v(2) v(3) v(4) v(5) v(6) v(7) v(8) v(9) v(10)
print v(11) v(12) v(13) v(14) v(15)
print i(vs0) i(vs1) i(vs2) i(vs3) i(vs4) i(vs5) i(vs6) i(vs7) i(vs8) i(vs9)
print i(vs10) i(vs11) i(vs12) i(vs13) i(vs14) i(vs15) i(vs16) i(vs17) i(vs18) i(vs19)
.endc
.end
