controls oracle ac-0197
* Generated (plan F2.7, ADR 0012): do not edit; regenerate with `pnpm sim oracle regen`. ac seed 20261031 index 197 nodes 16 elements 21
.options sparse gmin=1e-12 noopac
RG1 1 0 1000000000000
RG2 2 0 1000000000000
RG3 3 0 1000000000000
RG4 4 0 1000000000000
RG5 5 0 1000000000000
RG6 6 0 1000000000000
RG7 7 0 1000000000000
RG8 8 0 1000000000000
RG9 9 0 1000000000000
RG10 10 0 1000000000000
RG11 11 0 1000000000000
RG12 12 0 1000000000000
RG13 13 0 1000000000000
RG14 14 0 1000000000000
RG15 15 0 1000000000000
VS0 15 s0 0
L0 s0 14 15e-3
VS1 6 s1 0
R1 s1 13 82e0
VS2 0 s2 0
V2 e2 s2 DC 0 AC 56e-1 180
RI2 e2 15 68e-3
VS3 5 s3 0
R3 s3 12 12e1
VS4 7 s4 0
V4 e4 s4 DC 0 AC 10e0 0
RI4 e4 m4 56e-1
LI4 m4 4 15e-6
VS5 3 s5 0
C5 s5 9 22e-5
VS6 11 s6 0
R6 s6 12 22e1
VS7 3 s7 0
R7 s7 15 27e-1
VS8 0 s8 0
R8 s8 9 82e0
VS9 4 s9 0
R9 s9 14 47e2
VS10 2 s10 0
V10 e10 s10 DC 0 AC 18e-1 0
RI10 e10 15 22e-2
VS11 6 s11 0
C11 s11 10 22e-4
VS12 7 s12 0
R12 s12 11 39e1
VS13 10 s13 0
V13 e13 s13 DC 0 AC 10e1 120
RI13 e13 8 22e-1
VS14 10 s14 0
R14 s14 12 82e3
VS15 3 s15 0
L15 s15 1 39e-2
VS16 1 s16 0
L16 s16 8 39e-3
VS17 15 s17 0
C17 s17 13 39e-7
VS18 8 s18 0
L18 s18 2 15e-4
VS19 8 s19 0
L19 s19 9 18e-2
VS20 7 s20 0
R20 s20 5 39e3
.control
set numdgt=17
ac lin 1 60 60
print v(1) v(2) v(3) v(4) v(5) v(6) v(7) v(8) v(9) v(10)
print v(11) v(12) v(13) v(14) v(15)
print i(vs0) i(vs1) i(vs2) i(vs3) i(vs4) i(vs5) i(vs6) i(vs7) i(vs8) i(vs9)
print i(vs10) i(vs11) i(vs12) i(vs13) i(vs14) i(vs15) i(vs16) i(vs17) i(vs18) i(vs19)
print i(vs20)
.endc
.end
