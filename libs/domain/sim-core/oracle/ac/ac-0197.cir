controls oracle ac-0197
* Generated (plan F2.7, ADR 0012): do not edit; regenerate with `pnpm sim oracle regen`. ac seed 20261031 index 197 nodes 16 elements 22
.options sparse gmin=1e-12 noopac
RG1 1 0 1000000000000
RG2 2 0 1000000000000
RG3 3 0 1000000000000
RG4 4 0 1000000000000
RG5 5 0 1000000000000
RG6 6 0 1000000000000
RG7 7 0 1000000000000
RG8 8 0 1000000000000
RG9 9 0 1000000000000
RG10 10 0 1000000000000
RG11 11 0 1000000000000
RG12 12 0 1000000000000
RG13 13 0 1000000000000
RG14 14 0 1000000000000
RG15 15 0 1000000000000
VS0 12 s0 0
C0 s0 10 22e-4
VS1 8 s1 0
R1 s1 5 56e3
VS2 7 s2 0
L2 s2 8 39e-4
VS3 0 s3 0
R3 s3 13 33e1
VS4 4 s4 0
R4 s4 9 22e1
VS5 14 s5 0
R5 s5 2 56e0
VS6 8 s6 0
C6 s6 7 22e-6
VS7 3 s7 0
L7 s7 2 27e-4
VS8 2 s8 0
C8 s8 7 15e-7
VS9 12 s9 0
R9 s9 11 39e2
VS10 6 s10 0
C10 s10 9 56e-7
VS11 10 s11 0
R11 s11 1 39e2
VS12 0 s12 0
C12 s12 3 56e-6
VS13 13 s13 0
R13 s13 5 82e-2
VS14 15 s14 0
C14 s14 5 33e-4
VS15 11 s15 0
L15 s15 15 12e-3
VS16 0 s16 0
V16 e16 s16 DC 0 AC 27e-1 0
RI16 e16 4 39e-1
VS17 0 s17 0
C17 s17 6 27e-6
VS18 1 s18 0
V18 e18 s18 DC 0 AC 56e0 120
RI18 e18 11 33e-2
VS19 11 s19 0
V19 e19 s19 DC 0 AC 82e0 180
RI19 e19 7 82e-3
VS20 14 s20 0
C20 s20 1 47e-6
VS21 10 s21 0
V21 e21 s21 DC 0 AC 10e1 120
RI21 e21 9 22e-1
.control
set numdgt=17
ac lin 1 60 60
print v(1) v(2) v(3) v(4) v(5) v(6) v(7) v(8) v(9) v(10)
print v(11) v(12) v(13) v(14) v(15)
print i(vs0) i(vs1) i(vs2) i(vs3) i(vs4) i(vs5) i(vs6) i(vs7) i(vs8) i(vs9)
print i(vs10) i(vs11) i(vs12) i(vs13) i(vs14) i(vs15) i(vs16) i(vs17) i(vs18) i(vs19)
print i(vs20) i(vs21)
.endc
.end
