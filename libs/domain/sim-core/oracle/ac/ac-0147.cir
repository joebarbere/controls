controls oracle ac-0147
* Generated (plan F2.7, ADR 0012): do not edit; regenerate with `pnpm sim oracle regen`. ac seed 20261031 index 147 nodes 19 elements 38
.options sparse gmin=1e-12 noopac
RG1 1 0 1000000000000
RG2 2 0 1000000000000
RG3 3 0 1000000000000
RG4 4 0 1000000000000
RG5 5 0 1000000000000
RG6 6 0 1000000000000
RG7 7 0 1000000000000
RG8 8 0 1000000000000
RG9 9 0 1000000000000
RG10 10 0 1000000000000
RG11 11 0 1000000000000
RG12 12 0 1000000000000
RG13 13 0 1000000000000
RG14 14 0 1000000000000
RG15 15 0 1000000000000
RG16 16 0 1000000000000
RG17 17 0 1000000000000
RG18 18 0 1000000000000
VS0 0 s0 0
V0 e0 s0 DC 0 AC 22e1 -120
RI0 e0 11 47e-3
VS1 10 s1 0
V1 e1 s1 DC 0 AC 68e1 120
RI1 e1 12 15e-3
VS2 14 s2 0
V2 e2 s2 DC 0 AC 56e0 120
RI2 e2 1 47e-1
VS3 12 s3 0
V3 e3 s3 DC 0 AC 22e0 0
RI3 e3 16 15e-1
VS4 8 s4 0
R4 s4 1 39e0
VS5 4 s5 0
V5 e5 s5 DC 0 AC 56e-1 -120
RI5 e5 m5 12e-1
LI5 m5 10 18e-7
VS6 2 s6 0
R6 s6 1 39e2
VS7 12 s7 0
R7 s7 7 56e2
VS8 4 s8 0
L8 s8 0 15e-5
VS9 14 s9 0
R9 s9 13 18e2
VS10 6 s10 0
R10 s10 5 12e0
VS11 3 s11 0
V11 e11 s11 DC 0 AC 39e1 180
RI11 e11 4 12e-3
VS12 7 s12 0
L12 s12 15 33e-3
VS13 7 s13 0
L13 s13 3 68e-2
VS14 1 s14 0
C14 s14 2 56e-4
VS15 7 s15 0
L15 s15 11 33e-3
VS16 13 s16 0
C16 s16 12 47e-5
VS17 14 s17 0
C17 s17 11 47e-4
VS18 12 s18 0
L18 s18 4 15e-2
VS19 0 s19 0
C19 s19 18 15e-5
VS20 13 s20 0
C20 s20 6 82e-5
VS21 6 s21 0
C21 s21 11 12e-5
VS22 10 s22 0
R22 s22 14 47e2
VS23 4 s23 0
L23 s23 14 18e-4
VS24 6 s24 0
R24 s24 17 47e-1
VS25 9 s25 0
R25 s25 1 22e3
VS26 8 s26 0
C26 s26 17 12e-4
VS27 8 s27 0
C27 s27 16 56e-7
VS28 16 s28 0
L28 s28 10 10e-3
VS29 3 s29 0
L29 s29 18 82e-2
VS30 6 s30 0
R30 s30 15 12e-1
VS31 8 s31 0
L31 s31 5 39e-2
VS32 8 s32 0
C32 s32 11 33e-5
VS33 5 s33 0
C33 s33 14 82e-7
VS34 9 s34 0
C34 s34 8 10e-4
VS35 8 s35 0
V35 e35 s35 DC 0 AC 22e1 -120
RI35 e35 17 27e-2
VS36 2 s36 0
L36 s36 16 56e-3
VS37 17 s37 0
C37 s37 4 18e-5
.control
set numdgt=17
ac lin 1 60 60
print v(1) v(2) v(3) v(4) v(5) v(6) v(7) v(8) v(9) v(10)
print v(11) v(12) v(13) v(14) v(15) v(16) v(17) v(18)
print i(vs0) i(vs1) i(vs2) i(vs3) i(vs4) i(vs5) i(vs6) i(vs7) i(vs8) i(vs9)
print i(vs10) i(vs11) i(vs12) i(vs13) i(vs14) i(vs15) i(vs16) i(vs17) i(vs18) i(vs19)
print i(vs20) i(vs21) i(vs22) i(vs23) i(vs24) i(vs25) i(vs26) i(vs27) i(vs28) i(vs29)
print i(vs30) i(vs31) i(vs32) i(vs33) i(vs34) i(vs35) i(vs36) i(vs37)
.endc
.end
