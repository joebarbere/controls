controls oracle ac-0147
* Generated (plan F2.7, ADR 0012): do not edit; regenerate with `pnpm sim oracle regen`. ac seed 20261031 index 147 nodes 19 elements 32
.options sparse gmin=1e-12 noopac
RG1 1 0 1000000000000
RG2 2 0 1000000000000
RG3 3 0 1000000000000
RG4 4 0 1000000000000
RG5 5 0 1000000000000
RG6 6 0 1000000000000
RG7 7 0 1000000000000
RG8 8 0 1000000000000
RG9 9 0 1000000000000
RG10 10 0 1000000000000
RG11 11 0 1000000000000
RG12 12 0 1000000000000
RG13 13 0 1000000000000
RG14 14 0 1000000000000
RG15 15 0 1000000000000
RG16 16 0 1000000000000
RG17 17 0 1000000000000
RG18 18 0 1000000000000
VS0 10 s0 0
R0 s0 14 47e2
VS1 0 s1 0
R1 s1 15 18e3
VS2 0 s2 0
V2 e2 s2 DC 0 AC 82e-1 0
RI2 e2 3 12e-2
VS3 3 s3 0
C3 s3 1 12e-5
VS4 2 s4 0
C4 s4 8 39e-7
VS5 6 s5 0
L5 s5 18 12e-5
VS6 11 s6 0
L6 s6 9 39e-2
VS7 2 s7 0
C7 s7 16 12e-4
VS8 9 s8 0
V8 e8 s8 DC 0 AC 12e1 -120
RI8 e8 18 18e-1
VS9 17 s9 0
V9 e9 s9 DC 0 AC 15e-1 0
RI9 e9 16 12e-3
VS10 10 s10 0
L10 s10 5 56e-2
VS11 1 s11 0
V11 e11 s11 DC 0 AC 82e1 -120
RI11 e11 7 18e-2
VS12 3 s12 0
V12 e12 s12 DC 0 AC 15e1 0
RI12 e12 14 12e-1
VS13 11 s13 0
R13 s13 8 68e3
VS14 7 s14 0
C14 s14 12 33e-7
VS15 6 s15 0
V15 e15 s15 DC 0 AC 22e1 -120
RI15 e15 7 47e-3
VS16 4 s16 0
C16 s16 3 12e-4
VS17 0 s17 0
L17 s17 7 68e-2
VS18 10 s18 0
V18 e18 s18 DC 0 AC 68e1 120
RI18 e18 12 15e-3
VS19 4 s19 0
L19 s19 0 15e-2
VS20 15 s20 0
V20 e20 s20 DC 0 AC 56e-1 -120
RI20 e20 10 22e-2
VS21 2 s21 0
V21 e21 s21 DC 0 AC 15e-1 120
RI21 e21 11 39e-1
VS22 6 s22 0
R22 s22 17 47e-1
VS23 18 s23 0
V23 e23 s23 DC 0 AC 15e1 0
RI23 e23 0 18e-1
VS24 2 s24 0
L24 s24 1 10e-3
VS25 13 s25 0
L25 s25 5 15e-3
VS26 2 s26 0
C26 s26 0 18e-5
VS27 10 s27 0
L27 s27 2 56e-3
VS28 13 s28 0
R28 s28 7 12e1
VS29 2 s29 0
V29 e29 s29 DC 0 AC 22e1 -120
RI29 e29 17 27e-2
VS30 12 s30 0
L30 s30 2 33e-3
VS31 13 s31 0
C31 s31 2 12e-7
.control
set numdgt=17
ac lin 1 60 60
print v(1) v(2) v(3) v(4) v(5) v(6) v(7) v(8) v(9) v(10)
print v(11) v(12) v(13) v(14) v(15) v(16) v(17) v(18)
print i(vs0) i(vs1) i(vs2) i(vs3) i(vs4) i(vs5) i(vs6) i(vs7) i(vs8) i(vs9)
print i(vs10) i(vs11) i(vs12) i(vs13) i(vs14) i(vs15) i(vs16) i(vs17) i(vs18) i(vs19)
print i(vs20) i(vs21) i(vs22) i(vs23) i(vs24) i(vs25) i(vs26) i(vs27) i(vs28) i(vs29)
print i(vs30) i(vs31)
.endc
.end
