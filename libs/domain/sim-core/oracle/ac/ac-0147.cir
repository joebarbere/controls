controls oracle ac-0147
* Generated (plan F2.7, ADR 0012): do not edit; regenerate with `pnpm sim oracle regen`. ac seed 20261031 index 147 nodes 19 elements 29
.options sparse gmin=1e-12 noopac
RG1 1 0 1000000000000
RG2 2 0 1000000000000
RG3 3 0 1000000000000
RG4 4 0 1000000000000
RG5 5 0 1000000000000
RG6 6 0 1000000000000
RG7 7 0 1000000000000
RG8 8 0 1000000000000
RG9 9 0 1000000000000
RG10 10 0 1000000000000
RG11 11 0 1000000000000
RG12 12 0 1000000000000
RG13 13 0 1000000000000
RG14 14 0 1000000000000
RG15 15 0 1000000000000
RG16 16 0 1000000000000
RG17 17 0 1000000000000
RG18 18 0 1000000000000
VS0 9 s0 0
L0 s0 1 10e-3
VS1 0 s1 0
V1 e1 s1 DC 0 AC 12e1 -120
RI1 e1 18 18e-1
VS2 10 s2 0
L2 s2 5 56e-2
VS3 3 s3 0
C3 s3 1 12e-5
VS4 13 s4 0
C4 s4 9 12e-7
VS5 15 s5 0
V5 e5 s5 DC 0 AC 56e-1 -120
RI5 e5 10 22e-2
VS6 10 s6 0
R6 s6 14 47e2
VS7 18 s7 0
V7 e7 s7 DC 0 AC 15e1 0
RI7 e7 2 18e-1
VS8 2 s8 0
R8 s8 15 18e3
VS9 4 s9 0
L9 s9 2 15e-2
VS10 9 s10 0
C10 s10 2 18e-5
VS11 10 s11 0
V11 e11 s11 DC 0 AC 68e1 120
RI11 e11 12 15e-3
VS12 7 s12 0
C12 s12 12 33e-7
VS13 3 s13 0
V13 e13 s13 DC 0 AC 15e1 0
RI13 e13 14 12e-1
VS14 9 s14 0
V14 e14 s14 DC 0 AC 15e-1 120
RI14 e14 11 39e-1
VS15 6 s15 0
L15 s15 18 12e-5
VS16 6 s16 0
V16 e16 s16 DC 0 AC 22e1 -120
RI16 e16 7 47e-3
VS17 9 s17 0
C17 s17 16 12e-4
VS18 11 s18 0
L18 s18 0 39e-2
VS19 2 s19 0
L19 s19 7 68e-2
VS20 6 s20 0
R20 s20 17 47e-1
VS21 12 s21 0
L21 s21 9 33e-3
VS22 9 s22 0
V22 e22 s22 DC 0 AC 22e1 -120
RI22 e22 17 27e-2
VS23 2 s23 0
V23 e23 s23 DC 0 AC 82e-1 0
RI23 e23 3 12e-2
VS24 13 s24 0
R24 s24 7 12e1
VS25 11 s25 0
R25 s25 8 68e3
VS26 17 s26 0
V26 e26 s26 DC 0 AC 15e-1 0
RI26 e26 16 12e-3
VS27 10 s27 0
L27 s27 9 56e-3
VS28 1 s28 0
V28 e28 s28 DC 0 AC 82e1 -120
RI28 e28 7 18e-2
.control
set numdgt=17
ac lin 1 60 60
print v(1) v(2) v(3) v(4) v(5) v(6) v(7) v(8) v(9) v(10)
print v(11) v(12) v(13) v(14) v(15) v(16) v(17) v(18)
print i(vs0) i(vs1) i(vs2) i(vs3) i(vs4) i(vs5) i(vs6) i(vs7) i(vs8) i(vs9)
print i(vs10) i(vs11) i(vs12) i(vs13) i(vs14) i(vs15) i(vs16) i(vs17) i(vs18) i(vs19)
print i(vs20) i(vs21) i(vs22) i(vs23) i(vs24) i(vs25) i(vs26) i(vs27) i(vs28)
.endc
.end
