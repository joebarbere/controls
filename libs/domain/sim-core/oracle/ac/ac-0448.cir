controls oracle ac-0448
* Generated (plan F2.7, ADR 0012): do not edit; regenerate with `pnpm sim oracle regen`. ac seed 20261031 index 448 nodes 7 elements 11
.options sparse gmin=1e-12 noopac
RG1 1 0 1000000000000
RG2 2 0 1000000000000
RG3 3 0 1000000000000
RG4 4 0 1000000000000
RG5 5 0 1000000000000
RG6 6 0 1000000000000
VS0 5 s0 0
L0 s0 0 82e-4
VS1 0 s1 0
L1 s1 6 12e-4
VS2 0 s2 0
L2 s2 2 82e-2
VS3 6 s3 0
R3 s3 3 56e0
VS4 1 s4 0
C4 s4 3 68e-5
VS5 2 s5 0
C5 s5 5 12e-5
VS6 4 s6 0
L6 s6 2 10e-2
VS7 0 s7 0
V7 e7 s7 DC 0 AC 47e1 -120
RI7 e7 m7 47e-2
LI7 m7 1 15e-6
VS8 1 s8 0
C8 s8 5 33e-7
VS9 4 s9 0
R9 s9 0 68e1
VS10 0 s10 0
L10 s10 4 47e-3
.control
set numdgt=17
ac lin 1 60 60
print v(1) v(2) v(3) v(4) v(5) v(6)
print i(vs0) i(vs1) i(vs2) i(vs3) i(vs4) i(vs5) i(vs6) i(vs7) i(vs8) i(vs9)
print i(vs10)
.endc
.end
