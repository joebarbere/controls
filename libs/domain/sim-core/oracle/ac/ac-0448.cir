controls oracle ac-0448
* Generated (plan F2.7, ADR 0012): do not edit; regenerate with `pnpm sim oracle regen`. ac seed 20261031 index 448 nodes 7 elements 8
.options sparse gmin=1e-12 noopac
RG1 1 0 1000000000000
RG2 2 0 1000000000000
RG3 3 0 1000000000000
RG4 4 0 1000000000000
RG5 5 0 1000000000000
RG6 6 0 1000000000000
VS0 2 s0 0
C0 s0 6 68e-5
VS1 0 s1 0
L1 s1 6 12e-4
VS2 1 s2 0
C2 s2 5 15e-5
VS3 2 s3 0
L3 s3 5 39e-2
VS4 1 s4 0
C4 s4 4 10e-6
VS5 0 s5 0
V5 e5 s5 DC 0 AC 47e1 -120
RI5 e5 1 47e-2
VS6 1 s6 0
R6 s6 3 12e-2
VS7 2 s7 0
V7 e7 s7 DC 0 AC 33e0 0
RI7 e7 0 68e-3
.control
set numdgt=17
ac lin 1 60 60
print v(1) v(2) v(3) v(4) v(5) v(6)
print i(vs0) i(vs1) i(vs2) i(vs3) i(vs4) i(vs5) i(vs6) i(vs7)
.endc
.end
