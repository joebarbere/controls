controls oracle ac-0448
* Generated (plan F2.7, ADR 0012): do not edit; regenerate with `pnpm sim oracle regen`. ac seed 20261031 index 448 nodes 7 elements 10
.options sparse gmin=1e-12 noopac
RG1 1 0 1000000000000
RG2 2 0 1000000000000
RG3 3 0 1000000000000
RG4 4 0 1000000000000
RG5 5 0 1000000000000
RG6 6 0 1000000000000
VS0 0 s0 0
V0 e0 s0 DC 0 AC 33e0 0
RI0 e0 n0 68e-3
H0 n0 h0 VS7 10e-4
ED0 h0 6 d0 0 12e-6
F0 0 d0 VS7 1
LD0 d0 0 1
VS1 0 s1 0
C1 s1 2 68e-5
VS2 1 s2 0
C2 s2 4 10e-6
VS3 1 s3 0
C3 s3 5 15e-5
VS4 1 s4 0
R4 s4 3 12e-2
VS5 6 s5 0
L5 s5 2 12e-4
VS6 0 s6 0
L6 s6 5 39e-2
VS7 6 s7 0
V7 e7 s7 DC 0 AC 47e1 -120
RI7 e7 m7 47e-2
LI7 m7 n7 47e-5
H7 n7 h7 VS0 10e-4
ED7 h7 1 d7 0 12e-6
F7 0 d7 VS0 1
LD7 d7 0 1
VS8 5 s8 0
C8 s8 3 33e-7
VS9 2 s9 0
L9 s9 4 82e-2
.control
set numdgt=17
ac lin 1 60 60
print v(1) v(2) v(3) v(4) v(5) v(6)
print i(vs0) i(vs1) i(vs2) i(vs3) i(vs4) i(vs5) i(vs6) i(vs7) i(vs8) i(vs9)
.endc
.end
