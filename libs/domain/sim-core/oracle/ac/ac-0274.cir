controls oracle ac-0274
* Generated (plan F2.7, ADR 0012): do not edit; regenerate with `pnpm sim oracle regen`. ac seed 20261031 index 274 nodes 22 elements 41
.options sparse gmin=1e-12 noopac
RG1 1 0 1000000000000
RG2 2 0 1000000000000
RG3 3 0 1000000000000
RG4 4 0 1000000000000
RG5 5 0 1000000000000
RG6 6 0 1000000000000
RG7 7 0 1000000000000
RG8 8 0 1000000000000
RG9 9 0 1000000000000
RG10 10 0 1000000000000
RG11 11 0 1000000000000
RG12 12 0 1000000000000
RG13 13 0 1000000000000
RG14 14 0 1000000000000
RG15 15 0 1000000000000
RG16 16 0 1000000000000
RG17 17 0 1000000000000
RG18 18 0 1000000000000
RG19 19 0 1000000000000
RG20 20 0 1000000000000
RG21 21 0 1000000000000
VS0 8 s0 0
L0 s0 9 15e-5
VS1 0 s1 0
V1 e1 s1 DC 0 AC 68e0 180
RI1 e1 10 15e-3
VS2 1 s2 0
R2 s2 11 33e3
VS3 21 s3 0
R3 s3 9 10e3
VS4 2 s4 0
C4 s4 5 10e-7
VS5 16 s5 0
R5 s5 1 56e3
VS6 6 s6 0
V6 e6 s6 DC 0 AC 47e0 -120
RI6 e6 4 39e-1
VS7 13 s7 0
C7 s7 1 10e-6
VS8 6 s8 0
R8 s8 15 39e2
VS9 3 s9 0
C9 s9 17 39e-7
VS10 8 s10 0
C10 s10 10 39e-6
VS11 14 s11 0
L11 s11 8 18e-4
VS12 0 s12 0
R12 s12 10 12e1
VS13 9 s13 0
V13 e13 s13 DC 0 AC 33e1 0
RI13 e13 15 10e-1
VS14 18 s14 0
R14 s14 2 47e0
VS15 7 s15 0
V15 e15 s15 DC 0 AC 47e0 -120
RI15 e15 2 10e-2
VS16 10 s16 0
V16 e16 s16 DC 0 AC 82e0 0
RI16 e16 17 56e-3
VS17 18 s17 0
R17 s17 9 82e-1
VS18 18 s18 0
L18 s18 14 68e-2
VS19 6 s19 0
R19 s19 4 18e2
VS20 13 s20 0
V20 e20 s20 DC 0 AC 18e-1 120
RI20 e20 5 56e-1
VS21 2 s21 0
R21 s21 3 33e1
VS22 4 s22 0
C22 s22 11 56e-7
VS23 16 s23 0
L23 s23 17 33e-2
VS24 5 s24 0
L24 s24 9 47e-2
VS25 14 s25 0
L25 s25 11 10e-2
VS26 11 s26 0
C26 s26 2 18e-6
VS27 6 s27 0
R27 s27 11 82e1
VS28 1 s28 0
V28 e28 s28 DC 0 AC 82e-1 180
RI28 e28 5 12e-2
VS29 12 s29 0
R29 s29 16 15e1
VS30 17 s30 0
R30 s30 2 47e-2
VS31 14 s31 0
C31 s31 7 15e-5
VS32 12 s32 0
V32 e32 s32 DC 0 AC 68e1 120
RI32 e32 9 33e-2
VS33 18 s33 0
C33 s33 13 10e-6
VS34 3 s34 0
R34 s34 16 22e3
VS35 1 s35 0
L35 s35 3 39e-5
VS36 18 s36 0
L36 s36 11 18e-2
VS37 2 s37 0
C37 s37 19 56e-4
VS38 6 s38 0
V38 e38 s38 DC 0 AC 56e-1 120
RI38 e38 12 47e-1
VS39 20 s39 0
L39 s39 12 22e-4
VS40 9 s40 0
L40 s40 8 27e-3
.control
set numdgt=17
ac lin 1 60 60
print v(1) v(2) v(3) v(4) v(5) v(6) v(7) v(8) v(9) v(10)
print v(11) v(12) v(13) v(14) v(15) v(16) v(17) v(18) v(19) v(20)
print v(21)
print i(vs0) i(vs1) i(vs2) i(vs3) i(vs4) i(vs5) i(vs6) i(vs7) i(vs8) i(vs9)
print i(vs10) i(vs11) i(vs12) i(vs13) i(vs14) i(vs15) i(vs16) i(vs17) i(vs18) i(vs19)
print i(vs20) i(vs21) i(vs22) i(vs23) i(vs24) i(vs25) i(vs26) i(vs27) i(vs28) i(vs29)
print i(vs30) i(vs31) i(vs32) i(vs33) i(vs34) i(vs35) i(vs36) i(vs37) i(vs38) i(vs39)
print i(vs40)
.endc
.end
