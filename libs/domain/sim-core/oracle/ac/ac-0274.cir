controls oracle ac-0274
* Generated (plan F2.7, ADR 0012): do not edit; regenerate with `pnpm sim oracle regen`. ac seed 20261031 index 274 nodes 22 elements 44
.options sparse gmin=1e-12 noopac
RG1 1 0 1000000000000
RG2 2 0 1000000000000
RG3 3 0 1000000000000
RG4 4 0 1000000000000
RG5 5 0 1000000000000
RG6 6 0 1000000000000
RG7 7 0 1000000000000
RG8 8 0 1000000000000
RG9 9 0 1000000000000
RG10 10 0 1000000000000
RG11 11 0 1000000000000
RG12 12 0 1000000000000
RG13 13 0 1000000000000
RG14 14 0 1000000000000
RG15 15 0 1000000000000
RG16 16 0 1000000000000
RG17 17 0 1000000000000
RG18 18 0 1000000000000
RG19 19 0 1000000000000
RG20 20 0 1000000000000
RG21 21 0 1000000000000
VS0 0 s0 0
V0 e0 s0 DC 0 AC 82e0 0
RI0 e0 n0 56e-3
H0 n0 h0 VS1 -82e-4
ED0 h0 17 d0 0 -47e-7
F0 0 d0 VS1 1
LD0 d0 0 1
VS1 2 s1 0
V1 e1 s1 DC 0 AC 68e0 180
RI1 e1 m1 15e-3
LI1 m1 n1 82e-5
H1 n1 h1 VS0 -82e-4
ED1 h1 0 d1 0 -47e-7
F1 0 d1 VS0 1
LD1 d1 0 1
VS2 14 s2 0
L2 s2 11 10e-2
VS3 1 s3 0
R3 s3 11 33e3
VS4 8 s4 0
C4 s4 0 39e-6
VS5 3 s5 0
C5 s5 17 39e-7
VS6 18 s6 0
R6 s6 9 82e-1
VS7 12 s7 0
R7 s7 16 15e1
VS8 16 s8 0
R8 s8 1 56e3
VS9 6 s9 0
V9 e9 s9 DC 0 AC 56e-1 120
RI9 e9 12 47e-1
VS10 18 s10 0
R10 s10 10 47e0
VS11 18 s11 0
L11 s11 11 18e-2
VS12 14 s12 0
C12 s12 7 15e-5
VS13 1 s13 0
L13 s13 3 39e-5
VS14 9 s14 0
V14 e14 s14 DC 0 AC 33e1 0
RI14 e14 15 10e-1
VS15 4 s15 0
C15 s15 11 56e-7
VS16 19 s16 0
L16 s16 2 39e-5
VS17 11 s17 0
C17 s17 10 18e-6
VS18 18 s18 0
L18 s18 14 68e-2
VS19 2 s19 0
R19 s19 0 12e1
VS20 5 s20 0
L20 s20 9 47e-2
VS21 10 s21 0
C21 s21 19 56e-4
VS22 14 s22 0
L22 s22 8 18e-4
VS23 13 s23 0
V23 e23 s23 DC 0 AC 18e-1 120
RI23 e23 m23 56e-1
LI23 m23 5 82e-5
VS24 8 s24 0
L24 s24 9 15e-5
VS25 9 s25 0
L25 s25 8 27e-3
VS26 18 s26 0
C26 s26 13 10e-6
VS27 20 s27 0
L27 s27 12 22e-4
VS28 2 s28 0
R28 s28 7 12e0
VS29 21 s29 0
V29 e29 s29 DC 0 AC 22e1 120
RI29 e29 20 68e-3
VS30 17 s30 0
R30 s30 10 47e-2
VS31 12 s31 0
V31 e31 s31 DC 0 AC 68e1 120
RI31 e31 9 33e-2
VS32 6 s32 0
R32 s32 4 18e2
VS33 1 s33 0
V33 e33 s33 DC 0 AC 82e-1 180
RI33 e33 5 12e-2
VS34 6 s34 0
R34 s34 15 39e2
VS35 6 s35 0
V35 e35 s35 DC 0 AC 47e0 -120
RI35 e35 4 39e-1
VS36 21 s36 0
R36 s36 9 10e3
VS37 16 s37 0
L37 s37 17 33e-2
VS38 10 s38 0
R38 s38 3 33e1
VS39 13 s39 0
C39 s39 1 10e-6
VS40 7 s40 0
V40 e40 s40 DC 0 AC 47e0 -120
RI40 e40 m40 10e-2
LI40 m40 10 15e-6
VS41 6 s41 0
R41 s41 11 82e1
VS42 10 s42 0
C42 s42 5 10e-7
VS43 3 s43 0
R43 s43 16 22e3
.control
set numdgt=17
ac lin 1 60 60
print v(1) v(2) v(3) v(4) v(5) v(6) v(7) v(8) v(9) v(10)
print v(11) v(12) v(13) v(14) v(15) v(16) v(17) v(18) v(19) v(20)
print v(21)
print i(vs0) i(vs1) i(vs2) i(vs3) i(vs4) i(vs5) i(vs6) i(vs7) i(vs8) i(vs9)
print i(vs10) i(vs11) i(vs12) i(vs13) i(vs14) i(vs15) i(vs16) i(vs17) i(vs18) i(vs19)
print i(vs20) i(vs21) i(vs22) i(vs23) i(vs24) i(vs25) i(vs26) i(vs27) i(vs28) i(vs29)
print i(vs30) i(vs31) i(vs32) i(vs33) i(vs34) i(vs35) i(vs36) i(vs37) i(vs38) i(vs39)
print i(vs40) i(vs41) i(vs42) i(vs43)
.endc
.end
