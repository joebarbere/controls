controls oracle ac-0274
* Generated (plan F2.7, ADR 0012): do not edit; regenerate with `pnpm sim oracle regen`. ac seed 20261031 index 274 nodes 22 elements 30
.options sparse gmin=1e-12 noopac
RG1 1 0 1000000000000
RG2 2 0 1000000000000
RG3 3 0 1000000000000
RG4 4 0 1000000000000
RG5 5 0 1000000000000
RG6 6 0 1000000000000
RG7 7 0 1000000000000
RG8 8 0 1000000000000
RG9 9 0 1000000000000
RG10 10 0 1000000000000
RG11 11 0 1000000000000
RG12 12 0 1000000000000
RG13 13 0 1000000000000
RG14 14 0 1000000000000
RG15 15 0 1000000000000
RG16 16 0 1000000000000
RG17 17 0 1000000000000
RG18 18 0 1000000000000
RG19 19 0 1000000000000
RG20 20 0 1000000000000
RG21 21 0 1000000000000
VS0 12 s0 0
R0 s0 21 22e-2
VS1 0 s1 0
V1 e1 s1 DC 0 AC 68e0 -120
RI1 e1 15 10e-2
VS2 12 s2 0
C2 s2 3 12e-4
VS3 9 s3 0
C3 s3 16 82e-7
VS4 6 s4 0
C4 s4 8 10e-5
VS5 2 s5 0
R5 s5 16 22e1
VS6 17 s6 0
C6 s6 3 56e-5
VS7 15 s7 0
R7 s7 11 39e0
VS8 13 s8 0
C8 s8 1 10e-6
VS9 19 s9 0
V9 e9 s9 DC 0 AC 82e1 0
RI9 e9 18 10e-3
VS10 10 s10 0
L10 s10 11 18e-5
VS11 18 s11 0
R11 s11 21 10e2
VS12 18 s12 0
R12 s12 15 47e0
VS13 1 s13 0
V13 e13 s13 DC 0 AC 82e-1 180
RI13 e13 m13 12e-2
LI13 m13 5 10e-5
VS14 3 s14 0
R14 s14 9 27e-2
VS15 16 s15 0
L15 s15 20 22e-3
VS16 4 s16 0
R16 s16 6 15e-2
VS17 17 s17 0
C17 s17 5 68e-5
VS18 8 s18 0
L18 s18 16 10e-2
VS19 2 s19 0
V19 e19 s19 DC 0 AC 22e-1 0
RI19 e19 m19 10e-2
LI19 m19 12 68e-7
VS20 8 s20 0
R20 s20 15 68e-2
VS21 18 s21 0
C21 s21 13 10e-6
VS22 7 s22 0
R22 s22 0 82e2
VS23 7 s23 0
L23 s23 1 56e-3
VS24 10 s24 0
C24 s24 19 10e-6
VS25 18 s25 0
R25 s25 9 82e-1
VS26 3 s26 0
L26 s26 4 33e-3
VS27 14 s27 0
R27 s27 21 47e3
VS28 20 s28 0
C28 s28 6 27e-6
VS29 14 s29 0
L29 s29 19 18e-2
.control
set numdgt=17
ac lin 1 60 60
print v(1) v(2) v(3) v(4) v(5) v(6) v(7) v(8) v(9) v(10)
print v(11) v(12) v(13) v(14) v(15) v(16) v(17) v(18) v(19) v(20)
print v(21)
print i(vs0) i(vs1) i(vs2) i(vs3) i(vs4) i(vs5) i(vs6) i(vs7) i(vs8) i(vs9)
print i(vs10) i(vs11) i(vs12) i(vs13) i(vs14) i(vs15) i(vs16) i(vs17) i(vs18) i(vs19)
print i(vs20) i(vs21) i(vs22) i(vs23) i(vs24) i(vs25) i(vs26) i(vs27) i(vs28) i(vs29)
.endc
.end
