controls oracle ac-0178
* Generated (plan F2.7, ADR 0012): do not edit; regenerate with `pnpm sim oracle regen`. ac seed 20261031 index 178 nodes 22 elements 33
.options sparse gmin=1e-12 noopac
RG1 1 0 1000000000000
RG2 2 0 1000000000000
RG3 3 0 1000000000000
RG4 4 0 1000000000000
RG5 5 0 1000000000000
RG6 6 0 1000000000000
RG7 7 0 1000000000000
RG8 8 0 1000000000000
RG9 9 0 1000000000000
RG10 10 0 1000000000000
RG11 11 0 1000000000000
RG12 12 0 1000000000000
RG13 13 0 1000000000000
RG14 14 0 1000000000000
RG15 15 0 1000000000000
RG16 16 0 1000000000000
RG17 17 0 1000000000000
RG18 18 0 1000000000000
RG19 19 0 1000000000000
RG20 20 0 1000000000000
RG21 21 0 1000000000000
VS0 20 s0 0
L0 s0 14 10e-4
VS1 3 s1 0
L1 s1 20 47e-4
VS2 18 s2 0
R2 s2 20 15e-1
VS3 2 s3 0
R3 s3 4 18e-2
VS4 19 s4 0
L4 s4 3 27e-2
VS5 6 s5 0
C5 s5 7 22e-7
VS6 21 s6 0
R6 s6 4 12e0
VS7 3 s7 0
R7 s7 1 82e3
VS8 8 s8 0
C8 s8 16 68e-6
VS9 12 s9 0
R9 s9 20 68e2
VS10 0 s10 0
V10 e10 s10 DC 0 AC 56e0 180
RI10 e10 6 56e-2
VS11 6 s11 0
C11 s11 13 15e-4
VS12 8 s12 0
C12 s12 11 27e-4
VS13 16 s13 0
V13 e13 s13 DC 0 AC 12e0 -120
RI13 e13 m13 12e-3
LI13 m13 1 15e-6
VS14 0 s14 0
L14 s14 9 68e-3
VS15 21 s15 0
C15 s15 10 27e-7
VS16 11 s16 0
V16 e16 s16 DC 0 AC 12e-1 180
RI16 e16 10 27e-3
VS17 12 s17 0
L17 s17 1 12e-4
VS18 4 s18 0
R18 s18 20 68e-2
VS19 4 s19 0
R19 s19 9 22e0
VS20 18 s20 0
R20 s20 4 22e-1
VS21 9 s21 0
L21 s21 8 47e-3
VS22 5 s22 0
L22 s22 14 10e-5
VS23 5 s23 0
R23 s23 17 47e0
VS24 6 s24 0
L24 s24 17 22e-2
VS25 10 s25 0
R25 s25 14 33e0
VS26 18 s26 0
L26 s26 14 15e-4
VS27 5 s27 0
C27 s27 15 82e-4
VS28 14 s28 0
C28 s28 17 12e-6
VS29 2 s29 0
R29 s29 19 33e2
VS30 4 s30 0
R30 s30 7 33e3
VS31 13 s31 0
C31 s31 19 27e-4
VS32 14 s32 0
C32 s32 15 56e-7
.control
set numdgt=17
ac lin 1 60 60
print v(1) v(2) v(3) v(4) v(5) v(6) v(7) v(8) v(9) v(10)
print v(11) v(12) v(13) v(14) v(15) v(16) v(17) v(18) v(19) v(20)
print v(21)
print i(vs0) i(vs1) i(vs2) i(vs3) i(vs4) i(vs5) i(vs6) i(vs7) i(vs8) i(vs9)
print i(vs10) i(vs11) i(vs12) i(vs13) i(vs14) i(vs15) i(vs16) i(vs17) i(vs18) i(vs19)
print i(vs20) i(vs21) i(vs22) i(vs23) i(vs24) i(vs25) i(vs26) i(vs27) i(vs28) i(vs29)
print i(vs30) i(vs31) i(vs32)
.endc
.end
