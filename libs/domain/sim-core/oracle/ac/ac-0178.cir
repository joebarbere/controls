controls oracle ac-0178
* Generated (plan F2.7, ADR 0012): do not edit; regenerate with `pnpm sim oracle regen`. ac seed 20261031 index 178 nodes 22 elements 38
.options sparse gmin=1e-12 noopac
RG1 1 0 1000000000000
RG2 2 0 1000000000000
RG3 3 0 1000000000000
RG4 4 0 1000000000000
RG5 5 0 1000000000000
RG6 6 0 1000000000000
RG7 7 0 1000000000000
RG8 8 0 1000000000000
RG9 9 0 1000000000000
RG10 10 0 1000000000000
RG11 11 0 1000000000000
RG12 12 0 1000000000000
RG13 13 0 1000000000000
RG14 14 0 1000000000000
RG15 15 0 1000000000000
RG16 16 0 1000000000000
RG17 17 0 1000000000000
RG18 18 0 1000000000000
RG19 19 0 1000000000000
RG20 20 0 1000000000000
RG21 21 0 1000000000000
VS0 21 s0 0
R0 s0 6 12e0
VS1 9 s1 0
C1 s1 15 18e-5
VS2 19 s2 0
L2 s2 3 27e-2
VS3 6 s3 0
R3 s3 20 68e-2
VS4 14 s4 0
R4 s4 20 47e3
VS5 5 s5 0
L5 s5 14 10e-5
VS6 11 s6 0
C6 s6 2 18e-7
VS7 8 s7 0
R7 s7 14 82e0
VS8 3 s8 0
L8 s8 20 47e-4
VS9 14 s9 0
C9 s9 17 12e-6
VS10 11 s10 0
R10 s10 2 18e-2
VS11 3 s11 0
R11 s11 1 82e3
VS12 17 s12 0
L12 s12 18 47e-5
VS13 0 s13 0
V13 e13 s13 DC 0 AC 22e-1 180
RI13 e13 7 33e-3
VS14 9 s14 0
L14 s14 8 47e-3
VS15 8 s15 0
C15 s15 16 68e-6
VS16 13 s16 0
V16 e16 s16 DC 0 AC 18e-1 180
RI16 e16 12 12e-1
VS17 2 s17 0
R17 s17 6 18e-2
VS18 6 s18 0
R18 s18 1 47e3
VS19 8 s19 0
C19 s19 11 27e-4
VS20 12 s20 0
R20 s20 20 68e2
VS21 18 s21 0
R21 s21 20 27e0
VS22 5 s22 0
C22 s22 15 82e-4
VS23 6 s23 0
R23 s23 9 22e0
VS24 3 s24 0
R24 s24 5 68e2
VS25 18 s25 0
L25 s25 14 15e-4
VS26 13 s26 0
C26 s26 19 27e-4
VS27 2 s27 0
V27 e27 s27 DC 0 AC 39e-1 0
RI27 e27 12 27e-2
VS28 11 s28 0
V28 e28 s28 DC 0 AC 12e-1 180
RI28 e28 10 27e-3
VS29 9 s29 0
C29 s29 2 33e-6
VS30 6 s30 0
R30 s30 7 33e3
VS31 16 s31 0
C31 s31 11 12e-6
VS32 21 s32 0
R32 s32 5 47e-1
VS33 19 s33 0
R33 s33 2 10e-1
VS34 2 s34 0
R34 s34 11 15e-2
VS35 4 s35 0
L35 s35 9 68e-3
VS36 0 s36 0
L36 s36 17 22e-2
VS37 20 s37 0
L37 s37 14 10e-4
.control
set numdgt=17
ac lin 1 60 60
print v(1) v(2) v(3) v(4) v(5) v(6) v(7) v(8) v(9) v(10)
print v(11) v(12) v(13) v(14) v(15) v(16) v(17) v(18) v(19) v(20)
print v(21)
print i(vs0) i(vs1) i(vs2) i(vs3) i(vs4) i(vs5) i(vs6) i(vs7) i(vs8) i(vs9)
print i(vs10) i(vs11) i(vs12) i(vs13) i(vs14) i(vs15) i(vs16) i(vs17) i(vs18) i(vs19)
print i(vs20) i(vs21) i(vs22) i(vs23) i(vs24) i(vs25) i(vs26) i(vs27) i(vs28) i(vs29)
print i(vs30) i(vs31) i(vs32) i(vs33) i(vs34) i(vs35) i(vs36) i(vs37)
.endc
.end
