controls oracle ac-0172
* Generated (plan F2.7, ADR 0012): do not edit; regenerate with `pnpm sim oracle regen`. ac seed 20261031 index 172 nodes 14 elements 26
.options sparse gmin=1e-12 noopac
RG1 1 0 1000000000000
RG2 2 0 1000000000000
RG3 3 0 1000000000000
RG4 4 0 1000000000000
RG5 5 0 1000000000000
RG6 6 0 1000000000000
RG7 7 0 1000000000000
RG8 8 0 1000000000000
RG9 9 0 1000000000000
RG10 10 0 1000000000000
RG11 11 0 1000000000000
RG12 12 0 1000000000000
RG13 13 0 1000000000000
VS0 2 s0 0
L0 s0 0 15e-5
VS1 2 s1 0
L1 s1 8 33e-2
VS2 8 s2 0
L2 s2 3 15e-3
VS3 11 s3 0
R3 s3 8 27e2
VS4 0 s4 0
V4 e4 s4 DC 0 AC 68e-1 120
RI4 e4 m4 82e-1
LI4 m4 10 33e-7
VS5 5 s5 0
L5 s5 8 82e-5
VS6 7 s6 0
V6 e6 s6 DC 0 AC 27e-1 -120
RI6 e6 6 39e-2
VS7 7 s7 0
V7 e7 s7 DC 0 AC 12e-1 120
RI7 e7 3 82e-2
VS8 13 s8 0
R8 s8 3 22e-2
VS9 7 s9 0
C9 s9 1 47e-4
VS10 5 s10 0
L10 s10 12 27e-2
VS11 9 s11 0
L11 s11 12 22e-2
VS12 13 s12 0
V12 e12 s12 DC 0 AC 10e0 180
RI12 e12 m12 15e-1
LI12 m12 2 10e-7
VS13 11 s13 0
L13 s13 2 33e-3
VS14 12 s14 0
L14 s14 4 39e-5
VS15 11 s15 0
C15 s15 10 15e-7
VS16 13 s16 0
R16 s16 4 10e-1
VS17 1 s17 0
R17 s17 9 10e2
VS18 1 s18 0
L18 s18 0 27e-5
VS19 0 s19 0
C19 s19 4 10e-5
VS20 7 s20 0
C20 s20 12 18e-6
VS21 3 s21 0
C21 s21 5 12e-5
VS22 6 s22 0
R22 s22 10 22e-1
VS23 1 s23 0
R23 s23 11 68e2
VS24 1 s24 0
L24 s24 8 18e-5
VS25 0 s25 0
C25 s25 4 33e-4
.control
set numdgt=17
ac lin 1 60 60
print v(1) v(2) v(3) v(4) v(5) v(6) v(7) v(8) v(9) v(10)
print v(11) v(12) v(13)
print i(vs0) i(vs1) i(vs2) i(vs3) i(vs4) i(vs5) i(vs6) i(vs7) i(vs8) i(vs9)
print i(vs10) i(vs11) i(vs12) i(vs13) i(vs14) i(vs15) i(vs16) i(vs17) i(vs18) i(vs19)
print i(vs20) i(vs21) i(vs22) i(vs23) i(vs24) i(vs25)
.endc
.end
