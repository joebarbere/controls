controls oracle ac-0300
* Generated (plan F2.7, ADR 0012): do not edit; regenerate with `pnpm sim oracle regen`. ac seed 20261031 index 300 nodes 11 elements 17
.options sparse gmin=1e-12 noopac
RG1 1 0 1000000000000
RG2 2 0 1000000000000
RG3 3 0 1000000000000
RG4 4 0 1000000000000
RG5 5 0 1000000000000
RG6 6 0 1000000000000
RG7 7 0 1000000000000
RG8 8 0 1000000000000
RG9 9 0 1000000000000
RG10 10 0 1000000000000
VS0 9 s0 0
R0 s0 5 27e-2
VS1 6 s1 0
C1 s1 8 82e-4
VS2 7 s2 0
C2 s2 3 22e-5
VS3 6 s3 0
R3 s3 2 12e3
VS4 5 s4 0
R4 s4 4 33e2
VS5 7 s5 0
C5 s5 2 33e-4
VS6 0 s6 0
V6 e6 s6 DC 0 AC 47e1 0
RI6 e6 5 10e-1
VS7 9 s7 0
R7 s7 7 15e1
VS8 0 s8 0
R8 s8 4 15e1
VS9 3 s9 0
V9 e9 s9 DC 0 AC 47e0 120
RI9 e9 8 18e-1
VS10 10 s10 0
L10 s10 6 68e-2
VS11 8 s11 0
L11 s11 7 33e-4
VS12 7 s12 0
R12 s12 1 12e3
VS13 9 s13 0
C13 s13 0 39e-5
VS14 6 s14 0
R14 s14 7 10e3
VS15 0 s15 0
V15 e15 s15 DC 0 AC 47e0 -120
RI15 e15 10 33e-1
VS16 4 s16 0
V16 e16 s16 DC 0 AC 39e0 0
RI16 e16 3 18e-1
.control
set numdgt=17
ac lin 1 60 60
print v(1) v(2) v(3) v(4) v(5) v(6) v(7) v(8) v(9) v(10)
print i(vs0) i(vs1) i(vs2) i(vs3) i(vs4) i(vs5) i(vs6) i(vs7) i(vs8) i(vs9)
print i(vs10) i(vs11) i(vs12) i(vs13) i(vs14) i(vs15) i(vs16)
.endc
.end
