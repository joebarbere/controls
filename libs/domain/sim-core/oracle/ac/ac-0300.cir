controls oracle ac-0300
* Generated (plan F2.7, ADR 0012): do not edit; regenerate with `pnpm sim oracle regen`. ac seed 20261031 index 300 nodes 11 elements 16
.options sparse gmin=1e-12 noopac
RG1 1 0 1000000000000
RG2 2 0 1000000000000
RG3 3 0 1000000000000
RG4 4 0 1000000000000
RG5 5 0 1000000000000
RG6 6 0 1000000000000
RG7 7 0 1000000000000
RG8 8 0 1000000000000
RG9 9 0 1000000000000
RG10 10 0 1000000000000
VS0 0 s0 0
V0 e0 s0 DC 0 AC 47e0 -120
RI0 e0 10 33e-1
VS1 9 s1 0
C1 s1 0 39e-5
VS2 6 s2 0
V2 e2 s2 DC 0 AC 15e-1 0
RI2 e2 3 68e-3
VS3 5 s3 0
R3 s3 6 10e-2
VS4 4 s4 0
R4 s4 9 82e-2
VS5 7 s5 0
C5 s5 5 12e-6
VS6 8 s6 0
V6 e6 s6 DC 0 AC 18e1 -120
RI6 e6 5 68e-3
VS7 9 s7 0
R7 s7 7 15e1
VS8 1 s8 0
L8 s8 5 68e-2
VS9 4 s9 0
R9 s9 10 33e-2
VS10 7 s10 0
C10 s10 3 22e-5
VS11 7 s11 0
R11 s11 1 12e3
VS12 6 s12 0
R12 s12 7 10e3
VS13 4 s13 0
R13 s13 2 39e0
VS14 2 s14 0
V14 e14 s14 DC 0 AC 82e1 0
RI14 e14 m14 33e-1
LI14 m14 9 22e-6
VS15 4 s15 0
C15 s15 8 47e-6
.control
set numdgt=17
ac lin 1 60 60
print v(1) v(2) v(3) v(4) v(5) v(6) v(7) v(8) v(9) v(10)
print i(vs0) i(vs1) i(vs2) i(vs3) i(vs4) i(vs5) i(vs6) i(vs7) i(vs8) i(vs9)
print i(vs10) i(vs11) i(vs12) i(vs13) i(vs14) i(vs15)
.endc
.end
