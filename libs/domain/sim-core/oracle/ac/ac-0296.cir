controls oracle ac-0296
* Generated (plan F2.7, ADR 0012): do not edit; regenerate with `pnpm sim oracle regen`. ac seed 20261031 index 296 nodes 11 elements 19
.options sparse gmin=1e-12 noopac
RG1 1 0 1000000000000
RG2 2 0 1000000000000
RG3 3 0 1000000000000
RG4 4 0 1000000000000
RG5 5 0 1000000000000
RG6 6 0 1000000000000
RG7 7 0 1000000000000
RG8 8 0 1000000000000
RG9 9 0 1000000000000
RG10 10 0 1000000000000
VS0 9 s0 0
L0 s0 3 82e-3
VS1 0 s1 0
V1 e1 s1 DC 0 AC 56e0 120
RI1 e1 4 39e-3
VS2 0 s2 0
R2 s2 9 33e3
VS3 4 s3 0
L3 s3 7 27e-5
VS4 6 s4 0
L4 s4 9 82e-3
VS5 5 s5 0
V5 e5 s5 DC 0 AC 15e-1 0
RI5 e5 m5 18e-3
LI5 m5 0 56e-7
VS6 10 s6 0
L6 s6 1 22e-5
VS7 9 s7 0
L7 s7 3 15e-3
VS8 7 s8 0
L8 s8 0 22e-4
VS9 2 s9 0
V9 e9 s9 DC 0 AC 27e-1 -120
RI9 e9 0 15e-3
VS10 10 s10 0
L10 s10 8 27e-2
VS11 3 s11 0
L11 s11 4 22e-2
VS12 10 s12 0
V12 e12 s12 DC 0 AC 47e1 0
RI12 e12 5 27e-2
VS13 8 s13 0
C13 s13 2 10e-7
VS14 4 s14 0
V14 e14 s14 DC 0 AC 56e-1 0
RI14 e14 0 18e-1
VS15 8 s15 0
L15 s15 6 56e-3
VS16 7 s16 0
R16 s16 1 82e3
VS17 4 s17 0
R17 s17 6 82e0
VS18 0 s18 0
C18 s18 10 47e-6
.control
set numdgt=17
ac lin 1 60 60
print v(1) v(2) v(3) v(4) v(5) v(6) v(7) v(8) v(9) v(10)
print i(vs0) i(vs1) i(vs2) i(vs3) i(vs4) i(vs5) i(vs6) i(vs7) i(vs8) i(vs9)
print i(vs10) i(vs11) i(vs12) i(vs13) i(vs14) i(vs15) i(vs16) i(vs17) i(vs18)
.endc
.end
