controls oracle ac-0296
* Generated (plan F2.7, ADR 0012): do not edit; regenerate with `pnpm sim oracle regen`. ac seed 20261031 index 296 nodes 11 elements 12
.options sparse gmin=1e-12 noopac
RG1 1 0 1000000000000
RG2 2 0 1000000000000
RG3 3 0 1000000000000
RG4 4 0 1000000000000
RG5 5 0 1000000000000
RG6 6 0 1000000000000
RG7 7 0 1000000000000
RG8 8 0 1000000000000
RG9 9 0 1000000000000
RG10 10 0 1000000000000
VS0 0 s0 0
V0 e0 s0 DC 0 AC 68e1 0
RI0 e0 4 22e-1
VS1 7 s1 0
L1 s1 10 82e-3
VS2 1 s2 0
V2 e2 s2 DC 0 AC 68e0 180
RI2 e2 6 56e-2
VS3 3 s3 0
C3 s3 0 12e-7
VS4 1 s4 0
R4 s4 0 10e3
VS5 6 s5 0
R5 s5 9 39e0
VS6 8 s6 0
V6 e6 s6 DC 0 AC 27e-1 -120
RI6 e6 6 15e-3
VS7 9 s7 0
L7 s7 1 56e-2
VS8 7 s8 0
R8 s8 2 27e2
VS9 7 s9 0
V9 e9 s9 DC 0 AC 56e0 120
RI9 e9 4 39e-3
VS10 5 s10 0
R10 s10 6 56e1
VS11 3 s11 0
R11 s11 1 22e1
.control
set numdgt=17
ac lin 1 60 60
print v(1) v(2) v(3) v(4) v(5) v(6) v(7) v(8) v(9) v(10)
print i(vs0) i(vs1) i(vs2) i(vs3) i(vs4) i(vs5) i(vs6) i(vs7) i(vs8) i(vs9)
print i(vs10) i(vs11)
.endc
.end
