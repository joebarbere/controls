controls oracle ac-0263
* Generated (plan F2.7, ADR 0012): do not edit; regenerate with `pnpm sim oracle regen`. ac seed 20261031 index 263 nodes 28 elements 49
.options sparse gmin=1e-12 noopac
RG1 1 0 1000000000000
RG2 2 0 1000000000000
RG3 3 0 1000000000000
RG4 4 0 1000000000000
RG5 5 0 1000000000000
RG6 6 0 1000000000000
RG7 7 0 1000000000000
RG8 8 0 1000000000000
RG9 9 0 1000000000000
RG10 10 0 1000000000000
RG11 11 0 1000000000000
RG12 12 0 1000000000000
RG13 13 0 1000000000000
RG14 14 0 1000000000000
RG15 15 0 1000000000000
RG16 16 0 1000000000000
RG17 17 0 1000000000000
RG18 18 0 1000000000000
RG19 19 0 1000000000000
RG20 20 0 1000000000000
RG21 21 0 1000000000000
RG22 22 0 1000000000000
RG23 23 0 1000000000000
RG24 24 0 1000000000000
RG25 25 0 1000000000000
RG26 26 0 1000000000000
RG27 27 0 1000000000000
VS0 0 s0 0
V0 e0 s0 DC 0 AC 10e1 180
RI0 e0 9 47e-1
VS1 1 s1 0
C1 s1 2 15e-4
VS2 8 s2 0
C2 s2 15 18e-6
VS3 10 s3 0
V3 e3 s3 DC 0 AC 27e1 120
RI3 e3 m3 33e-2
LI3 m3 0 12e-7
VS4 11 s4 0
C4 s4 27 10e-5
VS5 12 s5 0
L5 s5 26 10e-2
VS6 5 s6 0
V6 e6 s6 DC 0 AC 39e1 180
RI6 e6 m6 82e-1
LI6 m6 15 12e-7
VS7 25 s7 0
L7 s7 8 18e-2
VS8 0 s8 0
R8 s8 18 12e-2
VS9 9 s9 0
R9 s9 12 47e-2
VS10 13 s10 0
R10 s10 25 10e2
VS11 21 s11 0
L11 s11 7 15e-4
VS12 8 s12 0
V12 e12 s12 DC 0 AC 10e-1 -120
RI12 e12 7 33e-1
VS13 17 s13 0
C13 s13 7 47e-6
VS14 3 s14 0
V14 e14 s14 DC 0 AC 15e-1 0
RI14 e14 7 39e-3
VS15 2 s15 0
C15 s15 16 12e-4
VS16 14 s16 0
R16 s16 5 68e1
VS17 17 s17 0
L17 s17 12 27e-5
VS18 14 s18 0
L18 s18 23 27e-2
VS19 24 s19 0
V19 e19 s19 DC 0 AC 27e-1 120
RI19 e19 16 82e-2
VS20 12 s20 0
R20 s20 8 22e2
VS21 15 s21 0
V21 e21 s21 DC 0 AC 82e-1 120
RI21 e21 m21 33e-2
LI21 m21 12 33e-6
VS22 6 s22 0
C22 s22 23 15e-7
VS23 22 s23 0
R23 s23 27 82e2
VS24 20 s24 0
R24 s24 8 15e2
VS25 20 s25 0
R25 s25 22 15e2
VS26 26 s26 0
V26 e26 s26 DC 0 AC 15e0 0
RI26 e26 2 10e-3
VS27 26 s27 0
L27 s27 22 15e-2
VS28 21 s28 0
V28 e28 s28 DC 0 AC 82e1 180
RI28 e28 m28 12e-3
LI28 m28 13 15e-7
VS29 18 s29 0
C29 s29 3 12e-5
VS30 1 s30 0
L30 s30 21 82e-5
VS31 19 s31 0
R31 s31 12 82e-2
VS32 18 s32 0
C32 s32 27 56e-7
VS33 24 s33 0
L33 s33 16 68e-4
VS34 6 s34 0
L34 s34 24 39e-5
VS35 16 s35 0
R35 s35 13 15e0
VS36 7 s36 0
L36 s36 25 47e-4
VS37 5 s37 0
V37 e37 s37 DC 0 AC 33e-1 180
RI37 e37 15 22e-2
VS38 10 s38 0
R38 s38 19 68e2
VS39 22 s39 0
R39 s39 4 33e0
VS40 14 s40 0
C40 s40 4 56e-6
VS41 23 s41 0
R41 s41 7 33e1
VS42 9 s42 0
R42 s42 12 18e3
VS43 21 s43 0
R43 s43 13 33e2
VS44 11 s44 0
C44 s44 9 39e-5
VS45 5 s45 0
C45 s45 17 56e-7
VS46 5 s46 0
L46 s46 7 18e-3
VS47 22 s47 0
C47 s47 0 56e-7
VS48 15 s48 0
C48 s48 20 82e-7
.control
set numdgt=17
ac lin 1 60 60
print v(1) v(2) v(3) v(4) v(5) v(6) v(7) v(8) v(9) v(10)
print v(11) v(12) v(13) v(14) v(15) v(16) v(17) v(18) v(19) v(20)
print v(21) v(22) v(23) v(24) v(25) v(26) v(27)
print i(vs0) i(vs1) i(vs2) i(vs3) i(vs4) i(vs5) i(vs6) i(vs7) i(vs8) i(vs9)
print i(vs10) i(vs11) i(vs12) i(vs13) i(vs14) i(vs15) i(vs16) i(vs17) i(vs18) i(vs19)
print i(vs20) i(vs21) i(vs22) i(vs23) i(vs24) i(vs25) i(vs26) i(vs27) i(vs28) i(vs29)
print i(vs30) i(vs31) i(vs32) i(vs33) i(vs34) i(vs35) i(vs36) i(vs37) i(vs38) i(vs39)
print i(vs40) i(vs41) i(vs42) i(vs43) i(vs44) i(vs45) i(vs46) i(vs47) i(vs48)
.endc
.end
