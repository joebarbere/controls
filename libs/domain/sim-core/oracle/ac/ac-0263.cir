controls oracle ac-0263
* Generated (plan F2.7, ADR 0012): do not edit; regenerate with `pnpm sim oracle regen`. ac seed 20261031 index 263 nodes 28 elements 49
.options sparse gmin=1e-12 noopac
RG1 1 0 1000000000000
RG2 2 0 1000000000000
RG3 3 0 1000000000000
RG4 4 0 1000000000000
RG5 5 0 1000000000000
RG6 6 0 1000000000000
RG7 7 0 1000000000000
RG8 8 0 1000000000000
RG9 9 0 1000000000000
RG10 10 0 1000000000000
RG11 11 0 1000000000000
RG12 12 0 1000000000000
RG13 13 0 1000000000000
RG14 14 0 1000000000000
RG15 15 0 1000000000000
RG16 16 0 1000000000000
RG17 17 0 1000000000000
RG18 18 0 1000000000000
RG19 19 0 1000000000000
RG20 20 0 1000000000000
RG21 21 0 1000000000000
RG22 22 0 1000000000000
RG23 23 0 1000000000000
RG24 24 0 1000000000000
RG25 25 0 1000000000000
RG26 26 0 1000000000000
RG27 27 0 1000000000000
VS0 1 s0 0
L0 s0 4 47e-4
VS1 2 s1 0
L1 s1 10 12e-4
VS2 13 s2 0
R2 s2 25 10e2
VS3 15 s3 0
L3 s3 11 33e-4
VS4 3 s4 0
L4 s4 11 27e-5
VS5 5 s5 0
L5 s5 12 39e-3
VS6 0 s6 0
L6 s6 14 15e-3
VS7 0 s7 0
V7 e7 s7 DC 0 AC 47e0 0
RI7 e7 m7 39e-2
LI7 m7 24 27e-7
VS8 1 s8 0
L8 s8 22 82e-2
VS9 3 s9 0
C9 s9 21 27e-5
VS10 15 s10 0
L10 s10 12 27e-5
VS11 18 s11 0
R11 s11 9 68e-1
VS12 3 s12 0
C12 s12 19 56e-4
VS13 20 s13 0
V13 e13 s13 DC 0 AC 27e0 0
RI13 e13 15 10e-3
VS14 20 s14 0
C14 s14 8 27e-7
VS15 15 s15 0
C15 s15 7 47e-6
VS16 18 s16 0
R16 s16 16 82e1
VS17 6 s17 0
R17 s17 0 39e0
VS18 20 s18 0
L18 s18 21 27e-3
VS19 15 s19 0
R19 s19 11 82e-1
VS20 21 s20 0
L20 s20 12 15e-2
VS21 10 s21 0
L21 s21 12 39e-3
VS22 9 s22 0
L22 s22 23 15e-3
VS23 3 s23 0
V23 e23 s23 DC 0 AC 15e-1 0
RI23 e23 m23 39e-3
LI23 m23 7 22e-5
VS24 17 s24 0
R24 s24 22 10e1
VS25 18 s25 0
R25 s25 11 22e0
VS26 7 s26 0
R26 s26 14 12e3
VS27 18 s27 0
C27 s27 0 56e-4
VS28 24 s28 0
R28 s28 20 56e-2
VS29 11 s29 0
C29 s29 4 56e-4
VS30 22 s30 0
C30 s30 7 22e-5
VS31 27 s31 0
R31 s31 22 22e3
VS32 8 s32 0
R32 s32 1 12e3
VS33 20 s33 0
L33 s33 10 33e-4
VS34 26 s34 0
L34 s34 0 15e-3
VS35 5 s35 0
L35 s35 3 22e-3
VS36 16 s36 0
R36 s36 13 15e0
VS37 21 s37 0
C37 s37 3 39e-4
VS38 12 s38 0
L38 s38 26 10e-2
VS39 7 s39 0
R39 s39 24 27e0
VS40 6 s40 0
R40 s40 11 22e0
VS41 19 s41 0
R41 s41 12 82e-2
VS42 21 s42 0
R42 s42 23 27e-2
VS43 27 s43 0
C43 s43 2 47e-6
VS44 12 s44 0
C44 s44 3 10e-5
VS45 17 s45 0
L45 s45 0 15e-3
VS46 7 s46 0
L46 s46 25 47e-4
VS47 11 s47 0
R47 s47 4 56e1
VS48 26 s48 0
L48 s48 10 12e-2
.control
set numdgt=17
ac lin 1 60 60
print v(1) v(2) v(3) v(4) v(5) v(6) v(7) v(8) v(9) v(10)
print v(11) v(12) v(13) v(14) v(15) v(16) v(17) v(18) v(19) v(20)
print v(21) v(22) v(23) v(24) v(25) v(26) v(27)
print i(vs0) i(vs1) i(vs2) i(vs3) i(vs4) i(vs5) i(vs6) i(vs7) i(vs8) i(vs9)
print i(vs10) i(vs11) i(vs12) i(vs13) i(vs14) i(vs15) i(vs16) i(vs17) i(vs18) i(vs19)
print i(vs20) i(vs21) i(vs22) i(vs23) i(vs24) i(vs25) i(vs26) i(vs27) i(vs28) i(vs29)
print i(vs30) i(vs31) i(vs32) i(vs33) i(vs34) i(vs35) i(vs36) i(vs37) i(vs38) i(vs39)
print i(vs40) i(vs41) i(vs42) i(vs43) i(vs44) i(vs45) i(vs46) i(vs47) i(vs48)
.endc
.end
