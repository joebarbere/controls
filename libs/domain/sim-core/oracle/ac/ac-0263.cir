controls oracle ac-0263
* Generated (plan F2.7, ADR 0012): do not edit; regenerate with `pnpm sim oracle regen`. ac seed 20261031 index 263 nodes 28 elements 44
.options sparse gmin=1e-12 noopac
RG1 1 0 1000000000000
RG2 2 0 1000000000000
RG3 3 0 1000000000000
RG4 4 0 1000000000000
RG5 5 0 1000000000000
RG6 6 0 1000000000000
RG7 7 0 1000000000000
RG8 8 0 1000000000000
RG9 9 0 1000000000000
RG10 10 0 1000000000000
RG11 11 0 1000000000000
RG12 12 0 1000000000000
RG13 13 0 1000000000000
RG14 14 0 1000000000000
RG15 15 0 1000000000000
RG16 16 0 1000000000000
RG17 17 0 1000000000000
RG18 18 0 1000000000000
RG19 19 0 1000000000000
RG20 20 0 1000000000000
RG21 21 0 1000000000000
RG22 22 0 1000000000000
RG23 23 0 1000000000000
RG24 24 0 1000000000000
RG25 25 0 1000000000000
RG26 26 0 1000000000000
RG27 27 0 1000000000000
VS0 2 s0 0
L0 s0 10 12e-4
VS1 18 s1 0
R1 s1 11 22e0
VS2 20 s2 0
L2 s2 21 27e-3
VS3 8 s3 0
R3 s3 1 12e3
VS4 21 s4 0
C4 s4 0 39e-4
VS5 7 s5 0
L5 s5 25 47e-4
VS6 3 s6 0
R6 s6 11 82e-1
VS7 13 s7 0
R7 s7 25 10e2
VS8 18 s8 0
C8 s8 15 56e-4
VS9 3 s9 0
C9 s9 7 47e-6
VS10 7 s10 0
R10 s10 24 27e0
VS11 17 s11 0
R11 s11 22 10e1
VS12 27 s12 0
R12 s12 22 22e3
VS13 12 s13 0
L13 s13 26 10e-2
VS14 18 s14 0
R14 s14 16 82e1
VS15 9 s15 0
L15 s15 23 15e-3
VS16 5 s16 0
L16 s16 0 22e-3
VS17 20 s17 0
L17 s17 10 33e-4
VS18 21 s18 0
L18 s18 12 15e-2
VS19 11 s19 0
R19 s19 4 56e1
VS20 1 s20 0
L20 s20 4 47e-4
VS21 3 s21 0
L21 s21 11 33e-4
VS22 6 s22 0
R22 s22 15 39e0
VS23 0 s23 0
L23 s23 11 27e-5
VS24 3 s24 0
L24 s24 12 27e-5
VS25 16 s25 0
R25 s25 13 15e0
VS26 22 s26 0
C26 s26 7 22e-5
VS27 21 s27 0
R27 s27 23 27e-2
VS28 26 s28 0
L28 s28 10 12e-2
VS29 0 s29 0
V29 e29 s29 DC 0 AC 15e-1 0
RI29 e29 7 39e-3
VS30 15 s30 0
V30 e30 s30 DC 0 AC 47e0 0
RI30 e30 24 39e-2
VS31 20 s31 0
V31 e31 s31 DC 0 AC 27e0 0
RI31 e31 3 10e-3
VS32 12 s32 0
C32 s32 0 10e-5
VS33 20 s33 0
C33 s33 8 27e-7
VS34 11 s34 0
C34 s34 4 56e-4
VS35 15 s35 0
L35 s35 14 15e-3
VS36 24 s36 0
R36 s36 20 56e-2
VS37 1 s37 0
L37 s37 22 82e-2
VS38 26 s38 0
L38 s38 15 15e-3
VS39 19 s39 0
R39 s39 12 82e-2
VS40 7 s40 0
R40 s40 14 12e3
VS41 6 s41 0
R41 s41 11 22e0
VS42 10 s42 0
L42 s42 12 39e-3
VS43 0 s43 0
C43 s43 21 27e-5
.control
set numdgt=17
ac lin 1 60 60
print v(1) v(2) v(3) v(4) v(5) v(6) v(7) v(8) v(9) v(10)
print v(11) v(12) v(13) v(14) v(15) v(16) v(17) v(18) v(19) v(20)
print v(21) v(22) v(23) v(24) v(25) v(26) v(27)
print i(vs0) i(vs1) i(vs2) i(vs3) i(vs4) i(vs5) i(vs6) i(vs7) i(vs8) i(vs9)
print i(vs10) i(vs11) i(vs12) i(vs13) i(vs14) i(vs15) i(vs16) i(vs17) i(vs18) i(vs19)
print i(vs20) i(vs21) i(vs22) i(vs23) i(vs24) i(vs25) i(vs26) i(vs27) i(vs28) i(vs29)
print i(vs30) i(vs31) i(vs32) i(vs33) i(vs34) i(vs35) i(vs36) i(vs37) i(vs38) i(vs39)
print i(vs40) i(vs41) i(vs42) i(vs43)
.endc
.end
