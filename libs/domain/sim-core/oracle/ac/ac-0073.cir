controls oracle ac-0073
* Generated (plan F2.7, ADR 0012): do not edit; regenerate with `pnpm sim oracle regen`. ac seed 20261031 index 73 nodes 25 elements 44
.options sparse gmin=1e-12 noopac
RG1 1 0 1000000000000
RG2 2 0 1000000000000
RG3 3 0 1000000000000
RG4 4 0 1000000000000
RG5 5 0 1000000000000
RG6 6 0 1000000000000
RG7 7 0 1000000000000
RG8 8 0 1000000000000
RG9 9 0 1000000000000
RG10 10 0 1000000000000
RG11 11 0 1000000000000
RG12 12 0 1000000000000
RG13 13 0 1000000000000
RG14 14 0 1000000000000
RG15 15 0 1000000000000
RG16 16 0 1000000000000
RG17 17 0 1000000000000
RG18 18 0 1000000000000
RG19 19 0 1000000000000
RG20 20 0 1000000000000
RG21 21 0 1000000000000
RG22 22 0 1000000000000
RG23 23 0 1000000000000
RG24 24 0 1000000000000
VS0 2 s0 0
R0 s0 13 68e1
VS1 6 s1 0
C1 s1 10 18e-6
VS2 5 s2 0
L2 s2 9 27e-2
VS3 0 s3 0
V3 e3 s3 DC 0 AC 15e-1 -120
RI3 e3 15 15e-2
VS4 5 s4 0
L4 s4 14 68e-5
VS5 8 s5 0
C5 s5 9 33e-4
VS6 13 s6 0
L6 s6 11 47e-5
VS7 19 s7 0
L7 s7 11 47e-5
VS8 16 s8 0
R8 s8 6 10e-2
VS9 16 s9 0
L9 s9 5 18e-3
VS10 7 s10 0
V10 e10 s10 DC 0 AC 22e1 -120
RI10 e10 m10 33e-2
LI10 m10 2 12e-5
VS11 0 s11 0
R11 s11 19 33e1
VS12 20 s12 0
C12 s12 1 27e-5
VS13 21 s13 0
V13 e13 s13 DC 0 AC 47e0 120
RI13 e13 2 12e-2
VS14 5 s14 0
R14 s14 18 56e3
VS15 20 s15 0
C15 s15 23 22e-4
VS16 0 s16 0
R16 s16 11 39e0
VS17 9 s17 0
C17 s17 5 27e-4
VS18 7 s18 0
R18 s18 20 68e0
VS19 8 s19 0
C19 s19 24 33e-6
VS20 3 s20 0
R20 s20 6 22e3
VS21 0 s21 0
R21 s21 21 56e-1
VS22 12 s22 0
L22 s22 22 56e-4
VS23 0 s23 0
R23 s23 17 47e-1
VS24 11 s24 0
V24 e24 s24 DC 0 AC 47e1 120
RI24 e24 m24 10e-1
LI24 m24 1 22e-7
VS25 20 s25 0
L25 s25 4 18e-4
VS26 5 s26 0
C26 s26 19 39e-4
VS27 2 s27 0
R27 s27 23 12e2
VS28 15 s28 0
R28 s28 16 82e3
VS29 12 s29 0
C29 s29 7 39e-6
VS30 16 s30 0
R30 s30 6 39e2
VS31 4 s31 0
R31 s31 16 10e0
VS32 7 s32 0
L32 s32 19 39e-4
VS33 14 s33 0
L33 s33 3 68e-4
VS34 18 s34 0
L34 s34 3 82e-4
VS35 2 s35 0
C35 s35 14 22e-5
VS36 16 s36 0
R36 s36 8 27e0
VS37 10 s37 0
R37 s37 21 47e0
VS38 24 s38 0
C38 s38 11 47e-5
VS39 3 s39 0
C39 s39 10 27e-6
VS40 14 s40 0
L40 s40 20 56e-4
VS41 3 s41 0
R41 s41 8 82e1
VS42 15 s42 0
V42 e42 s42 DC 0 AC 27e-1 180
RI42 e42 17 12e-1
VS43 2 s43 0
V43 e43 s43 DC 0 AC 10e0 120
RI43 e43 22 18e-2
.control
set numdgt=17
ac lin 1 60 60
print v(1) v(2) v(3) v(4) v(5) v(6) v(7) v(8) v(9) v(10)
print v(11) v(12) v(13) v(14) v(15) v(16) v(17) v(18) v(19) v(20)
print v(21) v(22) v(23) v(24)
print i(vs0) i(vs1) i(vs2) i(vs3) i(vs4) i(vs5) i(vs6) i(vs7) i(vs8) i(vs9)
print i(vs10) i(vs11) i(vs12) i(vs13) i(vs14) i(vs15) i(vs16) i(vs17) i(vs18) i(vs19)
print i(vs20) i(vs21) i(vs22) i(vs23) i(vs24) i(vs25) i(vs26) i(vs27) i(vs28) i(vs29)
print i(vs30) i(vs31) i(vs32) i(vs33) i(vs34) i(vs35) i(vs36) i(vs37) i(vs38) i(vs39)
print i(vs40) i(vs41) i(vs42) i(vs43)
.endc
.end
