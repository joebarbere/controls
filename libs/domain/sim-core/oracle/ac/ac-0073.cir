controls oracle ac-0073
* Generated (plan F2.7, ADR 0012): do not edit; regenerate with `pnpm sim oracle regen`. ac seed 20261031 index 73 nodes 25 elements 30
.options sparse gmin=1e-12 noopac
RG1 1 0 1000000000000
RG2 2 0 1000000000000
RG3 3 0 1000000000000
RG4 4 0 1000000000000
RG5 5 0 1000000000000
RG6 6 0 1000000000000
RG7 7 0 1000000000000
RG8 8 0 1000000000000
RG9 9 0 1000000000000
RG10 10 0 1000000000000
RG11 11 0 1000000000000
RG12 12 0 1000000000000
RG13 13 0 1000000000000
RG14 14 0 1000000000000
RG15 15 0 1000000000000
RG16 16 0 1000000000000
RG17 17 0 1000000000000
RG18 18 0 1000000000000
RG19 19 0 1000000000000
RG20 20 0 1000000000000
RG21 21 0 1000000000000
RG22 22 0 1000000000000
RG23 23 0 1000000000000
RG24 24 0 1000000000000
VS0 19 s0 0
R0 s0 11 33e1
VS1 21 s1 0
C1 s1 2 22e-4
VS2 10 s2 0
R2 s2 21 47e0
VS3 12 s3 0
R3 s3 13 10e-1
VS4 0 s4 0
V4 e4 s4 DC 0 AC 47e1 120
RI4 e4 1 10e-1
VS5 7 s5 0
R5 s5 22 22e2
VS6 5 s6 0
R6 s6 9 27e-1
VS7 14 s7 0
L7 s7 2 10e-2
VS8 13 s8 0
C8 s8 23 39e-7
VS9 19 s9 0
R9 s9 0 39e0
VS10 21 s10 0
C10 s10 6 27e-6
VS11 5 s11 0
V11 e11 s11 DC 0 AC 15e0 180
RI11 e11 3 39e-1
VS12 0 s12 0
R12 s12 6 12e1
VS13 5 s13 0
V13 e13 s13 DC 0 AC 82e1 0
RI13 e13 24 33e-2
VS14 21 s14 0
C14 s14 18 12e-6
VS15 5 s15 0
L15 s15 1 33e-3
VS16 0 s16 0
L16 s16 16 47e-2
VS17 0 s17 0
C17 s17 17 68e-6
VS18 3 s18 0
R18 s18 8 82e1
VS19 16 s19 0
L19 s19 5 18e-3
VS20 12 s20 0
L20 s20 22 56e-4
VS21 6 s21 0
R21 s21 8 12e3
VS22 15 s22 0
V22 e22 s22 DC 0 AC 27e0 180
RI22 e22 23 82e-1
VS23 11 s23 0
L23 s23 0 47e-5
VS24 20 s24 0
R24 s24 2 82e-1
VS25 12 s25 0
C25 s25 7 39e-6
VS26 4 s26 0
V26 e26 s26 DC 0 AC 47e-1 -120
RI26 e26 10 33e-2
VS27 19 s27 0
R27 s27 21 56e-1
VS28 15 s28 0
V28 e28 s28 DC 0 AC 22e-1 0
RI28 e28 11 15e-3
VS29 7 s29 0
L29 s29 11 39e-4
.control
set numdgt=17
ac lin 1 60 60
print v(1) v(2) v(3) v(4) v(5) v(6) v(7) v(8) v(9) v(10)
print v(11) v(12) v(13) v(14) v(15) v(16) v(17) v(18) v(19) v(20)
print v(21) v(22) v(23) v(24)
print i(vs0) i(vs1) i(vs2) i(vs3) i(vs4) i(vs5) i(vs6) i(vs7) i(vs8) i(vs9)
print i(vs10) i(vs11) i(vs12) i(vs13) i(vs14) i(vs15) i(vs16) i(vs17) i(vs18) i(vs19)
print i(vs20) i(vs21) i(vs22) i(vs23) i(vs24) i(vs25) i(vs26) i(vs27) i(vs28) i(vs29)
.endc
.end
