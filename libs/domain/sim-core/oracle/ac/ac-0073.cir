controls oracle ac-0073
* Generated (plan F2.7, ADR 0012): do not edit; regenerate with `pnpm sim oracle regen`. ac seed 20261031 index 73 nodes 25 elements 37
.options sparse gmin=1e-12 noopac
RG1 1 0 1000000000000
RG2 2 0 1000000000000
RG3 3 0 1000000000000
RG4 4 0 1000000000000
RG5 5 0 1000000000000
RG6 6 0 1000000000000
RG7 7 0 1000000000000
RG8 8 0 1000000000000
RG9 9 0 1000000000000
RG10 10 0 1000000000000
RG11 11 0 1000000000000
RG12 12 0 1000000000000
RG13 13 0 1000000000000
RG14 14 0 1000000000000
RG15 15 0 1000000000000
RG16 16 0 1000000000000
RG17 17 0 1000000000000
RG18 18 0 1000000000000
RG19 19 0 1000000000000
RG20 20 0 1000000000000
RG21 21 0 1000000000000
RG22 22 0 1000000000000
RG23 23 0 1000000000000
RG24 24 0 1000000000000
VS0 19 s0 0
R0 s0 11 39e0
VS1 3 s1 0
R1 s1 8 82e1
VS2 0 s2 0
R2 s2 9 27e-1
VS3 6 s3 0
R3 s3 8 12e3
VS4 0 s4 0
V4 e4 s4 DC 0 AC 82e1 0
RI4 e4 n4 33e-2
H4 n4 h4 VS10 18e-3
ED4 h4 24 d4 0 -10e-5
F4 0 d4 VS10 1
LD4 d4 0 1
VS5 7 s5 0
R5 s5 22 22e2
VS6 0 s6 0
L6 s6 1 33e-3
VS7 12 s7 0
R7 s7 13 10e-1
VS8 13 s8 0
C8 s8 23 39e-7
VS9 0 s9 0
R9 s9 17 56e3
VS10 0 s10 0
V10 e10 s10 DC 0 AC 15e0 180
RI10 e10 m10 39e-1
LI10 m10 n10 47e-7
H10 n10 h10 VS4 18e-3
ED10 h10 3 d10 0 -10e-5
F10 0 d10 VS4 1
LD10 d10 0 1
VS11 18 s11 0
L11 s11 22 18e-4
VS12 11 s12 0
V12 e12 s12 DC 0 AC 47e1 120
RI12 e12 m12 10e-1
LI12 m12 1 39e-7
VS13 21 s13 0
C13 s13 18 12e-6
VS14 19 s14 0
R14 s14 5 33e1
VS15 21 s15 0
C15 s15 6 27e-6
VS16 12 s16 0
V16 e16 s16 DC 0 AC 39e-1 -120
RI16 e16 9 33e-3
VS17 12 s17 0
L17 s17 22 56e-4
VS18 15 s18 0
V18 e18 s18 DC 0 AC 27e0 180
RI18 e18 m18 82e-1
LI18 m18 23 10e-5
VS19 14 s19 0
L19 s19 2 10e-2
VS20 11 s20 0
R20 s20 6 12e1
VS21 10 s21 0
R21 s21 21 47e0
VS22 20 s22 0
R22 s22 2 82e-1
VS23 12 s23 0
R23 s23 24 27e0
VS24 21 s24 0
C24 s24 2 22e-4
VS25 19 s25 0
R25 s25 21 56e-1
VS26 14 s26 0
V26 e26 s26 DC 0 AC 22e1 -120
RI26 e26 m26 33e-2
LI26 m26 13 82e-7
VS27 5 s27 0
L27 s27 11 47e-5
VS28 11 s28 0
L28 s28 16 47e-2
VS29 12 s29 0
L29 s29 20 68e-5
VS30 12 s30 0
C30 s30 7 39e-6
VS31 15 s31 0
V31 e31 s31 DC 0 AC 22e-1 0
RI31 e31 m31 15e-3
LI31 m31 5 15e-5
VS32 11 s32 0
C32 s32 17 68e-6
VS33 4 s33 0
V33 e33 s33 DC 0 AC 47e-1 -120
RI33 e33 10 33e-2
VS34 7 s34 0
L34 s34 5 39e-4
VS35 16 s35 0
L35 s35 0 18e-3
VS36 4 s36 0
L36 s36 7 18e-4
.control
set numdgt=17
ac lin 1 60 60
print v(1) v(2) v(3) v(4) v(5) v(6) v(7) v(8) v(9) v(10)
print v(11) v(12) v(13) v(14) v(15) v(16) v(17) v(18) v(19) v(20)
print v(21) v(22) v(23) v(24)
print i(vs0) i(vs1) i(vs2) i(vs3) i(vs4) i(vs5) i(vs6) i(vs7) i(vs8) i(vs9)
print i(vs10) i(vs11) i(vs12) i(vs13) i(vs14) i(vs15) i(vs16) i(vs17) i(vs18) i(vs19)
print i(vs20) i(vs21) i(vs22) i(vs23) i(vs24) i(vs25) i(vs26) i(vs27) i(vs28) i(vs29)
print i(vs30) i(vs31) i(vs32) i(vs33) i(vs34) i(vs35) i(vs36)
.endc
.end
