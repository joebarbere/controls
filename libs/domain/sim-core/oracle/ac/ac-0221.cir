controls oracle ac-0221
* Generated (plan F2.7, ADR 0012): do not edit; regenerate with `pnpm sim oracle regen`. ac seed 20261031 index 221 nodes 24 elements 34
.options sparse gmin=1e-12 noopac
RG1 1 0 1000000000000
RG2 2 0 1000000000000
RG3 3 0 1000000000000
RG4 4 0 1000000000000
RG5 5 0 1000000000000
RG6 6 0 1000000000000
RG7 7 0 1000000000000
RG8 8 0 1000000000000
RG9 9 0 1000000000000
RG10 10 0 1000000000000
RG11 11 0 1000000000000
RG12 12 0 1000000000000
RG13 13 0 1000000000000
RG14 14 0 1000000000000
RG15 15 0 1000000000000
RG16 16 0 1000000000000
RG17 17 0 1000000000000
RG18 18 0 1000000000000
RG19 19 0 1000000000000
RG20 20 0 1000000000000
RG21 21 0 1000000000000
RG22 22 0 1000000000000
RG23 23 0 1000000000000
VS0 5 s0 0
L0 s0 17 10e-5
VS1 0 s1 0
V1 e1 s1 DC 0 AC 82e-1 -120
RI1 e1 1 22e-2
VS2 8 s2 0
C2 s2 5 56e-5
VS3 11 s3 0
C3 s3 5 15e-5
VS4 14 s4 0
R4 s4 22 39e0
VS5 0 s5 0
R5 s5 16 82e3
VS6 11 s6 0
V6 e6 s6 DC 0 AC 47e0 120
RI6 e6 23 33e-1
VS7 15 s7 0
C7 s7 0 22e-4
VS8 1 s8 0
V8 e8 s8 DC 0 AC 56e0 -120
RI8 e8 16 39e-2
VS9 20 s9 0
L9 s9 21 56e-4
VS10 22 s10 0
L10 s10 2 27e-4
VS11 22 s11 0
L11 s11 3 39e-5
VS12 9 s12 0
V12 e12 s12 DC 0 AC 10e0 180
RI12 e12 1 47e-3
VS13 17 s13 0
L13 s13 1 82e-5
VS14 14 s14 0
C14 s14 0 18e-4
VS15 16 s15 0
L15 s15 7 33e-3
VS16 6 s16 0
V16 e16 s16 DC 0 AC 12e-1 120
RI16 e16 8 18e-2
VS17 21 s17 0
L17 s17 11 47e-3
VS18 23 s18 0
R18 s18 2 82e-1
VS19 18 s19 0
R19 s19 4 39e2
VS20 18 s20 0
C20 s20 10 68e-4
VS21 5 s21 0
R21 s21 19 15e-1
VS22 9 s22 0
C22 s22 22 82e-5
VS23 4 s23 0
R23 s23 7 39e2
VS24 12 s24 0
L24 s24 13 12e-4
VS25 3 s25 0
C25 s25 9 15e-4
VS26 12 s26 0
R26 s26 20 22e-1
VS27 0 s27 0
L27 s27 10 82e-3
VS28 9 s28 0
R28 s28 15 33e0
VS29 23 s29 0
L29 s29 12 10e-2
VS30 17 s30 0
L30 s30 7 27e-5
VS31 12 s31 0
L31 s31 6 27e-2
VS32 4 s32 0
V32 e32 s32 DC 0 AC 15e-1 180
RI32 e32 m32 12e-3
LI32 m32 1 27e-5
VS33 19 s33 0
L33 s33 13 18e-5
.control
set numdgt=17
ac lin 1 60 60
print v(1) v(2) v(3) v(4) v(5) v(6) v(7) v(8) v(9) v(10)
print v(11) v(12) v(13) v(14) v(15) v(16) v(17) v(18) v(19) v(20)
print v(21) v(22) v(23)
print i(vs0) i(vs1) i(vs2) i(vs3) i(vs4) i(vs5) i(vs6) i(vs7) i(vs8) i(vs9)
print i(vs10) i(vs11) i(vs12) i(vs13) i(vs14) i(vs15) i(vs16) i(vs17) i(vs18) i(vs19)
print i(vs20) i(vs21) i(vs22) i(vs23) i(vs24) i(vs25) i(vs26) i(vs27) i(vs28) i(vs29)
print i(vs30) i(vs31) i(vs32) i(vs33)
.endc
.end
