controls oracle ac-0014
* Generated (plan F2.7, ADR 0012): do not edit; regenerate with `pnpm sim oracle regen`. ac seed 20261031 index 14 nodes 18 elements 26
.options sparse gmin=1e-12 noopac
RG1 1 0 1000000000000
RG2 2 0 1000000000000
RG3 3 0 1000000000000
RG4 4 0 1000000000000
RG5 5 0 1000000000000
RG6 6 0 1000000000000
RG7 7 0 1000000000000
RG8 8 0 1000000000000
RG9 9 0 1000000000000
RG10 10 0 1000000000000
RG11 11 0 1000000000000
RG12 12 0 1000000000000
RG13 13 0 1000000000000
RG14 14 0 1000000000000
RG15 15 0 1000000000000
RG16 16 0 1000000000000
RG17 17 0 1000000000000
VS0 0 s0 0
V0 e0 s0 DC 0 AC 33e1 -120
RI0 e0 n0 68e-1
H0 n0 h0 VS2 47e-4
ED0 h0 2 d0 0 -33e-7
F0 0 d0 VS2 1
LD0 d0 0 1
VS1 4 s1 0
C1 s1 7 10e-4
VS2 13 s2 0
V2 e2 s2 DC 0 AC 15e-1 -120
RI2 e2 m2 22e-3
LI2 m2 n2 18e-7
H2 n2 h2 VS0 47e-4
ED2 h2 9 d2 0 -33e-7
F2 0 d2 VS0 1
LD2 d2 0 1
VS3 12 s3 0
C3 s3 9 12e-5
VS4 3 s4 0
V4 e4 s4 DC 0 AC 39e-1 0
RI4 e4 m4 18e-1
LI4 m4 1 10e-6
VS5 4 s5 0
V5 e5 s5 DC 0 AC 27e-1 -120
RI5 e5 m5 68e-2
LI5 m5 10 22e-6
VS6 9 s6 0
R6 s6 7 22e1
VS7 8 s7 0
L7 s7 15 39e-4
VS8 17 s8 0
R8 s8 2 68e3
VS9 9 s9 0
R9 s9 8 18e-1
VS10 3 s10 0
R10 s10 16 12e-2
VS11 13 s11 0
C11 s11 14 18e-5
VS12 1 s12 0
L12 s12 15 18e-5
VS13 2 s13 0
V13 e13 s13 DC 0 AC 39e-1 0
RI13 e13 m13 15e-3
LI13 m13 5 56e-7
VS14 10 s14 0
C14 s14 16 27e-6
VS15 6 s15 0
C15 s15 11 82e-6
VS16 12 s16 0
V16 e16 s16 DC 0 AC 47e-1 120
RI16 e16 1 56e-2
VS17 16 s17 0
V17 e17 s17 DC 0 AC 47e0 120
RI17 e17 0 15e-1
VS18 9 s18 0
R18 s18 11 12e0
VS19 11 s19 0
R19 s19 3 39e2
VS20 17 s20 0
R20 s20 9 22e3
VS21 1 s21 0
V21 e21 s21 DC 0 AC 82e0 180
RI21 e21 m21 39e-2
LI21 m21 9 47e-5
VS22 3 s22 0
L22 s22 4 27e-3
VS23 6 s23 0
C23 s23 0 27e-6
VS24 1 s24 0
R24 s24 14 33e3
VS25 3 s25 0
R25 s25 5 39e1
.control
set numdgt=17
ac lin 1 60 60
print v(1) v(2) v(3) v(4) v(5) v(6) v(7) v(8) v(9) v(10)
print v(11) v(12) v(13) v(14) v(15) v(16) v(17)
print i(vs0) i(vs1) i(vs2) i(vs3) i(vs4) i(vs5) i(vs6) i(vs7) i(vs8) i(vs9)
print i(vs10) i(vs11) i(vs12) i(vs13) i(vs14) i(vs15) i(vs16) i(vs17) i(vs18) i(vs19)
print i(vs20) i(vs21) i(vs22) i(vs23) i(vs24) i(vs25)
.endc
.end
