controls oracle ac-0014
* Generated (plan F2.7, ADR 0012): do not edit; regenerate with `pnpm sim oracle regen`. ac seed 20261031 index 14 nodes 18 elements 18
.options sparse gmin=1e-12 noopac
RG1 1 0 1000000000000
RG2 2 0 1000000000000
RG3 3 0 1000000000000
RG4 4 0 1000000000000
RG5 5 0 1000000000000
RG6 6 0 1000000000000
RG7 7 0 1000000000000
RG8 8 0 1000000000000
RG9 9 0 1000000000000
RG10 10 0 1000000000000
RG11 11 0 1000000000000
RG12 12 0 1000000000000
RG13 13 0 1000000000000
RG14 14 0 1000000000000
RG15 15 0 1000000000000
RG16 16 0 1000000000000
RG17 17 0 1000000000000
VS0 3 s0 0
L0 s0 4 27e-3
VS1 9 s1 0
R1 s1 16 82e-2
VS2 0 s2 0
V2 e2 s2 DC 0 AC 47e0 120
RI2 e2 13 15e-1
VS3 3 s3 0
R3 s3 5 39e1
VS4 9 s4 0
R4 s4 8 18e-1
VS5 3 s5 0
V5 e5 s5 DC 0 AC 39e-1 0
RI5 e5 1 18e-1
VS6 11 s6 0
R6 s6 3 39e2
VS7 17 s7 0
R7 s7 9 22e3
VS8 16 s8 0
C8 s8 14 18e-5
VS9 12 s9 0
C9 s9 9 12e-5
VS10 16 s10 0
V10 e10 s10 DC 0 AC 15e-1 -120
RI10 e10 9 22e-3
VS11 10 s11 0
C11 s11 0 27e-6
VS12 17 s12 0
R12 s12 2 68e3
VS13 9 s13 0
R13 s13 11 12e0
VS14 9 s14 0
R14 s14 7 22e1
VS15 8 s15 0
L15 s15 15 39e-4
VS16 3 s16 0
R16 s16 0 12e-2
VS17 6 s17 0
C17 s17 11 82e-6
.control
set numdgt=17
ac lin 1 60 60
print v(1) v(2) v(3) v(4) v(5) v(6) v(7) v(8) v(9) v(10)
print v(11) v(12) v(13) v(14) v(15) v(16) v(17)
print i(vs0) i(vs1) i(vs2) i(vs3) i(vs4) i(vs5) i(vs6) i(vs7) i(vs8) i(vs9)
print i(vs10) i(vs11) i(vs12) i(vs13) i(vs14) i(vs15) i(vs16) i(vs17)
.endc
.end
