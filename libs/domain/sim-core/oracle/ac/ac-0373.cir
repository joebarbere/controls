controls oracle ac-0373
* Generated (plan F2.7, ADR 0012): do not edit; regenerate with `pnpm sim oracle regen`. ac seed 20261031 index 373 nodes 21 elements 42
.options sparse gmin=1e-12 noopac
RG1 1 0 1000000000000
RG2 2 0 1000000000000
RG3 3 0 1000000000000
RG4 4 0 1000000000000
RG5 5 0 1000000000000
RG6 6 0 1000000000000
RG7 7 0 1000000000000
RG8 8 0 1000000000000
RG9 9 0 1000000000000
RG10 10 0 1000000000000
RG11 11 0 1000000000000
RG12 12 0 1000000000000
RG13 13 0 1000000000000
RG14 14 0 1000000000000
RG15 15 0 1000000000000
RG16 16 0 1000000000000
RG17 17 0 1000000000000
RG18 18 0 1000000000000
RG19 19 0 1000000000000
RG20 20 0 1000000000000
VS0 18 s0 0
L0 s0 4 47e-3
VS1 1 s1 0
L1 s1 8 47e-4
VS2 9 s2 0
R2 s2 2 18e3
VS3 10 s3 0
R3 s3 6 12e0
VS4 18 s4 0
C4 s4 4 10e-5
VS5 11 s5 0
R5 s5 8 18e-1
VS6 17 s6 0
C6 s6 16 56e-4
VS7 18 s7 0
R7 s7 14 39e2
VS8 2 s8 0
L8 s8 12 22e-4
VS9 9 s9 0
L9 s9 18 18e-4
VS10 10 s10 0
C10 s10 0 15e-6
VS11 0 s11 0
C11 s11 14 18e-6
VS12 13 s12 0
C12 s12 2 47e-4
VS13 3 s13 0
C13 s13 9 15e-5
VS14 9 s14 0
C14 s14 19 22e-7
VS15 1 s15 0
R15 s15 2 12e3
VS16 0 s16 0
V16 e16 s16 DC 0 AC 18e-1 -120
RI16 e16 m16 15e-3
LI16 m16 n16 39e-6
H16 n16 h16 VS19 -47e-4
ED16 h16 15 d16 0 39e-5
F16 0 d16 VS19 1
LD16 d16 0 1
VS17 13 s17 0
L17 s17 15 39e-5
VS18 14 s18 0
L18 s18 20 33e-4
VS19 8 s19 0
V19 e19 s19 DC 0 AC 68e0 180
RI19 e19 n19 56e-2
H19 n19 h19 VS16 -47e-4
ED19 h19 15 d19 0 39e-5
F19 0 d19 VS16 1
LD19 d19 0 1
VS20 5 s20 0
C20 s20 10 56e-6
VS21 7 s21 0
C21 s21 14 10e-6
VS22 18 s22 0
R22 s22 6 22e0
VS23 19 s23 0
L23 s23 16 56e-3
VS24 10 s24 0
L24 s24 17 68e-5
VS25 0 s25 0
R25 s25 8 12e2
VS26 11 s26 0
R26 s26 3 56e-2
VS27 18 s27 0
V27 e27 s27 DC 0 AC 10e1 -120
RI27 e27 m27 10e-1
LI27 m27 17 47e-7
VS28 19 s28 0
C28 s28 11 10e-7
VS29 5 s29 0
L29 s29 2 10e-5
VS30 17 s30 0
C30 s30 15 33e-7
VS31 20 s31 0
V31 e31 s31 DC 0 AC 27e-1 -120
RI31 e31 m31 39e-2
LI31 m31 5 56e-6
VS32 7 s32 0
C32 s32 17 56e-7
VS33 15 s33 0
L33 s33 20 68e-3
VS34 3 s34 0
R34 s34 8 56e3
VS35 18 s35 0
R35 s35 2 27e2
VS36 3 s36 0
V36 e36 s36 DC 0 AC 82e0 0
RI36 e36 0 47e-2
VS37 14 s37 0
C37 s37 12 27e-7
VS38 19 s38 0
L38 s38 4 18e-4
VS39 14 s39 0
C39 s39 8 18e-5
VS40 1 s40 0
L40 s40 0 33e-3
VS41 17 s41 0
C41 s41 1 82e-6
.control
set numdgt=17
ac lin 1 60 60
print v(1) v(2) v(3) v(4) v(5) v(6) v(7) v(8) v(9) v(10)
print v(11) v(12) v(13) v(14) v(15) v(16) v(17) v(18) v(19) v(20)
print i(vs0) i(vs1) i(vs2) i(vs3) i(vs4) i(vs5) i(vs6) i(vs7) i(vs8) i(vs9)
print i(vs10) i(vs11) i(vs12) i(vs13) i(vs14) i(vs15) i(vs16) i(vs17) i(vs18) i(vs19)
print i(vs20) i(vs21) i(vs22) i(vs23) i(vs24) i(vs25) i(vs26) i(vs27) i(vs28) i(vs29)
print i(vs30) i(vs31) i(vs32) i(vs33) i(vs34) i(vs35) i(vs36) i(vs37) i(vs38) i(vs39)
print i(vs40) i(vs41)
.endc
.end
