controls oracle ac-0373
* Generated (plan F2.7, ADR 0012): do not edit; regenerate with `pnpm sim oracle regen`. ac seed 20261031 index 373 nodes 21 elements 41
.options sparse gmin=1e-12 noopac
RG1 1 0 1000000000000
RG2 2 0 1000000000000
RG3 3 0 1000000000000
RG4 4 0 1000000000000
RG5 5 0 1000000000000
RG6 6 0 1000000000000
RG7 7 0 1000000000000
RG8 8 0 1000000000000
RG9 9 0 1000000000000
RG10 10 0 1000000000000
RG11 11 0 1000000000000
RG12 12 0 1000000000000
RG13 13 0 1000000000000
RG14 14 0 1000000000000
RG15 15 0 1000000000000
RG16 16 0 1000000000000
RG17 17 0 1000000000000
RG18 18 0 1000000000000
RG19 19 0 1000000000000
RG20 20 0 1000000000000
VS0 7 s0 0
C0 s0 17 56e-7
VS1 7 s1 0
C1 s1 14 10e-6
VS2 0 s2 0
V2 e2 s2 DC 0 AC 82e0 0
RI2 e2 8 47e-2
VS3 9 s3 0
L3 s3 18 18e-4
VS4 1 s4 0
L4 s4 3 47e-4
VS5 3 s5 0
V5 e5 s5 DC 0 AC 68e0 180
RI5 e5 15 56e-2
VS6 10 s6 0
L6 s6 17 68e-5
VS7 8 s7 0
V7 e7 s7 DC 0 AC 18e-1 -120
RI7 e7 15 15e-3
VS8 8 s8 0
C8 s8 14 18e-6
VS9 14 s9 0
L9 s9 20 33e-4
VS10 14 s10 0
C10 s10 12 27e-7
VS11 11 s11 0
R11 s11 0 56e-2
VS12 13 s12 0
L12 s12 15 39e-5
VS13 13 s13 0
C13 s13 2 47e-4
VS14 19 s14 0
L14 s14 4 18e-4
VS15 5 s15 0
L15 s15 2 10e-5
VS16 11 s16 0
R16 s16 3 18e-1
VS17 20 s17 0
V17 e17 s17 DC 0 AC 27e-1 -120
RI17 e17 5 39e-2
VS18 17 s18 0
C18 s18 16 56e-4
VS19 8 s19 0
R19 s19 3 12e2
VS20 18 s20 0
V20 e20 s20 DC 0 AC 10e1 -120
RI20 e20 17 10e-1
VS21 1 s21 0
L21 s21 8 33e-3
VS22 10 s22 0
C22 s22 8 15e-6
VS23 18 s23 0
R23 s23 14 39e2
VS24 17 s24 0
C24 s24 15 33e-7
VS25 18 s25 0
R25 s25 2 27e2
VS26 18 s26 0
L26 s26 4 47e-3
VS27 9 s27 0
R27 s27 2 18e3
VS28 0 s28 0
R28 s28 3 56e3
VS29 9 s29 0
C29 s29 19 22e-7
VS30 15 s30 0
L30 s30 20 68e-3
VS31 2 s31 0
L31 s31 12 22e-4
VS32 10 s32 0
R32 s32 6 12e0
VS33 0 s33 0
C33 s33 9 15e-5
VS34 17 s34 0
C34 s34 1 82e-6
VS35 19 s35 0
L35 s35 16 56e-3
VS36 19 s36 0
C36 s36 11 10e-7
VS37 1 s37 0
R37 s37 2 12e3
VS38 5 s38 0
C38 s38 10 56e-6
VS39 14 s39 0
C39 s39 3 18e-5
VS40 18 s40 0
C40 s40 4 10e-5
.control
set numdgt=17
ac lin 1 60 60
print v(1) v(2) v(3) v(4) v(5) v(6) v(7) v(8) v(9) v(10)
print v(11) v(12) v(13) v(14) v(15) v(16) v(17) v(18) v(19) v(20)
print i(vs0) i(vs1) i(vs2) i(vs3) i(vs4) i(vs5) i(vs6) i(vs7) i(vs8) i(vs9)
print i(vs10) i(vs11) i(vs12) i(vs13) i(vs14) i(vs15) i(vs16) i(vs17) i(vs18) i(vs19)
print i(vs20) i(vs21) i(vs22) i(vs23) i(vs24) i(vs25) i(vs26) i(vs27) i(vs28) i(vs29)
print i(vs30) i(vs31) i(vs32) i(vs33) i(vs34) i(vs35) i(vs36) i(vs37) i(vs38) i(vs39)
print i(vs40)
.endc
.end
