controls oracle ac-0373
* Generated (plan F2.7, ADR 0012): do not edit; regenerate with `pnpm sim oracle regen`. ac seed 20261031 index 373 nodes 21 elements 27
.options sparse gmin=1e-12 noopac
RG1 1 0 1000000000000
RG2 2 0 1000000000000
RG3 3 0 1000000000000
RG4 4 0 1000000000000
RG5 5 0 1000000000000
RG6 6 0 1000000000000
RG7 7 0 1000000000000
RG8 8 0 1000000000000
RG9 9 0 1000000000000
RG10 10 0 1000000000000
RG11 11 0 1000000000000
RG12 12 0 1000000000000
RG13 13 0 1000000000000
RG14 14 0 1000000000000
RG15 15 0 1000000000000
RG16 16 0 1000000000000
RG17 17 0 1000000000000
RG18 18 0 1000000000000
RG19 19 0 1000000000000
RG20 20 0 1000000000000
VS0 3 s0 0
R0 s0 12 68e0
VS1 5 s1 0
C1 s1 4 47e-7
VS2 20 s2 0
R2 s2 7 47e2
VS3 12 s3 0
R3 s3 9 22e0
VS4 5 s4 0
C4 s4 9 47e-7
VS5 17 s5 0
L5 s5 19 15e-4
VS6 0 s6 0
V6 e6 s6 DC 0 AC 47e-1 -120
RI6 e6 m6 18e-3
LI6 m6 7 12e-5
VS7 4 s7 0
L7 s7 14 56e-4
VS8 20 s8 0
V8 e8 s8 DC 0 AC 39e0 0
RI8 e8 m8 18e-3
LI8 m8 5 22e-5
VS9 13 s9 0
R9 s9 9 68e2
VS10 1 s10 0
L10 s10 19 47e-4
VS11 7 s11 0
R11 s11 11 22e3
VS12 10 s12 0
C12 s12 16 56e-6
VS13 1 s13 0
V13 e13 s13 DC 0 AC 15e0 0
RI13 e13 8 27e-2
VS14 19 s14 0
V14 e14 s14 DC 0 AC 68e0 180
RI14 e14 m14 56e-2
LI14 m14 15 18e-5
VS15 17 s15 0
R15 s15 7 33e3
VS16 6 s16 0
C16 s16 5 33e-6
VS17 10 s17 0
L17 s17 17 68e-5
VS18 11 s18 0
L18 s18 14 12e-2
VS19 6 s19 0
R19 s19 13 27e0
VS20 18 s20 0
R20 s20 15 10e0
VS21 2 s21 0
L21 s21 4 18e-5
VS22 8 s22 0
V22 e22 s22 DC 0 AC 18e-1 -120
RI22 e22 m22 15e-3
LI22 m22 15 47e-6
VS23 2 s23 0
R23 s23 16 47e0
VS24 20 s24 0
V24 e24 s24 DC 0 AC 39e0 120
RI24 e24 m24 27e-1
LI24 m24 0 82e-5
VS25 18 s25 0
L25 s25 4 47e-3
VS26 3 s26 0
V26 e26 s26 DC 0 AC 12e1 -120
RI26 e26 7 12e-2
.control
set numdgt=17
ac lin 1 60 60
print v(1) v(2) v(3) v(4) v(5) v(6) v(7) v(8) v(9) v(10)
print v(11) v(12) v(13) v(14) v(15) v(16) v(17) v(18) v(19) v(20)
print i(vs0) i(vs1) i(vs2) i(vs3) i(vs4) i(vs5) i(vs6) i(vs7) i(vs8) i(vs9)
print i(vs10) i(vs11) i(vs12) i(vs13) i(vs14) i(vs15) i(vs16) i(vs17) i(vs18) i(vs19)
print i(vs20) i(vs21) i(vs22) i(vs23) i(vs24) i(vs25) i(vs26)
.endc
.end
