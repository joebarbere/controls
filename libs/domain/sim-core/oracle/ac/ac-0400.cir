controls oracle ac-0400
* Generated (plan F2.7, ADR 0012): do not edit; regenerate with `pnpm sim oracle regen`. ac seed 20261031 index 400 nodes 25 elements 35
.options sparse gmin=1e-12 noopac
RG1 1 0 1000000000000
RG2 2 0 1000000000000
RG3 3 0 1000000000000
RG4 4 0 1000000000000
RG5 5 0 1000000000000
RG6 6 0 1000000000000
RG7 7 0 1000000000000
RG8 8 0 1000000000000
RG9 9 0 1000000000000
RG10 10 0 1000000000000
RG11 11 0 1000000000000
RG12 12 0 1000000000000
RG13 13 0 1000000000000
RG14 14 0 1000000000000
RG15 15 0 1000000000000
RG16 16 0 1000000000000
RG17 17 0 1000000000000
RG18 18 0 1000000000000
RG19 19 0 1000000000000
RG20 20 0 1000000000000
RG21 21 0 1000000000000
RG22 22 0 1000000000000
RG23 23 0 1000000000000
RG24 24 0 1000000000000
VS0 0 s0 0
V0 e0 s0 DC 0 AC 10e0 -120
RI0 e0 17 18e-3
VS1 11 s1 0
L1 s1 22 56e-3
VS2 22 s2 0
C2 s2 24 68e-5
VS3 12 s3 0
V3 e3 s3 DC 0 AC 22e-1 180
RI3 e3 17 47e-1
VS4 18 s4 0
R4 s4 4 10e-1
VS5 8 s5 0
R5 s5 11 33e-1
VS6 0 s6 0
L6 s6 15 10e-2
VS7 15 s7 0
R7 s7 7 47e1
VS8 9 s8 0
V8 e8 s8 DC 0 AC 47e-1 -120
RI8 e8 19 47e-2
VS9 19 s9 0
C9 s9 0 39e-6
VS10 13 s10 0
L10 s10 0 12e-5
VS11 12 s11 0
C11 s11 20 18e-6
VS12 5 s12 0
R12 s12 15 15e-2
VS13 20 s13 0
L13 s13 3 33e-2
VS14 21 s14 0
R14 s14 16 33e-2
VS15 14 s15 0
L15 s15 12 12e-5
VS16 13 s16 0
R16 s16 11 22e2
VS17 23 s17 0
R17 s17 6 27e1
VS18 13 s18 0
L18 s18 11 56e-3
VS19 15 s19 0
C19 s19 10 47e-7
VS20 7 s20 0
V20 e20 s20 DC 0 AC 22e0 120
RI20 e20 2 27e-3
VS21 23 s21 0
V21 e21 s21 DC 0 AC 22e-1 120
RI21 e21 22 68e-3
VS22 7 s22 0
R22 s22 1 82e3
VS23 21 s23 0
C23 s23 24 68e-6
VS24 20 s24 0
V24 e24 s24 DC 0 AC 15e1 180
RI24 e24 13 12e-3
VS25 4 s25 0
C25 s25 13 33e-5
VS26 12 s26 0
R26 s26 24 15e2
VS27 6 s27 0
C27 s27 3 33e-6
VS28 9 s28 0
C28 s28 20 18e-7
VS29 21 s29 0
R29 s29 8 18e-2
VS30 21 s30 0
R30 s30 24 47e-1
VS31 12 s31 0
R31 s31 8 47e0
VS32 22 s32 0
C32 s32 20 56e-5
VS33 16 s33 0
R33 s33 0 56e-1
VS34 6 s34 0
R34 s34 20 15e2
.control
set numdgt=17
ac lin 1 60 60
print v(1) v(2) v(3) v(4) v(5) v(6) v(7) v(8) v(9) v(10)
print v(11) v(12) v(13) v(14) v(15) v(16) v(17) v(18) v(19) v(20)
print v(21) v(22) v(23) v(24)
print i(vs0) i(vs1) i(vs2) i(vs3) i(vs4) i(vs5) i(vs6) i(vs7) i(vs8) i(vs9)
print i(vs10) i(vs11) i(vs12) i(vs13) i(vs14) i(vs15) i(vs16) i(vs17) i(vs18) i(vs19)
print i(vs20) i(vs21) i(vs22) i(vs23) i(vs24) i(vs25) i(vs26) i(vs27) i(vs28) i(vs29)
print i(vs30) i(vs31) i(vs32) i(vs33) i(vs34)
.endc
.end
