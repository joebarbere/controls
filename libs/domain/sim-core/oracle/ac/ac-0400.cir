controls oracle ac-0400
* Generated (plan F2.7, ADR 0012): do not edit; regenerate with `pnpm sim oracle regen`. ac seed 20261031 index 400 nodes 25 elements 47
.options sparse gmin=1e-12 noopac
RG1 1 0 1000000000000
RG2 2 0 1000000000000
RG3 3 0 1000000000000
RG4 4 0 1000000000000
RG5 5 0 1000000000000
RG6 6 0 1000000000000
RG7 7 0 1000000000000
RG8 8 0 1000000000000
RG9 9 0 1000000000000
RG10 10 0 1000000000000
RG11 11 0 1000000000000
RG12 12 0 1000000000000
RG13 13 0 1000000000000
RG14 14 0 1000000000000
RG15 15 0 1000000000000
RG16 16 0 1000000000000
RG17 17 0 1000000000000
RG18 18 0 1000000000000
RG19 19 0 1000000000000
RG20 20 0 1000000000000
RG21 21 0 1000000000000
RG22 22 0 1000000000000
RG23 23 0 1000000000000
RG24 24 0 1000000000000
VS0 4 s0 0
C0 s0 9 18e-4
VS1 15 s1 0
R1 s1 18 56e-2
VS2 0 s2 0
V2 e2 s2 DC 0 AC 22e0 120
RI2 e2 8 27e-3
VS3 5 s3 0
C3 s3 4 10e-6
VS4 10 s4 0
R4 s4 14 39e-2
VS5 19 s5 0
R5 s5 9 47e0
VS6 15 s6 0
V6 e6 s6 DC 0 AC 27e1 120
RI6 e6 m6 18e-2
LI6 m6 24 56e-5
VS7 1 s7 0
V7 e7 s7 DC 0 AC 27e0 120
RI7 e7 12 12e-1
VS8 15 s8 0
L8 s8 2 22e-2
VS9 8 s9 0
C9 s9 17 33e-4
VS10 4 s10 0
V10 e10 s10 DC 0 AC 27e-1 180
RI10 e10 20 56e-3
VS11 5 s11 0
C11 s11 15 15e-5
VS12 2 s12 0
V12 e12 s12 DC 0 AC 18e-1 -120
RI12 e12 6 12e-2
VS13 19 s13 0
R13 s13 21 12e1
VS14 6 s14 0
R14 s14 11 33e-2
VS15 5 s15 0
C15 s15 0 47e-4
VS16 19 s16 0
L16 s16 14 39e-4
VS17 14 s17 0
L17 s17 20 22e-3
VS18 7 s18 0
L18 s18 24 18e-4
VS19 20 s19 0
R19 s19 10 10e-2
VS20 7 s20 0
R20 s20 1 22e0
VS21 21 s21 0
R21 s21 7 22e-2
VS22 6 s22 0
V22 e22 s22 DC 0 AC 68e0 -120
RI22 e22 m22 12e-1
LI22 m22 10 56e-6
VS23 5 s23 0
R23 s23 12 56e-2
VS24 5 s24 0
V24 e24 s24 DC 0 AC 22e1 -120
RI24 e24 18 56e-2
VS25 4 s25 0
V25 e25 s25 DC 0 AC 10e0 -120
RI25 e25 17 18e-3
VS26 23 s26 0
C26 s26 0 47e-6
VS27 12 s27 0
R27 s27 0 39e-2
VS28 5 s28 0
V28 e28 s28 DC 0 AC 56e1 180
RI28 e28 m28 10e-1
LI28 m28 15 12e-5
VS29 12 s29 0
V29 e29 s29 DC 0 AC 10e0 -120
RI29 e29 m29 12e-2
LI29 m29 13 82e-5
VS30 14 s30 0
C30 s30 15 12e-7
VS31 18 s31 0
C31 s31 13 33e-5
VS32 15 s32 0
C32 s32 3 18e-7
VS33 13 s33 0
L33 s33 4 12e-5
VS34 17 s34 0
L34 s34 0 12e-2
VS35 0 s35 0
V35 e35 s35 DC 0 AC 18e0 180
RI35 e35 m35 22e-1
LI35 m35 8 18e-5
VS36 1 s36 0
C36 s36 16 15e-4
VS37 18 s37 0
R37 s37 14 82e3
VS38 4 s38 0
R38 s38 7 56e1
VS39 1 s39 0
R39 s39 7 27e1
VS40 17 s40 0
C40 s40 19 12e-4
VS41 22 s41 0
R41 s41 2 82e3
VS42 11 s42 0
R42 s42 15 15e2
VS43 23 s43 0
C43 s43 12 47e-7
VS44 22 s44 0
V44 e44 s44 DC 0 AC 39e0 0
RI44 e44 4 22e-3
VS45 3 s45 0
C45 s45 16 27e-6
VS46 10 s46 0
L46 s46 0 56e-2
.control
set numdgt=17
ac lin 1 60 60
print v(1) v(2) v(3) v(4) v(5) v(6) v(7) v(8) v(9) v(10)
print v(11) v(12) v(13) v(14) v(15) v(16) v(17) v(18) v(19) v(20)
print v(21) v(22) v(23) v(24)
print i(vs0) i(vs1) i(vs2) i(vs3) i(vs4) i(vs5) i(vs6) i(vs7) i(vs8) i(vs9)
print i(vs10) i(vs11) i(vs12) i(vs13) i(vs14) i(vs15) i(vs16) i(vs17) i(vs18) i(vs19)
print i(vs20) i(vs21) i(vs22) i(vs23) i(vs24) i(vs25) i(vs26) i(vs27) i(vs28) i(vs29)
print i(vs30) i(vs31) i(vs32) i(vs33) i(vs34) i(vs35) i(vs36) i(vs37) i(vs38) i(vs39)
print i(vs40) i(vs41) i(vs42) i(vs43) i(vs44) i(vs45) i(vs46)
.endc
.end
