controls oracle ac-0459
* Generated (plan F2.7, ADR 0012): do not edit; regenerate with `pnpm sim oracle regen`. ac seed 20261031 index 459 nodes 26 elements 41
.options sparse gmin=1e-12 noopac
RG1 1 0 1000000000000
RG2 2 0 1000000000000
RG3 3 0 1000000000000
RG4 4 0 1000000000000
RG5 5 0 1000000000000
RG6 6 0 1000000000000
RG7 7 0 1000000000000
RG8 8 0 1000000000000
RG9 9 0 1000000000000
RG10 10 0 1000000000000
RG11 11 0 1000000000000
RG12 12 0 1000000000000
RG13 13 0 1000000000000
RG14 14 0 1000000000000
RG15 15 0 1000000000000
RG16 16 0 1000000000000
RG17 17 0 1000000000000
RG18 18 0 1000000000000
RG19 19 0 1000000000000
RG20 20 0 1000000000000
RG21 21 0 1000000000000
RG22 22 0 1000000000000
RG23 23 0 1000000000000
RG24 24 0 1000000000000
RG25 25 0 1000000000000
VS0 0 s0 0
V0 e0 s0 DC 0 AC 12e1 -120
RI0 e0 n0 18e-1
H0 n0 h0 VS5 82e-3
ED0 h0 17 d0 0 -15e-7
F0 0 d0 VS5 1
LD0 d0 0 1
VS1 1 s1 0
C1 s1 18 39e-5
VS2 25 s2 0
R2 s2 20 33e3
VS3 10 s3 0
R3 s3 9 10e2
VS4 22 s4 0
C4 s4 1 68e-7
VS5 4 s5 0
V5 e5 s5 DC 0 AC 15e1 120
RI5 e5 n5 15e-2
H5 n5 h5 VS0 82e-3
ED5 h5 3 d5 0 -15e-7
F5 0 d5 VS0 1
LD5 d5 0 1
VS6 3 s6 0
L6 s6 5 82e-4
VS7 1 s7 0
C7 s7 13 56e-6
VS8 13 s8 0
L8 s8 12 56e-5
VS9 21 s9 0
R9 s9 8 10e2
VS10 25 s10 0
C10 s10 21 27e-4
VS11 1 s11 0
V11 e11 s11 DC 0 AC 12e1 -120
RI11 e11 m11 56e-1
LI11 m11 8 68e-6
VS12 1 s12 0
L12 s12 4 10e-3
VS13 10 s13 0
C13 s13 6 68e-7
VS14 23 s14 0
L14 s14 15 12e-4
VS15 23 s15 0
R15 s15 0 33e0
VS16 15 s16 0
V16 e16 s16 DC 0 AC 27e0 120
RI16 e16 14 39e-1
VS17 15 s17 0
R17 s17 24 33e-2
VS18 18 s18 0
R18 s18 16 27e3
VS19 5 s19 0
V19 e19 s19 DC 0 AC 22e-1 -120
RI19 e19 m19 27e-2
LI19 m19 4 68e-7
VS20 2 s20 0
C20 s20 10 10e-5
VS21 17 s21 0
C21 s21 7 10e-4
VS22 21 s22 0
V22 e22 s22 DC 0 AC 39e1 180
RI22 e22 m22 68e-1
LI22 m22 16 27e-5
VS23 18 s23 0
L23 s23 11 22e-5
VS24 11 s24 0
R24 s24 24 22e-1
VS25 17 s25 0
L25 s25 5 33e-5
VS26 12 s26 0
V26 e26 s26 DC 0 AC 27e-1 0
RI26 e26 22 39e-3
VS27 13 s27 0
L27 s27 10 12e-3
VS28 9 s28 0
L28 s28 14 12e-4
VS29 18 s29 0
C29 s29 6 56e-7
VS30 21 s30 0
L30 s30 2 33e-3
VS31 23 s31 0
R31 s31 7 22e-1
VS32 13 s32 0
L32 s32 20 22e-2
VS33 15 s33 0
C33 s33 14 18e-4
VS34 10 s34 0
L34 s34 19 15e-4
VS35 20 s35 0
R35 s35 23 15e3
VS36 0 s36 0
L36 s36 22 82e-4
VS37 6 s37 0
L37 s37 14 27e-4
VS38 5 s38 0
V38 e38 s38 DC 0 AC 82e-1 120
RI38 e38 m38 10e-1
LI38 m38 10 82e-5
VS39 24 s39 0
R39 s39 18 22e1
VS40 19 s40 0
R40 s40 6 27e0
.control
set numdgt=17
ac lin 1 60 60
print v(1) v(2) v(3) v(4) v(5) v(6) v(7) v(8) v(9) v(10)
print v(11) v(12) v(13) v(14) v(15) v(16) v(17) v(18) v(19) v(20)
print v(21) v(22) v(23) v(24) v(25)
print i(vs0) i(vs1) i(vs2) i(vs3) i(vs4) i(vs5) i(vs6) i(vs7) i(vs8) i(vs9)
print i(vs10) i(vs11) i(vs12) i(vs13) i(vs14) i(vs15) i(vs16) i(vs17) i(vs18) i(vs19)
print i(vs20) i(vs21) i(vs22) i(vs23) i(vs24) i(vs25) i(vs26) i(vs27) i(vs28) i(vs29)
print i(vs30) i(vs31) i(vs32) i(vs33) i(vs34) i(vs35) i(vs36) i(vs37) i(vs38) i(vs39)
print i(vs40)
.endc
.end
