controls oracle ac-0459
* Generated (plan F2.7, ADR 0012): do not edit; regenerate with `pnpm sim oracle regen`. ac seed 20261031 index 459 nodes 26 elements 41
.options sparse gmin=1e-12 noopac
RG1 1 0 1000000000000
RG2 2 0 1000000000000
RG3 3 0 1000000000000
RG4 4 0 1000000000000
RG5 5 0 1000000000000
RG6 6 0 1000000000000
RG7 7 0 1000000000000
RG8 8 0 1000000000000
RG9 9 0 1000000000000
RG10 10 0 1000000000000
RG11 11 0 1000000000000
RG12 12 0 1000000000000
RG13 13 0 1000000000000
RG14 14 0 1000000000000
RG15 15 0 1000000000000
RG16 16 0 1000000000000
RG17 17 0 1000000000000
RG18 18 0 1000000000000
RG19 19 0 1000000000000
RG20 20 0 1000000000000
RG21 21 0 1000000000000
RG22 22 0 1000000000000
RG23 23 0 1000000000000
RG24 24 0 1000000000000
RG25 25 0 1000000000000
VS0 10 s0 0
R0 s0 19 56e3
VS1 18 s1 0
L1 s1 23 10e-2
VS2 6 s2 0
L2 s2 21 10e-2
VS3 17 s3 0
L3 s3 19 56e-5
VS4 1 s4 0
L4 s4 12 56e-5
VS5 0 s5 0
V5 e5 s5 DC 0 AC 15e1 0
RI5 e5 m5 33e-1
LI5 m5 21 10e-6
VS6 7 s6 0
V6 e6 s6 DC 0 AC 15e0 180
RI6 e6 m6 27e-2
LI6 m6 5 39e-7
VS7 19 s7 0
L7 s7 4 82e-2
VS8 12 s8 0
R8 s8 20 18e3
VS9 15 s9 0
L9 s9 3 47e-5
VS10 7 s10 0
L10 s10 22 12e-2
VS11 10 s11 0
L11 s11 19 15e-5
VS12 17 s12 0
L12 s12 25 27e-4
VS13 9 s13 0
R13 s13 2 27e-1
VS14 11 s14 0
L14 s14 17 33e-2
VS15 5 s15 0
L15 s15 20 18e-3
VS16 23 s16 0
V16 e16 s16 DC 0 AC 82e-1 120
RI16 e16 1 33e-2
VS17 14 s17 0
L17 s17 6 12e-3
VS18 16 s18 0
L18 s18 5 68e-5
VS19 25 s19 0
V19 e19 s19 DC 0 AC 33e1 -120
RI19 e19 9 22e-1
VS20 14 s20 0
R20 s20 0 33e2
VS21 1 s21 0
L21 s21 6 22e-3
VS22 4 s22 0
C22 s22 2 47e-4
VS23 18 s23 0
R23 s23 16 33e2
VS24 20 s24 0
C24 s24 3 82e-7
VS25 6 s25 0
R25 s25 8 39e1
VS26 10 s26 0
L26 s26 23 27e-3
VS27 7 s27 0
R27 s27 9 10e3
VS28 10 s28 0
V28 e28 s28 DC 0 AC 68e0 -120
RI28 e28 13 68e-3
VS29 1 s29 0
L29 s29 23 22e-3
VS30 22 s30 0
V30 e30 s30 DC 0 AC 68e0 0
RI30 e30 m30 12e-1
LI30 m30 11 15e-6
VS31 9 s31 0
R31 s31 15 22e1
VS32 25 s32 0
V32 e32 s32 DC 0 AC 10e-1 120
RI32 e32 m32 47e-2
LI32 m32 13 15e-6
VS33 0 s33 0
C33 s33 1 56e-6
VS34 21 s34 0
R34 s34 16 47e3
VS35 10 s35 0
R35 s35 9 22e0
VS36 1 s36 0
L36 s36 10 12e-3
VS37 2 s37 0
C37 s37 24 33e-6
VS38 20 s38 0
V38 e38 s38 DC 0 AC 22e1 120
RI38 e38 25 27e-1
VS39 24 s39 0
R39 s39 14 22e-1
VS40 0 s40 0
V40 e40 s40 DC 0 AC 12e1 -120
RI40 e40 8 56e-1
.control
set numdgt=17
ac lin 1 60 60
print v(1) v(2) v(3) v(4) v(5) v(6) v(7) v(8) v(9) v(10)
print v(11) v(12) v(13) v(14) v(15) v(16) v(17) v(18) v(19) v(20)
print v(21) v(22) v(23) v(24) v(25)
print i(vs0) i(vs1) i(vs2) i(vs3) i(vs4) i(vs5) i(vs6) i(vs7) i(vs8) i(vs9)
print i(vs10) i(vs11) i(vs12) i(vs13) i(vs14) i(vs15) i(vs16) i(vs17) i(vs18) i(vs19)
print i(vs20) i(vs21) i(vs22) i(vs23) i(vs24) i(vs25) i(vs26) i(vs27) i(vs28) i(vs29)
print i(vs30) i(vs31) i(vs32) i(vs33) i(vs34) i(vs35) i(vs36) i(vs37) i(vs38) i(vs39)
print i(vs40)
.endc
.end
