controls oracle ac-0459
* Generated (plan F2.7, ADR 0012): do not edit; regenerate with `pnpm sim oracle regen`. ac seed 20261031 index 459 nodes 26 elements 31
.options sparse gmin=1e-12 noopac
RG1 1 0 1000000000000
RG2 2 0 1000000000000
RG3 3 0 1000000000000
RG4 4 0 1000000000000
RG5 5 0 1000000000000
RG6 6 0 1000000000000
RG7 7 0 1000000000000
RG8 8 0 1000000000000
RG9 9 0 1000000000000
RG10 10 0 1000000000000
RG11 11 0 1000000000000
RG12 12 0 1000000000000
RG13 13 0 1000000000000
RG14 14 0 1000000000000
RG15 15 0 1000000000000
RG16 16 0 1000000000000
RG17 17 0 1000000000000
RG18 18 0 1000000000000
RG19 19 0 1000000000000
RG20 20 0 1000000000000
RG21 21 0 1000000000000
RG22 22 0 1000000000000
RG23 23 0 1000000000000
RG24 24 0 1000000000000
RG25 25 0 1000000000000
VS0 23 s0 0
R0 s0 7 22e-1
VS1 6 s1 0
L1 s1 14 27e-4
VS2 24 s2 0
R2 s2 18 22e1
VS3 0 s3 0
V3 e3 s3 DC 0 AC 27e0 120
RI3 e3 14 39e-1
VS4 21 s4 0
L4 s4 2 33e-3
VS5 22 s5 0
C5 s5 1 68e-7
VS6 17 s6 0
C6 s6 7 10e-4
VS7 10 s7 0
R7 s7 9 10e2
VS8 2 s8 0
C8 s8 10 10e-5
VS9 1 s9 0
V9 e9 s9 DC 0 AC 12e1 -120
RI9 e9 8 56e-1
VS10 0 s10 0
C10 s10 14 18e-4
VS11 5 s11 0
V11 e11 s11 DC 0 AC 82e-1 120
RI11 e11 10 10e-1
VS12 10 s12 0
L12 s12 19 15e-4
VS13 25 s13 0
R13 s13 20 33e3
VS14 15 s14 0
L14 s14 10 12e-3
VS15 23 s15 0
L15 s15 0 12e-4
VS16 11 s16 0
R16 s16 24 22e-1
VS17 5 s17 0
V17 e17 s17 DC 0 AC 22e-1 -120
RI17 e17 4 27e-2
VS18 18 s18 0
C18 s18 6 56e-7
VS19 1 s19 0
C19 s19 18 39e-5
VS20 18 s20 0
R20 s20 16 27e3
VS21 23 s21 0
R21 s21 13 33e0
VS22 15 s22 0
L22 s22 12 56e-5
VS23 4 s23 0
V23 e23 s23 DC 0 AC 15e1 120
RI23 e23 3 15e-2
VS24 10 s24 0
C24 s24 6 68e-7
VS25 15 s25 0
L25 s25 20 22e-2
VS26 18 s26 0
L26 s26 11 22e-5
VS27 20 s27 0
R27 s27 23 15e3
VS28 1 s28 0
L28 s28 4 10e-3
VS29 1 s29 0
C29 s29 15 56e-6
VS30 9 s30 0
L30 s30 14 12e-4
.control
set numdgt=17
ac lin 1 60 60
print v(1) v(2) v(3) v(4) v(5) v(6) v(7) v(8) v(9) v(10)
print v(11) v(12) v(13) v(14) v(15) v(16) v(17) v(18) v(19) v(20)
print v(21) v(22) v(23) v(24) v(25)
print i(vs0) i(vs1) i(vs2) i(vs3) i(vs4) i(vs5) i(vs6) i(vs7) i(vs8) i(vs9)
print i(vs10) i(vs11) i(vs12) i(vs13) i(vs14) i(vs15) i(vs16) i(vs17) i(vs18) i(vs19)
print i(vs20) i(vs21) i(vs22) i(vs23) i(vs24) i(vs25) i(vs26) i(vs27) i(vs28) i(vs29)
print i(vs30)
.endc
.end
