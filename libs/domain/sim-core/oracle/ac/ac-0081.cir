controls oracle ac-0081
* Generated (plan F2.7, ADR 0012): do not edit; regenerate with `pnpm sim oracle regen`. ac seed 20261031 index 81 nodes 24 elements 31
.options sparse gmin=1e-12 noopac
RG1 1 0 1000000000000
RG2 2 0 1000000000000
RG3 3 0 1000000000000
RG4 4 0 1000000000000
RG5 5 0 1000000000000
RG6 6 0 1000000000000
RG7 7 0 1000000000000
RG8 8 0 1000000000000
RG9 9 0 1000000000000
RG10 10 0 1000000000000
RG11 11 0 1000000000000
RG12 12 0 1000000000000
RG13 13 0 1000000000000
RG14 14 0 1000000000000
RG15 15 0 1000000000000
RG16 16 0 1000000000000
RG17 17 0 1000000000000
RG18 18 0 1000000000000
RG19 19 0 1000000000000
RG20 20 0 1000000000000
RG21 21 0 1000000000000
RG22 22 0 1000000000000
RG23 23 0 1000000000000
VS0 12 s0 0
C0 s0 2 56e-5
VS1 0 s1 0
C1 s1 1 82e-6
VS2 3 s2 0
L2 s2 11 56e-5
VS3 16 s3 0
C3 s3 21 39e-6
VS4 13 s4 0
L4 s4 15 56e-4
VS5 18 s5 0
R5 s5 16 18e-2
VS6 6 s6 0
R6 s6 10 12e3
VS7 2 s7 0
L7 s7 11 18e-4
VS8 2 s8 0
R8 s8 5 15e3
VS9 11 s9 0
L9 s9 19 18e-4
VS10 11 s10 0
L10 s10 20 56e-3
VS11 17 s11 0
C11 s11 10 68e-6
VS12 23 s12 0
R12 s12 19 12e3
VS13 14 s13 0
R13 s13 15 22e-1
VS14 19 s14 0
R14 s14 8 56e2
VS15 0 s15 0
V15 e15 s15 DC 0 AC 56e1 0
RI15 e15 19 33e-1
VS16 2 s16 0
R16 s16 9 22e0
VS17 17 s17 0
L17 s17 2 33e-2
VS18 22 s18 0
R18 s18 6 47e3
VS19 5 s19 0
V19 e19 s19 DC 0 AC 47e-1 -120
RI19 e19 13 18e-1
VS20 23 s20 0
L20 s20 1 22e-5
VS21 1 s21 0
V21 e21 s21 DC 0 AC 39e0 180
RI21 e21 11 47e-2
VS22 6 s22 0
R22 s22 1 39e-1
VS23 23 s23 0
C23 s23 15 39e-4
VS24 3 s24 0
C24 s24 23 68e-5
VS25 11 s25 0
L25 s25 10 18e-2
VS26 13 s26 0
L26 s26 20 12e-4
VS27 18 s27 0
R27 s27 10 27e-2
VS28 7 s28 0
R28 s28 2 68e1
VS29 4 s29 0
C29 s29 3 15e-7
VS30 12 s30 0
L30 s30 2 82e-4
.control
set numdgt=17
ac lin 1 60 60
print v(1) v(2) v(3) v(4) v(5) v(6) v(7) v(8) v(9) v(10)
print v(11) v(12) v(13) v(14) v(15) v(16) v(17) v(18) v(19) v(20)
print v(21) v(22) v(23)
print i(vs0) i(vs1) i(vs2) i(vs3) i(vs4) i(vs5) i(vs6) i(vs7) i(vs8) i(vs9)
print i(vs10) i(vs11) i(vs12) i(vs13) i(vs14) i(vs15) i(vs16) i(vs17) i(vs18) i(vs19)
print i(vs20) i(vs21) i(vs22) i(vs23) i(vs24) i(vs25) i(vs26) i(vs27) i(vs28) i(vs29)
print i(vs30)
.endc
.end
