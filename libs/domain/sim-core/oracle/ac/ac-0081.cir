controls oracle ac-0081
* Generated (plan F2.7, ADR 0012): do not edit; regenerate with `pnpm sim oracle regen`. ac seed 20261031 index 81 nodes 24 elements 39
.options sparse gmin=1e-12 noopac
RG1 1 0 1000000000000
RG2 2 0 1000000000000
RG3 3 0 1000000000000
RG4 4 0 1000000000000
RG5 5 0 1000000000000
RG6 6 0 1000000000000
RG7 7 0 1000000000000
RG8 8 0 1000000000000
RG9 9 0 1000000000000
RG10 10 0 1000000000000
RG11 11 0 1000000000000
RG12 12 0 1000000000000
RG13 13 0 1000000000000
RG14 14 0 1000000000000
RG15 15 0 1000000000000
RG16 16 0 1000000000000
RG17 17 0 1000000000000
RG18 18 0 1000000000000
RG19 19 0 1000000000000
RG20 20 0 1000000000000
RG21 21 0 1000000000000
RG22 22 0 1000000000000
RG23 23 0 1000000000000
VS0 0 s0 0
V0 e0 s0 DC 0 AC 56e1 0
RI0 e0 19 33e-1
VS1 23 s1 0
C1 s1 15 39e-4
VS2 11 s2 0
L2 s2 19 18e-4
VS3 17 s3 0
V3 e3 s3 DC 0 AC 12e-1 0
RI3 e3 m3 18e-1
LI3 m3 21 39e-7
VS4 1 s4 0
V4 e4 s4 DC 0 AC 39e0 180
RI4 e4 m4 47e-2
LI4 m4 11 22e-5
VS5 6 s5 0
R5 s5 10 12e3
VS6 7 s6 0
R6 s6 2 68e1
VS7 9 s7 0
L7 s7 0 15e-2
VS8 11 s8 0
L8 s8 10 18e-2
VS9 17 s9 0
C9 s9 10 68e-6
VS10 2 s10 0
R10 s10 8 27e0
VS11 0 s11 0
C11 s11 1 82e-6
VS12 13 s12 0
L12 s12 15 56e-4
VS13 19 s13 0
R13 s13 8 56e2
VS14 18 s14 0
R14 s14 16 18e-2
VS15 2 s15 0
R15 s15 5 15e3
VS16 2 s16 0
L16 s16 11 18e-4
VS17 4 s17 0
C17 s17 3 15e-7
VS18 3 s18 0
C18 s18 23 68e-5
VS19 6 s19 0
R19 s19 1 39e-1
VS20 18 s20 0
R20 s20 10 27e-2
VS21 17 s21 0
L21 s21 2 33e-2
VS22 17 s22 0
R22 s22 7 47e-1
VS23 12 s23 0
L23 s23 2 82e-4
VS24 16 s24 0
C24 s24 12 82e-6
VS25 3 s25 0
L25 s25 11 56e-5
VS26 2 s26 0
R26 s26 9 22e0
VS27 4 s27 0
V27 e27 s27 DC 0 AC 27e-1 0
RI27 e27 m27 27e-2
LI27 m27 0 22e-6
VS28 14 s28 0
R28 s28 15 22e-1
VS29 22 s29 0
R29 s29 6 47e3
VS30 13 s30 0
L30 s30 20 12e-4
VS31 5 s31 0
V31 e31 s31 DC 0 AC 47e-1 -120
RI31 e31 m31 18e-1
LI31 m31 13 27e-5
VS32 14 s32 0
R32 s32 0 47e0
VS33 16 s33 0
C33 s33 21 39e-6
VS34 23 s34 0
R34 s34 19 12e3
VS35 11 s35 0
L35 s35 20 56e-3
VS36 23 s36 0
L36 s36 1 22e-5
VS37 12 s37 0
C37 s37 2 56e-5
VS38 18 s38 0
C38 s38 22 18e-6
.control
set numdgt=17
ac lin 1 60 60
print v(1) v(2) v(3) v(4) v(5) v(6) v(7) v(8) v(9) v(10)
print v(11) v(12) v(13) v(14) v(15) v(16) v(17) v(18) v(19) v(20)
print v(21) v(22) v(23)
print i(vs0) i(vs1) i(vs2) i(vs3) i(vs4) i(vs5) i(vs6) i(vs7) i(vs8) i(vs9)
print i(vs10) i(vs11) i(vs12) i(vs13) i(vs14) i(vs15) i(vs16) i(vs17) i(vs18) i(vs19)
print i(vs20) i(vs21) i(vs22) i(vs23) i(vs24) i(vs25) i(vs26) i(vs27) i(vs28) i(vs29)
print i(vs30) i(vs31) i(vs32) i(vs33) i(vs34) i(vs35) i(vs36) i(vs37) i(vs38)
.endc
.end
