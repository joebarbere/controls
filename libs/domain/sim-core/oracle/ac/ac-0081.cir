controls oracle ac-0081
* Generated (plan F2.7, ADR 0012): do not edit; regenerate with `pnpm sim oracle regen`. ac seed 20261031 index 81 nodes 24 elements 41
.options sparse gmin=1e-12 noopac
RG1 1 0 1000000000000
RG2 2 0 1000000000000
RG3 3 0 1000000000000
RG4 4 0 1000000000000
RG5 5 0 1000000000000
RG6 6 0 1000000000000
RG7 7 0 1000000000000
RG8 8 0 1000000000000
RG9 9 0 1000000000000
RG10 10 0 1000000000000
RG11 11 0 1000000000000
RG12 12 0 1000000000000
RG13 13 0 1000000000000
RG14 14 0 1000000000000
RG15 15 0 1000000000000
RG16 16 0 1000000000000
RG17 17 0 1000000000000
RG18 18 0 1000000000000
RG19 19 0 1000000000000
RG20 20 0 1000000000000
RG21 21 0 1000000000000
RG22 22 0 1000000000000
RG23 23 0 1000000000000
VS0 2 s0 0
R0 s0 21 15e-2
VS1 17 s1 0
L1 s1 2 33e-2
VS2 0 s2 0
L2 s2 6 39e-3
VS3 0 s3 0
C3 s3 10 27e-7
VS4 0 s4 0
V4 e4 s4 DC 0 AC 10e1 180
RI4 e4 m4 56e-2
LI4 m4 20 22e-6
VS5 20 s5 0
C5 s5 3 47e-7
VS6 18 s6 0
R6 s6 10 27e-2
VS7 3 s7 0
C7 s7 23 68e-5
VS8 9 s8 0
R8 s8 22 33e2
VS9 22 s9 0
L9 s9 12 56e-4
VS10 20 s10 0
C10 s10 1 18e-7
VS11 15 s11 0
R11 s11 2 22e-1
VS12 21 s12 0
R12 s12 3 18e-1
VS13 2 s13 0
R13 s13 9 15e3
VS14 2 s14 0
L14 s14 16 18e-4
VS15 11 s15 0
C15 s15 16 12e-4
VS16 3 s16 0
L16 s16 0 18e-4
VS17 16 s17 0
L17 s17 10 18e-2
VS18 7 s18 0
C18 s18 8 15e-5
VS19 6 s19 0
C19 s19 4 39e-4
VS20 11 s20 0
V20 e20 s20 DC 0 AC 56e0 180
RI20 e20 14 22e-1
VS21 20 s21 0
L21 s21 23 82e-4
VS22 8 s22 0
V22 e22 s22 DC 0 AC 15e0 0
RI22 e22 m22 39e-1
LI22 m22 11 47e-5
VS23 8 s23 0
C23 s23 17 39e-5
VS24 11 s24 0
L24 s24 5 47e-3
VS25 0 s25 0
C25 s25 7 82e-7
VS26 5 s26 0
R26 s26 4 68e1
VS27 12 s27 0
V27 e27 s27 DC 0 AC 12e-1 180
RI27 e27 m27 27e-2
LI27 m27 23 47e-7
VS28 13 s28 0
V28 e28 s28 DC 0 AC 39e0 180
RI28 e28 m28 47e-2
LI28 m28 8 15e-7
VS29 9 s29 0
C29 s29 3 22e-6
VS30 3 s30 0
L30 s30 4 39e-2
VS31 13 s31 0
C31 s31 12 27e-6
VS32 14 s32 0
L32 s32 9 47e-2
VS33 23 s33 0
R33 s33 19 12e3
VS34 11 s34 0
V34 e34 s34 DC 0 AC 56e1 0
RI34 e34 m34 33e-1
LI34 m34 19 12e-7
VS35 20 s35 0
C35 s35 2 12e-4
VS36 16 s36 0
L36 s36 19 18e-4
VS37 1 s37 0
C37 s37 2 27e-6
VS38 16 s38 0
C38 s38 15 47e-7
VS39 14 s39 0
R39 s39 18 18e-2
VS40 12 s40 0
L40 s40 3 82e-4
.control
set numdgt=17
ac lin 1 60 60
print v(1) v(2) v(3) v(4) v(5) v(6) v(7) v(8) v(9) v(10)
print v(11) v(12) v(13) v(14) v(15) v(16) v(17) v(18) v(19) v(20)
print v(21) v(22) v(23)
print i(vs0) i(vs1) i(vs2) i(vs3) i(vs4) i(vs5) i(vs6) i(vs7) i(vs8) i(vs9)
print i(vs10) i(vs11) i(vs12) i(vs13) i(vs14) i(vs15) i(vs16) i(vs17) i(vs18) i(vs19)
print i(vs20) i(vs21) i(vs22) i(vs23) i(vs24) i(vs25) i(vs26) i(vs27) i(vs28) i(vs29)
print i(vs30) i(vs31) i(vs32) i(vs33) i(vs34) i(vs35) i(vs36) i(vs37) i(vs38) i(vs39)
print i(vs40)
.endc
.end
