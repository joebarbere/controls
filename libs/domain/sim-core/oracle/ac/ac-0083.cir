controls oracle ac-0083
* Generated (plan F2.7, ADR 0012): do not edit; regenerate with `pnpm sim oracle regen`. ac seed 20261031 index 83 nodes 2 elements 3
.options sparse gmin=1e-12 noopac
RG1 1 0 1000000000000
VS0 0 s0 0
V0 e0 s0 DC 0 AC 15e-1 0
RI0 e0 m0 82e-2
LI0 m0 1 39e-5
VS1 0 s1 0
C1 s1 1 56e-4
VS2 1 s2 0
C2 s2 0 82e-5
.control
set numdgt=17
ac lin 1 60 60
print v(1)
print i(vs0) i(vs1) i(vs2)
.endc
.end
