controls oracle ac-0038
* Generated (plan F2.7, ADR 0012): do not edit; regenerate with `pnpm sim oracle regen`. ac seed 20261031 index 38 nodes 29 elements 50
.options sparse gmin=1e-12 noopac
RG1 1 0 1000000000000
RG2 2 0 1000000000000
RG3 3 0 1000000000000
RG4 4 0 1000000000000
RG5 5 0 1000000000000
RG6 6 0 1000000000000
RG7 7 0 1000000000000
RG8 8 0 1000000000000
RG9 9 0 1000000000000
RG10 10 0 1000000000000
RG11 11 0 1000000000000
RG12 12 0 1000000000000
RG13 13 0 1000000000000
RG14 14 0 1000000000000
RG15 15 0 1000000000000
RG16 16 0 1000000000000
RG17 17 0 1000000000000
RG18 18 0 1000000000000
RG19 19 0 1000000000000
RG20 20 0 1000000000000
RG21 21 0 1000000000000
RG22 22 0 1000000000000
RG23 23 0 1000000000000
RG24 24 0 1000000000000
RG25 25 0 1000000000000
RG26 26 0 1000000000000
RG27 27 0 1000000000000
RG28 28 0 1000000000000
VS0 5 s0 0
R0 s0 11 15e2
VS1 16 s1 0
L1 s1 7 27e-4
VS2 9 s2 0
R2 s2 2 82e2
VS3 0 s3 0
V3 e3 s3 DC 0 AC 22e-1 120
RI3 e3 12 33e-2
VS4 17 s4 0
C4 s4 13 33e-4
VS5 21 s5 0
L5 s5 17 39e-5
VS6 11 s6 0
R6 s6 4 47e-1
VS7 20 s7 0
L7 s7 16 18e-4
VS8 20 s8 0
L8 s8 11 68e-2
VS9 6 s9 0
V9 e9 s9 DC 0 AC 39e0 120
RI9 e9 m9 47e-2
LI9 m9 27 12e-7
VS10 10 s10 0
L10 s10 22 22e-3
VS11 6 s11 0
C11 s11 25 39e-7
VS12 19 s12 0
R12 s12 10 56e0
VS13 27 s13 0
C13 s13 13 82e-6
VS14 25 s14 0
C14 s14 26 33e-7
VS15 5 s15 0
C15 s15 13 10e-4
VS16 20 s16 0
C16 s16 22 68e-7
VS17 8 s17 0
R17 s17 28 12e-1
VS18 5 s18 0
L18 s18 8 18e-3
VS19 20 s19 0
C19 s19 13 12e-4
VS20 24 s20 0
R20 s20 1 39e1
VS21 1 s21 0
V21 e21 s21 DC 0 AC 39e0 -120
RI21 e21 22 12e-3
VS22 14 s22 0
R22 s22 23 12e3
VS23 18 s23 0
C23 s23 3 82e-7
VS24 12 s24 0
L24 s24 26 47e-5
VS25 19 s25 0
C25 s25 13 15e-4
VS26 16 s26 0
C26 s26 6 68e-5
VS27 0 s27 0
V27 e27 s27 DC 0 AC 10e0 180
RI27 e27 m27 68e-1
LI27 m27 4 39e-5
VS28 19 s28 0
R28 s28 12 18e-1
VS29 27 s29 0
R29 s29 15 15e3
VS30 4 s30 0
L30 s30 11 10e-2
VS31 15 s31 0
C31 s31 7 12e-6
VS32 21 s32 0
R32 s32 0 18e-1
VS33 12 s33 0
R33 s33 15 15e2
VS34 14 s34 0
L34 s34 2 68e-5
VS35 10 s35 0
R35 s35 2 33e-2
VS36 26 s36 0
R36 s36 19 68e-1
VS37 27 s37 0
L37 s37 21 33e-2
VS38 7 s38 0
L38 s38 23 39e-4
VS39 17 s39 0
V39 e39 s39 DC 0 AC 68e1 120
RI39 e39 6 68e-2
VS40 6 s40 0
L40 s40 28 39e-3
VS41 22 s41 0
V41 e41 s41 DC 0 AC 12e-1 180
RI41 e41 14 56e-2
VS42 18 s42 0
L42 s42 19 18e-4
VS43 10 s43 0
R43 s43 3 12e2
VS44 8 s44 0
R44 s44 28 27e2
VS45 7 s45 0
L45 s45 4 12e-2
VS46 8 s46 0
L46 s46 13 56e-4
VS47 15 s47 0
R47 s47 24 82e0
VS48 18 s48 0
L48 s48 9 27e-3
VS49 3 s49 0
R49 s49 23 47e3
.control
set numdgt=17
ac lin 1 60 60
print v(1) v(2) v(3) v(4) v(5) v(6) v(7) v(8) v(9) v(10)
print v(11) v(12) v(13) v(14) v(15) v(16) v(17) v(18) v(19) v(20)
print v(21) v(22) v(23) v(24) v(25) v(26) v(27) v(28)
print i(vs0) i(vs1) i(vs2) i(vs3) i(vs4) i(vs5) i(vs6) i(vs7) i(vs8) i(vs9)
print i(vs10) i(vs11) i(vs12) i(vs13) i(vs14) i(vs15) i(vs16) i(vs17) i(vs18) i(vs19)
print i(vs20) i(vs21) i(vs22) i(vs23) i(vs24) i(vs25) i(vs26) i(vs27) i(vs28) i(vs29)
print i(vs30) i(vs31) i(vs32) i(vs33) i(vs34) i(vs35) i(vs36) i(vs37) i(vs38) i(vs39)
print i(vs40) i(vs41) i(vs42) i(vs43) i(vs44) i(vs45) i(vs46) i(vs47) i(vs48) i(vs49)
.endc
.end
