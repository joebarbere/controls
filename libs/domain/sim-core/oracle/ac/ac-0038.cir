controls oracle ac-0038
* Generated (plan F2.7, ADR 0012): do not edit; regenerate with `pnpm sim oracle regen`. ac seed 20261031 index 38 nodes 29 elements 45
.options sparse gmin=1e-12 noopac
RG1 1 0 1000000000000
RG2 2 0 1000000000000
RG3 3 0 1000000000000
RG4 4 0 1000000000000
RG5 5 0 1000000000000
RG6 6 0 1000000000000
RG7 7 0 1000000000000
RG8 8 0 1000000000000
RG9 9 0 1000000000000
RG10 10 0 1000000000000
RG11 11 0 1000000000000
RG12 12 0 1000000000000
RG13 13 0 1000000000000
RG14 14 0 1000000000000
RG15 15 0 1000000000000
RG16 16 0 1000000000000
RG17 17 0 1000000000000
RG18 18 0 1000000000000
RG19 19 0 1000000000000
RG20 20 0 1000000000000
RG21 21 0 1000000000000
RG22 22 0 1000000000000
RG23 23 0 1000000000000
RG24 24 0 1000000000000
RG25 25 0 1000000000000
RG26 26 0 1000000000000
RG27 27 0 1000000000000
RG28 28 0 1000000000000
VS0 13 s0 0
R0 s0 4 33e0
VS1 23 s1 0
L1 s1 5 10e-2
VS2 8 s2 0
L2 s2 10 68e-5
VS3 17 s3 0
C3 s3 18 18e-6
VS4 12 s4 0
R4 s4 15 15e2
VS5 6 s5 0
R5 s5 15 15e3
VS6 14 s6 0
L6 s6 22 10e-2
VS7 12 s7 0
R7 s7 1 27e2
VS8 2 s8 0
R8 s8 10 68e0
VS9 27 s9 0
R9 s9 5 56e2
VS10 25 s10 0
R10 s10 24 12e0
VS11 0 s11 0
V11 e11 s11 DC 0 AC 39e0 120
RI11 e11 m11 47e-2
LI11 m11 6 10e-7
VS12 27 s12 0
L12 s12 28 10e-4
VS13 18 s13 0
L13 s13 19 18e-4
VS14 19 s14 0
R14 s14 12 18e-1
VS15 14 s15 0
R15 s15 20 27e1
VS16 11 s16 0
L16 s16 3 27e-2
VS17 21 s17 0
L17 s17 8 27e-4
VS18 5 s18 0
L18 s18 20 33e-3
VS19 16 s19 0
C19 s19 1 82e-7
VS20 19 s20 0
R20 s20 16 10e-2
VS21 3 s21 0
C21 s21 19 15e-5
VS22 15 s22 0
C22 s22 7 12e-6
VS23 12 s23 0
L23 s23 26 47e-5
VS24 12 s24 0
R24 s24 23 68e3
VS25 11 s25 0
V25 e25 s25 DC 0 AC 82e1 -120
RI25 e25 25 18e-2
VS26 0 s26 0
R26 s26 3 82e1
VS27 5 s27 0
L27 s27 8 18e-3
VS28 7 s28 0
R28 s28 17 56e3
VS29 19 s29 0
R29 s29 10 56e0
VS30 6 s30 0
L30 s30 21 33e-2
VS31 10 s31 0
L31 s31 22 22e-3
VS32 25 s32 0
C32 s32 26 33e-7
VS33 16 s33 0
L33 s33 5 15e-3
VS34 9 s34 0
C34 s34 23 33e-7
VS35 9 s35 0
R35 s35 4 82e3
VS36 8 s36 0
L36 s36 13 56e-4
VS37 5 s37 0
L37 s37 23 39e-4
VS38 24 s38 0
R38 s38 28 12e3
VS39 7 s39 0
R39 s39 11 39e3
VS40 6 s40 0
L40 s40 4 22e-5
VS41 8 s41 0
R41 s41 28 27e2
VS42 6 s42 0
C42 s42 13 82e-6
VS43 2 s43 0
L43 s43 13 15e-2
VS44 25 s44 0
L44 s44 14 27e-5
.control
set numdgt=17
ac lin 1 60 60
print v(1) v(2) v(3) v(4) v(5) v(6) v(7) v(8) v(9) v(10)
print v(11) v(12) v(13) v(14) v(15) v(16) v(17) v(18) v(19) v(20)
print v(21) v(22) v(23) v(24) v(25) v(26) v(27) v(28)
print i(vs0) i(vs1) i(vs2) i(vs3) i(vs4) i(vs5) i(vs6) i(vs7) i(vs8) i(vs9)
print i(vs10) i(vs11) i(vs12) i(vs13) i(vs14) i(vs15) i(vs16) i(vs17) i(vs18) i(vs19)
print i(vs20) i(vs21) i(vs22) i(vs23) i(vs24) i(vs25) i(vs26) i(vs27) i(vs28) i(vs29)
print i(vs30) i(vs31) i(vs32) i(vs33) i(vs34) i(vs35) i(vs36) i(vs37) i(vs38) i(vs39)
print i(vs40) i(vs41) i(vs42) i(vs43) i(vs44)
.endc
.end
