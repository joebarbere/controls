controls oracle ac-0038
* Generated (plan F2.7, ADR 0012): do not edit; regenerate with `pnpm sim oracle regen`. ac seed 20261031 index 38 nodes 29 elements 37
.options sparse gmin=1e-12 noopac
RG1 1 0 1000000000000
RG2 2 0 1000000000000
RG3 3 0 1000000000000
RG4 4 0 1000000000000
RG5 5 0 1000000000000
RG6 6 0 1000000000000
RG7 7 0 1000000000000
RG8 8 0 1000000000000
RG9 9 0 1000000000000
RG10 10 0 1000000000000
RG11 11 0 1000000000000
RG12 12 0 1000000000000
RG13 13 0 1000000000000
RG14 14 0 1000000000000
RG15 15 0 1000000000000
RG16 16 0 1000000000000
RG17 17 0 1000000000000
RG18 18 0 1000000000000
RG19 19 0 1000000000000
RG20 20 0 1000000000000
RG21 21 0 1000000000000
RG22 22 0 1000000000000
RG23 23 0 1000000000000
RG24 24 0 1000000000000
RG25 25 0 1000000000000
RG26 26 0 1000000000000
RG27 27 0 1000000000000
RG28 28 0 1000000000000
VS0 9 s0 0
R0 s0 4 82e3
VS1 14 s1 0
L1 s1 22 10e-2
VS2 8 s2 0
L2 s2 13 56e-4
VS3 7 s3 0
R3 s3 0 39e3
VS4 15 s4 0
C4 s4 7 12e-6
VS5 5 s5 0
L5 s5 8 18e-3
VS6 6 s6 0
R6 s6 3 82e1
VS7 3 s7 0
C7 s7 19 15e-5
VS8 25 s8 0
C8 s8 26 33e-7
VS9 7 s9 0
R9 s9 17 56e3
VS10 23 s10 0
L10 s10 5 10e-2
VS11 8 s11 0
L11 s11 10 68e-5
VS12 0 s12 0
L12 s12 3 27e-2
VS13 12 s13 0
R13 s13 23 68e3
VS14 12 s14 0
L14 s14 26 47e-5
VS15 16 s15 0
L15 s15 5 15e-3
VS16 12 s16 0
R16 s16 15 15e2
VS17 19 s17 0
R17 s17 12 18e-1
VS18 11 s18 0
R18 s18 15 15e3
VS19 8 s19 0
R19 s19 28 27e2
VS20 2 s20 0
R20 s20 10 68e0
VS21 27 s21 0
L21 s21 28 10e-4
VS22 17 s22 0
C22 s22 18 18e-6
VS23 5 s23 0
L23 s23 23 39e-4
VS24 11 s24 0
C24 s24 13 82e-6
VS25 0 s25 0
V25 e25 s25 DC 0 AC 82e1 -120
RI25 e25 25 18e-2
VS26 11 s26 0
L26 s26 4 22e-5
VS27 5 s27 0
L27 s27 20 33e-3
VS28 18 s28 0
L28 s28 19 18e-4
VS29 6 s29 0
V29 e29 s29 DC 0 AC 39e0 120
RI29 e29 11 47e-2
VS30 19 s30 0
R30 s30 10 56e0
VS31 12 s31 0
R31 s31 1 27e2
VS32 19 s32 0
R32 s32 16 10e-2
VS33 11 s33 0
L33 s33 21 33e-2
VS34 10 s34 0
L34 s34 22 22e-3
VS35 24 s35 0
R35 s35 28 12e3
VS36 13 s36 0
R36 s36 4 33e0
.control
set numdgt=17
ac lin 1 60 60
print v(1) v(2) v(3) v(4) v(5) v(6) v(7) v(8) v(9) v(10)
print v(11) v(12) v(13) v(14) v(15) v(16) v(17) v(18) v(19) v(20)
print v(21) v(22) v(23) v(24) v(25) v(26) v(27) v(28)
print i(vs0) i(vs1) i(vs2) i(vs3) i(vs4) i(vs5) i(vs6) i(vs7) i(vs8) i(vs9)
print i(vs10) i(vs11) i(vs12) i(vs13) i(vs14) i(vs15) i(vs16) i(vs17) i(vs18) i(vs19)
print i(vs20) i(vs21) i(vs22) i(vs23) i(vs24) i(vs25) i(vs26) i(vs27) i(vs28) i(vs29)
print i(vs30) i(vs31) i(vs32) i(vs33) i(vs34) i(vs35) i(vs36)
.endc
.end
