controls oracle ac-0139
* Generated (plan F2.7, ADR 0012): do not edit; regenerate with `pnpm sim oracle regen`. ac seed 20261031 index 139 nodes 18 elements 33
.options sparse gmin=1e-12 noopac
RG1 1 0 1000000000000
RG2 2 0 1000000000000
RG3 3 0 1000000000000
RG4 4 0 1000000000000
RG5 5 0 1000000000000
RG6 6 0 1000000000000
RG7 7 0 1000000000000
RG8 8 0 1000000000000
RG9 9 0 1000000000000
RG10 10 0 1000000000000
RG11 11 0 1000000000000
RG12 12 0 1000000000000
RG13 13 0 1000000000000
RG14 14 0 1000000000000
RG15 15 0 1000000000000
RG16 16 0 1000000000000
RG17 17 0 1000000000000
VS0 11 s0 0
L0 s0 3 27e-3
VS1 4 s1 0
R1 s1 0 15e2
VS2 15 s2 0
L2 s2 1 33e-4
VS3 15 s3 0
R3 s3 11 39e-1
VS4 2 s4 0
L4 s4 3 12e-3
VS5 16 s5 0
R5 s5 13 15e0
VS6 11 s6 0
R6 s6 1 10e0
VS7 1 s7 0
L7 s7 6 15e-4
VS8 3 s8 0
R8 s8 0 33e-1
VS9 16 s9 0
C9 s9 1 12e-6
VS10 0 s10 0
V10 e10 s10 DC 0 AC 22e0 -120
RI10 e10 n10 15e-2
H10 n10 h10 VS12 -10e-4
ED10 h10 12 d10 0 -27e-7
F10 0 d10 VS12 1
LD10 d10 0 1
VS11 12 s11 0
C11 s11 2 12e-7
VS12 6 s12 0
V12 e12 s12 DC 0 AC 22e0 180
RI12 e12 n12 22e-3
H12 n12 h12 VS10 -10e-4
ED12 h12 13 d12 0 -27e-7
F12 0 d12 VS10 1
LD12 d12 0 1
VS13 7 s13 0
R13 s13 0 68e0
VS14 14 s14 0
V14 e14 s14 DC 0 AC 56e0 120
RI14 e14 0 27e-3
VS15 17 s15 0
R15 s15 7 56e1
VS16 10 s16 0
R16 s16 6 10e1
VS17 0 s17 0
L17 s17 2 18e-2
VS18 2 s18 0
C18 s18 9 18e-7
VS19 3 s19 0
L19 s19 5 56e-4
VS20 6 s20 0
V20 e20 s20 DC 0 AC 82e0 120
RI20 e20 3 22e-2
VS21 0 s21 0
V21 e21 s21 DC 0 AC 82e-1 0
RI21 e21 10 68e-3
VS22 0 s22 0
R22 s22 7 39e-1
VS23 16 s23 0
L23 s23 4 39e-5
VS24 8 s24 0
R24 s24 12 27e-1
VS25 15 s25 0
L25 s25 14 22e-3
VS26 8 s26 0
C26 s26 14 68e-4
VS27 4 s27 0
L27 s27 10 33e-3
VS28 13 s28 0
R28 s28 5 68e3
VS29 3 s29 0
L29 s29 9 22e-5
VS30 2 s30 0
C30 s30 17 10e-6
VS31 9 s31 0
C31 s31 11 12e-7
VS32 12 s32 0
V32 e32 s32 DC 0 AC 33e0 180
RI32 e32 10 10e-1
.control
set numdgt=17
ac lin 1 60 60
print v(1) v(2) v(3) v(4) v(5) v(6) v(7) v(8) v(9) v(10)
print v(11) v(12) v(13) v(14) v(15) v(16) v(17)
print i(vs0) i(vs1) i(vs2) i(vs3) i(vs4) i(vs5) i(vs6) i(vs7) i(vs8) i(vs9)
print i(vs10) i(vs11) i(vs12) i(vs13) i(vs14) i(vs15) i(vs16) i(vs17) i(vs18) i(vs19)
print i(vs20) i(vs21) i(vs22) i(vs23) i(vs24) i(vs25) i(vs26) i(vs27) i(vs28) i(vs29)
print i(vs30) i(vs31) i(vs32)
.endc
.end
