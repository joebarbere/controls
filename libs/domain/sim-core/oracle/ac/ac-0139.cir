controls oracle ac-0139
* Generated (plan F2.7, ADR 0012): do not edit; regenerate with `pnpm sim oracle regen`. ac seed 20261031 index 139 nodes 18 elements 32
.options sparse gmin=1e-12 noopac
RG1 1 0 1000000000000
RG2 2 0 1000000000000
RG3 3 0 1000000000000
RG4 4 0 1000000000000
RG5 5 0 1000000000000
RG6 6 0 1000000000000
RG7 7 0 1000000000000
RG8 8 0 1000000000000
RG9 9 0 1000000000000
RG10 10 0 1000000000000
RG11 11 0 1000000000000
RG12 12 0 1000000000000
RG13 13 0 1000000000000
RG14 14 0 1000000000000
RG15 15 0 1000000000000
RG16 16 0 1000000000000
RG17 17 0 1000000000000
VS0 0 s0 0
V0 e0 s0 DC 0 AC 68e0 180
RI0 e0 m0 15e-3
LI0 m0 13 12e-5
VS1 2 s1 0
L1 s1 14 12e-3
VS2 17 s2 0
R2 s2 8 47e3
VS3 9 s3 0
R3 s3 15 68e3
VS4 11 s4 0
R4 s4 2 39e1
VS5 5 s5 0
V5 e5 s5 DC 0 AC 12e1 180
RI5 e5 m5 33e-2
LI5 m5 2 68e-7
VS6 2 s6 0
R6 s6 4 15e-1
VS7 6 s7 0
C7 s7 7 39e-7
VS8 16 s8 0
C8 s8 1 12e-6
VS9 14 s9 0
V9 e9 s9 DC 0 AC 33e1 0
RI9 e9 m9 33e-2
LI9 m9 7 33e-6
VS10 15 s10 0
R10 s10 11 27e-1
VS11 17 s11 0
R11 s11 14 18e-2
VS12 17 s12 0
V12 e12 s12 DC 0 AC 27e-1 -120
RI12 e12 m12 22e-2
LI12 m12 6 56e-6
VS13 1 s13 0
R13 s13 5 82e-2
VS14 12 s14 0
V14 e14 s14 DC 0 AC 33e0 180
RI14 e14 m14 10e-1
LI14 m14 10 18e-5
VS15 2 s15 0
R15 s15 12 22e3
VS16 16 s16 0
L16 s16 14 47e-5
VS17 3 s17 0
L17 s17 13 15e-3
VS18 1 s18 0
R18 s18 6 22e-2
VS19 3 s19 0
L19 s19 2 18e-2
VS20 14 s20 0
R20 s20 0 68e2
VS21 9 s21 0
R21 s21 1 33e1
VS22 15 s22 0
L22 s22 12 15e-4
VS23 12 s23 0
L23 s23 13 56e-3
VS24 3 s24 0
V24 e24 s24 DC 0 AC 82e-1 0
RI24 e24 m24 68e-3
LI24 m24 10 22e-6
VS25 17 s25 0
R25 s25 6 82e-1
VS26 16 s26 0
C26 s26 15 39e-7
VS27 4 s27 0
R27 s27 1 39e3
VS28 14 s28 0
R28 s28 0 33e-1
VS29 7 s29 0
R29 s29 2 68e2
VS30 0 s30 0
R30 s30 15 56e0
VS31 12 s31 0
L31 s31 8 56e-5
.control
set numdgt=17
ac lin 1 60 60
print v(1) v(2) v(3) v(4) v(5) v(6) v(7) v(8) v(9) v(10)
print v(11) v(12) v(13) v(14) v(15) v(16) v(17)
print i(vs0) i(vs1) i(vs2) i(vs3) i(vs4) i(vs5) i(vs6) i(vs7) i(vs8) i(vs9)
print i(vs10) i(vs11) i(vs12) i(vs13) i(vs14) i(vs15) i(vs16) i(vs17) i(vs18) i(vs19)
print i(vs20) i(vs21) i(vs22) i(vs23) i(vs24) i(vs25) i(vs26) i(vs27) i(vs28) i(vs29)
print i(vs30) i(vs31)
.endc
.end
