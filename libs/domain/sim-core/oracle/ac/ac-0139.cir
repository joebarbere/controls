controls oracle ac-0139
* Generated (plan F2.7, ADR 0012): do not edit; regenerate with `pnpm sim oracle regen`. ac seed 20261031 index 139 nodes 18 elements 30
.options sparse gmin=1e-12 noopac
RG1 1 0 1000000000000
RG2 2 0 1000000000000
RG3 3 0 1000000000000
RG4 4 0 1000000000000
RG5 5 0 1000000000000
RG6 6 0 1000000000000
RG7 7 0 1000000000000
RG8 8 0 1000000000000
RG9 9 0 1000000000000
RG10 10 0 1000000000000
RG11 11 0 1000000000000
RG12 12 0 1000000000000
RG13 13 0 1000000000000
RG14 14 0 1000000000000
RG15 15 0 1000000000000
RG16 16 0 1000000000000
RG17 17 0 1000000000000
VS0 0 s0 0
V0 e0 s0 DC 0 AC 82e-1 0
RI0 e0 10 68e-3
VS1 16 s1 0
C1 s1 1 12e-6
VS2 3 s2 0
L2 s2 5 56e-4
VS3 2 s3 0
L3 s3 3 12e-3
VS4 2 s4 0
C4 s4 17 10e-6
VS5 11 s5 0
L5 s5 3 27e-3
VS6 16 s6 0
L6 s6 4 39e-5
VS7 14 s7 0
V7 e7 s7 DC 0 AC 56e0 120
RI7 e7 0 27e-3
VS8 15 s8 0
L8 s8 1 33e-4
VS9 9 s9 0
C9 s9 11 12e-7
VS10 15 s10 0
L10 s10 14 22e-3
VS11 7 s11 0
R11 s11 0 68e0
VS12 4 s12 0
L12 s12 10 33e-3
VS13 12 s13 0
V13 e13 s13 DC 0 AC 33e0 180
RI13 e13 10 10e-1
VS14 4 s14 0
R14 s14 0 15e2
VS15 0 s15 0
R15 s15 7 39e-1
VS16 2 s16 0
C16 s16 9 18e-7
VS17 0 s17 0
L17 s17 2 18e-2
VS18 3 s18 0
L18 s18 9 22e-5
VS19 8 s19 0
C19 s19 14 68e-4
VS20 16 s20 0
R20 s20 13 15e0
VS21 0 s21 0
V21 e21 s21 DC 0 AC 22e0 -120
RI21 e21 12 15e-2
VS22 10 s22 0
R22 s22 6 10e1
VS23 17 s23 0
R23 s23 7 56e1
VS24 15 s24 0
R24 s24 11 39e-1
VS25 1 s25 0
L25 s25 6 15e-4
VS26 12 s26 0
C26 s26 2 12e-7
VS27 11 s27 0
R27 s27 1 10e0
VS28 6 s28 0
V28 e28 s28 DC 0 AC 82e0 120
RI28 e28 3 22e-2
VS29 3 s29 0
R29 s29 0 33e-1
.control
set numdgt=17
ac lin 1 60 60
print v(1) v(2) v(3) v(4) v(5) v(6) v(7) v(8) v(9) v(10)
print v(11) v(12) v(13) v(14) v(15) v(16) v(17)
print i(vs0) i(vs1) i(vs2) i(vs3) i(vs4) i(vs5) i(vs6) i(vs7) i(vs8) i(vs9)
print i(vs10) i(vs11) i(vs12) i(vs13) i(vs14) i(vs15) i(vs16) i(vs17) i(vs18) i(vs19)
print i(vs20) i(vs21) i(vs22) i(vs23) i(vs24) i(vs25) i(vs26) i(vs27) i(vs28) i(vs29)
.endc
.end
