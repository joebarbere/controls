controls oracle ac-0117
* Generated (plan F2.7, ADR 0012): do not edit; regenerate with `pnpm sim oracle regen`. ac seed 20261031 index 117 nodes 6 elements 6
.options sparse gmin=1e-12 noopac
RG1 1 0 1000000000000
RG2 2 0 1000000000000
RG3 3 0 1000000000000
RG4 4 0 1000000000000
RG5 5 0 1000000000000
VS0 2 s0 0
R0 s0 1 22e-2
VS1 4 s1 0
R1 s1 5 82e-2
VS2 0 s2 0
V2 e2 s2 DC 0 AC 22e0 0
RI2 e2 5 12e-2
VS3 0 s3 0
L3 s3 3 56e-4
VS4 3 s4 0
L4 s4 1 82e-4
VS5 2 s5 0
V5 e5 s5 DC 0 AC 10e0 -120
RI5 e5 4 68e-3
.control
set numdgt=17
ac lin 1 60 60
print v(1) v(2) v(3) v(4) v(5)
print i(vs0) i(vs1) i(vs2) i(vs3) i(vs4) i(vs5)
.endc
.end
