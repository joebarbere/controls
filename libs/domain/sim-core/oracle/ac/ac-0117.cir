controls oracle ac-0117
* Generated (plan F2.7, ADR 0012): do not edit; regenerate with `pnpm sim oracle regen`. ac seed 20261031 index 117 nodes 6 elements 11
.options sparse gmin=1e-12 noopac
RG1 1 0 1000000000000
RG2 2 0 1000000000000
RG3 3 0 1000000000000
RG4 4 0 1000000000000
RG5 5 0 1000000000000
VS0 0 s0 0
R0 s0 1 27e-2
VS1 0 s1 0
V1 e1 s1 DC 0 AC 22e0 0
RI1 e1 5 12e-2
VS2 2 s2 0
L2 s2 3 47e-4
VS3 4 s3 0
R3 s3 5 82e-2
VS4 3 s4 0
V4 e4 s4 DC 0 AC 27e-1 0
RI4 e4 1 22e-1
VS5 3 s5 0
R5 s5 1 82e1
VS6 4 s6 0
R6 s6 3 15e2
VS7 4 s7 0
R7 s7 5 56e2
VS8 2 s8 0
R8 s8 0 18e-1
VS9 3 s9 0
R9 s9 2 22e3
VS10 3 s10 0
R10 s10 0 56e-1
.control
set numdgt=17
ac lin 1 60 60
print v(1) v(2) v(3) v(4) v(5)
print i(vs0) i(vs1) i(vs2) i(vs3) i(vs4) i(vs5) i(vs6) i(vs7) i(vs8) i(vs9)
print i(vs10)
.endc
.end
