controls oracle ac-0117
* Generated (plan F2.7, ADR 0012): do not edit; regenerate with `pnpm sim oracle regen`. ac seed 20261031 index 117 nodes 6 elements 6
.options sparse gmin=1e-12 noopac
RG1 1 0 1000000000000
RG2 2 0 1000000000000
RG3 3 0 1000000000000
RG4 4 0 1000000000000
RG5 5 0 1000000000000
VS0 0 s0 0
V0 e0 s0 DC 0 AC 22e0 0
RI0 e0 5 12e-2
VS1 0 s1 0
L1 s1 3 56e-4
VS2 4 s2 0
R2 s2 5 82e-2
VS3 2 s3 0
V3 e3 s3 DC 0 AC 10e0 -120
RI3 e3 4 68e-3
VS4 5 s4 0
C4 s4 0 56e-5
VS5 3 s5 0
L5 s5 1 82e-4
.control
set numdgt=17
ac lin 1 60 60
print v(1) v(2) v(3) v(4) v(5)
print i(vs0) i(vs1) i(vs2) i(vs3) i(vs4) i(vs5)
.endc
.end
