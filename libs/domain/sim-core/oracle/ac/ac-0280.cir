controls oracle ac-0280
* Generated (plan F2.7, ADR 0012): do not edit; regenerate with `pnpm sim oracle regen`. ac seed 20261031 index 280 nodes 5 elements 5
.options sparse gmin=1e-12 noopac
RG1 1 0 1000000000000
RG2 2 0 1000000000000
RG3 3 0 1000000000000
RG4 4 0 1000000000000
VS0 0 s0 0
V0 e0 s0 DC 0 AC 10e0 120
RI0 e0 4 56e-3
VS1 1 s1 0
L1 s1 3 10e-5
VS2 4 s2 0
L2 s2 0 18e-5
VS3 0 s3 0
L3 s3 3 68e-3
VS4 4 s4 0
R4 s4 2 68e-2
.control
set numdgt=17
ac lin 1 60 60
print v(1) v(2) v(3) v(4)
print i(vs0) i(vs1) i(vs2) i(vs3) i(vs4)
.endc
.end
