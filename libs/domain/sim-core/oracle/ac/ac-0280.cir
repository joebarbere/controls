controls oracle ac-0280
* Generated (plan F2.7, ADR 0012): do not edit; regenerate with `pnpm sim oracle regen`. ac seed 20261031 index 280 nodes 5 elements 6
.options sparse gmin=1e-12 noopac
RG1 1 0 1000000000000
RG2 2 0 1000000000000
RG3 3 0 1000000000000
RG4 4 0 1000000000000
VS0 4 s0 0
L0 s0 0 18e-5
VS1 1 s1 0
L1 s1 2 22e-3
VS2 1 s2 0
L2 s2 3 10e-5
VS3 0 s3 0
V3 e3 s3 DC 0 AC 10e0 120
RI3 e3 4 56e-3
VS4 0 s4 0
L4 s4 3 68e-3
VS5 4 s5 0
R5 s5 2 68e-2
.control
set numdgt=17
ac lin 1 60 60
print v(1) v(2) v(3) v(4)
print i(vs0) i(vs1) i(vs2) i(vs3) i(vs4) i(vs5)
.endc
.end
