controls oracle ac-0230
* Generated (plan F2.7, ADR 0012): do not edit; regenerate with `pnpm sim oracle regen`. ac seed 20261031 index 230 nodes 16 elements 26
.options sparse gmin=1e-12 noopac
RG1 1 0 1000000000000
RG2 2 0 1000000000000
RG3 3 0 1000000000000
RG4 4 0 1000000000000
RG5 5 0 1000000000000
RG6 6 0 1000000000000
RG7 7 0 1000000000000
RG8 8 0 1000000000000
RG9 9 0 1000000000000
RG10 10 0 1000000000000
RG11 11 0 1000000000000
RG12 12 0 1000000000000
RG13 13 0 1000000000000
RG14 14 0 1000000000000
RG15 15 0 1000000000000
VS0 5 s0 0
R0 s0 11 27e3
VS1 3 s1 0
C1 s1 14 82e-4
VS2 10 s2 0
R2 s2 4 18e1
VS3 0 s3 0
L3 s3 11 68e-2
VS4 9 s4 0
L4 s4 15 47e-2
VS5 15 s5 0
R5 s5 12 22e1
VS6 7 s6 0
R6 s6 0 27e2
VS7 7 s7 0
L7 s7 9 56e-5
VS8 12 s8 0
C8 s8 7 15e-7
VS9 11 s9 0
L9 s9 8 56e-2
VS10 1 s10 0
R10 s10 9 39e-1
VS11 0 s11 0
C11 s11 6 39e-4
VS12 11 s12 0
L12 s12 14 33e-4
VS13 12 s13 0
R13 s13 10 39e2
VS14 11 s14 0
C14 s14 3 39e-6
VS15 10 s15 0
R15 s15 12 22e0
VS16 7 s16 0
L16 s16 12 18e-4
VS17 0 s17 0
V17 e17 s17 DC 0 AC 56e1 180
RI17 e17 2 22e-3
VS18 10 s18 0
C18 s18 8 12e-6
VS19 8 s19 0
R19 s19 15 10e3
VS20 2 s20 0
R20 s20 1 12e2
VS21 0 s21 0
R21 s21 7 39e3
VS22 1 s22 0
R22 s22 3 68e0
VS23 13 s23 0
R23 s23 15 12e0
VS24 10 s24 0
L24 s24 15 10e-2
VS25 10 s25 0
L25 s25 4 12e-4
.control
set numdgt=17
ac lin 1 60 60
print v(1) v(2) v(3) v(4) v(5) v(6) v(7) v(8) v(9) v(10)
print v(11) v(12) v(13) v(14) v(15)
print i(vs0) i(vs1) i(vs2) i(vs3) i(vs4) i(vs5) i(vs6) i(vs7) i(vs8) i(vs9)
print i(vs10) i(vs11) i(vs12) i(vs13) i(vs14) i(vs15) i(vs16) i(vs17) i(vs18) i(vs19)
print i(vs20) i(vs21) i(vs22) i(vs23) i(vs24) i(vs25)
.endc
.end
