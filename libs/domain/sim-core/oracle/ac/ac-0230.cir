controls oracle ac-0230
* Generated (plan F2.7, ADR 0012): do not edit; regenerate with `pnpm sim oracle regen`. ac seed 20261031 index 230 nodes 16 elements 22
.options sparse gmin=1e-12 noopac
RG1 1 0 1000000000000
RG2 2 0 1000000000000
RG3 3 0 1000000000000
RG4 4 0 1000000000000
RG5 5 0 1000000000000
RG6 6 0 1000000000000
RG7 7 0 1000000000000
RG8 8 0 1000000000000
RG9 9 0 1000000000000
RG10 10 0 1000000000000
RG11 11 0 1000000000000
RG12 12 0 1000000000000
RG13 13 0 1000000000000
RG14 14 0 1000000000000
RG15 15 0 1000000000000
VS0 7 s0 0
R0 s0 0 27e2
VS1 12 s1 0
C1 s1 3 27e-4
VS2 4 s2 0
R2 s2 0 18e2
VS3 5 s3 0
L3 s3 15 27e-2
VS4 9 s4 0
L4 s4 15 47e-2
VS5 5 s5 0
R5 s5 13 10e-1
VS6 13 s6 0
R6 s6 12 47e-1
VS7 0 s7 0
V7 e7 s7 DC 0 AC 56e1 180
RI7 e7 2 22e-3
VS8 8 s8 0
L8 s8 0 56e-3
VS9 7 s9 0
L9 s9 9 56e-5
VS10 10 s10 0
R10 s10 12 22e0
VS11 6 s11 0
C11 s11 3 39e-6
VS12 0 s12 0
L12 s12 11 68e-2
VS13 4 s13 0
V13 e13 s13 DC 0 AC 18e1 180
RI13 e13 m13 68e-1
LI13 m13 14 22e-5
VS14 11 s14 0
L14 s14 14 33e-4
VS15 10 s15 0
L15 s15 15 10e-2
VS16 8 s16 0
R16 s16 15 10e3
VS17 5 s17 0
R17 s17 12 82e-2
VS18 11 s18 0
C18 s18 3 39e-6
VS19 1 s19 0
R19 s19 9 39e-1
VS20 1 s20 0
L20 s20 4 68e-4
VS21 2 s21 0
L21 s21 6 15e-5
.control
set numdgt=17
ac lin 1 60 60
print v(1) v(2) v(3) v(4) v(5) v(6) v(7) v(8) v(9) v(10)
print v(11) v(12) v(13) v(14) v(15)
print i(vs0) i(vs1) i(vs2) i(vs3) i(vs4) i(vs5) i(vs6) i(vs7) i(vs8) i(vs9)
print i(vs10) i(vs11) i(vs12) i(vs13) i(vs14) i(vs15) i(vs16) i(vs17) i(vs18) i(vs19)
print i(vs20) i(vs21)
.endc
.end
