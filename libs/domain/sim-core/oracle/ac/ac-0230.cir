controls oracle ac-0230
* Generated (plan F2.7, ADR 0012): do not edit; regenerate with `pnpm sim oracle regen`. ac seed 20261031 index 230 nodes 16 elements 30
.options sparse gmin=1e-12 noopac
RG1 1 0 1000000000000
RG2 2 0 1000000000000
RG3 3 0 1000000000000
RG4 4 0 1000000000000
RG5 5 0 1000000000000
RG6 6 0 1000000000000
RG7 7 0 1000000000000
RG8 8 0 1000000000000
RG9 9 0 1000000000000
RG10 10 0 1000000000000
RG11 11 0 1000000000000
RG12 12 0 1000000000000
RG13 13 0 1000000000000
RG14 14 0 1000000000000
RG15 15 0 1000000000000
VS0 0 s0 0
V0 e0 s0 DC 0 AC 56e1 180
RI0 e0 m0 22e-3
LI0 m0 2 68e-6
VS1 10 s1 0
C1 s1 8 12e-6
VS2 9 s2 0
L2 s2 15 47e-2
VS3 10 s3 0
L3 s3 15 10e-2
VS4 0 s4 0
C4 s4 6 39e-4
VS5 0 s5 0
L5 s5 11 68e-2
VS6 11 s6 0
C6 s6 3 39e-6
VS7 10 s7 0
R7 s7 4 18e1
VS8 12 s8 0
C8 s8 7 15e-7
VS9 3 s9 0
C9 s9 14 82e-4
VS10 5 s10 0
C10 s10 8 12e-6
VS11 0 s11 0
R11 s11 7 39e3
VS12 8 s12 0
R12 s12 15 10e3
VS13 7 s13 0
R13 s13 0 27e2
VS14 7 s14 0
L14 s14 9 56e-5
VS15 10 s15 0
L15 s15 4 12e-4
VS16 4 s16 0
L16 s16 9 10e-4
VS17 5 s17 0
R17 s17 11 27e3
VS18 1 s18 0
R18 s18 9 39e-1
VS19 13 s19 0
R19 s19 4 39e3
VS20 13 s20 0
R20 s20 15 12e0
VS21 2 s21 0
R21 s21 1 12e2
VS22 9 s22 0
C22 s22 6 18e-7
VS23 7 s23 0
L23 s23 12 18e-4
VS24 12 s24 0
R24 s24 10 39e2
VS25 15 s25 0
R25 s25 12 22e1
VS26 11 s26 0
L26 s26 14 33e-4
VS27 11 s27 0
L27 s27 8 56e-2
VS28 1 s28 0
R28 s28 3 68e0
VS29 10 s29 0
R29 s29 12 22e0
.control
set numdgt=17
ac lin 1 60 60
print v(1) v(2) v(3) v(4) v(5) v(6) v(7) v(8) v(9) v(10)
print v(11) v(12) v(13) v(14) v(15)
print i(vs0) i(vs1) i(vs2) i(vs3) i(vs4) i(vs5) i(vs6) i(vs7) i(vs8) i(vs9)
print i(vs10) i(vs11) i(vs12) i(vs13) i(vs14) i(vs15) i(vs16) i(vs17) i(vs18) i(vs19)
print i(vs20) i(vs21) i(vs22) i(vs23) i(vs24) i(vs25) i(vs26) i(vs27) i(vs28) i(vs29)
.endc
.end
