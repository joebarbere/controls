controls oracle ac-0422
* Generated (plan F2.7, ADR 0012): do not edit; regenerate with `pnpm sim oracle regen`. ac seed 20261031 index 422 nodes 17 elements 28
.options sparse gmin=1e-12 noopac
RG1 1 0 1000000000000
RG2 2 0 1000000000000
RG3 3 0 1000000000000
RG4 4 0 1000000000000
RG5 5 0 1000000000000
RG6 6 0 1000000000000
RG7 7 0 1000000000000
RG8 8 0 1000000000000
RG9 9 0 1000000000000
RG10 10 0 1000000000000
RG11 11 0 1000000000000
RG12 12 0 1000000000000
RG13 13 0 1000000000000
RG14 14 0 1000000000000
RG15 15 0 1000000000000
RG16 16 0 1000000000000
VS0 13 s0 0
L0 s0 4 56e-4
VS1 12 s1 0
R1 s1 10 12e1
VS2 0 s2 0
V2 e2 s2 DC 0 AC 18e1 120
RI2 e2 15 12e-2
VS3 7 s3 0
C3 s3 3 18e-5
VS4 6 s4 0
V4 e4 s4 DC 0 AC 18e1 180
RI4 e4 8 18e-3
VS5 4 s5 0
L5 s5 5 68e-5
VS6 5 s6 0
R6 s6 16 22e-2
VS7 0 s7 0
V7 e7 s7 DC 0 AC 82e0 -120
RI7 e7 1 33e-3
VS8 6 s8 0
C8 s8 14 27e-5
VS9 0 s9 0
V9 e9 s9 DC 0 AC 47e0 120
RI9 e9 9 33e-3
VS10 11 s10 0
R10 s10 9 33e0
VS11 15 s11 0
C11 s11 0 47e-7
VS12 4 s12 0
C12 s12 6 15e-6
VS13 11 s13 0
R13 s13 5 68e0
VS14 6 s14 0
L14 s14 4 56e-2
VS15 8 s15 0
C15 s15 14 12e-4
VS16 16 s16 0
R16 s16 10 68e-2
VS17 13 s17 0
V17 e17 s17 DC 0 AC 82e-1 0
RI17 e17 10 33e-2
VS18 14 s18 0
L18 s18 16 68e-4
VS19 11 s19 0
R19 s19 4 47e-1
VS20 13 s20 0
C20 s20 16 27e-4
VS21 11 s21 0
L21 s21 2 10e-3
VS22 11 s22 0
V22 e22 s22 DC 0 AC 15e0 120
RI22 e22 7 47e-3
VS23 1 s23 0
L23 s23 16 47e-3
VS24 0 s24 0
C24 s24 7 56e-6
VS25 6 s25 0
V25 e25 s25 DC 0 AC 82e1 -120
RI25 e25 11 22e-1
VS26 4 s26 0
L26 s26 8 18e-2
VS27 13 s27 0
L27 s27 11 33e-3
.control
set numdgt=17
ac lin 1 60 60
print v(1) v(2) v(3) v(4) v(5) v(6) v(7) v(8) v(9) v(10)
print v(11) v(12) v(13) v(14) v(15) v(16)
print i(vs0) i(vs1) i(vs2) i(vs3) i(vs4) i(vs5) i(vs6) i(vs7) i(vs8) i(vs9)
print i(vs10) i(vs11) i(vs12) i(vs13) i(vs14) i(vs15) i(vs16) i(vs17) i(vs18) i(vs19)
print i(vs20) i(vs21) i(vs22) i(vs23) i(vs24) i(vs25) i(vs26) i(vs27)
.endc
.end
