controls oracle ac-0422
* Generated (plan F2.7, ADR 0012): do not edit; regenerate with `pnpm sim oracle regen`. ac seed 20261031 index 422 nodes 17 elements 32
.options sparse gmin=1e-12 noopac
RG1 1 0 1000000000000
RG2 2 0 1000000000000
RG3 3 0 1000000000000
RG4 4 0 1000000000000
RG5 5 0 1000000000000
RG6 6 0 1000000000000
RG7 7 0 1000000000000
RG8 8 0 1000000000000
RG9 9 0 1000000000000
RG10 10 0 1000000000000
RG11 11 0 1000000000000
RG12 12 0 1000000000000
RG13 13 0 1000000000000
RG14 14 0 1000000000000
RG15 15 0 1000000000000
RG16 16 0 1000000000000
VS0 15 s0 0
C0 s0 7 47e-7
VS1 16 s1 0
R1 s1 10 68e-2
VS2 5 s2 0
R2 s2 16 22e-2
VS3 11 s3 0
L3 s3 0 10e-3
VS4 0 s4 0
V4 e4 s4 DC 0 AC 10e-1 180
RI4 e4 1 82e-1
VS5 15 s5 0
R5 s5 14 12e-2
VS6 13 s6 0
L6 s6 11 33e-3
VS7 3 s7 0
L7 s7 12 56e-2
VS8 6 s8 0
V8 e8 s8 DC 0 AC 18e1 180
RI8 e8 8 18e-3
VS9 6 s9 0
V9 e9 s9 DC 0 AC 82e1 -120
RI9 e9 11 22e-1
VS10 1 s10 0
L10 s10 16 47e-3
VS11 11 s11 0
R11 s11 5 68e0
VS12 7 s12 0
C12 s12 2 56e-6
VS13 13 s13 0
V13 e13 s13 DC 0 AC 82e-1 0
RI13 e13 10 33e-2
VS14 7 s14 0
V14 e14 s14 DC 0 AC 82e0 -120
RI14 e14 1 33e-3
VS15 12 s15 0
L15 s15 2 39e-3
VS16 11 s16 0
R16 s16 9 33e0
VS17 8 s17 0
C17 s17 14 12e-4
VS18 6 s18 0
L18 s18 4 56e-2
VS19 4 s19 0
L19 s19 5 68e-5
VS20 6 s20 0
C20 s20 14 27e-5
VS21 4 s21 0
L21 s21 8 18e-2
VS22 13 s22 0
C22 s22 16 27e-4
VS23 11 s23 0
V23 e23 s23 DC 0 AC 15e0 120
RI23 e23 2 47e-3
VS24 14 s24 0
L24 s24 16 68e-4
VS25 2 s25 0
C25 s25 3 18e-5
VS26 7 s26 0
V26 e26 s26 DC 0 AC 18e1 120
RI26 e26 15 12e-2
VS27 12 s27 0
R27 s27 10 12e1
VS28 13 s28 0
L28 s28 4 56e-4
VS29 4 s29 0
C29 s29 6 15e-6
VS30 11 s30 0
R30 s30 4 47e-1
VS31 7 s31 0
V31 e31 s31 DC 0 AC 47e0 120
RI31 e31 9 33e-3
.control
set numdgt=17
ac lin 1 60 60
print v(1) v(2) v(3) v(4) v(5) v(6) v(7) v(8) v(9) v(10)
print v(11) v(12) v(13) v(14) v(15) v(16)
print i(vs0) i(vs1) i(vs2) i(vs3) i(vs4) i(vs5) i(vs6) i(vs7) i(vs8) i(vs9)
print i(vs10) i(vs11) i(vs12) i(vs13) i(vs14) i(vs15) i(vs16) i(vs17) i(vs18) i(vs19)
print i(vs20) i(vs21) i(vs22) i(vs23) i(vs24) i(vs25) i(vs26) i(vs27) i(vs28) i(vs29)
print i(vs30) i(vs31)
.endc
.end
