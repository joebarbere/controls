controls oracle ac-0422
* Generated (plan F2.7, ADR 0012): do not edit; regenerate with `pnpm sim oracle regen`. ac seed 20261031 index 422 nodes 17 elements 32
.options sparse gmin=1e-12 noopac
RG1 1 0 1000000000000
RG2 2 0 1000000000000
RG3 3 0 1000000000000
RG4 4 0 1000000000000
RG5 5 0 1000000000000
RG6 6 0 1000000000000
RG7 7 0 1000000000000
RG8 8 0 1000000000000
RG9 9 0 1000000000000
RG10 10 0 1000000000000
RG11 11 0 1000000000000
RG12 12 0 1000000000000
RG13 13 0 1000000000000
RG14 14 0 1000000000000
RG15 15 0 1000000000000
RG16 16 0 1000000000000
VS0 4 s0 0
L0 s0 2 68e-5
VS1 11 s1 0
L1 s1 4 33e-5
VS2 3 s2 0
L2 s2 10 27e-2
VS3 0 s3 0
R3 s3 2 12e0
VS4 14 s4 0
L4 s4 7 82e-3
VS5 12 s5 0
L5 s5 6 39e-3
VS6 13 s6 0
C6 s6 7 12e-7
VS7 15 s7 0
L7 s7 11 56e-2
VS8 5 s8 0
L8 s8 12 56e-2
VS9 1 s9 0
C9 s9 10 82e-7
VS10 16 s10 0
R10 s10 2 56e2
VS11 11 s11 0
C11 s11 5 12e-7
VS12 0 s12 0
L12 s12 11 12e-2
VS13 2 s13 0
L13 s13 10 33e-3
VS14 0 s14 0
V14 e14 s14 DC 0 AC 82e0 -120
RI14 e14 1 33e-3
VS15 4 s15 0
R15 s15 5 12e3
VS16 0 s16 0
R16 s16 9 15e3
VS17 10 s17 0
C17 s17 14 12e-6
VS18 12 s18 0
C18 s18 8 10e-6
VS19 4 s19 0
R19 s19 5 39e0
VS20 1 s20 0
V20 e20 s20 DC 0 AC 68e0 0
RI20 e20 12 39e-3
VS21 8 s21 0
L21 s21 10 18e-3
VS22 3 s22 0
L22 s22 16 15e-4
VS23 11 s23 0
V23 e23 s23 DC 0 AC 15e0 120
RI23 e23 m23 47e-3
LI23 m23 7 47e-6
VS24 8 s24 0
R24 s24 16 22e2
VS25 3 s25 0
V25 e25 s25 DC 0 AC 15e-1 120
RI25 e25 m25 47e-3
LI25 m25 5 68e-6
VS26 9 s26 0
L26 s26 15 68e-3
VS27 12 s27 0
C27 s27 10 33e-6
VS28 2 s28 0
V28 e28 s28 DC 0 AC 39e-1 180
RI28 e28 3 47e-2
VS29 6 s29 0
R29 s29 3 22e3
VS30 13 s30 0
C30 s30 0 82e-7
VS31 7 s31 0
R31 s31 1 82e3
.control
set numdgt=17
ac lin 1 60 60
print v(1) v(2) v(3) v(4) v(5) v(6) v(7) v(8) v(9) v(10)
print v(11) v(12) v(13) v(14) v(15) v(16)
print i(vs0) i(vs1) i(vs2) i(vs3) i(vs4) i(vs5) i(vs6) i(vs7) i(vs8) i(vs9)
print i(vs10) i(vs11) i(vs12) i(vs13) i(vs14) i(vs15) i(vs16) i(vs17) i(vs18) i(vs19)
print i(vs20) i(vs21) i(vs22) i(vs23) i(vs24) i(vs25) i(vs26) i(vs27) i(vs28) i(vs29)
print i(vs30) i(vs31)
.endc
.end
