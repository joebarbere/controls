controls oracle ac-0001
* Generated (plan F2.7, ADR 0012): do not edit; regenerate with `pnpm sim oracle regen`. ac seed 20261031 index 1 nodes 26 elements 44
.options sparse gmin=1e-12 noopac
RG1 1 0 1000000000000
RG2 2 0 1000000000000
RG3 3 0 1000000000000
RG4 4 0 1000000000000
RG5 5 0 1000000000000
RG6 6 0 1000000000000
RG7 7 0 1000000000000
RG8 8 0 1000000000000
RG9 9 0 1000000000000
RG10 10 0 1000000000000
RG11 11 0 1000000000000
RG12 12 0 1000000000000
RG13 13 0 1000000000000
RG14 14 0 1000000000000
RG15 15 0 1000000000000
RG16 16 0 1000000000000
RG17 17 0 1000000000000
RG18 18 0 1000000000000
RG19 19 0 1000000000000
RG20 20 0 1000000000000
RG21 21 0 1000000000000
RG22 22 0 1000000000000
RG23 23 0 1000000000000
RG24 24 0 1000000000000
RG25 25 0 1000000000000
VS0 17 s0 0
R0 s0 5 56e-1
VS1 0 s1 0
C1 s1 1 18e-4
VS2 4 s2 0
R2 s2 25 15e-2
VS3 0 s3 0
V3 e3 s3 DC 0 AC 39e-1 0
RI3 e3 22 15e-2
VS4 14 s4 0
R4 s4 20 47e0
VS5 6 s5 0
L5 s5 19 47e-4
VS6 1 s6 0
L6 s6 5 12e-5
VS7 6 s7 0
L7 s7 24 22e-2
VS8 25 s8 0
C8 s8 18 39e-4
VS9 1 s9 0
V9 e9 s9 DC 0 AC 68e0 0
RI9 e9 23 15e-1
VS10 8 s10 0
L10 s10 17 15e-2
VS11 16 s11 0
L11 s11 17 18e-3
VS12 23 s12 0
V12 e12 s12 DC 0 AC 10e0 180
RI12 e12 10 47e-3
VS13 18 s13 0
V13 e13 s13 DC 0 AC 22e0 0
RI13 e13 8 47e-2
VS14 9 s14 0
R14 s14 14 12e-2
VS15 24 s15 0
C15 s15 13 33e-4
VS16 19 s16 0
R16 s16 23 15e0
VS17 1 s17 0
R17 s17 6 47e-1
VS18 6 s18 0
C18 s18 25 47e-4
VS19 19 s19 0
C19 s19 16 18e-4
VS20 1 s20 0
L20 s20 11 12e-5
VS21 3 s21 0
V21 e21 s21 DC 0 AC 68e-1 0
RI21 e21 m21 39e-3
LI21 m21 12 10e-7
VS22 9 s22 0
R22 s22 17 10e2
VS23 8 s23 0
C23 s23 5 22e-6
VS24 22 s24 0
V24 e24 s24 DC 0 AC 22e-1 -120
RI24 e24 13 15e-1
VS25 25 s25 0
C25 s25 1 33e-5
VS26 2 s26 0
R26 s26 5 47e-1
VS27 21 s27 0
L27 s27 0 39e-4
VS28 4 s28 0
L28 s28 15 33e-4
VS29 10 s29 0
R29 s29 4 68e-2
VS30 3 s30 0
L30 s30 5 39e-5
VS31 4 s31 0
C31 s31 21 56e-5
VS32 1 s32 0
L32 s32 13 33e-5
VS33 24 s33 0
C33 s33 20 12e-5
VS34 1 s34 0
R34 s34 12 68e1
VS35 9 s35 0
L35 s35 25 12e-4
VS36 4 s36 0
C36 s36 5 47e-7
VS37 25 s37 0
R37 s37 15 12e0
VS38 23 s38 0
R38 s38 2 12e0
VS39 9 s39 0
L39 s39 6 33e-2
VS40 6 s40 0
C40 s40 11 27e-4
VS41 1 s41 0
R41 s41 7 22e1
VS42 7 s42 0
R42 s42 19 39e0
VS43 24 s43 0
L43 s43 14 68e-4
.control
set numdgt=17
ac lin 1 60 60
print v(1) v(2) v(3) v(4) v(5) v(6) v(7) v(8) v(9) v(10)
print v(11) v(12) v(13) v(14) v(15) v(16) v(17) v(18) v(19) v(20)
print v(21) v(22) v(23) v(24) v(25)
print i(vs0) i(vs1) i(vs2) i(vs3) i(vs4) i(vs5) i(vs6) i(vs7) i(vs8) i(vs9)
print i(vs10) i(vs11) i(vs12) i(vs13) i(vs14) i(vs15) i(vs16) i(vs17) i(vs18) i(vs19)
print i(vs20) i(vs21) i(vs22) i(vs23) i(vs24) i(vs25) i(vs26) i(vs27) i(vs28) i(vs29)
print i(vs30) i(vs31) i(vs32) i(vs33) i(vs34) i(vs35) i(vs36) i(vs37) i(vs38) i(vs39)
print i(vs40) i(vs41) i(vs42) i(vs43)
.endc
.end
