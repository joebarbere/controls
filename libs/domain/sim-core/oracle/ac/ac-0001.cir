controls oracle ac-0001
* Generated (plan F2.7, ADR 0012): do not edit; regenerate with `pnpm sim oracle regen`. ac seed 20261031 index 1 nodes 26 elements 32
.options sparse gmin=1e-12 noopac
RG1 1 0 1000000000000
RG2 2 0 1000000000000
RG3 3 0 1000000000000
RG4 4 0 1000000000000
RG5 5 0 1000000000000
RG6 6 0 1000000000000
RG7 7 0 1000000000000
RG8 8 0 1000000000000
RG9 9 0 1000000000000
RG10 10 0 1000000000000
RG11 11 0 1000000000000
RG12 12 0 1000000000000
RG13 13 0 1000000000000
RG14 14 0 1000000000000
RG15 15 0 1000000000000
RG16 16 0 1000000000000
RG17 17 0 1000000000000
RG18 18 0 1000000000000
RG19 19 0 1000000000000
RG20 20 0 1000000000000
RG21 21 0 1000000000000
RG22 22 0 1000000000000
RG23 23 0 1000000000000
RG24 24 0 1000000000000
RG25 25 0 1000000000000
VS0 0 s0 0
R0 s0 24 12e0
VS1 7 s1 0
C1 s1 2 68e-7
VS2 25 s2 0
L2 s2 1 18e-4
VS3 15 s3 0
R3 s3 1 15e0
VS4 16 s4 0
C4 s4 21 15e-5
VS5 1 s5 0
L5 s5 15 22e-3
VS6 25 s6 0
C6 s6 1 12e-5
VS7 2 s7 0
R7 s7 18 82e2
VS8 11 s8 0
L8 s8 0 22e-2
VS9 10 s9 0
C9 s9 19 22e-7
VS10 23 s10 0
R10 s10 1 10e2
VS11 0 s11 0
V11 e11 s11 DC 0 AC 10e0 120
RI11 e11 23 56e-2
VS12 8 s12 0
R12 s12 16 10e3
VS13 19 s13 0
L13 s13 25 10e-5
VS14 1 s14 0
V14 e14 s14 DC 0 AC 68e0 0
RI14 e14 7 15e-1
VS15 2 s15 0
R15 s15 20 12e2
VS16 0 s16 0
C16 s16 13 22e-7
VS17 25 s17 0
V17 e17 s17 DC 0 AC 10e1 -120
RI17 e17 6 27e-1
VS18 14 s18 0
C18 s18 21 12e-7
VS19 5 s19 0
V19 e19 s19 DC 0 AC 39e-1 0
RI19 e19 12 15e-2
VS20 7 s20 0
C20 s20 3 39e-4
VS21 7 s21 0
C21 s21 17 68e-6
VS22 24 s22 0
L22 s22 20 82e-2
VS23 7 s23 0
R23 s23 20 15e-2
VS24 19 s24 0
L24 s24 5 15e-2
VS25 9 s25 0
L25 s25 1 47e-3
VS26 23 s26 0
C26 s26 22 18e-5
VS27 5 s27 0
R27 s27 8 12e-2
VS28 14 s28 0
V28 e28 s28 DC 0 AC 22e1 0
RI28 e28 4 56e-3
VS29 19 s29 0
R29 s29 14 68e1
VS30 17 s30 0
L30 s30 5 22e-2
VS31 1 s31 0
L31 s31 11 12e-4
.control
set numdgt=17
ac lin 1 60 60
print v(1) v(2) v(3) v(4) v(5) v(6) v(7) v(8) v(9) v(10)
print v(11) v(12) v(13) v(14) v(15) v(16) v(17) v(18) v(19) v(20)
print v(21) v(22) v(23) v(24) v(25)
print i(vs0) i(vs1) i(vs2) i(vs3) i(vs4) i(vs5) i(vs6) i(vs7) i(vs8) i(vs9)
print i(vs10) i(vs11) i(vs12) i(vs13) i(vs14) i(vs15) i(vs16) i(vs17) i(vs18) i(vs19)
print i(vs20) i(vs21) i(vs22) i(vs23) i(vs24) i(vs25) i(vs26) i(vs27) i(vs28) i(vs29)
print i(vs30) i(vs31)
.endc
.end
