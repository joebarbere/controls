controls oracle ac-0001
* Generated (plan F2.7, ADR 0012): do not edit; regenerate with `pnpm sim oracle regen`. ac seed 20261031 index 1 nodes 26 elements 42
.options sparse gmin=1e-12 noopac
RG1 1 0 1000000000000
RG2 2 0 1000000000000
RG3 3 0 1000000000000
RG4 4 0 1000000000000
RG5 5 0 1000000000000
RG6 6 0 1000000000000
RG7 7 0 1000000000000
RG8 8 0 1000000000000
RG9 9 0 1000000000000
RG10 10 0 1000000000000
RG11 11 0 1000000000000
RG12 12 0 1000000000000
RG13 13 0 1000000000000
RG14 14 0 1000000000000
RG15 15 0 1000000000000
RG16 16 0 1000000000000
RG17 17 0 1000000000000
RG18 18 0 1000000000000
RG19 19 0 1000000000000
RG20 20 0 1000000000000
RG21 21 0 1000000000000
RG22 22 0 1000000000000
RG23 23 0 1000000000000
RG24 24 0 1000000000000
RG25 25 0 1000000000000
VS0 25 s0 0
L0 s0 9 82e-3
VS1 7 s1 0
C1 s1 18 82e-4
VS2 0 s2 0
V2 e2 s2 DC 0 AC 10e1 -120
RI2 e2 6 27e-1
VS3 13 s3 0
R3 s3 16 47e-2
VS4 14 s4 0
V4 e4 s4 DC 0 AC 22e1 0
RI4 e4 4 56e-3
VS5 19 s5 0
R5 s5 14 68e1
VS6 19 s6 0
L6 s6 5 15e-2
VS7 0 s7 0
C7 s7 1 12e-5
VS8 15 s8 0
R8 s8 1 15e0
VS9 1 s9 0
L9 s9 15 22e-3
VS10 23 s10 0
C10 s10 22 18e-5
VS11 11 s11 0
L11 s11 7 22e-2
VS12 7 s12 0
C12 s12 13 22e-7
VS13 7 s13 0
R13 s13 24 12e0
VS14 5 s14 0
R14 s14 15 47e1
VS15 17 s15 0
L15 s15 5 22e-2
VS16 25 s16 0
C16 s16 3 39e-4
VS17 2 s17 0
R17 s17 4 12e0
VS18 10 s18 0
R18 s18 5 68e-2
VS19 3 s19 0
R19 s19 22 22e0
VS20 19 s20 0
L20 s20 0 10e-5
VS21 24 s21 0
L21 s21 20 82e-2
VS22 0 s22 0
L22 s22 1 18e-4
VS23 9 s23 0
L23 s23 1 47e-3
VS24 25 s24 0
C24 s24 17 68e-6
VS25 8 s25 0
R25 s25 16 10e3
VS26 2 s26 0
R26 s26 20 12e2
VS27 2 s27 0
R27 s27 18 82e2
VS28 1 s28 0
V28 e28 s28 DC 0 AC 68e0 0
RI28 e28 m28 15e-1
LI28 m28 25 47e-6
VS29 5 s29 0
R29 s29 8 12e-2
VS30 25 s30 0
R30 s30 20 15e-2
VS31 1 s31 0
L31 s31 11 12e-4
VS32 16 s32 0
C32 s32 21 15e-5
VS33 20 s33 0
L33 s33 12 33e-3
VS34 10 s34 0
C34 s34 19 22e-7
VS35 1 s35 0
L35 s35 6 18e-3
VS36 14 s36 0
C36 s36 21 12e-7
VS37 5 s37 0
V37 e37 s37 DC 0 AC 39e-1 0
RI37 e37 m37 15e-2
LI37 m37 12 33e-6
VS38 23 s38 0
R38 s38 1 10e2
VS39 7 s39 0
V39 e39 s39 DC 0 AC 10e0 120
RI39 e39 m39 56e-2
LI39 m39 23 15e-7
VS40 22 s40 0
C40 s40 14 33e-4
VS41 25 s41 0
C41 s41 2 68e-7
.control
set numdgt=17
ac lin 1 60 60
print v(1) v(2) v(3) v(4) v(5) v(6) v(7) v(8) v(9) v(10)
print v(11) v(12) v(13) v(14) v(15) v(16) v(17) v(18) v(19) v(20)
print v(21) v(22) v(23) v(24) v(25)
print i(vs0) i(vs1) i(vs2) i(vs3) i(vs4) i(vs5) i(vs6) i(vs7) i(vs8) i(vs9)
print i(vs10) i(vs11) i(vs12) i(vs13) i(vs14) i(vs15) i(vs16) i(vs17) i(vs18) i(vs19)
print i(vs20) i(vs21) i(vs22) i(vs23) i(vs24) i(vs25) i(vs26) i(vs27) i(vs28) i(vs29)
print i(vs30) i(vs31) i(vs32) i(vs33) i(vs34) i(vs35) i(vs36) i(vs37) i(vs38) i(vs39)
print i(vs40) i(vs41)
.endc
.end
