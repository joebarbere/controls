controls oracle ac-0392
* Generated (plan F2.7, ADR 0012): do not edit; regenerate with `pnpm sim oracle regen`. ac seed 20261031 index 392 nodes 22 elements 24
.options sparse gmin=1e-12 noopac
RG1 1 0 1000000000000
RG2 2 0 1000000000000
RG3 3 0 1000000000000
RG4 4 0 1000000000000
RG5 5 0 1000000000000
RG6 6 0 1000000000000
RG7 7 0 1000000000000
RG8 8 0 1000000000000
RG9 9 0 1000000000000
RG10 10 0 1000000000000
RG11 11 0 1000000000000
RG12 12 0 1000000000000
RG13 13 0 1000000000000
RG14 14 0 1000000000000
RG15 15 0 1000000000000
RG16 16 0 1000000000000
RG17 17 0 1000000000000
RG18 18 0 1000000000000
RG19 19 0 1000000000000
RG20 20 0 1000000000000
RG21 21 0 1000000000000
VS0 7 s0 0
C0 s0 13 47e-5
VS1 7 s1 0
R1 s1 18 22e-2
VS2 8 s2 0
R2 s2 14 10e3
VS3 10 s3 0
C3 s3 20 12e-4
VS4 4 s4 0
L4 s4 6 27e-4
VS5 1 s5 0
R5 s5 21 15e-1
VS6 0 s6 0
V6 e6 s6 DC 0 AC 12e1 0
RI6 e6 18 47e-1
VS7 14 s7 0
R7 s7 2 33e-1
VS8 5 s8 0
C8 s8 7 56e-6
VS9 19 s9 0
R9 s9 13 39e0
VS10 17 s10 0
V10 e10 s10 DC 0 AC 82e1 120
RI10 e10 21 27e-3
VS11 1 s11 0
L11 s11 7 22e-5
VS12 20 s12 0
V12 e12 s12 DC 0 AC 12e0 -120
RI12 e12 9 12e-2
VS13 15 s13 0
R13 s13 8 82e0
VS14 2 s14 0
R14 s14 8 10e-1
VS15 3 s15 0
L15 s15 11 39e-2
VS16 16 s16 0
L16 s16 3 33e-3
VS17 7 s17 0
V17 e17 s17 DC 0 AC 12e-1 120
RI17 e17 15 18e-3
VS18 16 s18 0
C18 s18 4 12e-5
VS19 6 s19 0
V19 e19 s19 DC 0 AC 33e0 0
RI19 e19 21 47e-3
VS20 7 s20 0
R20 s20 3 27e3
VS21 9 s21 0
L21 s21 16 47e-2
VS22 12 s22 0
R22 s22 18 18e-2
VS23 9 s23 0
L23 s23 12 39e-4
.control
set numdgt=17
ac lin 1 60 60
print v(1) v(2) v(3) v(4) v(5) v(6) v(7) v(8) v(9) v(10)
print v(11) v(12) v(13) v(14) v(15) v(16) v(17) v(18) v(19) v(20)
print v(21)
print i(vs0) i(vs1) i(vs2) i(vs3) i(vs4) i(vs5) i(vs6) i(vs7) i(vs8) i(vs9)
print i(vs10) i(vs11) i(vs12) i(vs13) i(vs14) i(vs15) i(vs16) i(vs17) i(vs18) i(vs19)
print i(vs20) i(vs21) i(vs22) i(vs23)
.endc
.end
