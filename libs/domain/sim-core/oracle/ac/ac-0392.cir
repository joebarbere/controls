controls oracle ac-0392
* Generated (plan F2.7, ADR 0012): do not edit; regenerate with `pnpm sim oracle regen`. ac seed 20261031 index 392 nodes 22 elements 30
.options sparse gmin=1e-12 noopac
RG1 1 0 1000000000000
RG2 2 0 1000000000000
RG3 3 0 1000000000000
RG4 4 0 1000000000000
RG5 5 0 1000000000000
RG6 6 0 1000000000000
RG7 7 0 1000000000000
RG8 8 0 1000000000000
RG9 9 0 1000000000000
RG10 10 0 1000000000000
RG11 11 0 1000000000000
RG12 12 0 1000000000000
RG13 13 0 1000000000000
RG14 14 0 1000000000000
RG15 15 0 1000000000000
RG16 16 0 1000000000000
RG17 17 0 1000000000000
RG18 18 0 1000000000000
RG19 19 0 1000000000000
RG20 20 0 1000000000000
RG21 21 0 1000000000000
VS0 13 s0 0
R0 s0 7 68e0
VS1 19 s1 0
L1 s1 17 33e-5
VS2 7 s2 0
R2 s2 1 22e0
VS3 4 s3 0
R3 s3 2 22e-1
VS4 5 s4 0
C4 s4 20 15e-5
VS5 15 s5 0
C5 s5 8 33e-6
VS6 19 s6 0
R6 s6 6 47e-1
VS7 3 s7 0
R7 s7 1 12e1
VS8 9 s8 0
R8 s8 18 33e1
VS9 0 s9 0
V9 e9 s9 DC 0 AC 68e1 120
RI9 e9 m9 33e-1
LI9 m9 21 82e-7
VS10 12 s10 0
C10 s10 4 12e-5
VS11 14 s11 0
L11 s11 9 27e-4
VS12 18 s12 0
C12 s12 8 22e-5
VS13 5 s13 0
C13 s13 10 12e-7
VS14 20 s14 0
L14 s14 13 27e-3
VS15 4 s15 0
L15 s15 6 27e-4
VS16 7 s16 0
V16 e16 s16 DC 0 AC 12e-1 120
RI16 e16 m16 18e-3
LI16 m16 15 68e-5
VS17 2 s17 0
V17 e17 s17 DC 0 AC 82e-1 -120
RI17 e17 m17 68e-3
LI17 m17 14 15e-7
VS18 0 s18 0
C18 s18 11 56e-4
VS19 16 s19 0
C19 s19 17 47e-5
VS20 10 s20 0
V20 e20 s20 DC 0 AC 10e1 120
RI20 e20 8 82e-2
VS21 7 s21 0
V21 e21 s21 DC 0 AC 33e0 0
RI21 e21 m21 47e-3
LI21 m21 0 82e-7
VS22 12 s22 0
V22 e22 s22 DC 0 AC 10e1 0
RI22 e22 9 10e-3
VS23 5 s23 0
L23 s23 4 18e-2
VS24 7 s24 0
R24 s24 3 27e3
VS25 12 s25 0
L25 s25 3 33e-3
VS26 15 s26 0
L26 s26 16 39e-2
VS27 18 s27 0
V27 e27 s27 DC 0 AC 22e1 -120
RI27 e27 m27 68e-3
LI27 m27 4 18e-7
VS28 21 s28 0
V28 e28 s28 DC 0 AC 56e-1 120
RI28 e28 m28 39e-3
LI28 m28 18 39e-6
VS29 6 s29 0
L29 s29 11 22e-2
.control
set numdgt=17
ac lin 1 60 60
print v(1) v(2) v(3) v(4) v(5) v(6) v(7) v(8) v(9) v(10)
print v(11) v(12) v(13) v(14) v(15) v(16) v(17) v(18) v(19) v(20)
print v(21)
print i(vs0) i(vs1) i(vs2) i(vs3) i(vs4) i(vs5) i(vs6) i(vs7) i(vs8) i(vs9)
print i(vs10) i(vs11) i(vs12) i(vs13) i(vs14) i(vs15) i(vs16) i(vs17) i(vs18) i(vs19)
print i(vs20) i(vs21) i(vs22) i(vs23) i(vs24) i(vs25) i(vs26) i(vs27) i(vs28) i(vs29)
.endc
.end
