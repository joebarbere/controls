controls oracle ac-0392
* Generated (plan F2.7, ADR 0012): do not edit; regenerate with `pnpm sim oracle regen`. ac seed 20261031 index 392 nodes 22 elements 30
.options sparse gmin=1e-12 noopac
RG1 1 0 1000000000000
RG2 2 0 1000000000000
RG3 3 0 1000000000000
RG4 4 0 1000000000000
RG5 5 0 1000000000000
RG6 6 0 1000000000000
RG7 7 0 1000000000000
RG8 8 0 1000000000000
RG9 9 0 1000000000000
RG10 10 0 1000000000000
RG11 11 0 1000000000000
RG12 12 0 1000000000000
RG13 13 0 1000000000000
RG14 14 0 1000000000000
RG15 15 0 1000000000000
RG16 16 0 1000000000000
RG17 17 0 1000000000000
RG18 18 0 1000000000000
RG19 19 0 1000000000000
RG20 20 0 1000000000000
RG21 21 0 1000000000000
VS0 0 s0 0
V0 e0 s0 DC 0 AC 12e1 0
RI0 e0 m0 47e-1
LI0 m0 18 39e-5
VS1 4 s1 0
L1 s1 6 27e-4
VS2 17 s2 0
V2 e2 s2 DC 0 AC 82e1 120
RI2 e2 m2 27e-3
LI2 m2 21 82e-5
VS3 19 s3 0
R3 s3 13 39e0
VS4 9 s4 0
L4 s4 12 39e-4
VS5 20 s5 0
V5 e5 s5 DC 0 AC 12e0 -120
RI5 e5 m5 12e-2
LI5 m5 9 18e-6
VS6 12 s6 0
R6 s6 18 18e-2
VS7 7 s7 0
C7 s7 13 47e-5
VS8 8 s8 0
R8 s8 14 10e3
VS9 1 s9 0
R9 s9 21 15e-1
VS10 9 s10 0
L10 s10 16 47e-2
VS11 3 s11 0
L11 s11 11 39e-2
VS12 5 s12 0
C12 s12 7 56e-6
VS13 7 s13 0
R13 s13 3 27e3
VS14 16 s14 0
L14 s14 3 33e-3
VS15 2 s15 0
R15 s15 8 10e-1
VS16 1 s16 0
R16 s16 11 18e3
VS17 7 s17 0
R17 s17 18 22e-2
VS18 6 s18 0
V18 e18 s18 DC 0 AC 33e0 0
RI18 e18 21 47e-3
VS19 1 s19 0
L19 s19 7 22e-5
VS20 10 s20 0
C20 s20 20 12e-4
VS21 12 s21 0
C21 s21 2 15e-4
VS22 14 s22 0
R22 s22 2 33e-1
VS23 15 s23 0
R23 s23 8 82e0
VS24 16 s24 0
L24 s24 19 18e-2
VS25 5 s25 0
L25 s25 0 33e-3
VS26 5 s26 0
V26 e26 s26 DC 0 AC 15e-1 180
RI26 e26 m26 39e-1
LI26 m26 17 10e-7
VS27 16 s27 0
C27 s27 4 12e-5
VS28 10 s28 0
R28 s28 1 56e-1
VS29 7 s29 0
V29 e29 s29 DC 0 AC 12e-1 120
RI29 e29 m29 18e-3
LI29 m29 15 12e-7
.control
set numdgt=17
ac lin 1 60 60
print v(1) v(2) v(3) v(4) v(5) v(6) v(7) v(8) v(9) v(10)
print v(11) v(12) v(13) v(14) v(15) v(16) v(17) v(18) v(19) v(20)
print v(21)
print i(vs0) i(vs1) i(vs2) i(vs3) i(vs4) i(vs5) i(vs6) i(vs7) i(vs8) i(vs9)
print i(vs10) i(vs11) i(vs12) i(vs13) i(vs14) i(vs15) i(vs16) i(vs17) i(vs18) i(vs19)
print i(vs20) i(vs21) i(vs22) i(vs23) i(vs24) i(vs25) i(vs26) i(vs27) i(vs28) i(vs29)
.endc
.end
