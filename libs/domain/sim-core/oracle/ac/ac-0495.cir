controls oracle ac-0495
* Generated (plan F2.7, ADR 0012): do not edit; regenerate with `pnpm sim oracle regen`. ac seed 20261031 index 495 nodes 9 elements 16
.options sparse gmin=1e-12 noopac
RG1 1 0 1000000000000
RG2 2 0 1000000000000
RG3 3 0 1000000000000
RG4 4 0 1000000000000
RG5 5 0 1000000000000
RG6 6 0 1000000000000
RG7 7 0 1000000000000
RG8 8 0 1000000000000
VS0 6 s0 0
C0 s0 2 68e-7
VS1 8 s1 0
L1 s1 7 82e-2
VS2 2 s2 0
L2 s2 5 68e-2
VS3 1 s3 0
R3 s3 0 10e2
VS4 0 s4 0
R4 s4 1 47e2
VS5 1 s5 0
R5 s5 7 82e-2
VS6 0 s6 0
C6 s6 3 56e-7
VS7 8 s7 0
L7 s7 3 39e-5
VS8 4 s8 0
R8 s8 5 12e0
VS9 3 s9 0
L9 s9 8 68e-5
VS10 3 s10 0
R10 s10 1 15e-1
VS11 8 s11 0
L11 s11 2 82e-5
VS12 8 s12 0
C12 s12 4 15e-6
VS13 0 s13 0
V13 e13 s13 DC 0 AC 82e-1 0
RI13 e13 m13 15e-3
LI13 m13 8 18e-7
VS14 4 s14 0
R14 s14 6 33e1
VS15 2 s15 0
L15 s15 0 18e-3
.control
set numdgt=17
ac lin 1 60 60
print v(1) v(2) v(3) v(4) v(5) v(6) v(7) v(8)
print i(vs0) i(vs1) i(vs2) i(vs3) i(vs4) i(vs5) i(vs6) i(vs7) i(vs8) i(vs9)
print i(vs10) i(vs11) i(vs12) i(vs13) i(vs14) i(vs15)
.endc
.end
