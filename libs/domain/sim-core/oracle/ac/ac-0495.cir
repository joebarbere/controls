controls oracle ac-0495
* Generated (plan F2.7, ADR 0012): do not edit; regenerate with `pnpm sim oracle regen`. ac seed 20261031 index 495 nodes 9 elements 14
.options sparse gmin=1e-12 noopac
RG1 1 0 1000000000000
RG2 2 0 1000000000000
RG3 3 0 1000000000000
RG4 4 0 1000000000000
RG5 5 0 1000000000000
RG6 6 0 1000000000000
RG7 7 0 1000000000000
RG8 8 0 1000000000000
VS0 0 s0 0
R0 s0 5 18e-1
VS1 4 s1 0
L1 s1 8 56e-5
VS2 4 s2 0
R2 s2 5 12e0
VS3 2 s3 0
L3 s3 5 68e-2
VS4 4 s4 0
R4 s4 6 33e1
VS5 0 s5 0
R5 s5 1 47e2
VS6 5 s6 0
R6 s6 0 18e2
VS7 1 s7 0
R7 s7 5 22e3
VS8 8 s8 0
L8 s8 2 82e-5
VS9 1 s9 0
R9 s9 7 82e-2
VS10 0 s10 0
C10 s10 3 56e-7
VS11 8 s11 0
C11 s11 4 15e-6
VS12 3 s12 0
L12 s12 8 68e-5
VS13 0 s13 0
V13 e13 s13 DC 0 AC 82e-1 0
RI13 e13 8 15e-3
.control
set numdgt=17
ac lin 1 60 60
print v(1) v(2) v(3) v(4) v(5) v(6) v(7) v(8)
print i(vs0) i(vs1) i(vs2) i(vs3) i(vs4) i(vs5) i(vs6) i(vs7) i(vs8) i(vs9)
print i(vs10) i(vs11) i(vs12) i(vs13)
.endc
.end
