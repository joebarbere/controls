controls oracle ac-0055
* Generated (plan F2.7, ADR 0012): do not edit; regenerate with `pnpm sim oracle regen`. ac seed 20261031 index 55 nodes 8 elements 13
.options sparse gmin=1e-12 noopac
RG1 1 0 1000000000000
RG2 2 0 1000000000000
RG3 3 0 1000000000000
RG4 4 0 1000000000000
RG5 5 0 1000000000000
RG6 6 0 1000000000000
RG7 7 0 1000000000000
VS0 0 s0 0
R0 s0 4 12e2
VS1 1 s1 0
C1 s1 4 15e-6
VS2 0 s2 0
V2 e2 s2 DC 0 AC 12e0 120
RI2 e2 7 47e-1
VS3 7 s3 0
R3 s3 5 12e0
VS4 6 s4 0
R4 s4 4 39e2
VS5 3 s5 0
V5 e5 s5 DC 0 AC 56e1 180
RI5 e5 2 68e-3
VS6 5 s6 0
L6 s6 4 22e-3
VS7 6 s7 0
L7 s7 4 47e-4
VS8 1 s8 0
L8 s8 2 12e-5
VS9 6 s9 0
L9 s9 1 27e-4
VS10 3 s10 0
R10 s10 5 33e-1
VS11 3 s11 0
L11 s11 1 15e-3
VS12 6 s12 0
R12 s12 4 18e-1
.control
set numdgt=17
ac lin 1 60 60
print v(1) v(2) v(3) v(4) v(5) v(6) v(7)
print i(vs0) i(vs1) i(vs2) i(vs3) i(vs4) i(vs5) i(vs6) i(vs7) i(vs8) i(vs9)
print i(vs10) i(vs11) i(vs12)
.endc
.end
