controls oracle ac-0055
* Generated (plan F2.7, ADR 0012): do not edit; regenerate with `pnpm sim oracle regen`. ac seed 20261031 index 55 nodes 8 elements 14
.options sparse gmin=1e-12 noopac
RG1 1 0 1000000000000
RG2 2 0 1000000000000
RG3 3 0 1000000000000
RG4 4 0 1000000000000
RG5 5 0 1000000000000
RG6 6 0 1000000000000
RG7 7 0 1000000000000
VS0 7 s0 0
R0 s0 5 12e0
VS1 1 s1 0
L1 s1 2 12e-5
VS2 0 s2 0
L2 s2 2 82e-4
VS3 4 s3 0
L3 s3 6 22e-3
VS4 0 s4 0
R4 s4 4 12e2
VS5 6 s5 0
R5 s5 4 39e2
VS6 6 s6 0
R6 s6 2 15e1
VS7 0 s7 0
V7 e7 s7 DC 0 AC 12e0 120
RI7 e7 7 47e-1
VS8 3 s8 0
R8 s8 7 10e-2
VS9 6 s9 0
L9 s9 4 47e-4
VS10 1 s10 0
C10 s10 4 15e-6
VS11 5 s11 0
L11 s11 4 22e-3
VS12 3 s12 0
L12 s12 1 15e-3
VS13 6 s13 0
R13 s13 4 18e-1
.control
set numdgt=17
ac lin 1 60 60
print v(1) v(2) v(3) v(4) v(5) v(6) v(7)
print i(vs0) i(vs1) i(vs2) i(vs3) i(vs4) i(vs5) i(vs6) i(vs7) i(vs8) i(vs9)
print i(vs10) i(vs11) i(vs12) i(vs13)
.endc
.end
