controls oracle ac-0232
* Generated (plan F2.7, ADR 0012): do not edit; regenerate with `pnpm sim oracle regen`. ac seed 20261031 index 232 nodes 24 elements 31
.options sparse gmin=1e-12 noopac
RG1 1 0 1000000000000
RG2 2 0 1000000000000
RG3 3 0 1000000000000
RG4 4 0 1000000000000
RG5 5 0 1000000000000
RG6 6 0 1000000000000
RG7 7 0 1000000000000
RG8 8 0 1000000000000
RG9 9 0 1000000000000
RG10 10 0 1000000000000
RG11 11 0 1000000000000
RG12 12 0 1000000000000
RG13 13 0 1000000000000
RG14 14 0 1000000000000
RG15 15 0 1000000000000
RG16 16 0 1000000000000
RG17 17 0 1000000000000
RG18 18 0 1000000000000
RG19 19 0 1000000000000
RG20 20 0 1000000000000
RG21 21 0 1000000000000
RG22 22 0 1000000000000
RG23 23 0 1000000000000
VS0 9 s0 0
L0 s0 0 22e-5
VS1 22 s1 0
R1 s1 3 82e0
VS2 13 s2 0
R2 s2 15 68e-1
VS3 0 s3 0
V3 e3 s3 DC 0 AC 82e-1 180
RI3 e3 19 39e-3
VS4 15 s4 0
V4 e4 s4 DC 0 AC 10e0 -120
RI4 e4 16 10e-2
VS5 2 s5 0
R5 s5 11 33e0
VS6 5 s6 0
R6 s6 6 15e-2
VS7 22 s7 0
C7 s7 19 33e-7
VS8 22 s8 0
R8 s8 13 82e-2
VS9 16 s9 0
C9 s9 13 15e-5
VS10 18 s10 0
L10 s10 9 22e-3
VS11 3 s11 0
R11 s11 18 12e-2
VS12 9 s12 0
R12 s12 1 27e3
VS13 17 s13 0
R13 s13 2 68e1
VS14 18 s14 0
C14 s14 14 33e-4
VS15 22 s15 0
L15 s15 5 56e-4
VS16 20 s16 0
V16 e16 s16 DC 0 AC 56e1 0
RI16 e16 9 10e-3
VS17 6 s17 0
R17 s17 18 10e3
VS18 2 s18 0
L18 s18 3 10e-2
VS19 0 s19 0
L19 s19 8 56e-2
VS20 12 s20 0
L20 s20 3 18e-2
VS21 18 s21 0
R21 s21 5 12e0
VS22 10 s22 0
R22 s22 1 10e1
VS23 18 s23 0
C23 s23 13 47e-6
VS24 15 s24 0
R24 s24 7 82e1
VS25 19 s25 0
R25 s25 21 39e3
VS26 4 s26 0
L26 s26 20 12e-4
VS27 8 s27 0
C27 s27 6 27e-5
VS28 7 s28 0
C28 s28 15 12e-7
VS29 9 s29 0
R29 s29 21 18e3
VS30 19 s30 0
L30 s30 23 56e-5
.control
set numdgt=17
ac lin 1 60 60
print v(1) v(2) v(3) v(4) v(5) v(6) v(7) v(8) v(9) v(10)
print v(11) v(12) v(13) v(14) v(15) v(16) v(17) v(18) v(19) v(20)
print v(21) v(22) v(23)
print i(vs0) i(vs1) i(vs2) i(vs3) i(vs4) i(vs5) i(vs6) i(vs7) i(vs8) i(vs9)
print i(vs10) i(vs11) i(vs12) i(vs13) i(vs14) i(vs15) i(vs16) i(vs17) i(vs18) i(vs19)
print i(vs20) i(vs21) i(vs22) i(vs23) i(vs24) i(vs25) i(vs26) i(vs27) i(vs28) i(vs29)
print i(vs30)
.endc
.end
