controls oracle ac-0232
* Generated (plan F2.7, ADR 0012): do not edit; regenerate with `pnpm sim oracle regen`. ac seed 20261031 index 232 nodes 24 elements 39
.options sparse gmin=1e-12 noopac
RG1 1 0 1000000000000
RG2 2 0 1000000000000
RG3 3 0 1000000000000
RG4 4 0 1000000000000
RG5 5 0 1000000000000
RG6 6 0 1000000000000
RG7 7 0 1000000000000
RG8 8 0 1000000000000
RG9 9 0 1000000000000
RG10 10 0 1000000000000
RG11 11 0 1000000000000
RG12 12 0 1000000000000
RG13 13 0 1000000000000
RG14 14 0 1000000000000
RG15 15 0 1000000000000
RG16 16 0 1000000000000
RG17 17 0 1000000000000
RG18 18 0 1000000000000
RG19 19 0 1000000000000
RG20 20 0 1000000000000
RG21 21 0 1000000000000
RG22 22 0 1000000000000
RG23 23 0 1000000000000
VS0 5 s0 0
R0 s0 6 15e-2
VS1 18 s1 0
L1 s1 9 22e-3
VS2 8 s2 0
L2 s2 12 18e-2
VS3 22 s3 0
C3 s3 19 33e-7
VS4 10 s4 0
R4 s4 1 10e1
VS5 7 s5 0
C5 s5 15 12e-7
VS6 9 s6 0
R6 s6 1 27e3
VS7 2 s7 0
L7 s7 3 10e-2
VS8 18 s8 0
C8 s8 14 33e-4
VS9 22 s9 0
R9 s9 13 82e-2
VS10 2 s10 0
R10 s10 11 33e0
VS11 17 s11 0
R11 s11 2 68e1
VS12 18 s12 0
C12 s12 13 47e-6
VS13 8 s13 0
C13 s13 6 27e-5
VS14 3 s14 0
R14 s14 18 12e-2
VS15 9 s15 0
L15 s15 0 22e-5
VS16 10 s16 0
L16 s16 20 10e-3
VS17 0 s17 0
V17 e17 s17 DC 0 AC 82e-1 180
RI17 e17 19 39e-3
VS18 15 s18 0
R18 s18 7 82e1
VS19 0 s19 0
L19 s19 8 56e-2
VS20 11 s20 0
C20 s20 6 39e-4
VS21 12 s21 0
L21 s21 3 18e-2
VS22 20 s22 0
V22 e22 s22 DC 0 AC 47e1 -120
RI22 e22 17 56e-2
VS23 16 s23 0
C23 s23 13 15e-5
VS24 9 s24 0
L24 s24 14 33e-5
VS25 6 s25 0
R25 s25 18 10e3
VS26 22 s26 0
R26 s26 3 82e0
VS27 9 s27 0
R27 s27 21 18e3
VS28 7 s28 0
V28 e28 s28 DC 0 AC 18e1 120
RI28 e28 2 56e-3
VS29 23 s29 0
R29 s29 20 82e-1
VS30 19 s30 0
L30 s30 23 56e-5
VS31 22 s31 0
L31 s31 5 56e-4
VS32 4 s32 0
L32 s32 20 12e-4
VS33 20 s33 0
V33 e33 s33 DC 0 AC 56e1 0
RI33 e33 9 10e-3
VS34 18 s34 0
R34 s34 5 12e0
VS35 18 s35 0
L35 s35 4 56e-3
VS36 19 s36 0
R36 s36 21 39e3
VS37 13 s37 0
R37 s37 15 68e-1
VS38 15 s38 0
V38 e38 s38 DC 0 AC 10e0 -120
RI38 e38 16 10e-2
.control
set numdgt=17
ac lin 1 60 60
print v(1) v(2) v(3) v(4) v(5) v(6) v(7) v(8) v(9) v(10)
print v(11) v(12) v(13) v(14) v(15) v(16) v(17) v(18) v(19) v(20)
print v(21) v(22) v(23)
print i(vs0) i(vs1) i(vs2) i(vs3) i(vs4) i(vs5) i(vs6) i(vs7) i(vs8) i(vs9)
print i(vs10) i(vs11) i(vs12) i(vs13) i(vs14) i(vs15) i(vs16) i(vs17) i(vs18) i(vs19)
print i(vs20) i(vs21) i(vs22) i(vs23) i(vs24) i(vs25) i(vs26) i(vs27) i(vs28) i(vs29)
print i(vs30) i(vs31) i(vs32) i(vs33) i(vs34) i(vs35) i(vs36) i(vs37) i(vs38)
.endc
.end
