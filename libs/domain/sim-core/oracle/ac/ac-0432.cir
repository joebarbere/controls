controls oracle ac-0432
* Generated (plan F2.7, ADR 0012): do not edit; regenerate with `pnpm sim oracle regen`. ac seed 20261031 index 432 nodes 30 elements 54
.options sparse gmin=1e-12 noopac
RG1 1 0 1000000000000
RG2 2 0 1000000000000
RG3 3 0 1000000000000
RG4 4 0 1000000000000
RG5 5 0 1000000000000
RG6 6 0 1000000000000
RG7 7 0 1000000000000
RG8 8 0 1000000000000
RG9 9 0 1000000000000
RG10 10 0 1000000000000
RG11 11 0 1000000000000
RG12 12 0 1000000000000
RG13 13 0 1000000000000
RG14 14 0 1000000000000
RG15 15 0 1000000000000
RG16 16 0 1000000000000
RG17 17 0 1000000000000
RG18 18 0 1000000000000
RG19 19 0 1000000000000
RG20 20 0 1000000000000
RG21 21 0 1000000000000
RG22 22 0 1000000000000
RG23 23 0 1000000000000
RG24 24 0 1000000000000
RG25 25 0 1000000000000
RG26 26 0 1000000000000
RG27 27 0 1000000000000
RG28 28 0 1000000000000
RG29 29 0 1000000000000
VS0 22 s0 0
L0 s0 19 82e-5
VS1 21 s1 0
C1 s1 9 18e-7
VS2 12 s2 0
C2 s2 13 33e-6
VS3 15 s3 0
R3 s3 14 33e-2
VS4 21 s4 0
L4 s4 2 12e-4
VS5 0 s5 0
V5 e5 s5 DC 0 AC 22e1 -120
RI5 e5 14 47e-1
VS6 10 s6 0
R6 s6 29 10e1
VS7 29 s7 0
V7 e7 s7 DC 0 AC 47e-1 0
RI7 e7 0 39e-1
VS8 5 s8 0
C8 s8 19 12e-6
VS9 5 s9 0
V9 e9 s9 DC 0 AC 18e0 0
RI9 e9 4 47e-3
VS10 26 s10 0
L10 s10 27 15e-5
VS11 15 s11 0
R11 s11 3 27e1
VS12 20 s12 0
R12 s12 14 27e2
VS13 22 s13 0
L13 s13 29 18e-4
VS14 11 s14 0
C14 s14 16 82e-6
VS15 6 s15 0
L15 s15 14 12e-4
VS16 25 s16 0
R16 s16 24 56e-1
VS17 25 s17 0
V17 e17 s17 DC 0 AC 82e1 120
RI17 e17 2 27e-2
VS18 26 s18 0
L18 s18 5 82e-2
VS19 15 s19 0
V19 e19 s19 DC 0 AC 82e0 0
RI19 e19 11 22e-2
VS20 14 s20 0
R20 s20 12 12e2
VS21 13 s21 0
R21 s21 20 12e1
VS22 0 s22 0
C22 s22 18 56e-6
VS23 23 s23 0
L23 s23 8 56e-5
VS24 24 s24 0
R24 s24 19 15e0
VS25 5 s25 0
L25 s25 17 18e-2
VS26 6 s26 0
L26 s26 17 27e-2
VS27 8 s27 0
R27 s27 17 27e0
VS28 4 s28 0
L28 s28 0 33e-3
VS29 11 s29 0
C29 s29 22 22e-5
VS30 14 s30 0
C30 s30 17 56e-6
VS31 12 s31 0
R31 s31 7 33e3
VS32 2 s32 0
R32 s32 14 15e-2
VS33 16 s33 0
V33 e33 s33 DC 0 AC 22e1 180
RI33 e33 15 27e-3
VS34 7 s34 0
R34 s34 27 12e2
VS35 6 s35 0
R35 s35 19 22e-2
VS36 14 s36 0
V36 e36 s36 DC 0 AC 33e-1 0
RI36 e36 21 10e-1
VS37 0 s37 0
R37 s37 18 15e2
VS38 14 s38 0
V38 e38 s38 DC 0 AC 15e-1 0
RI38 e38 28 18e-1
VS39 29 s39 0
R39 s39 12 39e-2
VS40 21 s40 0
C40 s40 16 15e-6
VS41 12 s41 0
C41 s41 16 18e-6
VS42 12 s42 0
L42 s42 7 22e-3
VS43 18 s43 0
V43 e43 s43 DC 0 AC 15e0 0
RI43 e43 13 18e-3
VS44 2 s44 0
R44 s44 12 68e1
VS45 13 s45 0
R45 s45 18 18e3
VS46 12 s46 0
C46 s46 24 15e-4
VS47 1 s47 0
V47 e47 s47 DC 0 AC 68e-1 0
RI47 e47 20 10e-1
VS48 21 s48 0
V48 e48 s48 DC 0 AC 10e0 -120
RI48 e48 9 68e-2
VS49 5 s49 0
C49 s49 26 27e-5
VS50 8 s50 0
L50 s50 4 12e-2
VS51 8 s51 0
R51 s51 27 82e2
VS52 0 s52 0
C52 s52 1 47e-7
VS53 10 s53 0
L53 s53 6 39e-3
.control
set numdgt=17
ac lin 1 60 60
print v(1) v(2) v(3) v(4) v(5) v(6) v(7) v(8) v(9) v(10)
print v(11) v(12) v(13) v(14) v(15) v(16) v(17) v(18) v(19) v(20)
print v(21) v(22) v(23) v(24) v(25) v(26) v(27) v(28) v(29)
print i(vs0) i(vs1) i(vs2) i(vs3) i(vs4) i(vs5) i(vs6) i(vs7) i(vs8) i(vs9)
print i(vs10) i(vs11) i(vs12) i(vs13) i(vs14) i(vs15) i(vs16) i(vs17) i(vs18) i(vs19)
print i(vs20) i(vs21) i(vs22) i(vs23) i(vs24) i(vs25) i(vs26) i(vs27) i(vs28) i(vs29)
print i(vs30) i(vs31) i(vs32) i(vs33) i(vs34) i(vs35) i(vs36) i(vs37) i(vs38) i(vs39)
print i(vs40) i(vs41) i(vs42) i(vs43) i(vs44) i(vs45) i(vs46) i(vs47) i(vs48) i(vs49)
print i(vs50) i(vs51) i(vs52) i(vs53)
.endc
.end
