controls oracle ac-0432
* Generated (plan F2.7, ADR 0012): do not edit; regenerate with `pnpm sim oracle regen`. ac seed 20261031 index 432 nodes 30 elements 46
.options sparse gmin=1e-12 noopac
RG1 1 0 1000000000000
RG2 2 0 1000000000000
RG3 3 0 1000000000000
RG4 4 0 1000000000000
RG5 5 0 1000000000000
RG6 6 0 1000000000000
RG7 7 0 1000000000000
RG8 8 0 1000000000000
RG9 9 0 1000000000000
RG10 10 0 1000000000000
RG11 11 0 1000000000000
RG12 12 0 1000000000000
RG13 13 0 1000000000000
RG14 14 0 1000000000000
RG15 15 0 1000000000000
RG16 16 0 1000000000000
RG17 17 0 1000000000000
RG18 18 0 1000000000000
RG19 19 0 1000000000000
RG20 20 0 1000000000000
RG21 21 0 1000000000000
RG22 22 0 1000000000000
RG23 23 0 1000000000000
RG24 24 0 1000000000000
RG25 25 0 1000000000000
RG26 26 0 1000000000000
RG27 27 0 1000000000000
RG28 28 0 1000000000000
RG29 29 0 1000000000000
VS0 11 s0 0
L0 s0 22 18e-5
VS1 0 s1 0
R1 s1 12 12e2
VS2 26 s2 0
C2 s2 20 15e-5
VS3 15 s3 0
R3 s3 26 22e2
VS4 0 s4 0
V4 e4 s4 DC 0 AC 27e0 -120
RI4 e4 m4 18e-3
LI4 m4 14 82e-5
VS5 22 s5 0
R5 s5 16 22e1
VS6 10 s6 0
C6 s6 22 10e-4
VS7 4 s7 0
R7 s7 13 10e-2
VS8 1 s8 0
V8 e8 s8 DC 0 AC 22e1 -120
RI8 e8 21 10e-1
VS9 12 s9 0
C9 s9 16 18e-6
VS10 29 s10 0
L10 s10 5 82e-2
VS11 12 s11 0
L11 s11 7 22e-3
VS12 20 s12 0
R12 s12 21 33e2
VS13 14 s13 0
C13 s13 18 47e-7
VS14 2 s14 0
C14 s14 21 10e-7
VS15 6 s15 0
L15 s15 4 22e-3
VS16 11 s16 0
V16 e16 s16 DC 0 AC 27e1 0
RI16 e16 m16 33e-1
LI16 m16 9 15e-5
VS17 29 s17 0
R17 s17 12 39e-2
VS18 7 s18 0
L18 s18 26 82e-3
VS19 2 s19 0
R19 s19 0 15e-2
VS20 3 s20 0
L20 s20 26 47e-2
VS21 7 s21 0
R21 s21 27 12e2
VS22 23 s22 0
R22 s22 10 68e3
VS23 27 s23 0
R23 s23 18 82e1
VS24 12 s24 0
V24 e24 s24 DC 0 AC 22e1 180
RI24 e24 8 27e-3
VS25 7 s25 0
C25 s25 9 82e-5
VS26 18 s26 0
L26 s26 9 68e-5
VS27 1 s27 0
R27 s27 25 10e2
VS28 5 s28 0
R28 s28 15 18e1
VS29 22 s29 0
L29 s29 9 12e-5
VS30 22 s30 0
V30 e30 s30 DC 0 AC 27e-1 0
RI30 e30 m30 33e-1
LI30 m30 24 27e-5
VS31 25 s31 0
R31 s31 17 27e-1
VS32 12 s32 0
C32 s32 24 15e-4
VS33 22 s33 0
C33 s33 6 82e-5
VS34 27 s34 0
V34 e34 s34 DC 0 AC 56e-1 -120
RI34 e34 28 15e-2
VS35 8 s35 0
V35 e35 s35 DC 0 AC 12e1 120
RI35 e35 m35 39e-1
LI35 m35 0 39e-7
VS36 0 s36 0
V36 e36 s36 DC 0 AC 39e1 120
RI36 e36 m36 39e-2
LI36 m36 3 15e-7
VS37 13 s37 0
C37 s37 25 18e-4
VS38 17 s38 0
R38 s38 29 56e-2
VS39 25 s39 0
V39 e39 s39 DC 0 AC 82e1 120
RI39 e39 2 27e-2
VS40 19 s40 0
L40 s40 6 10e-2
VS41 19 s41 0
V41 e41 s41 DC 0 AC 15e1 0
RI41 e41 m41 12e-2
LI41 m41 26 82e-6
VS42 19 s42 0
R42 s42 28 18e2
VS43 18 s43 0
V43 e43 s43 DC 0 AC 68e0 180
RI43 e43 9 15e-2
VS44 16 s44 0
R44 s44 4 33e-2
VS45 23 s45 0
R45 s45 27 12e-1
.control
set numdgt=17
ac lin 1 60 60
print v(1) v(2) v(3) v(4) v(5) v(6) v(7) v(8) v(9) v(10)
print v(11) v(12) v(13) v(14) v(15) v(16) v(17) v(18) v(19) v(20)
print v(21) v(22) v(23) v(24) v(25) v(26) v(27) v(28) v(29)
print i(vs0) i(vs1) i(vs2) i(vs3) i(vs4) i(vs5) i(vs6) i(vs7) i(vs8) i(vs9)
print i(vs10) i(vs11) i(vs12) i(vs13) i(vs14) i(vs15) i(vs16) i(vs17) i(vs18) i(vs19)
print i(vs20) i(vs21) i(vs22) i(vs23) i(vs24) i(vs25) i(vs26) i(vs27) i(vs28) i(vs29)
print i(vs30) i(vs31) i(vs32) i(vs33) i(vs34) i(vs35) i(vs36) i(vs37) i(vs38) i(vs39)
print i(vs40) i(vs41) i(vs42) i(vs43) i(vs44) i(vs45)
.endc
.end
