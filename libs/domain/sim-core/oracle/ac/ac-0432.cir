controls oracle ac-0432
* Generated (plan F2.7, ADR 0012): do not edit; regenerate with `pnpm sim oracle regen`. ac seed 20261031 index 432 nodes 30 elements 57
.options sparse gmin=1e-12 noopac
RG1 1 0 1000000000000
RG2 2 0 1000000000000
RG3 3 0 1000000000000
RG4 4 0 1000000000000
RG5 5 0 1000000000000
RG6 6 0 1000000000000
RG7 7 0 1000000000000
RG8 8 0 1000000000000
RG9 9 0 1000000000000
RG10 10 0 1000000000000
RG11 11 0 1000000000000
RG12 12 0 1000000000000
RG13 13 0 1000000000000
RG14 14 0 1000000000000
RG15 15 0 1000000000000
RG16 16 0 1000000000000
RG17 17 0 1000000000000
RG18 18 0 1000000000000
RG19 19 0 1000000000000
RG20 20 0 1000000000000
RG21 21 0 1000000000000
RG22 22 0 1000000000000
RG23 23 0 1000000000000
RG24 24 0 1000000000000
RG25 25 0 1000000000000
RG26 26 0 1000000000000
RG27 27 0 1000000000000
RG28 28 0 1000000000000
RG29 29 0 1000000000000
VS0 12 s0 0
C0 s0 24 15e-4
VS1 12 s1 0
R1 s1 7 33e3
VS2 25 s2 0
R2 s2 24 56e-1
VS3 6 s3 0
R3 s3 19 22e-2
VS4 0 s4 0
V4 e4 s4 DC 0 AC 82e0 0
RI4 e4 m4 22e-2
LI4 m4 n4 10e-6
H4 n4 h4 VS6 -82e-3
ED4 h4 11 d4 0 39e-6
F4 0 d4 VS6 1
LD4 d4 0 1
VS5 21 s5 0
L5 s5 2 12e-4
VS6 25 s6 0
V6 e6 s6 DC 0 AC 82e1 120
RI6 e6 n6 27e-2
H6 n6 h6 VS4 -82e-3
ED6 h6 2 d6 0 39e-6
F6 0 d6 VS4 1
LD6 d6 0 1
VS7 2 s7 0
R7 s7 15 15e-2
VS8 23 s8 0
C8 s8 9 27e-7
VS9 14 s9 0
V9 e9 s9 DC 0 AC 22e1 -120
RI9 e9 15 47e-1
VS10 12 s10 0
C10 s10 13 33e-6
VS11 7 s11 0
R11 s11 27 12e2
VS12 6 s12 0
L12 s12 17 27e-2
VS13 26 s13 0
L13 s13 5 82e-2
VS14 29 s14 0
V14 e14 s14 DC 0 AC 47e-1 0
RI14 e14 14 39e-1
VS15 11 s15 0
C15 s15 22 22e-5
VS16 13 s16 0
R16 s16 18 18e3
VS17 0 s17 0
R17 s17 15 33e-2
VS18 6 s18 0
L18 s18 15 12e-4
VS19 18 s19 0
V19 e19 s19 DC 0 AC 15e0 0
RI19 e19 13 18e-3
VS20 4 s20 0
L20 s20 14 33e-3
VS21 8 s21 0
R21 s21 27 82e2
VS22 13 s22 0
R22 s22 20 12e1
VS23 16 s23 0
V23 e23 s23 DC 0 AC 22e1 180
RI23 e23 0 27e-3
VS24 15 s24 0
V24 e24 s24 DC 0 AC 33e-1 0
RI24 e24 21 10e-1
VS25 2 s25 0
R25 s25 12 68e1
VS26 5 s26 0
V26 e26 s26 DC 0 AC 18e0 0
RI26 e26 4 47e-3
VS27 22 s27 0
L27 s27 29 18e-4
VS28 12 s28 0
C28 s28 16 18e-6
VS29 21 s29 0
V29 e29 s29 DC 0 AC 10e0 -120
RI29 e29 9 68e-2
VS30 10 s30 0
L30 s30 6 39e-3
VS31 8 s31 0
L31 s31 4 12e-2
VS32 1 s32 0
V32 e32 s32 DC 0 AC 68e-1 0
RI32 e32 m32 10e-1
LI32 m32 20 68e-5
VS33 29 s33 0
R33 s33 12 39e-2
VS34 14 s34 0
R34 s34 18 15e2
VS35 15 s35 0
V35 e35 s35 DC 0 AC 15e-1 0
RI35 e35 m35 18e-1
LI35 m35 28 12e-7
VS36 5 s36 0
L36 s36 17 18e-2
VS37 14 s37 0
C37 s37 1 47e-7
VS38 8 s38 0
R38 s38 17 27e0
VS39 3 s39 0
R39 s39 11 39e1
VS40 5 s40 0
C40 s40 26 27e-5
VS41 0 s41 0
R41 s41 3 27e1
VS42 21 s42 0
C42 s42 16 15e-6
VS43 12 s43 0
L43 s43 7 22e-3
VS44 23 s44 0
L44 s44 8 56e-5
VS45 4 s45 0
R45 s45 28 27e2
VS46 21 s46 0
C46 s46 9 18e-7
VS47 15 s47 0
C47 s47 17 56e-6
VS48 26 s48 0
L48 s48 27 15e-5
VS49 10 s49 0
R49 s49 29 10e1
VS50 11 s50 0
C50 s50 16 82e-6
VS51 15 s51 0
R51 s51 12 12e2
VS52 5 s52 0
C52 s52 19 12e-6
VS53 24 s53 0
R53 s53 19 15e0
VS54 22 s54 0
L54 s54 19 82e-5
VS55 14 s55 0
C55 s55 18 56e-6
VS56 20 s56 0
R56 s56 15 27e2
.control
set numdgt=17
ac lin 1 60 60
print v(1) v(2) v(3) v(4) v(5) v(6) v(7) v(8) v(9) v(10)
print v(11) v(12) v(13) v(14) v(15) v(16) v(17) v(18) v(19) v(20)
print v(21) v(22) v(23) v(24) v(25) v(26) v(27) v(28) v(29)
print i(vs0) i(vs1) i(vs2) i(vs3) i(vs4) i(vs5) i(vs6) i(vs7) i(vs8) i(vs9)
print i(vs10) i(vs11) i(vs12) i(vs13) i(vs14) i(vs15) i(vs16) i(vs17) i(vs18) i(vs19)
print i(vs20) i(vs21) i(vs22) i(vs23) i(vs24) i(vs25) i(vs26) i(vs27) i(vs28) i(vs29)
print i(vs30) i(vs31) i(vs32) i(vs33) i(vs34) i(vs35) i(vs36) i(vs37) i(vs38) i(vs39)
print i(vs40) i(vs41) i(vs42) i(vs43) i(vs44) i(vs45) i(vs46) i(vs47) i(vs48) i(vs49)
print i(vs50) i(vs51) i(vs52) i(vs53) i(vs54) i(vs55) i(vs56)
.endc
.end
