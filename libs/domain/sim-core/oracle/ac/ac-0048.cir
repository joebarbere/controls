controls oracle ac-0048
* Generated (plan F2.7, ADR 0012): do not edit; regenerate with `pnpm sim oracle regen`. ac seed 20261031 index 48 nodes 27 elements 41
.options sparse gmin=1e-12 noopac
RG1 1 0 1000000000000
RG2 2 0 1000000000000
RG3 3 0 1000000000000
RG4 4 0 1000000000000
RG5 5 0 1000000000000
RG6 6 0 1000000000000
RG7 7 0 1000000000000
RG8 8 0 1000000000000
RG9 9 0 1000000000000
RG10 10 0 1000000000000
RG11 11 0 1000000000000
RG12 12 0 1000000000000
RG13 13 0 1000000000000
RG14 14 0 1000000000000
RG15 15 0 1000000000000
RG16 16 0 1000000000000
RG17 17 0 1000000000000
RG18 18 0 1000000000000
RG19 19 0 1000000000000
RG20 20 0 1000000000000
RG21 21 0 1000000000000
RG22 22 0 1000000000000
RG23 23 0 1000000000000
RG24 24 0 1000000000000
RG25 25 0 1000000000000
RG26 26 0 1000000000000
VS0 20 s0 0
R0 s0 10 15e-2
VS1 9 s1 0
L1 s1 14 10e-5
VS2 23 s2 0
R2 s2 24 82e1
VS3 1 s3 0
C3 s3 22 15e-7
VS4 20 s4 0
L4 s4 15 22e-2
VS5 23 s5 0
R5 s5 9 39e3
VS6 4 s6 0
R6 s6 17 56e0
VS7 0 s7 0
V7 e7 s7 DC 0 AC 47e1 0
RI7 e7 m7 27e-2
LI7 m7 4 68e-5
VS8 3 s8 0
L8 s8 9 10e-2
VS9 19 s9 0
R9 s9 13 33e0
VS10 17 s10 0
L10 s10 18 39e-2
VS11 8 s11 0
R11 s11 17 68e3
VS12 5 s12 0
L12 s12 16 82e-4
VS13 25 s13 0
V13 e13 s13 DC 0 AC 22e-1 180
RI13 e13 m13 22e-2
LI13 m13 14 10e-6
VS14 4 s14 0
V14 e14 s14 DC 0 AC 68e1 -120
RI14 e14 15 10e-2
VS15 22 s15 0
R15 s15 13 47e0
VS16 26 s16 0
V16 e16 s16 DC 0 AC 27e-1 120
RI16 e16 23 47e-3
VS17 17 s17 0
V17 e17 s17 DC 0 AC 47e-1 -120
RI17 e17 m17 33e-1
LI17 m17 21 18e-6
VS18 12 s18 0
R18 s18 3 39e3
VS19 8 s19 0
L19 s19 19 56e-5
VS20 23 s20 0
R20 s20 11 10e1
VS21 14 s21 0
V21 e21 s21 DC 0 AC 22e-1 180
RI21 e21 m21 22e-3
LI21 m21 9 47e-7
VS22 13 s22 0
V22 e22 s22 DC 0 AC 82e1 0
RI22 e22 m22 18e-2
LI22 m22 0 68e-7
VS23 19 s23 0
R23 s23 18 33e3
VS24 12 s24 0
L24 s24 10 56e-2
VS25 26 s25 0
R25 s25 21 15e2
VS26 18 s26 0
R26 s26 2 18e-2
VS27 2 s27 0
L27 s27 3 22e-2
VS28 19 s28 0
L28 s28 8 82e-5
VS29 10 s29 0
C29 s29 12 33e-4
VS30 6 s30 0
R30 s30 24 18e-1
VS31 5 s31 0
C31 s31 9 18e-6
VS32 13 s32 0
C32 s32 7 12e-4
VS33 20 s33 0
L33 s33 6 10e-3
VS34 21 s34 0
V34 e34 s34 DC 0 AC 15e1 180
RI34 e34 13 82e-2
VS35 4 s35 0
L35 s35 11 22e-3
VS36 15 s36 0
C36 s36 14 82e-7
VS37 15 s37 0
R37 s37 1 12e1
VS38 17 s38 0
R38 s38 16 10e3
VS39 20 s39 0
L39 s39 18 68e-4
VS40 7 s40 0
C40 s40 25 39e-6
.control
set numdgt=17
ac lin 1 60 60
print v(1) v(2) v(3) v(4) v(5) v(6) v(7) v(8) v(9) v(10)
print v(11) v(12) v(13) v(14) v(15) v(16) v(17) v(18) v(19) v(20)
print v(21) v(22) v(23) v(24) v(25) v(26)
print i(vs0) i(vs1) i(vs2) i(vs3) i(vs4) i(vs5) i(vs6) i(vs7) i(vs8) i(vs9)
print i(vs10) i(vs11) i(vs12) i(vs13) i(vs14) i(vs15) i(vs16) i(vs17) i(vs18) i(vs19)
print i(vs20) i(vs21) i(vs22) i(vs23) i(vs24) i(vs25) i(vs26) i(vs27) i(vs28) i(vs29)
print i(vs30) i(vs31) i(vs32) i(vs33) i(vs34) i(vs35) i(vs36) i(vs37) i(vs38) i(vs39)
print i(vs40)
.endc
.end
