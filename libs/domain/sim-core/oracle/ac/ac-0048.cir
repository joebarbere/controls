controls oracle ac-0048
* Generated (plan F2.7, ADR 0012): do not edit; regenerate with `pnpm sim oracle regen`. ac seed 20261031 index 48 nodes 27 elements 44
.options sparse gmin=1e-12 noopac
RG1 1 0 1000000000000
RG2 2 0 1000000000000
RG3 3 0 1000000000000
RG4 4 0 1000000000000
RG5 5 0 1000000000000
RG6 6 0 1000000000000
RG7 7 0 1000000000000
RG8 8 0 1000000000000
RG9 9 0 1000000000000
RG10 10 0 1000000000000
RG11 11 0 1000000000000
RG12 12 0 1000000000000
RG13 13 0 1000000000000
RG14 14 0 1000000000000
RG15 15 0 1000000000000
RG16 16 0 1000000000000
RG17 17 0 1000000000000
RG18 18 0 1000000000000
RG19 19 0 1000000000000
RG20 20 0 1000000000000
RG21 21 0 1000000000000
RG22 22 0 1000000000000
RG23 23 0 1000000000000
RG24 24 0 1000000000000
RG25 25 0 1000000000000
RG26 26 0 1000000000000
VS0 5 s0 0
C0 s0 0 56e-4
VS1 0 s1 0
V1 e1 s1 DC 0 AC 27e-1 -120
RI1 e1 m1 12e-2
LI1 m1 n1 15e-6
H1 n1 h1 VS7 27e-3
ED1 h1 12 d1 0 -12e-5
F1 0 d1 VS7 1
LD1 d1 0 1
VS2 8 s2 0
R2 s2 6 82e0
VS3 10 s3 0
L3 s3 15 22e-2
VS4 22 s4 0
L4 s4 19 82e-2
VS5 3 s5 0
L5 s5 22 12e-3
VS6 7 s6 0
R6 s6 2 39e-2
VS7 23 s7 0
V7 e7 s7 DC 0 AC 39e0 180
RI7 e7 n7 10e-1
H7 n7 h7 VS1 27e-3
ED7 h7 3 d7 0 -12e-5
F7 0 d7 VS1 1
LD7 d7 0 1
VS8 18 s8 0
R8 s8 21 27e3
VS9 2 s9 0
R9 s9 17 47e-1
VS10 18 s10 0
C10 s10 3 12e-6
VS11 8 s11 0
V11 e11 s11 DC 0 AC 68e1 0
RI11 e11 18 82e-3
VS12 2 s12 0
C12 s12 13 47e-7
VS13 2 s13 0
V13 e13 s13 DC 0 AC 56e0 -120
RI13 e13 m13 27e-2
LI13 m13 5 27e-5
VS14 20 s14 0
C14 s14 15 15e-7
VS15 15 s15 0
R15 s15 1 12e1
VS16 18 s16 0
R16 s16 9 82e0
VS17 3 s17 0
V17 e17 s17 DC 0 AC 12e1 -120
RI17 e17 m17 27e-3
LI17 m17 25 82e-7
VS18 24 s18 0
V18 e18 s18 DC 0 AC 68e1 -120
RI18 e18 10 18e-3
VS19 11 s19 0
L19 s19 12 22e-5
VS20 14 s20 0
R20 s20 25 15e2
VS21 23 s21 0
R21 s21 18 47e1
VS22 8 s22 0
L22 s22 2 22e-3
VS23 10 s23 0
L23 s23 11 18e-4
VS24 4 s24 0
V24 e24 s24 DC 0 AC 68e1 -120
RI24 e24 m24 10e-2
LI24 m24 15 47e-6
VS25 16 s25 0
L25 s25 2 10e-5
VS26 23 s26 0
C26 s26 7 27e-7
VS27 19 s27 0
C27 s27 15 27e-5
VS28 21 s28 0
C28 s28 0 15e-4
VS29 14 s29 0
L29 s29 4 27e-4
VS30 18 s30 0
C30 s30 9 33e-7
VS31 10 s31 0
R31 s31 0 15e-2
VS32 1 s32 0
C32 s32 16 10e-7
VS33 16 s33 0
V33 e33 s33 DC 0 AC 56e-1 180
RI33 e33 9 56e-3
VS34 13 s34 0
R34 s34 22 47e0
VS35 0 s35 0
V35 e35 s35 DC 0 AC 12e-1 120
RI35 e35 24 27e-2
VS36 4 s36 0
C36 s36 22 68e-5
VS37 17 s37 0
C37 s37 20 18e-4
VS38 10 s38 0
R38 s38 6 33e0
VS39 1 s39 0
R39 s39 26 27e-1
VS40 23 s40 0
V40 e40 s40 DC 0 AC 68e-1 120
RI40 e40 25 18e-3
VS41 26 s41 0
R41 s41 15 47e3
VS42 24 s42 0
R42 s42 18 56e-1
VS43 10 s43 0
L43 s43 17 22e-4
.control
set numdgt=17
ac lin 1 60 60
print v(1) v(2) v(3) v(4) v(5) v(6) v(7) v(8) v(9) v(10)
print v(11) v(12) v(13) v(14) v(15) v(16) v(17) v(18) v(19) v(20)
print v(21) v(22) v(23) v(24) v(25) v(26)
print i(vs0) i(vs1) i(vs2) i(vs3) i(vs4) i(vs5) i(vs6) i(vs7) i(vs8) i(vs9)
print i(vs10) i(vs11) i(vs12) i(vs13) i(vs14) i(vs15) i(vs16) i(vs17) i(vs18) i(vs19)
print i(vs20) i(vs21) i(vs22) i(vs23) i(vs24) i(vs25) i(vs26) i(vs27) i(vs28) i(vs29)
print i(vs30) i(vs31) i(vs32) i(vs33) i(vs34) i(vs35) i(vs36) i(vs37) i(vs38) i(vs39)
print i(vs40) i(vs41) i(vs42) i(vs43)
.endc
.end
