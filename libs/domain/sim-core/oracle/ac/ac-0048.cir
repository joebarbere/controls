controls oracle ac-0048
* Generated (plan F2.7, ADR 0012): do not edit; regenerate with `pnpm sim oracle regen`. ac seed 20261031 index 48 nodes 27 elements 37
.options sparse gmin=1e-12 noopac
RG1 1 0 1000000000000
RG2 2 0 1000000000000
RG3 3 0 1000000000000
RG4 4 0 1000000000000
RG5 5 0 1000000000000
RG6 6 0 1000000000000
RG7 7 0 1000000000000
RG8 8 0 1000000000000
RG9 9 0 1000000000000
RG10 10 0 1000000000000
RG11 11 0 1000000000000
RG12 12 0 1000000000000
RG13 13 0 1000000000000
RG14 14 0 1000000000000
RG15 15 0 1000000000000
RG16 16 0 1000000000000
RG17 17 0 1000000000000
RG18 18 0 1000000000000
RG19 19 0 1000000000000
RG20 20 0 1000000000000
RG21 21 0 1000000000000
RG22 22 0 1000000000000
RG23 23 0 1000000000000
RG24 24 0 1000000000000
RG25 25 0 1000000000000
RG26 26 0 1000000000000
VS0 10 s0 0
L0 s0 15 22e-2
VS1 0 s1 0
V1 e1 s1 DC 0 AC 27e-1 -120
RI1 e1 12 12e-2
VS2 10 s2 0
R2 s2 6 33e0
VS3 8 s3 0
L3 s3 2 22e-3
VS4 23 s4 0
R4 s4 18 47e1
VS5 26 s5 0
R5 s5 15 47e3
VS6 11 s6 0
L6 s6 12 22e-5
VS7 14 s7 0
L7 s7 4 27e-4
VS8 0 s8 0
V8 e8 s8 DC 0 AC 12e-1 120
RI8 e8 24 27e-2
VS9 10 s9 0
L9 s9 17 22e-4
VS10 3 s10 0
V10 e10 s10 DC 0 AC 12e1 -120
RI10 e10 25 27e-3
VS11 23 s11 0
V11 e11 s11 DC 0 AC 68e-1 120
RI11 e11 25 18e-3
VS12 4 s12 0
V12 e12 s12 DC 0 AC 68e1 -120
RI12 e12 15 10e-2
VS13 24 s13 0
V13 e13 s13 DC 0 AC 68e1 -120
RI13 e13 10 18e-3
VS14 23 s14 0
V14 e14 s14 DC 0 AC 39e0 180
RI14 e14 3 10e-1
VS15 13 s15 0
R15 s15 22 47e0
VS16 2 s16 0
R16 s16 17 47e-1
VS17 18 s17 0
C17 s17 3 12e-6
VS18 3 s18 0
L18 s18 22 12e-3
VS19 16 s19 0
L19 s19 2 10e-5
VS20 22 s20 0
L20 s20 19 82e-2
VS21 15 s21 0
R21 s21 1 12e1
VS22 14 s22 0
R22 s22 25 15e2
VS23 20 s23 0
C23 s23 15 15e-7
VS24 18 s24 0
C24 s24 9 33e-7
VS25 19 s25 0
C25 s25 15 27e-5
VS26 18 s26 0
R26 s26 9 82e0
VS27 17 s27 0
C27 s27 20 18e-4
VS28 10 s28 0
R28 s28 0 15e-2
VS29 7 s29 0
R29 s29 2 39e-2
VS30 1 s30 0
C30 s30 16 10e-7
VS31 18 s31 0
R31 s31 21 27e3
VS32 5 s32 0
C32 s32 0 56e-4
VS33 21 s33 0
C33 s33 0 15e-4
VS34 24 s34 0
R34 s34 18 56e-1
VS35 4 s35 0
C35 s35 22 68e-5
VS36 2 s36 0
C36 s36 13 47e-7
.control
set numdgt=17
ac lin 1 60 60
print v(1) v(2) v(3) v(4) v(5) v(6) v(7) v(8) v(9) v(10)
print v(11) v(12) v(13) v(14) v(15) v(16) v(17) v(18) v(19) v(20)
print v(21) v(22) v(23) v(24) v(25) v(26)
print i(vs0) i(vs1) i(vs2) i(vs3) i(vs4) i(vs5) i(vs6) i(vs7) i(vs8) i(vs9)
print i(vs10) i(vs11) i(vs12) i(vs13) i(vs14) i(vs15) i(vs16) i(vs17) i(vs18) i(vs19)
print i(vs20) i(vs21) i(vs22) i(vs23) i(vs24) i(vs25) i(vs26) i(vs27) i(vs28) i(vs29)
print i(vs30) i(vs31) i(vs32) i(vs33) i(vs34) i(vs35) i(vs36)
.endc
.end
