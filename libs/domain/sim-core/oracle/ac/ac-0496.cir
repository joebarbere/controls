controls oracle ac-0496
* Generated (plan F2.7, ADR 0012): do not edit; regenerate with `pnpm sim oracle regen`. ac seed 20261031 index 496 nodes 16 elements 23
.options sparse gmin=1e-12 noopac
RG1 1 0 1000000000000
RG2 2 0 1000000000000
RG3 3 0 1000000000000
RG4 4 0 1000000000000
RG5 5 0 1000000000000
RG6 6 0 1000000000000
RG7 7 0 1000000000000
RG8 8 0 1000000000000
RG9 9 0 1000000000000
RG10 10 0 1000000000000
RG11 11 0 1000000000000
RG12 12 0 1000000000000
RG13 13 0 1000000000000
RG14 14 0 1000000000000
RG15 15 0 1000000000000
VS0 14 s0 0
C0 s0 11 82e-6
VS1 14 s1 0
L1 s1 8 10e-2
VS2 2 s2 0
L2 s2 12 33e-5
VS3 7 s3 0
C3 s3 10 56e-6
VS4 1 s4 0
R4 s4 4 18e1
VS5 0 s5 0
V5 e5 s5 DC 0 AC 22e-1 0
RI5 e5 m5 56e-3
LI5 m5 n5 47e-7
H5 n5 h5 VS7 -27e-4
ED5 h5 15 d5 0 -27e-5
F5 0 d5 VS7 1
LD5 d5 0 1
VS6 4 s6 0
C6 s6 12 27e-6
VS7 4 s7 0
V7 e7 s7 DC 0 AC 22e1 180
RI7 e7 n7 15e-3
H7 n7 h7 VS5 -27e-4
ED7 h7 8 d7 0 -27e-5
F7 0 d7 VS5 1
LD7 d7 0 1
VS8 10 s8 0
L8 s8 1 18e-2
VS9 13 s9 0
C9 s9 9 56e-4
VS10 10 s10 0
R10 s10 9 39e-1
VS11 15 s11 0
V11 e11 s11 DC 0 AC 68e-1 0
RI11 e11 m11 33e-2
LI11 m11 7 56e-5
VS12 0 s12 0
V12 e12 s12 DC 0 AC 15e1 180
RI12 e12 12 82e-1
VS13 9 s13 0
L13 s13 14 18e-4
VS14 10 s14 0
R14 s14 12 27e2
VS15 0 s15 0
V15 e15 s15 DC 0 AC 47e-1 180
RI15 e15 m15 22e-3
LI15 m15 5 15e-7
VS16 8 s16 0
R16 s16 4 12e2
VS17 3 s17 0
R17 s17 1 22e0
VS18 4 s18 0
R18 s18 13 18e3
VS19 5 s19 0
L19 s19 4 22e-4
VS20 6 s20 0
L20 s20 3 15e-5
VS21 2 s21 0
C21 s21 6 33e-7
VS22 7 s22 0
C22 s22 11 15e-4
.control
set numdgt=17
ac lin 1 60 60
print v(1) v(2) v(3) v(4) v(5) v(6) v(7) v(8) v(9) v(10)
print v(11) v(12) v(13) v(14) v(15)
print i(vs0) i(vs1) i(vs2) i(vs3) i(vs4) i(vs5) i(vs6) i(vs7) i(vs8) i(vs9)
print i(vs10) i(vs11) i(vs12) i(vs13) i(vs14) i(vs15) i(vs16) i(vs17) i(vs18) i(vs19)
print i(vs20) i(vs21) i(vs22)
.endc
.end
