controls oracle ac-0496
* Generated (plan F2.7, ADR 0012): do not edit; regenerate with `pnpm sim oracle regen`. ac seed 20261031 index 496 nodes 16 elements 24
.options sparse gmin=1e-12 noopac
RG1 1 0 1000000000000
RG2 2 0 1000000000000
RG3 3 0 1000000000000
RG4 4 0 1000000000000
RG5 5 0 1000000000000
RG6 6 0 1000000000000
RG7 7 0 1000000000000
RG8 8 0 1000000000000
RG9 9 0 1000000000000
RG10 10 0 1000000000000
RG11 11 0 1000000000000
RG12 12 0 1000000000000
RG13 13 0 1000000000000
RG14 14 0 1000000000000
RG15 15 0 1000000000000
VS0 0 s0 0
V0 e0 s0 DC 0 AC 15e1 180
RI0 e0 12 82e-1
VS1 9 s1 0
R1 s1 5 47e-2
VS2 6 s2 0
L2 s2 3 15e-5
VS3 6 s3 0
R3 s3 8 33e0
VS4 7 s4 0
C4 s4 2 82e-5
VS5 8 s5 0
V5 e5 s5 DC 0 AC 18e1 120
RI5 e5 m5 82e-3
LI5 m5 2 82e-7
VS6 11 s6 0
V6 e6 s6 DC 0 AC 27e1 120
RI6 e6 m6 33e-3
LI6 m6 8 18e-7
VS7 15 s7 0
V7 e7 s7 DC 0 AC 33e0 0
RI7 e7 11 39e-1
VS8 10 s8 0
L8 s8 13 27e-4
VS9 13 s9 0
R9 s9 0 27e0
VS10 9 s10 0
L10 s10 1 27e-2
VS11 3 s11 0
C11 s11 7 22e-7
VS12 0 s12 0
R12 s12 8 39e0
VS13 2 s13 0
L13 s13 12 33e-5
VS14 12 s14 0
R14 s14 3 68e-2
VS15 8 s15 0
V15 e15 s15 DC 0 AC 15e0 -120
RI15 e15 3 27e-1
VS16 14 s16 0
L16 s16 13 22e-4
VS17 4 s17 0
C17 s17 12 27e-6
VS18 12 s18 0
C18 s18 15 33e-7
VS19 10 s19 0
R19 s19 12 27e2
VS20 1 s20 0
L20 s20 3 10e-2
VS21 0 s21 0
V21 e21 s21 DC 0 AC 47e-1 180
RI21 e21 5 22e-3
VS22 14 s22 0
C22 s22 11 82e-6
VS23 1 s23 0
R23 s23 4 18e1
.control
set numdgt=17
ac lin 1 60 60
print v(1) v(2) v(3) v(4) v(5) v(6) v(7) v(8) v(9) v(10)
print v(11) v(12) v(13) v(14) v(15)
print i(vs0) i(vs1) i(vs2) i(vs3) i(vs4) i(vs5) i(vs6) i(vs7) i(vs8) i(vs9)
print i(vs10) i(vs11) i(vs12) i(vs13) i(vs14) i(vs15) i(vs16) i(vs17) i(vs18) i(vs19)
print i(vs20) i(vs21) i(vs22) i(vs23)
.endc
.end
