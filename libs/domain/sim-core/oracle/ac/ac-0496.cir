controls oracle ac-0496
* Generated (plan F2.7, ADR 0012): do not edit; regenerate with `pnpm sim oracle regen`. ac seed 20261031 index 496 nodes 16 elements 21
.options sparse gmin=1e-12 noopac
RG1 1 0 1000000000000
RG2 2 0 1000000000000
RG3 3 0 1000000000000
RG4 4 0 1000000000000
RG5 5 0 1000000000000
RG6 6 0 1000000000000
RG7 7 0 1000000000000
RG8 8 0 1000000000000
RG9 9 0 1000000000000
RG10 10 0 1000000000000
RG11 11 0 1000000000000
RG12 12 0 1000000000000
RG13 13 0 1000000000000
RG14 14 0 1000000000000
RG15 15 0 1000000000000
VS0 6 s0 0
L0 s0 3 15e-5
VS1 9 s1 0
L1 s1 14 18e-4
VS2 10 s2 0
R2 s2 9 39e-1
VS3 0 s3 0
V3 e3 s3 DC 0 AC 68e-1 0
RI3 e3 7 33e-2
VS4 4 s4 0
R4 s4 13 18e3
VS5 1 s5 0
V5 e5 s5 DC 0 AC 22e-1 0
RI5 e5 0 56e-3
VS6 2 s6 0
C6 s6 6 33e-7
VS7 14 s7 0
C7 s7 11 82e-6
VS8 15 s8 0
R8 s8 4 18e1
VS9 7 s9 0
C9 s9 10 56e-6
VS10 4 s10 0
C10 s10 12 27e-6
VS11 10 s11 0
R11 s11 12 27e2
VS12 5 s12 0
L12 s12 4 22e-4
VS13 4 s13 0
V13 e13 s13 DC 0 AC 22e1 180
RI13 e13 8 15e-3
VS14 3 s14 0
R14 s14 15 22e0
VS15 7 s15 0
C15 s15 11 15e-4
VS16 1 s16 0
V16 e16 s16 DC 0 AC 15e1 180
RI16 e16 12 82e-1
VS17 2 s17 0
L17 s17 12 33e-5
VS18 10 s18 0
L18 s18 15 18e-2
VS19 8 s19 0
R19 s19 4 12e2
VS20 1 s20 0
V20 e20 s20 DC 0 AC 47e-1 180
RI20 e20 5 22e-3
.control
set numdgt=17
ac lin 1 60 60
print v(1) v(2) v(3) v(4) v(5) v(6) v(7) v(8) v(9) v(10)
print v(11) v(12) v(13) v(14) v(15)
print i(vs0) i(vs1) i(vs2) i(vs3) i(vs4) i(vs5) i(vs6) i(vs7) i(vs8) i(vs9)
print i(vs10) i(vs11) i(vs12) i(vs13) i(vs14) i(vs15) i(vs16) i(vs17) i(vs18) i(vs19)
print i(vs20)
.endc
.end
