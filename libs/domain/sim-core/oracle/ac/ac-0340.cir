controls oracle ac-0340
* Generated (plan F2.7, ADR 0012): do not edit; regenerate with `pnpm sim oracle regen`. ac seed 20261031 index 340 nodes 22 elements 34
.options sparse gmin=1e-12 noopac
RG1 1 0 1000000000000
RG2 2 0 1000000000000
RG3 3 0 1000000000000
RG4 4 0 1000000000000
RG5 5 0 1000000000000
RG6 6 0 1000000000000
RG7 7 0 1000000000000
RG8 8 0 1000000000000
RG9 9 0 1000000000000
RG10 10 0 1000000000000
RG11 11 0 1000000000000
RG12 12 0 1000000000000
RG13 13 0 1000000000000
RG14 14 0 1000000000000
RG15 15 0 1000000000000
RG16 16 0 1000000000000
RG17 17 0 1000000000000
RG18 18 0 1000000000000
RG19 19 0 1000000000000
RG20 20 0 1000000000000
RG21 21 0 1000000000000
VS0 7 s0 0
C0 s0 17 33e-4
VS1 0 s1 0
V1 e1 s1 DC 0 AC 18e-1 120
RI1 e1 m1 12e-3
LI1 m1 8 10e-6
VS2 16 s2 0
L2 s2 5 22e-2
VS3 1 s3 0
R3 s3 15 12e-2
VS4 14 s4 0
R4 s4 20 18e-1
VS5 13 s5 0
V5 e5 s5 DC 0 AC 56e1 180
RI5 e5 m5 82e-3
LI5 m5 20 15e-5
VS6 11 s6 0
L6 s6 12 22e-4
VS7 10 s7 0
V7 e7 s7 DC 0 AC 22e0 180
RI7 e7 8 33e-2
VS8 21 s8 0
C8 s8 2 12e-4
VS9 6 s9 0
V9 e9 s9 DC 0 AC 12e-1 120
RI9 e9 m9 10e-3
LI9 m9 19 33e-6
VS10 18 s10 0
R10 s10 6 18e-2
VS11 13 s11 0
L11 s11 17 18e-2
VS12 3 s12 0
V12 e12 s12 DC 0 AC 82e1 -120
RI12 e12 10 33e-1
VS13 17 s13 0
C13 s13 11 18e-4
VS14 18 s14 0
C14 s14 5 39e-7
VS15 13 s15 0
C15 s15 2 15e-7
VS16 21 s16 0
R16 s16 1 22e0
VS17 12 s17 0
C17 s17 1 56e-6
VS18 19 s18 0
V18 e18 s18 DC 0 AC 12e0 0
RI18 e18 m18 18e-2
LI18 m18 4 27e-6
VS19 1 s19 0
L19 s19 12 15e-5
VS20 4 s20 0
R20 s20 2 47e-1
VS21 16 s21 0
R21 s21 15 12e-1
VS22 15 s22 0
C22 s22 18 82e-5
VS23 10 s23 0
R23 s23 1 27e3
VS24 16 s24 0
R24 s24 20 68e1
VS25 1 s25 0
V25 e25 s25 DC 0 AC 10e1 120
RI25 e25 9 47e-3
VS26 0 s26 0
L26 s26 7 12e-3
VS27 3 s27 0
V27 e27 s27 DC 0 AC 10e-1 0
RI27 e27 18 12e-3
VS28 11 s28 0
C28 s28 1 47e-5
VS29 15 s29 0
V29 e29 s29 DC 0 AC 10e1 180
RI29 e29 m29 82e-2
LI29 m29 18 10e-5
VS30 16 s30 0
V30 e30 s30 DC 0 AC 47e0 -120
RI30 e30 1 82e-2
VS31 19 s31 0
R31 s31 7 22e2
VS32 18 s32 0
V32 e32 s32 DC 0 AC 33e0 120
RI32 e32 m32 18e-3
LI32 m32 14 18e-5
VS33 7 s33 0
R33 s33 9 18e-1
.control
set numdgt=17
ac lin 1 60 60
print v(1) v(2) v(3) v(4) v(5) v(6) v(7) v(8) v(9) v(10)
print v(11) v(12) v(13) v(14) v(15) v(16) v(17) v(18) v(19) v(20)
print v(21)
print i(vs0) i(vs1) i(vs2) i(vs3) i(vs4) i(vs5) i(vs6) i(vs7) i(vs8) i(vs9)
print i(vs10) i(vs11) i(vs12) i(vs13) i(vs14) i(vs15) i(vs16) i(vs17) i(vs18) i(vs19)
print i(vs20) i(vs21) i(vs22) i(vs23) i(vs24) i(vs25) i(vs26) i(vs27) i(vs28) i(vs29)
print i(vs30) i(vs31) i(vs32) i(vs33)
.endc
.end
