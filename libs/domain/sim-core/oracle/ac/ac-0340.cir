controls oracle ac-0340
* Generated (plan F2.7, ADR 0012): do not edit; regenerate with `pnpm sim oracle regen`. ac seed 20261031 index 340 nodes 22 elements 39
.options sparse gmin=1e-12 noopac
RG1 1 0 1000000000000
RG2 2 0 1000000000000
RG3 3 0 1000000000000
RG4 4 0 1000000000000
RG5 5 0 1000000000000
RG6 6 0 1000000000000
RG7 7 0 1000000000000
RG8 8 0 1000000000000
RG9 9 0 1000000000000
RG10 10 0 1000000000000
RG11 11 0 1000000000000
RG12 12 0 1000000000000
RG13 13 0 1000000000000
RG14 14 0 1000000000000
RG15 15 0 1000000000000
RG16 16 0 1000000000000
RG17 17 0 1000000000000
RG18 18 0 1000000000000
RG19 19 0 1000000000000
RG20 20 0 1000000000000
RG21 21 0 1000000000000
VS0 14 s0 0
R0 s0 8 56e1
VS1 1 s1 0
R1 s1 9 47e3
VS2 12 s2 0
R2 s2 5 82e1
VS3 4 s3 0
L3 s3 6 10e-5
VS4 7 s4 0
R4 s4 20 15e-1
VS5 13 s5 0
C5 s5 8 82e-6
VS6 7 s6 0
L6 s6 4 39e-3
VS7 0 s7 0
V7 e7 s7 DC 0 AC 12e-1 -120
RI7 e7 16 68e-2
VS8 2 s8 0
R8 s8 12 39e3
VS9 1 s9 0
V9 e9 s9 DC 0 AC 56e0 180
RI9 e9 13 47e-1
VS10 6 s10 0
C10 s10 21 15e-6
VS11 7 s11 0
L11 s11 17 12e-2
VS12 3 s12 0
R12 s12 21 15e3
VS13 17 s13 0
V13 e13 s13 DC 0 AC 18e0 0
RI13 e13 7 56e-2
VS14 16 s14 0
V14 e14 s14 DC 0 AC 18e0 120
RI14 e14 18 10e-3
VS15 0 s15 0
C15 s15 14 18e-6
VS16 10 s16 0
R16 s16 21 82e2
VS17 19 s17 0
R17 s17 1 10e1
VS18 19 s18 0
C18 s18 8 27e-4
VS19 8 s19 0
V19 e19 s19 DC 0 AC 10e1 0
RI19 e19 12 27e-3
VS20 3 s20 0
R20 s20 4 27e-1
VS21 4 s21 0
L21 s21 13 27e-5
VS22 1 s22 0
R22 s22 21 12e-1
VS23 8 s23 0
L23 s23 10 39e-4
VS24 21 s24 0
R24 s24 20 56e1
VS25 9 s25 0
V25 e25 s25 DC 0 AC 82e1 -120
RI25 e25 12 33e-1
VS26 7 s26 0
L26 s26 5 22e-5
VS27 0 s27 0
C27 s27 10 18e-6
VS28 11 s28 0
R28 s28 9 22e-2
VS29 8 s29 0
L29 s29 15 47e-2
VS30 16 s30 0
V30 e30 s30 DC 0 AC 47e0 -120
RI30 e30 8 82e-2
VS31 6 s31 0
R31 s31 20 82e3
VS32 14 s32 0
R32 s32 18 47e3
VS33 0 s33 0
C33 s33 7 47e-6
VS34 21 s34 0
R34 s34 4 12e2
VS35 11 s35 0
C35 s35 6 33e-5
VS36 15 s36 0
C36 s36 9 18e-7
VS37 17 s37 0
R37 s37 1 15e-1
VS38 18 s38 0
C38 s38 2 33e-4
.control
set numdgt=17
ac lin 1 60 60
print v(1) v(2) v(3) v(4) v(5) v(6) v(7) v(8) v(9) v(10)
print v(11) v(12) v(13) v(14) v(15) v(16) v(17) v(18) v(19) v(20)
print v(21)
print i(vs0) i(vs1) i(vs2) i(vs3) i(vs4) i(vs5) i(vs6) i(vs7) i(vs8) i(vs9)
print i(vs10) i(vs11) i(vs12) i(vs13) i(vs14) i(vs15) i(vs16) i(vs17) i(vs18) i(vs19)
print i(vs20) i(vs21) i(vs22) i(vs23) i(vs24) i(vs25) i(vs26) i(vs27) i(vs28) i(vs29)
print i(vs30) i(vs31) i(vs32) i(vs33) i(vs34) i(vs35) i(vs36) i(vs37) i(vs38)
.endc
.end
