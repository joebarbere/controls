controls oracle ac-0340
* Generated (plan F2.7, ADR 0012): do not edit; regenerate with `pnpm sim oracle regen`. ac seed 20261031 index 340 nodes 22 elements 37
.options sparse gmin=1e-12 noopac
RG1 1 0 1000000000000
RG2 2 0 1000000000000
RG3 3 0 1000000000000
RG4 4 0 1000000000000
RG5 5 0 1000000000000
RG6 6 0 1000000000000
RG7 7 0 1000000000000
RG8 8 0 1000000000000
RG9 9 0 1000000000000
RG10 10 0 1000000000000
RG11 11 0 1000000000000
RG12 12 0 1000000000000
RG13 13 0 1000000000000
RG14 14 0 1000000000000
RG15 15 0 1000000000000
RG16 16 0 1000000000000
RG17 17 0 1000000000000
RG18 18 0 1000000000000
RG19 19 0 1000000000000
RG20 20 0 1000000000000
RG21 21 0 1000000000000
VS0 4 s0 0
L0 s0 6 10e-5
VS1 8 s1 0
C1 s1 14 18e-6
VS2 6 s2 0
R2 s2 20 82e3
VS3 7 s3 0
L3 s3 4 39e-3
VS4 19 s4 0
C4 s4 17 27e-4
VS5 7 s5 0
L5 s5 0 12e-2
VS6 21 s6 0
R6 s6 20 56e1
VS7 0 s7 0
V7 e7 s7 DC 0 AC 18e0 0
RI7 e7 7 56e-2
VS8 21 s8 0
R8 s8 4 12e2
VS9 3 s9 0
R9 s9 21 15e3
VS10 0 s10 0
R10 s10 1 15e-1
VS11 1 s11 0
R11 s11 9 47e3
VS12 11 s12 0
R12 s12 9 22e-2
VS13 1 s13 0
R13 s13 21 12e-1
VS14 10 s14 0
R14 s14 21 82e2
VS15 2 s15 0
R15 s15 12 39e3
VS16 13 s16 0
C16 s16 17 82e-6
VS17 6 s17 0
C17 s17 21 15e-6
VS18 8 s18 0
C18 s18 10 18e-6
VS19 4 s19 0
L19 s19 13 27e-5
VS20 18 s20 0
C20 s20 2 33e-4
VS21 17 s21 0
L21 s21 15 47e-2
VS22 1 s22 0
V22 e22 s22 DC 0 AC 56e0 180
RI22 e22 13 47e-1
VS23 16 s23 0
V23 e23 s23 DC 0 AC 18e0 120
RI23 e23 18 10e-3
VS24 8 s24 0
V24 e24 s24 DC 0 AC 12e-1 -120
RI24 e24 16 68e-2
VS25 11 s25 0
C25 s25 6 33e-5
VS26 7 s26 0
L26 s26 5 22e-5
VS27 17 s27 0
L27 s27 10 39e-4
VS28 16 s28 0
V28 e28 s28 DC 0 AC 47e0 -120
RI28 e28 17 82e-2
VS29 9 s29 0
V29 e29 s29 DC 0 AC 82e1 -120
RI29 e29 12 33e-1
VS30 12 s30 0
R30 s30 5 82e1
VS31 14 s31 0
R31 s31 17 56e1
VS32 14 s32 0
R32 s32 18 47e3
VS33 8 s33 0
C33 s33 7 47e-6
VS34 7 s34 0
R34 s34 20 15e-1
VS35 17 s35 0
V35 e35 s35 DC 0 AC 10e1 0
RI35 e35 12 27e-3
VS36 3 s36 0
R36 s36 4 27e-1
.control
set numdgt=17
ac lin 1 60 60
print v(1) v(2) v(3) v(4) v(5) v(6) v(7) v(8) v(9) v(10)
print v(11) v(12) v(13) v(14) v(15) v(16) v(17) v(18) v(19) v(20)
print v(21)
print i(vs0) i(vs1) i(vs2) i(vs3) i(vs4) i(vs5) i(vs6) i(vs7) i(vs8) i(vs9)
print i(vs10) i(vs11) i(vs12) i(vs13) i(vs14) i(vs15) i(vs16) i(vs17) i(vs18) i(vs19)
print i(vs20) i(vs21) i(vs22) i(vs23) i(vs24) i(vs25) i(vs26) i(vs27) i(vs28) i(vs29)
print i(vs30) i(vs31) i(vs32) i(vs33) i(vs34) i(vs35) i(vs36)
.endc
.end
