controls oracle ac-0135
* Generated (plan F2.7, ADR 0012): do not edit; regenerate with `pnpm sim oracle regen`. ac seed 20261031 index 135 nodes 23 elements 44
.options sparse gmin=1e-12 noopac
RG1 1 0 1000000000000
RG2 2 0 1000000000000
RG3 3 0 1000000000000
RG4 4 0 1000000000000
RG5 5 0 1000000000000
RG6 6 0 1000000000000
RG7 7 0 1000000000000
RG8 8 0 1000000000000
RG9 9 0 1000000000000
RG10 10 0 1000000000000
RG11 11 0 1000000000000
RG12 12 0 1000000000000
RG13 13 0 1000000000000
RG14 14 0 1000000000000
RG15 15 0 1000000000000
RG16 16 0 1000000000000
RG17 17 0 1000000000000
RG18 18 0 1000000000000
RG19 19 0 1000000000000
RG20 20 0 1000000000000
RG21 21 0 1000000000000
RG22 22 0 1000000000000
VS0 1 s0 0
L0 s0 3 56e-3
VS1 0 s1 0
V1 e1 s1 DC 0 AC 10e0 0
RI1 e1 18 56e-1
VS2 9 s2 0
L2 s2 1 10e-4
VS3 14 s3 0
V3 e3 s3 DC 0 AC 12e0 120
RI3 e3 1 33e-2
VS4 1 s4 0
V4 e4 s4 DC 0 AC 10e1 -120
RI4 e4 5 82e-2
VS5 11 s5 0
C5 s5 21 15e-5
VS6 2 s6 0
C6 s6 15 27e-7
VS7 6 s7 0
L7 s7 12 47e-3
VS8 5 s8 0
R8 s8 4 10e-1
VS9 11 s9 0
L9 s9 17 22e-2
VS10 13 s10 0
V10 e10 s10 DC 0 AC 47e1 180
RI10 e10 20 22e-2
VS11 2 s11 0
R11 s11 12 56e0
VS12 0 s12 0
R12 s12 17 33e0
VS13 4 s13 0
L13 s13 1 56e-2
VS14 13 s14 0
R14 s14 17 12e2
VS15 17 s15 0
L15 s15 0 68e-3
VS16 16 s16 0
R16 s16 7 68e0
VS17 4 s17 0
L17 s17 22 68e-2
VS18 16 s18 0
L18 s18 13 47e-2
VS19 17 s19 0
C19 s19 5 33e-6
VS20 8 s20 0
V20 e20 s20 DC 0 AC 82e-1 180
RI20 e20 20 15e-3
VS21 4 s21 0
R21 s21 5 56e-2
VS22 13 s22 0
L22 s22 3 56e-3
VS23 14 s23 0
R23 s23 16 10e0
VS24 4 s24 0
C24 s24 19 12e-5
VS25 15 s25 0
C25 s25 2 39e-4
VS26 11 s26 0
V26 e26 s26 DC 0 AC 10e1 120
RI26 e26 5 68e-1
VS27 10 s27 0
R27 s27 18 47e-2
VS28 14 s28 0
C28 s28 8 82e-4
VS29 9 s29 0
R29 s29 13 33e0
VS30 10 s30 0
L30 s30 14 56e-3
VS31 11 s31 0
V31 e31 s31 DC 0 AC 22e0 0
RI31 e31 13 22e-3
VS32 21 s32 0
L32 s32 4 56e-4
VS33 15 s33 0
L33 s33 5 56e-4
VS34 10 s34 0
R34 s34 15 22e-1
VS35 15 s35 0
R35 s35 3 47e3
VS36 17 s36 0
C36 s36 11 82e-7
VS37 8 s37 0
C37 s37 13 47e-7
VS38 6 s38 0
L38 s38 14 12e-5
VS39 11 s39 0
R39 s39 19 33e2
VS40 5 s40 0
L40 s40 9 56e-4
VS41 19 s41 0
L41 s41 18 33e-3
VS42 3 s42 0
R42 s42 20 10e2
VS43 10 s43 0
R43 s43 2 10e1
.control
set numdgt=17
ac lin 1 60 60
print v(1) v(2) v(3) v(4) v(5) v(6) v(7) v(8) v(9) v(10)
print v(11) v(12) v(13) v(14) v(15) v(16) v(17) v(18) v(19) v(20)
print v(21) v(22)
print i(vs0) i(vs1) i(vs2) i(vs3) i(vs4) i(vs5) i(vs6) i(vs7) i(vs8) i(vs9)
print i(vs10) i(vs11) i(vs12) i(vs13) i(vs14) i(vs15) i(vs16) i(vs17) i(vs18) i(vs19)
print i(vs20) i(vs21) i(vs22) i(vs23) i(vs24) i(vs25) i(vs26) i(vs27) i(vs28) i(vs29)
print i(vs30) i(vs31) i(vs32) i(vs33) i(vs34) i(vs35) i(vs36) i(vs37) i(vs38) i(vs39)
print i(vs40) i(vs41) i(vs42) i(vs43)
.endc
.end
