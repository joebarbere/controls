controls oracle ac-0135
* Generated (plan F2.7, ADR 0012): do not edit; regenerate with `pnpm sim oracle regen`. ac seed 20261031 index 135 nodes 23 elements 33
.options sparse gmin=1e-12 noopac
RG1 1 0 1000000000000
RG2 2 0 1000000000000
RG3 3 0 1000000000000
RG4 4 0 1000000000000
RG5 5 0 1000000000000
RG6 6 0 1000000000000
RG7 7 0 1000000000000
RG8 8 0 1000000000000
RG9 9 0 1000000000000
RG10 10 0 1000000000000
RG11 11 0 1000000000000
RG12 12 0 1000000000000
RG13 13 0 1000000000000
RG14 14 0 1000000000000
RG15 15 0 1000000000000
RG16 16 0 1000000000000
RG17 17 0 1000000000000
RG18 18 0 1000000000000
RG19 19 0 1000000000000
RG20 20 0 1000000000000
RG21 21 0 1000000000000
RG22 22 0 1000000000000
VS0 17 s0 0
C0 s0 18 47e-5
VS1 13 s1 0
R1 s1 16 82e3
VS2 11 s2 0
R2 s2 22 12e2
VS3 2 s3 0
C3 s3 3 56e-6
VS4 13 s4 0
R4 s4 9 56e3
VS5 9 s5 0
R5 s5 4 18e1
VS6 11 s6 0
R6 s6 4 27e3
VS7 0 s7 0
V7 e7 s7 DC 0 AC 22e0 0
RI7 e7 13 22e-3
VS8 11 s8 0
R8 s8 20 10e0
VS9 1 s9 0
R9 s9 19 33e0
VS10 7 s10 0
L10 s10 6 47e-3
VS11 15 s11 0
V11 e11 s11 DC 0 AC 18e-1 180
RI11 e11 14 22e-2
VS12 16 s12 0
V12 e12 s12 DC 0 AC 27e1 120
RI12 e12 21 33e-3
VS13 0 s13 0
R13 s13 11 33e2
VS14 15 s14 0
R14 s14 21 47e1
VS15 14 s15 0
L15 s15 20 47e-3
VS16 8 s16 0
C16 s16 1 56e-6
VS17 9 s17 0
L17 s17 14 27e-2
VS18 13 s18 0
R18 s18 4 12e1
VS19 3 s19 0
C19 s19 13 68e-4
VS20 22 s20 0
L20 s20 16 47e-3
VS21 17 s21 0
R21 s21 5 47e2
VS22 4 s22 0
L22 s22 7 10e-4
VS23 6 s23 0
L23 s23 12 47e-3
VS24 19 s24 0
L24 s24 5 10e-5
VS25 10 s25 0
R25 s25 6 27e-2
VS26 2 s26 0
R26 s26 1 47e-2
VS27 6 s27 0
C27 s27 4 47e-5
VS28 11 s28 0
R28 s28 17 82e3
VS29 10 s29 0
V29 e29 s29 DC 0 AC 82e-1 180
RI29 e29 m29 15e-3
LI29 m29 2 10e-5
VS30 8 s30 0
R30 s30 11 22e-1
VS31 3 s31 0
L31 s31 12 39e-5
VS32 15 s32 0
V32 e32 s32 DC 0 AC 10e1 -120
RI32 e32 m32 82e-2
LI32 m32 18 33e-7
.control
set numdgt=17
ac lin 1 60 60
print v(1) v(2) v(3) v(4) v(5) v(6) v(7) v(8) v(9) v(10)
print v(11) v(12) v(13) v(14) v(15) v(16) v(17) v(18) v(19) v(20)
print v(21) v(22)
print i(vs0) i(vs1) i(vs2) i(vs3) i(vs4) i(vs5) i(vs6) i(vs7) i(vs8) i(vs9)
print i(vs10) i(vs11) i(vs12) i(vs13) i(vs14) i(vs15) i(vs16) i(vs17) i(vs18) i(vs19)
print i(vs20) i(vs21) i(vs22) i(vs23) i(vs24) i(vs25) i(vs26) i(vs27) i(vs28) i(vs29)
print i(vs30) i(vs31) i(vs32)
.endc
.end
