controls oracle ac-0135
* Generated (plan F2.7, ADR 0012): do not edit; regenerate with `pnpm sim oracle regen`. ac seed 20261031 index 135 nodes 23 elements 46
.options sparse gmin=1e-12 noopac
RG1 1 0 1000000000000
RG2 2 0 1000000000000
RG3 3 0 1000000000000
RG4 4 0 1000000000000
RG5 5 0 1000000000000
RG6 6 0 1000000000000
RG7 7 0 1000000000000
RG8 8 0 1000000000000
RG9 9 0 1000000000000
RG10 10 0 1000000000000
RG11 11 0 1000000000000
RG12 12 0 1000000000000
RG13 13 0 1000000000000
RG14 14 0 1000000000000
RG15 15 0 1000000000000
RG16 16 0 1000000000000
RG17 17 0 1000000000000
RG18 18 0 1000000000000
RG19 19 0 1000000000000
RG20 20 0 1000000000000
RG21 21 0 1000000000000
RG22 22 0 1000000000000
VS0 14 s0 0
C0 s0 8 82e-4
VS1 15 s1 0
L1 s1 5 56e-4
VS2 4 s2 0
C2 s2 19 12e-5
VS3 10 s3 0
L3 s3 14 56e-3
VS4 0 s4 0
R4 s4 17 33e0
VS5 5 s5 0
L5 s5 9 56e-4
VS6 10 s6 0
R6 s6 15 22e-1
VS7 0 s7 0
V7 e7 s7 DC 0 AC 10e0 0
RI7 e7 n7 56e-1
H7 n7 h7 VS16 39e-2
ED7 h7 18 d7 0 68e-5
F7 0 d7 VS16 1
LD7 d7 0 1
VS8 17 s8 0
C8 s8 11 82e-7
VS9 11 s9 0
L9 s9 17 22e-2
VS10 4 s10 0
R10 s10 5 56e-2
VS11 2 s11 0
R11 s11 12 56e0
VS12 6 s12 0
L12 s12 12 47e-3
VS13 4 s13 0
L13 s13 1 56e-2
VS14 16 s14 0
L14 s14 13 47e-2
VS15 11 s15 0
C15 s15 21 15e-5
VS16 22 s16 0
V16 e16 s16 DC 0 AC 82e-1 0
RI16 e16 m16 56e-1
LI16 m16 n16 47e-6
H16 n16 h16 VS7 39e-2
ED16 h16 21 d16 0 68e-5
F16 0 d16 VS7 1
LD16 d16 0 1
VS17 10 s17 0
R17 s17 2 10e1
VS18 17 s18 0
C18 s18 5 33e-6
VS19 13 s19 0
V19 e19 s19 DC 0 AC 47e1 180
RI19 e19 20 22e-2
VS20 1 s20 0
V20 e20 s20 DC 0 AC 10e1 -120
RI20 e20 5 82e-2
VS21 13 s21 0
L21 s21 3 56e-3
VS22 8 s22 0
V22 e22 s22 DC 0 AC 82e-1 180
RI22 e22 20 15e-3
VS23 13 s23 0
R23 s23 17 12e2
VS24 11 s24 0
R24 s24 19 33e2
VS25 8 s25 0
C25 s25 13 47e-7
VS26 4 s26 0
L26 s26 22 68e-2
VS27 19 s27 0
L27 s27 18 33e-3
VS28 14 s28 0
V28 e28 s28 DC 0 AC 12e0 120
RI28 e28 m28 33e-2
LI28 m28 1 39e-5
VS29 15 s29 0
C29 s29 2 39e-4
VS30 15 s30 0
R30 s30 3 47e3
VS31 11 s31 0
V31 e31 s31 DC 0 AC 22e0 0
RI31 e31 m31 22e-3
LI31 m31 13 33e-5
VS32 9 s32 0
L32 s32 1 10e-4
VS33 1 s33 0
L33 s33 3 56e-3
VS34 10 s34 0
R34 s34 18 47e-2
VS35 17 s35 0
L35 s35 0 68e-3
VS36 2 s36 0
C36 s36 15 27e-7
VS37 9 s37 0
R37 s37 13 33e0
VS38 16 s38 0
R38 s38 7 68e0
VS39 11 s39 0
V39 e39 s39 DC 0 AC 10e1 120
RI39 e39 m39 68e-1
LI39 m39 5 10e-5
VS40 6 s40 0
L40 s40 14 12e-5
VS41 21 s41 0
L41 s41 4 56e-4
VS42 3 s42 0
R42 s42 20 10e2
VS43 15 s43 0
V43 e43 s43 DC 0 AC 10e-1 0
RI43 e43 7 18e-3
VS44 14 s44 0
R44 s44 16 10e0
VS45 5 s45 0
R45 s45 4 10e-1
.control
set numdgt=17
ac lin 1 60 60
print v(1) v(2) v(3) v(4) v(5) v(6) v(7) v(8) v(9) v(10)
print v(11) v(12) v(13) v(14) v(15) v(16) v(17) v(18) v(19) v(20)
print v(21) v(22)
print i(vs0) i(vs1) i(vs2) i(vs3) i(vs4) i(vs5) i(vs6) i(vs7) i(vs8) i(vs9)
print i(vs10) i(vs11) i(vs12) i(vs13) i(vs14) i(vs15) i(vs16) i(vs17) i(vs18) i(vs19)
print i(vs20) i(vs21) i(vs22) i(vs23) i(vs24) i(vs25) i(vs26) i(vs27) i(vs28) i(vs29)
print i(vs30) i(vs31) i(vs32) i(vs33) i(vs34) i(vs35) i(vs36) i(vs37) i(vs38) i(vs39)
print i(vs40) i(vs41) i(vs42) i(vs43) i(vs44) i(vs45)
.endc
.end
