controls oracle ac-0148
* Generated (plan F2.7, ADR 0012): do not edit; regenerate with `pnpm sim oracle regen`. ac seed 20261031 index 148 nodes 27 elements 52
.options sparse gmin=1e-12 noopac
RG1 1 0 1000000000000
RG2 2 0 1000000000000
RG3 3 0 1000000000000
RG4 4 0 1000000000000
RG5 5 0 1000000000000
RG6 6 0 1000000000000
RG7 7 0 1000000000000
RG8 8 0 1000000000000
RG9 9 0 1000000000000
RG10 10 0 1000000000000
RG11 11 0 1000000000000
RG12 12 0 1000000000000
RG13 13 0 1000000000000
RG14 14 0 1000000000000
RG15 15 0 1000000000000
RG16 16 0 1000000000000
RG17 17 0 1000000000000
RG18 18 0 1000000000000
RG19 19 0 1000000000000
RG20 20 0 1000000000000
RG21 21 0 1000000000000
RG22 22 0 1000000000000
RG23 23 0 1000000000000
RG24 24 0 1000000000000
RG25 25 0 1000000000000
RG26 26 0 1000000000000
VS0 17 s0 0
R0 s0 0 39e-1
VS1 24 s1 0
R1 s1 26 12e2
VS2 8 s2 0
C2 s2 7 56e-7
VS3 12 s3 0
C3 s3 20 18e-7
VS4 0 s4 0
V4 e4 s4 DC 0 AC 39e0 -120
RI4 e4 6 10e-3
VS5 17 s5 0
R5 s5 10 27e-1
VS6 24 s6 0
C6 s6 25 10e-7
VS7 5 s7 0
C7 s7 3 39e-5
VS8 8 s8 0
V8 e8 s8 DC 0 AC 10e-1 180
RI8 e8 15 18e-2
VS9 23 s9 0
C9 s9 7 39e-5
VS10 6 s10 0
R10 s10 25 82e3
VS11 6 s11 0
R11 s11 1 22e2
VS12 11 s12 0
L12 s12 18 82e-2
VS13 14 s13 0
R13 s13 24 39e2
VS14 0 s14 0
L14 s14 2 33e-2
VS15 1 s15 0
C15 s15 22 82e-5
VS16 21 s16 0
R16 s16 17 68e2
VS17 14 s17 0
L17 s17 3 39e-4
VS18 16 s18 0
C18 s18 8 47e-5
VS19 7 s19 0
R19 s19 3 15e-2
VS20 10 s20 0
L20 s20 14 68e-5
VS21 14 s21 0
V21 e21 s21 DC 0 AC 27e-1 180
RI21 e21 18 12e-3
VS22 1 s22 0
L22 s22 5 56e-3
VS23 1 s23 0
L23 s23 10 47e-3
VS24 2 s24 0
V24 e24 s24 DC 0 AC 39e0 0
RI24 e24 22 22e-2
VS25 11 s25 0
R25 s25 17 68e1
VS26 19 s26 0
R26 s26 1 18e-1
VS27 2 s27 0
V27 e27 s27 DC 0 AC 68e-1 120
RI27 e27 20 82e-3
VS28 11 s28 0
V28 e28 s28 DC 0 AC 47e1 -120
RI28 e28 5 33e-1
VS29 10 s29 0
R29 s29 11 68e-1
VS30 6 s30 0
C30 s30 5 12e-5
VS31 16 s31 0
R31 s31 2 27e2
VS32 26 s32 0
R32 s32 4 27e1
VS33 1 s33 0
V33 e33 s33 DC 0 AC 68e0 120
RI33 e33 4 33e-3
VS34 25 s34 0
V34 e34 s34 DC 0 AC 15e-1 180
RI34 e34 21 27e-1
VS35 24 s35 0
C35 s35 21 82e-6
VS36 6 s36 0
C36 s36 8 15e-4
VS37 3 s37 0
L37 s37 22 22e-2
VS38 18 s38 0
R38 s38 17 39e2
VS39 9 s39 0
L39 s39 4 22e-4
VS40 10 s40 0
R40 s40 16 82e2
VS41 13 s41 0
R41 s41 12 47e-1
VS42 0 s42 0
V42 e42 s42 DC 0 AC 10e1 120
RI42 e42 9 10e-2
VS43 1 s43 0
V43 e43 s43 DC 0 AC 68e1 -120
RI43 e43 20 22e-3
VS44 15 s44 0
R44 s44 6 39e1
VS45 16 s45 0
L45 s45 11 56e-4
VS46 21 s46 0
L46 s46 23 68e-3
VS47 13 s47 0
R47 s47 18 12e-2
VS48 6 s48 0
L48 s48 14 33e-3
VS49 24 s49 0
R49 s49 25 68e-2
VS50 1 s50 0
L50 s50 7 12e-5
VS51 17 s51 0
L51 s51 16 22e-4
.control
set numdgt=17
ac lin 1 60 60
print v(1) v(2) v(3) v(4) v(5) v(6) v(7) v(8) v(9) v(10)
print v(11) v(12) v(13) v(14) v(15) v(16) v(17) v(18) v(19) v(20)
print v(21) v(22) v(23) v(24) v(25) v(26)
print i(vs0) i(vs1) i(vs2) i(vs3) i(vs4) i(vs5) i(vs6) i(vs7) i(vs8) i(vs9)
print i(vs10) i(vs11) i(vs12) i(vs13) i(vs14) i(vs15) i(vs16) i(vs17) i(vs18) i(vs19)
print i(vs20) i(vs21) i(vs22) i(vs23) i(vs24) i(vs25) i(vs26) i(vs27) i(vs28) i(vs29)
print i(vs30) i(vs31) i(vs32) i(vs33) i(vs34) i(vs35) i(vs36) i(vs37) i(vs38) i(vs39)
print i(vs40) i(vs41) i(vs42) i(vs43) i(vs44) i(vs45) i(vs46) i(vs47) i(vs48) i(vs49)
print i(vs50) i(vs51)
.endc
.end
