controls oracle ac-0148
* Generated (plan F2.7, ADR 0012): do not edit; regenerate with `pnpm sim oracle regen`. ac seed 20261031 index 148 nodes 27 elements 54
.options sparse gmin=1e-12 noopac
RG1 1 0 1000000000000
RG2 2 0 1000000000000
RG3 3 0 1000000000000
RG4 4 0 1000000000000
RG5 5 0 1000000000000
RG6 6 0 1000000000000
RG7 7 0 1000000000000
RG8 8 0 1000000000000
RG9 9 0 1000000000000
RG10 10 0 1000000000000
RG11 11 0 1000000000000
RG12 12 0 1000000000000
RG13 13 0 1000000000000
RG14 14 0 1000000000000
RG15 15 0 1000000000000
RG16 16 0 1000000000000
RG17 17 0 1000000000000
RG18 18 0 1000000000000
RG19 19 0 1000000000000
RG20 20 0 1000000000000
RG21 21 0 1000000000000
RG22 22 0 1000000000000
RG23 23 0 1000000000000
RG24 24 0 1000000000000
RG25 25 0 1000000000000
RG26 26 0 1000000000000
VS0 0 s0 0
V0 e0 s0 DC 0 AC 68e1 -120
RI0 e0 m0 22e-3
LI0 m0 20 47e-5
VS1 6 s1 0
C1 s1 17 68e-7
VS2 21 s2 0
L2 s2 23 68e-3
VS3 19 s3 0
R3 s3 0 18e-1
VS4 22 s4 0
R4 s4 9 12e0
VS5 26 s5 0
V5 e5 s5 DC 0 AC 47e0 120
RI5 e5 8 18e-1
VS6 24 s6 0
C6 s6 25 10e-7
VS7 8 s7 0
C7 s7 22 33e-4
VS8 0 s8 0
L8 s8 5 56e-3
VS9 11 s9 0
R9 s9 17 68e1
VS10 15 s10 0
L10 s10 8 39e-3
VS11 3 s11 0
V11 e11 s11 DC 0 AC 82e1 0
RI11 e11 4 12e-1
VS12 6 s12 0
R12 s12 0 22e2
VS13 10 s13 0
L13 s13 14 47e-4
VS14 3 s14 0
R14 s14 13 56e2
VS15 0 s15 0
L15 s15 7 12e-5
VS16 1 s16 0
L16 s16 2 33e-2
VS17 26 s17 0
V17 e17 s17 DC 0 AC 68e0 120
RI17 e17 m17 15e-1
LI17 m17 11 12e-7
VS18 3 s18 0
L18 s18 13 56e-4
VS19 24 s19 0
R19 s19 26 12e2
VS20 21 s20 0
R20 s20 2 12e-1
VS21 25 s21 0
L21 s21 22 12e-3
VS22 3 s22 0
R22 s22 10 22e-2
VS23 26 s23 0
V23 e23 s23 DC 0 AC 12e1 180
RI23 e23 m23 47e-2
LI23 m23 16 15e-5
VS24 11 s24 0
C24 s24 7 27e-5
VS25 21 s25 0
L25 s25 18 10e-2
VS26 14 s26 0
L26 s26 26 12e-5
VS27 24 s27 0
R27 s27 23 22e-2
VS28 10 s28 0
R28 s28 7 33e1
VS29 18 s29 0
R29 s29 26 56e1
VS30 3 s30 0
L30 s30 12 22e-3
VS31 11 s31 0
C31 s31 17 10e-5
VS32 1 s32 0
V32 e32 s32 DC 0 AC 39e0 -120
RI32 e32 m32 10e-3
LI32 m32 6 56e-5
VS33 4 s33 0
L33 s33 25 82e-2
VS34 20 s34 0
R34 s34 19 82e-1
VS35 19 s35 0
C35 s35 24 22e-7
VS36 17 s36 0
L36 s36 19 39e-4
VS37 17 s37 0
L37 s37 6 27e-2
VS38 25 s38 0
L38 s38 16 15e-4
VS39 15 s39 0
R39 s39 6 39e1
VS40 12 s40 0
L40 s40 25 39e-3
VS41 0 s41 0
L41 s41 16 82e-4
VS42 22 s42 0
L42 s42 2 47e-5
VS43 6 s43 0
L43 s43 4 33e-3
VS44 6 s44 0
R44 s44 26 47e0
VS45 24 s45 0
R45 s45 19 15e-2
VS46 11 s46 0
L46 s46 10 18e-4
VS47 5 s47 0
V47 e47 s47 DC 0 AC 27e-1 120
RI47 e47 22 12e-3
VS48 8 s48 0
V48 e48 s48 DC 0 AC 33e0 180
RI48 e48 m48 33e-3
LI48 m48 5 10e-7
VS49 9 s49 0
R49 s49 22 68e1
VS50 25 s50 0
C50 s50 13 12e-6
VS51 11 s51 0
L51 s51 9 15e-3
VS52 8 s52 0
C52 s52 7 56e-7
VS53 14 s53 0
R53 s53 20 68e2
.control
set numdgt=17
ac lin 1 60 60
print v(1) v(2) v(3) v(4) v(5) v(6) v(7) v(8) v(9) v(10)
print v(11) v(12) v(13) v(14) v(15) v(16) v(17) v(18) v(19) v(20)
print v(21) v(22) v(23) v(24) v(25) v(26)
print i(vs0) i(vs1) i(vs2) i(vs3) i(vs4) i(vs5) i(vs6) i(vs7) i(vs8) i(vs9)
print i(vs10) i(vs11) i(vs12) i(vs13) i(vs14) i(vs15) i(vs16) i(vs17) i(vs18) i(vs19)
print i(vs20) i(vs21) i(vs22) i(vs23) i(vs24) i(vs25) i(vs26) i(vs27) i(vs28) i(vs29)
print i(vs30) i(vs31) i(vs32) i(vs33) i(vs34) i(vs35) i(vs36) i(vs37) i(vs38) i(vs39)
print i(vs40) i(vs41) i(vs42) i(vs43) i(vs44) i(vs45) i(vs46) i(vs47) i(vs48) i(vs49)
print i(vs50) i(vs51) i(vs52) i(vs53)
.endc
.end
