controls oracle ac-0148
* Generated (plan F2.7, ADR 0012): do not edit; regenerate with `pnpm sim oracle regen`. ac seed 20261031 index 148 nodes 27 elements 53
.options sparse gmin=1e-12 noopac
RG1 1 0 1000000000000
RG2 2 0 1000000000000
RG3 3 0 1000000000000
RG4 4 0 1000000000000
RG5 5 0 1000000000000
RG6 6 0 1000000000000
RG7 7 0 1000000000000
RG8 8 0 1000000000000
RG9 9 0 1000000000000
RG10 10 0 1000000000000
RG11 11 0 1000000000000
RG12 12 0 1000000000000
RG13 13 0 1000000000000
RG14 14 0 1000000000000
RG15 15 0 1000000000000
RG16 16 0 1000000000000
RG17 17 0 1000000000000
RG18 18 0 1000000000000
RG19 19 0 1000000000000
RG20 20 0 1000000000000
RG21 21 0 1000000000000
RG22 22 0 1000000000000
RG23 23 0 1000000000000
RG24 24 0 1000000000000
RG25 25 0 1000000000000
RG26 26 0 1000000000000
VS0 1 s0 0
L0 s0 7 12e-5
VS1 13 s1 0
R1 s1 12 47e-1
VS2 26 s2 0
R2 s2 4 27e1
VS3 6 s3 0
C3 s3 8 15e-4
VS4 5 s4 0
C4 s4 3 39e-5
VS5 11 s5 0
L5 s5 18 82e-2
VS6 8 s6 0
C6 s6 7 56e-7
VS7 18 s7 0
R7 s7 17 39e2
VS8 16 s8 0
R8 s8 2 27e2
VS9 24 s9 0
R9 s9 25 68e-2
VS10 13 s10 0
R10 s10 18 12e-2
VS11 7 s11 0
R11 s11 3 15e-2
VS12 0 s12 0
V12 e12 s12 DC 0 AC 39e0 -120
RI12 e12 m12 10e-3
LI12 m12 6 68e-7
VS13 24 s13 0
C13 s13 21 82e-6
VS14 24 s14 0
R14 s14 26 12e2
VS15 6 s15 0
R15 s15 1 22e2
VS16 11 s16 0
R16 s16 17 68e1
VS17 23 s17 0
C17 s17 7 39e-5
VS18 0 s18 0
V18 e18 s18 DC 0 AC 10e1 120
RI18 e18 9 10e-2
VS19 1 s19 0
V19 e19 s19 DC 0 AC 68e1 -120
RI19 e19 m19 22e-3
LI19 m19 20 27e-7
VS20 6 s20 0
C20 s20 5 12e-5
VS21 21 s21 0
R21 s21 17 68e2
VS22 17 s22 0
R22 s22 10 27e-1
VS23 2 s23 0
V23 e23 s23 DC 0 AC 68e-1 120
RI23 e23 m23 82e-3
LI23 m23 20 10e-5
VS24 6 s24 0
R24 s24 25 82e3
VS25 10 s25 0
R25 s25 16 82e2
VS26 17 s26 0
L26 s26 16 22e-4
VS27 3 s27 0
L27 s27 22 22e-2
VS28 14 s28 0
V28 e28 s28 DC 0 AC 27e-1 180
RI28 e28 18 12e-3
VS29 2 s29 0
V29 e29 s29 DC 0 AC 39e0 0
RI29 e29 m29 22e-2
LI29 m29 22 12e-5
VS30 14 s30 0
R30 s30 24 39e2
VS31 21 s31 0
L31 s31 23 68e-3
VS32 1 s32 0
C32 s32 22 82e-5
VS33 1 s33 0
L33 s33 10 47e-3
VS34 14 s34 0
L34 s34 3 39e-4
VS35 9 s35 0
L35 s35 4 22e-4
VS36 1 s36 0
L36 s36 5 56e-3
VS37 12 s37 0
C37 s37 20 18e-7
VS38 16 s38 0
L38 s38 11 56e-4
VS39 19 s39 0
L39 s39 18 27e-2
VS40 0 s40 0
L40 s40 2 33e-2
VS41 17 s41 0
R41 s41 0 39e-1
VS42 8 s42 0
V42 e42 s42 DC 0 AC 10e-1 180
RI42 e42 15 18e-2
VS43 11 s43 0
V43 e43 s43 DC 0 AC 47e1 -120
RI43 e43 m43 33e-1
LI43 m43 5 47e-5
VS44 10 s44 0
R44 s44 11 68e-1
VS45 25 s45 0
V45 e45 s45 DC 0 AC 15e-1 180
RI45 e45 21 27e-1
VS46 15 s46 0
R46 s46 6 39e1
VS47 1 s47 0
V47 e47 s47 DC 0 AC 68e0 120
RI47 e47 m47 33e-3
LI47 m47 4 68e-5
VS48 19 s48 0
R48 s48 1 18e-1
VS49 6 s49 0
L49 s49 14 33e-3
VS50 24 s50 0
C50 s50 25 10e-7
VS51 16 s51 0
C51 s51 8 47e-5
VS52 10 s52 0
L52 s52 14 68e-5
.control
set numdgt=17
ac lin 1 60 60
print v(1) v(2) v(3) v(4) v(5) v(6) v(7) v(8) v(9) v(10)
print v(11) v(12) v(13) v(14) v(15) v(16) v(17) v(18) v(19) v(20)
print v(21) v(22) v(23) v(24) v(25) v(26)
print i(vs0) i(vs1) i(vs2) i(vs3) i(vs4) i(vs5) i(vs6) i(vs7) i(vs8) i(vs9)
print i(vs10) i(vs11) i(vs12) i(vs13) i(vs14) i(vs15) i(vs16) i(vs17) i(vs18) i(vs19)
print i(vs20) i(vs21) i(vs22) i(vs23) i(vs24) i(vs25) i(vs26) i(vs27) i(vs28) i(vs29)
print i(vs30) i(vs31) i(vs32) i(vs33) i(vs34) i(vs35) i(vs36) i(vs37) i(vs38) i(vs39)
print i(vs40) i(vs41) i(vs42) i(vs43) i(vs44) i(vs45) i(vs46) i(vs47) i(vs48) i(vs49)
print i(vs50) i(vs51) i(vs52)
.endc
.end
