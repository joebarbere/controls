controls oracle ac-0366
* Generated (plan F2.7, ADR 0012): do not edit; regenerate with `pnpm sim oracle regen`. ac seed 20261031 index 366 nodes 12 elements 18
.options sparse gmin=1e-12 noopac
RG1 1 0 1000000000000
RG2 2 0 1000000000000
RG3 3 0 1000000000000
RG4 4 0 1000000000000
RG5 5 0 1000000000000
RG6 6 0 1000000000000
RG7 7 0 1000000000000
RG8 8 0 1000000000000
RG9 9 0 1000000000000
RG10 10 0 1000000000000
RG11 11 0 1000000000000
VS0 4 s0 0
C0 s0 1 33e-7
VS1 0 s1 0
V1 e1 s1 DC 0 AC 15e0 180
RI1 e1 11 15e-3
VS2 7 s2 0
V2 e2 s2 DC 0 AC 27e-1 -120
RI2 e2 5 12e-3
VS3 4 s3 0
C3 s3 11 22e-4
VS4 10 s4 0
C4 s4 4 33e-7
VS5 9 s5 0
L5 s5 6 15e-5
VS6 8 s6 0
L6 s6 11 15e-2
VS7 1 s7 0
C7 s7 0 68e-7
VS8 9 s8 0
R8 s8 3 39e2
VS9 8 s9 0
C9 s9 3 27e-6
VS10 10 s10 0
R10 s10 1 12e3
VS11 4 s11 0
R11 s11 7 10e-2
VS12 4 s12 0
L12 s12 5 12e-4
VS13 5 s13 0
L13 s13 2 39e-2
VS14 4 s14 0
L14 s14 9 15e-4
VS15 1 s15 0
R15 s15 6 18e0
VS16 3 s16 0
C16 s16 4 15e-4
VS17 2 s17 0
C17 s17 6 39e-5
.control
set numdgt=17
ac lin 1 60 60
print v(1) v(2) v(3) v(4) v(5) v(6) v(7) v(8) v(9) v(10)
print v(11)
print i(vs0) i(vs1) i(vs2) i(vs3) i(vs4) i(vs5) i(vs6) i(vs7) i(vs8) i(vs9)
print i(vs10) i(vs11) i(vs12) i(vs13) i(vs14) i(vs15) i(vs16) i(vs17)
.endc
.end
