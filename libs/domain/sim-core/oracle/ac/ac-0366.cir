controls oracle ac-0366
* Generated (plan F2.7, ADR 0012): do not edit; regenerate with `pnpm sim oracle regen`. ac seed 20261031 index 366 nodes 12 elements 16
.options sparse gmin=1e-12 noopac
RG1 1 0 1000000000000
RG2 2 0 1000000000000
RG3 3 0 1000000000000
RG4 4 0 1000000000000
RG5 5 0 1000000000000
RG6 6 0 1000000000000
RG7 7 0 1000000000000
RG8 8 0 1000000000000
RG9 9 0 1000000000000
RG10 10 0 1000000000000
RG11 11 0 1000000000000
VS0 5 s0 0
R0 s0 11 82e-1
VS1 0 s1 0
V1 e1 s1 DC 0 AC 33e1 0
RI1 e1 6 33e-1
VS2 4 s2 0
V2 e2 s2 DC 0 AC 12e-1 180
RI2 e2 10 56e-1
VS3 3 s3 0
L3 s3 0 82e-3
VS4 7 s4 0
L4 s4 4 47e-4
VS5 9 s5 0
R5 s5 8 12e3
VS6 0 s6 0
R6 s6 7 10e-2
VS7 1 s7 0
R7 s7 11 27e0
VS8 0 s8 0
C8 s8 11 22e-4
VS9 0 s9 0
L9 s9 9 15e-4
VS10 10 s10 0
R10 s10 3 12e-1
VS11 8 s11 0
R11 s11 4 82e-1
VS12 8 s12 0
R12 s12 2 68e0
VS13 4 s13 0
V13 e13 s13 DC 0 AC 15e0 180
RI13 e13 11 15e-3
VS14 8 s14 0
L14 s14 11 15e-2
VS15 4 s15 0
R15 s15 10 12e0
.control
set numdgt=17
ac lin 1 60 60
print v(1) v(2) v(3) v(4) v(5) v(6) v(7) v(8) v(9) v(10)
print v(11)
print i(vs0) i(vs1) i(vs2) i(vs3) i(vs4) i(vs5) i(vs6) i(vs7) i(vs8) i(vs9)
print i(vs10) i(vs11) i(vs12) i(vs13) i(vs14) i(vs15)
.endc
.end
