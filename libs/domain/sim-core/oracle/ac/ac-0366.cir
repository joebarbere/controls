controls oracle ac-0366
* Generated (plan F2.7, ADR 0012): do not edit; regenerate with `pnpm sim oracle regen`. ac seed 20261031 index 366 nodes 12 elements 20
.options sparse gmin=1e-12 noopac
RG1 1 0 1000000000000
RG2 2 0 1000000000000
RG3 3 0 1000000000000
RG4 4 0 1000000000000
RG5 5 0 1000000000000
RG6 6 0 1000000000000
RG7 7 0 1000000000000
RG8 8 0 1000000000000
RG9 9 0 1000000000000
RG10 10 0 1000000000000
RG11 11 0 1000000000000
VS0 5 s0 0
L0 s0 7 27e-2
VS1 7 s1 0
L1 s1 0 47e-4
VS2 8 s2 0
L2 s2 11 15e-2
VS3 0 s3 0
V3 e3 s3 DC 0 AC 12e-1 180
RI3 e3 10 56e-1
VS4 5 s4 0
R4 s4 11 82e-1
VS5 4 s5 0
C5 s5 11 22e-4
VS6 4 s6 0
R6 s6 7 10e-2
VS7 9 s7 0
R7 s7 8 12e3
VS8 6 s8 0
V8 e8 s8 DC 0 AC 18e1 -120
RI8 e8 m8 22e-2
LI8 m8 2 56e-7
VS9 1 s9 0
R9 s9 11 27e0
VS10 3 s10 0
L10 s10 4 82e-3
VS11 0 s11 0
R11 s11 10 12e0
VS12 8 s12 0
R12 s12 0 82e-1
VS13 4 s13 0
L13 s13 1 47e-4
VS14 8 s14 0
R14 s14 2 68e0
VS15 4 s15 0
L15 s15 9 15e-4
VS16 0 s16 0
V16 e16 s16 DC 0 AC 15e0 180
RI16 e16 11 15e-3
VS17 2 s17 0
C17 s17 9 82e-5
VS18 10 s18 0
R18 s18 3 12e-1
VS19 4 s19 0
V19 e19 s19 DC 0 AC 33e1 0
RI19 e19 6 33e-1
.control
set numdgt=17
ac lin 1 60 60
print v(1) v(2) v(3) v(4) v(5) v(6) v(7) v(8) v(9) v(10)
print v(11)
print i(vs0) i(vs1) i(vs2) i(vs3) i(vs4) i(vs5) i(vs6) i(vs7) i(vs8) i(vs9)
print i(vs10) i(vs11) i(vs12) i(vs13) i(vs14) i(vs15) i(vs16) i(vs17) i(vs18) i(vs19)
.endc
.end
