controls oracle ac-0250
* Generated (plan F2.7, ADR 0012): do not edit; regenerate with `pnpm sim oracle regen`. ac seed 20261031 index 250 nodes 30 elements 62
.options sparse gmin=1e-12 noopac
RG1 1 0 1000000000000
RG2 2 0 1000000000000
RG3 3 0 1000000000000
RG4 4 0 1000000000000
RG5 5 0 1000000000000
RG6 6 0 1000000000000
RG7 7 0 1000000000000
RG8 8 0 1000000000000
RG9 9 0 1000000000000
RG10 10 0 1000000000000
RG11 11 0 1000000000000
RG12 12 0 1000000000000
RG13 13 0 1000000000000
RG14 14 0 1000000000000
RG15 15 0 1000000000000
RG16 16 0 1000000000000
RG17 17 0 1000000000000
RG18 18 0 1000000000000
RG19 19 0 1000000000000
RG20 20 0 1000000000000
RG21 21 0 1000000000000
RG22 22 0 1000000000000
RG23 23 0 1000000000000
RG24 24 0 1000000000000
RG25 25 0 1000000000000
RG26 26 0 1000000000000
RG27 27 0 1000000000000
RG28 28 0 1000000000000
RG29 29 0 1000000000000
VS0 0 s0 0
V0 e0 s0 DC 0 AC 12e0 -120
RI0 e0 m0 18e-2
LI0 m0 14 15e-6
VS1 27 s1 0
V1 e1 s1 DC 0 AC 10e-1 180
RI1 e1 m1 10e-3
LI1 m1 3 68e-7
VS2 11 s2 0
L2 s2 21 56e-2
VS3 6 s3 0
L3 s3 5 18e-2
VS4 2 s4 0
R4 s4 24 39e1
VS5 27 s5 0
C5 s5 28 15e-5
VS6 8 s6 0
V6 e6 s6 DC 0 AC 56e1 0
RI6 e6 27 33e-2
VS7 13 s7 0
V7 e7 s7 DC 0 AC 27e-1 180
RI7 e7 15 12e-1
VS8 17 s8 0
L8 s8 3 68e-2
VS9 9 s9 0
R9 s9 3 39e2
VS10 19 s10 0
V10 e10 s10 DC 0 AC 82e-1 120
RI10 e10 m10 15e-1
LI10 m10 25 18e-7
VS11 10 s11 0
R11 s11 20 22e0
VS12 21 s12 0
R12 s12 26 82e3
VS13 22 s13 0
R13 s13 27 15e3
VS14 20 s14 0
R14 s14 16 22e0
VS15 17 s15 0
R15 s15 27 68e2
VS16 3 s16 0
C16 s16 28 68e-5
VS17 22 s17 0
L17 s17 7 12e-4
VS18 10 s18 0
V18 e18 s18 DC 0 AC 33e0 120
RI18 e18 0 47e-2
VS19 4 s19 0
R19 s19 15 10e1
VS20 6 s20 0
C20 s20 18 56e-6
VS21 9 s21 0
L21 s21 6 47e-5
VS22 26 s22 0
V22 e22 s22 DC 0 AC 39e-1 120
RI22 e22 m22 56e-1
LI22 m22 7 39e-6
VS23 17 s23 0
R23 s23 7 33e-1
VS24 9 s24 0
C24 s24 4 27e-4
VS25 22 s25 0
R25 s25 7 18e2
VS26 1 s26 0
C26 s26 2 39e-5
VS27 6 s27 0
V27 e27 s27 DC 0 AC 33e-1 -120
RI27 e27 29 10e-1
VS28 21 s28 0
R28 s28 14 22e0
VS29 13 s29 0
C29 s29 25 22e-6
VS30 5 s30 0
R30 s30 27 10e0
VS31 6 s31 0
C31 s31 21 15e-6
VS32 28 s32 0
R32 s32 16 56e3
VS33 25 s33 0
L33 s33 17 12e-5
VS34 1 s34 0
R34 s34 23 82e3
VS35 15 s35 0
V35 e35 s35 DC 0 AC 33e-1 180
RI35 e35 m35 68e-3
LI35 m35 5 56e-7
VS36 15 s36 0
L36 s36 29 33e-4
VS37 16 s37 0
C37 s37 21 22e-7
VS38 29 s38 0
C38 s38 3 18e-7
VS39 8 s39 0
C39 s39 24 33e-6
VS40 6 s40 0
R40 s40 7 82e1
VS41 6 s41 0
V41 e41 s41 DC 0 AC 47e-1 -120
RI41 e41 m41 56e-2
LI41 m41 10 82e-5
VS42 12 s42 0
R42 s42 21 12e-2
VS43 24 s43 0
V43 e43 s43 DC 0 AC 39e1 120
RI43 e43 m43 82e-2
LI43 m43 4 15e-5
VS44 0 s44 0
C44 s44 25 12e-4
VS45 19 s45 0
L45 s45 23 27e-2
VS46 1 s46 0
L46 s46 27 56e-3
VS47 7 s47 0
C47 s47 10 27e-7
VS48 25 s48 0
L48 s48 10 27e-5
VS49 25 s49 0
L49 s49 22 39e-3
VS50 6 s50 0
V50 e50 s50 DC 0 AC 12e0 -120
RI50 e50 9 22e-3
VS51 10 s51 0
L51 s51 16 12e-5
VS52 5 s52 0
R52 s52 9 27e2
VS53 23 s53 0
L53 s53 27 56e-5
VS54 17 s54 0
C54 s54 20 47e-4
VS55 8 s55 0
C55 s55 15 68e-6
VS56 18 s56 0
L56 s56 7 56e-2
VS57 16 s57 0
R57 s57 11 12e0
VS58 16 s58 0
V58 e58 s58 DC 0 AC 27e1 180
RI58 e58 m58 10e-2
LI58 m58 10 56e-6
VS59 29 s59 0
L59 s59 25 27e-2
VS60 25 s60 0
L60 s60 2 82e-3
VS61 12 s61 0
R61 s61 14 22e2
.control
set numdgt=17
ac lin 1 60 60
print v(1) v(2) v(3) v(4) v(5) v(6) v(7) v(8) v(9) v(10)
print v(11) v(12) v(13) v(14) v(15) v(16) v(17) v(18) v(19) v(20)
print v(21) v(22) v(23) v(24) v(25) v(26) v(27) v(28) v(29)
print i(vs0) i(vs1) i(vs2) i(vs3) i(vs4) i(vs5) i(vs6) i(vs7) i(vs8) i(vs9)
print i(vs10) i(vs11) i(vs12) i(vs13) i(vs14) i(vs15) i(vs16) i(vs17) i(vs18) i(vs19)
print i(vs20) i(vs21) i(vs22) i(vs23) i(vs24) i(vs25) i(vs26) i(vs27) i(vs28) i(vs29)
print i(vs30) i(vs31) i(vs32) i(vs33) i(vs34) i(vs35) i(vs36) i(vs37) i(vs38) i(vs39)
print i(vs40) i(vs41) i(vs42) i(vs43) i(vs44) i(vs45) i(vs46) i(vs47) i(vs48) i(vs49)
print i(vs50) i(vs51) i(vs52) i(vs53) i(vs54) i(vs55) i(vs56) i(vs57) i(vs58) i(vs59)
print i(vs60) i(vs61)
.endc
.end
