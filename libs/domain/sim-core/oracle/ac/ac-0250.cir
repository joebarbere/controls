controls oracle ac-0250
* Generated (plan F2.7, ADR 0012): do not edit; regenerate with `pnpm sim oracle regen`. ac seed 20261031 index 250 nodes 30 elements 50
.options sparse gmin=1e-12 noopac
RG1 1 0 1000000000000
RG2 2 0 1000000000000
RG3 3 0 1000000000000
RG4 4 0 1000000000000
RG5 5 0 1000000000000
RG6 6 0 1000000000000
RG7 7 0 1000000000000
RG8 8 0 1000000000000
RG9 9 0 1000000000000
RG10 10 0 1000000000000
RG11 11 0 1000000000000
RG12 12 0 1000000000000
RG13 13 0 1000000000000
RG14 14 0 1000000000000
RG15 15 0 1000000000000
RG16 16 0 1000000000000
RG17 17 0 1000000000000
RG18 18 0 1000000000000
RG19 19 0 1000000000000
RG20 20 0 1000000000000
RG21 21 0 1000000000000
RG22 22 0 1000000000000
RG23 23 0 1000000000000
RG24 24 0 1000000000000
RG25 25 0 1000000000000
RG26 26 0 1000000000000
RG27 27 0 1000000000000
RG28 28 0 1000000000000
RG29 29 0 1000000000000
VS0 6 s0 0
L0 s0 11 12e-5
VS1 25 s1 0
R1 s1 17 82e3
VS2 0 s2 0
V2 e2 s2 DC 0 AC 68e1 -120
RI2 e2 2 82e-1
VS3 0 s3 0
L3 s3 17 39e-4
VS4 11 s4 0
R4 s4 20 56e-2
VS5 17 s5 0
C5 s5 1 27e-7
VS6 12 s6 0
V6 e6 s6 DC 0 AC 18e0 180
RI6 e6 25 33e-1
VS7 0 s7 0
R7 s7 29 10e1
VS8 24 s8 0
V8 e8 s8 DC 0 AC 68e1 0
RI8 e8 17 15e-2
VS9 25 s9 0
V9 e9 s9 DC 0 AC 22e0 0
RI9 e9 5 22e-1
VS10 2 s10 0
L10 s10 25 10e-3
VS11 26 s11 0
L11 s11 5 18e-2
VS12 25 s12 0
L12 s12 24 33e-4
VS13 5 s13 0
R13 s13 27 10e0
VS14 16 s14 0
R14 s14 21 56e-2
VS15 7 s15 0
R15 s15 10 33e0
VS16 1 s16 0
V16 e16 s16 DC 0 AC 56e-1 -120
RI16 e16 29 82e-3
VS17 15 s17 0
V17 e17 s17 DC 0 AC 33e-1 180
RI17 e17 5 68e-3
VS18 13 s18 0
L18 s18 24 22e-3
VS19 11 s19 0
L19 s19 3 10e-3
VS20 7 s20 0
V20 e20 s20 DC 0 AC 15e-1 0
RI20 e20 9 15e-2
VS21 18 s21 0
L21 s21 27 68e-2
VS22 1 s22 0
C22 s22 19 68e-6
VS23 12 s23 0
C23 s23 5 12e-6
VS24 24 s24 0
L24 s24 22 22e-2
VS25 12 s25 0
R25 s25 23 27e-2
VS26 11 s26 0
R26 s26 0 39e3
VS27 4 s27 0
L27 s27 1 39e-3
VS28 10 s28 0
R28 s28 23 22e-2
VS29 20 s29 0
R29 s29 13 56e-1
VS30 21 s30 0
R30 s30 15 15e2
VS31 11 s31 0
R31 s31 10 10e2
VS32 29 s32 0
V32 e32 s32 DC 0 AC 18e0 180
RI32 e32 4 10e-1
VS33 12 s33 0
R33 s33 3 56e1
VS34 25 s34 0
C34 s34 14 47e-5
VS35 8 s35 0
L35 s35 20 82e-4
VS36 13 s36 0
R36 s36 14 47e3
VS37 12 s37 0
C37 s37 5 56e-4
VS38 15 s38 0
R38 s38 20 15e1
VS39 5 s39 0
R39 s39 4 33e3
VS40 19 s40 0
L40 s40 23 27e-2
VS41 14 s41 0
R41 s41 26 12e1
VS42 19 s42 0
R42 s42 17 22e-1
VS43 9 s43 0
L43 s43 29 82e-4
VS44 4 s44 0
L44 s44 10 10e-4
VS45 23 s45 0
C45 s45 9 82e-6
VS46 23 s46 0
L46 s46 27 56e-5
VS47 27 s47 0
V47 e47 s47 DC 0 AC 82e0 -120
RI47 e47 18 10e-1
VS48 17 s48 0
C48 s48 14 82e-4
VS49 9 s49 0
R49 s49 28 68e3
.control
set numdgt=17
ac lin 1 60 60
print v(1) v(2) v(3) v(4) v(5) v(6) v(7) v(8) v(9) v(10)
print v(11) v(12) v(13) v(14) v(15) v(16) v(17) v(18) v(19) v(20)
print v(21) v(22) v(23) v(24) v(25) v(26) v(27) v(28) v(29)
print i(vs0) i(vs1) i(vs2) i(vs3) i(vs4) i(vs5) i(vs6) i(vs7) i(vs8) i(vs9)
print i(vs10) i(vs11) i(vs12) i(vs13) i(vs14) i(vs15) i(vs16) i(vs17) i(vs18) i(vs19)
print i(vs20) i(vs21) i(vs22) i(vs23) i(vs24) i(vs25) i(vs26) i(vs27) i(vs28) i(vs29)
print i(vs30) i(vs31) i(vs32) i(vs33) i(vs34) i(vs35) i(vs36) i(vs37) i(vs38) i(vs39)
print i(vs40) i(vs41) i(vs42) i(vs43) i(vs44) i(vs45) i(vs46) i(vs47) i(vs48) i(vs49)
.endc
.end
