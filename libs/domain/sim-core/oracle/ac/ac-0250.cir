controls oracle ac-0250
* Generated (plan F2.7, ADR 0012): do not edit; regenerate with `pnpm sim oracle regen`. ac seed 20261031 index 250 nodes 30 elements 56
.options sparse gmin=1e-12 noopac
RG1 1 0 1000000000000
RG2 2 0 1000000000000
RG3 3 0 1000000000000
RG4 4 0 1000000000000
RG5 5 0 1000000000000
RG6 6 0 1000000000000
RG7 7 0 1000000000000
RG8 8 0 1000000000000
RG9 9 0 1000000000000
RG10 10 0 1000000000000
RG11 11 0 1000000000000
RG12 12 0 1000000000000
RG13 13 0 1000000000000
RG14 14 0 1000000000000
RG15 15 0 1000000000000
RG16 16 0 1000000000000
RG17 17 0 1000000000000
RG18 18 0 1000000000000
RG19 19 0 1000000000000
RG20 20 0 1000000000000
RG21 21 0 1000000000000
RG22 22 0 1000000000000
RG23 23 0 1000000000000
RG24 24 0 1000000000000
RG25 25 0 1000000000000
RG26 26 0 1000000000000
RG27 27 0 1000000000000
RG28 28 0 1000000000000
RG29 29 0 1000000000000
VS0 28 s0 0
R0 s0 29 82e1
VS1 10 s1 0
R1 s1 23 22e-2
VS2 0 s2 0
V2 e2 s2 DC 0 AC 68e1 0
RI2 e2 m2 15e-2
LI2 m2 n2 10e-6
H2 n2 h2 VS3 -56e-3
ED2 h2 17 d2 0 -47e-5
F2 0 d2 VS3 1
LD2 d2 0 1
VS3 29 s3 0
V3 e3 s3 DC 0 AC 18e0 180
RI3 e3 m3 10e-1
LI3 m3 n3 56e-7
H3 n3 h3 VS2 -56e-3
ED3 h3 4 d3 0 -47e-5
F3 0 d3 VS2 1
LD3 d3 0 1
VS4 20 s4 0
R4 s4 13 56e-1
VS5 12 s5 0
R5 s5 23 27e-2
VS6 11 s6 0
R6 s6 10 10e2
VS7 18 s7 0
L7 s7 19 12e-5
VS8 21 s8 0
R8 s8 15 15e2
VS9 2 s9 0
L9 s9 25 10e-3
VS10 26 s10 0
R10 s10 29 10e1
VS11 26 s11 0
V11 e11 s11 DC 0 AC 68e1 -120
RI11 e11 2 82e-1
VS12 19 s12 0
L12 s12 23 27e-2
VS13 9 s13 0
R13 s13 28 68e3
VS14 12 s14 0
C14 s14 5 56e-4
VS15 16 s15 0
R15 s15 21 56e-2
VS16 7 s16 0
V16 e16 s16 DC 0 AC 15e-1 0
RI16 e16 m16 15e-2
LI16 m16 9 33e-5
VS17 11 s17 0
L17 s17 8 56e-4
VS18 6 s18 0
L18 s18 11 12e-5
VS19 25 s19 0
R19 s19 17 82e3
VS20 17 s20 0
C20 s20 1 27e-7
VS21 7 s21 0
R21 s21 10 33e0
VS22 18 s22 0
L22 s22 27 68e-2
VS23 4 s23 0
L23 s23 10 10e-4
VS24 12 s24 0
V24 e24 s24 DC 0 AC 18e0 180
RI24 e24 m24 33e-1
LI24 m24 25 15e-5
VS25 1 s25 0
C25 s25 19 68e-6
VS26 13 s26 0
L26 s26 0 22e-3
VS27 12 s27 0
R27 s27 3 56e1
VS28 9 s28 0
L28 s28 29 82e-4
VS29 25 s29 0
C29 s29 14 47e-5
VS30 0 s30 0
L30 s30 22 22e-2
VS31 14 s31 0
R31 s31 24 12e1
VS32 1 s32 0
V32 e32 s32 DC 0 AC 56e-1 -120
RI32 e32 29 82e-3
VS33 17 s33 0
C33 s33 14 82e-4
VS34 11 s34 0
L34 s34 3 10e-3
VS35 13 s35 0
R35 s35 14 47e3
VS36 22 s36 0
C36 s36 28 22e-7
VS37 8 s37 0
L37 s37 20 82e-4
VS38 11 s38 0
R38 s38 26 39e3
VS39 5 s39 0
R39 s39 4 33e3
VS40 23 s40 0
C40 s40 9 82e-6
VS41 24 s41 0
L41 s41 5 18e-2
VS42 19 s42 0
R42 s42 17 22e-1
VS43 15 s43 0
V43 e43 s43 DC 0 AC 33e-1 180
RI43 e43 m43 68e-3
LI43 m43 5 39e-6
VS44 11 s44 0
R44 s44 20 56e-2
VS45 27 s45 0
V45 e45 s45 DC 0 AC 82e0 -120
RI45 e45 18 10e-1
VS46 12 s46 0
C46 s46 5 12e-6
VS47 5 s47 0
R47 s47 27 10e0
VS48 4 s48 0
L48 s48 1 39e-3
VS49 6 s49 0
V49 e49 s49 DC 0 AC 15e-1 -120
RI49 e49 13 56e-1
VS50 23 s50 0
L50 s50 27 56e-5
VS51 26 s51 0
L51 s51 17 39e-4
VS52 15 s52 0
R52 s52 20 15e1
VS53 25 s53 0
L53 s53 0 33e-4
VS54 25 s54 0
V54 e54 s54 DC 0 AC 22e0 0
RI54 e54 m54 22e-1
LI54 m54 5 56e-5
VS55 6 s55 0
C55 s55 16 18e-7
.control
set numdgt=17
ac lin 1 60 60
print v(1) v(2) v(3) v(4) v(5) v(6) v(7) v(8) v(9) v(10)
print v(11) v(12) v(13) v(14) v(15) v(16) v(17) v(18) v(19) v(20)
print v(21) v(22) v(23) v(24) v(25) v(26) v(27) v(28) v(29)
print i(vs0) i(vs1) i(vs2) i(vs3) i(vs4) i(vs5) i(vs6) i(vs7) i(vs8) i(vs9)
print i(vs10) i(vs11) i(vs12) i(vs13) i(vs14) i(vs15) i(vs16) i(vs17) i(vs18) i(vs19)
print i(vs20) i(vs21) i(vs22) i(vs23) i(vs24) i(vs25) i(vs26) i(vs27) i(vs28) i(vs29)
print i(vs30) i(vs31) i(vs32) i(vs33) i(vs34) i(vs35) i(vs36) i(vs37) i(vs38) i(vs39)
print i(vs40) i(vs41) i(vs42) i(vs43) i(vs44) i(vs45) i(vs46) i(vs47) i(vs48) i(vs49)
print i(vs50) i(vs51) i(vs52) i(vs53) i(vs54) i(vs55)
.endc
.end
