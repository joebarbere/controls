controls oracle ac-0330
* Generated (plan F2.7, ADR 0012): do not edit; regenerate with `pnpm sim oracle regen`. ac seed 20261031 index 330 nodes 12 elements 13
.options sparse gmin=1e-12 noopac
RG1 1 0 1000000000000
RG2 2 0 1000000000000
RG3 3 0 1000000000000
RG4 4 0 1000000000000
RG5 5 0 1000000000000
RG6 6 0 1000000000000
RG7 7 0 1000000000000
RG8 8 0 1000000000000
RG9 9 0 1000000000000
RG10 10 0 1000000000000
RG11 11 0 1000000000000
VS0 9 s0 0
L0 s0 5 68e-2
VS1 0 s1 0
V1 e1 s1 DC 0 AC 12e-1 120
RI1 e1 5 10e-1
VS2 0 s2 0
R2 s2 7 18e1
VS3 2 s3 0
L3 s3 6 56e-5
VS4 4 s4 0
R4 s4 1 22e0
VS5 6 s5 0
L5 s5 5 82e-5
VS6 7 s6 0
C6 s6 8 82e-6
VS7 5 s7 0
V7 e7 s7 DC 0 AC 47e-1 180
RI7 e7 8 39e-2
VS8 8 s8 0
V8 e8 s8 DC 0 AC 10e1 0
RI8 e8 7 22e-2
VS9 4 s9 0
R9 s9 9 27e3
VS10 6 s10 0
V10 e10 s10 DC 0 AC 47e0 180
RI10 e10 10 22e-1
VS11 3 s11 0
R11 s11 0 10e-1
VS12 11 s12 0
L12 s12 5 56e-5
.control
set numdgt=17
ac lin 1 60 60
print v(1) v(2) v(3) v(4) v(5) v(6) v(7) v(8) v(9) v(10)
print v(11)
print i(vs0) i(vs1) i(vs2) i(vs3) i(vs4) i(vs5) i(vs6) i(vs7) i(vs8) i(vs9)
print i(vs10) i(vs11) i(vs12)
.endc
.end
