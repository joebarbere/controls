controls oracle ac-0330
* Generated (plan F2.7, ADR 0012): do not edit; regenerate with `pnpm sim oracle regen`. ac seed 20261031 index 330 nodes 12 elements 17
.options sparse gmin=1e-12 noopac
RG1 1 0 1000000000000
RG2 2 0 1000000000000
RG3 3 0 1000000000000
RG4 4 0 1000000000000
RG5 5 0 1000000000000
RG6 6 0 1000000000000
RG7 7 0 1000000000000
RG8 8 0 1000000000000
RG9 9 0 1000000000000
RG10 10 0 1000000000000
RG11 11 0 1000000000000
VS0 0 s0 0
V0 e0 s0 DC 0 AC 10e1 0
RI0 e0 n0 22e-2
H0 n0 h0 VS4 -39e-3
ED0 h0 7 d0 0 -27e-6
F0 0 d0 VS4 1
LD0 d0 0 1
VS1 9 s1 0
L1 s1 5 68e-2
VS2 8 s2 0
R2 s2 7 18e1
VS3 7 s3 0
R3 s3 3 82e-1
VS4 8 s4 0
V4 e4 s4 DC 0 AC 12e-1 120
RI4 e4 m4 10e-1
LI4 m4 n4 68e-5
H4 n4 h4 VS0 -39e-3
ED4 h4 5 d4 0 -27e-6
F4 0 d4 VS0 1
LD4 d4 0 1
VS5 6 s5 0
L5 s5 5 82e-5
VS6 3 s6 0
R6 s6 8 10e-1
VS7 11 s7 0
L7 s7 5 56e-5
VS8 0 s8 0
R8 s8 11 68e3
VS9 4 s9 0
R9 s9 1 22e0
VS10 1 s10 0
V10 e10 s10 DC 0 AC 56e1 180
RI10 e10 m10 27e-2
LI10 m10 2 56e-7
VS11 2 s11 0
L11 s11 6 56e-5
VS12 5 s12 0
V12 e12 s12 DC 0 AC 47e-1 180
RI12 e12 m12 39e-2
LI12 m12 0 10e-7
VS13 6 s13 0
V13 e13 s13 DC 0 AC 47e0 180
RI13 e13 10 22e-1
VS14 7 s14 0
C14 s14 0 82e-6
VS15 4 s15 0
R15 s15 9 27e3
VS16 8 s16 0
V16 e16 s16 DC 0 AC 56e0 0
RI16 e16 m16 33e-3
LI16 m16 10 10e-5
.control
set numdgt=17
ac lin 1 60 60
print v(1) v(2) v(3) v(4) v(5) v(6) v(7) v(8) v(9) v(10)
print v(11)
print i(vs0) i(vs1) i(vs2) i(vs3) i(vs4) i(vs5) i(vs6) i(vs7) i(vs8) i(vs9)
print i(vs10) i(vs11) i(vs12) i(vs13) i(vs14) i(vs15) i(vs16)
.endc
.end
