controls oracle ac-0330
* Generated (plan F2.7, ADR 0012): do not edit; regenerate with `pnpm sim oracle regen`. ac seed 20261031 index 330 nodes 12 elements 18
.options sparse gmin=1e-12 noopac
RG1 1 0 1000000000000
RG2 2 0 1000000000000
RG3 3 0 1000000000000
RG4 4 0 1000000000000
RG5 5 0 1000000000000
RG6 6 0 1000000000000
RG7 7 0 1000000000000
RG8 8 0 1000000000000
RG9 9 0 1000000000000
RG10 10 0 1000000000000
RG11 11 0 1000000000000
VS0 10 s0 0
R0 s0 11 27e3
VS1 9 s1 0
C1 s1 3 12e-4
VS2 4 s2 0
R2 s2 3 15e-1
VS3 4 s3 0
R3 s3 7 18e1
VS4 9 s4 0
R4 s4 1 56e1
VS5 0 s5 0
V5 e5 s5 DC 0 AC 12e-1 120
RI5 e5 10 82e-2
VS6 9 s6 0
V6 e6 s6 DC 0 AC 47e1 120
RI6 e6 m6 27e-1
LI6 m6 7 12e-7
VS7 6 s7 0
V7 e7 s7 DC 0 AC 12e1 -120
RI7 e7 1 10e-1
VS8 5 s8 0
R8 s8 2 27e2
VS9 2 s9 0
C9 s9 10 15e-5
VS10 9 s10 0
V10 e10 s10 DC 0 AC 47e-1 180
RI10 e10 m10 68e-1
LI10 m10 3 12e-7
VS11 8 s11 0
R11 s11 0 27e-1
VS12 11 s12 0
V12 e12 s12 DC 0 AC 15e0 0
RI12 e12 m12 33e-3
LI12 m12 5 12e-6
VS13 6 s13 0
L13 s13 4 56e-5
VS14 8 s14 0
C14 s14 9 33e-6
VS15 11 s15 0
C15 s15 8 18e-5
VS16 4 s16 0
V16 e16 s16 DC 0 AC 12e-1 120
RI16 e16 m16 10e-1
LI16 m16 5 47e-7
VS17 9 s17 0
R17 s17 10 68e1
.control
set numdgt=17
ac lin 1 60 60
print v(1) v(2) v(3) v(4) v(5) v(6) v(7) v(8) v(9) v(10)
print v(11)
print i(vs0) i(vs1) i(vs2) i(vs3) i(vs4) i(vs5) i(vs6) i(vs7) i(vs8) i(vs9)
print i(vs10) i(vs11) i(vs12) i(vs13) i(vs14) i(vs15) i(vs16) i(vs17)
.endc
.end
