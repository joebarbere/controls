controls oracle ac-0108
* Generated (plan F2.7, ADR 0012): do not edit; regenerate with `pnpm sim oracle regen`. ac seed 20261031 index 108 nodes 30 elements 58
.options sparse gmin=1e-12 noopac
RG1 1 0 1000000000000
RG2 2 0 1000000000000
RG3 3 0 1000000000000
RG4 4 0 1000000000000
RG5 5 0 1000000000000
RG6 6 0 1000000000000
RG7 7 0 1000000000000
RG8 8 0 1000000000000
RG9 9 0 1000000000000
RG10 10 0 1000000000000
RG11 11 0 1000000000000
RG12 12 0 1000000000000
RG13 13 0 1000000000000
RG14 14 0 1000000000000
RG15 15 0 1000000000000
RG16 16 0 1000000000000
RG17 17 0 1000000000000
RG18 18 0 1000000000000
RG19 19 0 1000000000000
RG20 20 0 1000000000000
RG21 21 0 1000000000000
RG22 22 0 1000000000000
RG23 23 0 1000000000000
RG24 24 0 1000000000000
RG25 25 0 1000000000000
RG26 26 0 1000000000000
RG27 27 0 1000000000000
RG28 28 0 1000000000000
RG29 29 0 1000000000000
VS0 4 s0 0
R0 s0 21 39e-2
VS1 22 s1 0
L1 s1 27 12e-4
VS2 23 s2 0
R2 s2 29 15e1
VS3 19 s3 0
R3 s3 3 33e3
VS4 0 s4 0
V4 e4 s4 DC 0 AC 56e1 0
RI4 e4 m4 15e-2
LI4 m4 13 18e-6
VS5 4 s5 0
C5 s5 3 10e-4
VS6 2 s6 0
L6 s6 13 10e-4
VS7 13 s7 0
R7 s7 14 22e0
VS8 28 s8 0
R8 s8 2 10e0
VS9 15 s9 0
R9 s9 16 27e-2
VS10 26 s10 0
C10 s10 8 56e-6
VS11 29 s11 0
C11 s11 10 27e-6
VS12 11 s12 0
L12 s12 16 33e-2
VS13 25 s13 0
R13 s13 17 12e3
VS14 21 s14 0
C14 s14 12 15e-5
VS15 17 s15 0
L15 s15 13 10e-3
VS16 0 s16 0
R16 s16 22 33e0
VS17 16 s17 0
L17 s17 29 10e-4
VS18 4 s18 0
V18 e18 s18 DC 0 AC 22e0 180
RI18 e18 m18 18e-3
LI18 m18 18 82e-7
VS19 29 s19 0
L19 s19 17 33e-5
VS20 12 s20 0
V20 e20 s20 DC 0 AC 15e-1 -120
RI20 e20 m20 22e-3
LI20 m20 29 56e-5
VS21 17 s21 0
R21 s21 22 39e1
VS22 27 s22 0
L22 s22 3 15e-5
VS23 15 s23 0
C23 s23 28 33e-5
VS24 29 s24 0
C24 s24 25 47e-4
VS25 3 s25 0
R25 s25 9 82e0
VS26 1 s26 0
L26 s26 6 18e-5
VS27 25 s27 0
L27 s27 10 18e-3
VS28 17 s28 0
L28 s28 21 82e-4
VS29 16 s29 0
C29 s29 10 68e-5
VS30 23 s30 0
L30 s30 12 12e-5
VS31 16 s31 0
L31 s31 3 47e-5
VS32 7 s32 0
C32 s32 25 33e-6
VS33 8 s33 0
L33 s33 18 47e-4
VS34 18 s34 0
L34 s34 26 68e-2
VS35 28 s35 0
R35 s35 14 22e-2
VS36 20 s36 0
R36 s36 2 27e0
VS37 28 s37 0
L37 s37 26 82e-5
VS38 28 s38 0
L38 s38 22 22e-5
VS39 29 s39 0
C39 s39 24 56e-6
VS40 4 s40 0
V40 e40 s40 DC 0 AC 56e1 0
RI40 e40 m40 18e-3
LI40 m40 10 56e-5
VS41 29 s41 0
L41 s41 18 18e-5
VS42 7 s42 0
R42 s42 17 12e-2
VS43 28 s43 0
L43 s43 3 68e-2
VS44 18 s44 0
R44 s44 11 56e0
VS45 26 s45 0
C45 s45 16 22e-6
VS46 24 s46 0
R46 s46 9 82e3
VS47 18 s47 0
R47 s47 7 47e-2
VS48 27 s48 0
V48 e48 s48 DC 0 AC 39e1 -120
RI48 e48 m48 15e-1
LI48 m48 10 15e-5
VS49 29 s49 0
R49 s49 6 27e-1
VS50 18 s50 0
C50 s50 17 56e-4
VS51 5 s51 0
L51 s51 2 18e-2
VS52 19 s52 0
L52 s52 21 15e-4
VS53 1 s53 0
V53 e53 s53 DC 0 AC 82e0 -120
RI53 e53 m53 47e-3
LI53 m53 12 27e-7
VS54 20 s54 0
R54 s54 23 82e2
VS55 5 s55 0
L55 s55 4 12e-2
VS56 22 s56 0
L56 s56 3 12e-2
VS57 29 s57 0
C57 s57 10 56e-6
.control
set numdgt=17
ac lin 1 60 60
print v(1) v(2) v(3) v(4) v(5) v(6) v(7) v(8) v(9) v(10)
print v(11) v(12) v(13) v(14) v(15) v(16) v(17) v(18) v(19) v(20)
print v(21) v(22) v(23) v(24) v(25) v(26) v(27) v(28) v(29)
print i(vs0) i(vs1) i(vs2) i(vs3) i(vs4) i(vs5) i(vs6) i(vs7) i(vs8) i(vs9)
print i(vs10) i(vs11) i(vs12) i(vs13) i(vs14) i(vs15) i(vs16) i(vs17) i(vs18) i(vs19)
print i(vs20) i(vs21) i(vs22) i(vs23) i(vs24) i(vs25) i(vs26) i(vs27) i(vs28) i(vs29)
print i(vs30) i(vs31) i(vs32) i(vs33) i(vs34) i(vs35) i(vs36) i(vs37) i(vs38) i(vs39)
print i(vs40) i(vs41) i(vs42) i(vs43) i(vs44) i(vs45) i(vs46) i(vs47) i(vs48) i(vs49)
print i(vs50) i(vs51) i(vs52) i(vs53) i(vs54) i(vs55) i(vs56) i(vs57)
.endc
.end
