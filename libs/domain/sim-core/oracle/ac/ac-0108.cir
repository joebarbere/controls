controls oracle ac-0108
* Generated (plan F2.7, ADR 0012): do not edit; regenerate with `pnpm sim oracle regen`. ac seed 20261031 index 108 nodes 30 elements 53
.options sparse gmin=1e-12 noopac
RG1 1 0 1000000000000
RG2 2 0 1000000000000
RG3 3 0 1000000000000
RG4 4 0 1000000000000
RG5 5 0 1000000000000
RG6 6 0 1000000000000
RG7 7 0 1000000000000
RG8 8 0 1000000000000
RG9 9 0 1000000000000
RG10 10 0 1000000000000
RG11 11 0 1000000000000
RG12 12 0 1000000000000
RG13 13 0 1000000000000
RG14 14 0 1000000000000
RG15 15 0 1000000000000
RG16 16 0 1000000000000
RG17 17 0 1000000000000
RG18 18 0 1000000000000
RG19 19 0 1000000000000
RG20 20 0 1000000000000
RG21 21 0 1000000000000
RG22 22 0 1000000000000
RG23 23 0 1000000000000
RG24 24 0 1000000000000
RG25 25 0 1000000000000
RG26 26 0 1000000000000
RG27 27 0 1000000000000
RG28 28 0 1000000000000
RG29 29 0 1000000000000
VS0 3 s0 0
R0 s0 27 22e-2
VS1 29 s1 0
C1 s1 10 27e-6
VS2 7 s2 0
L2 s2 22 33e-5
VS3 26 s3 0
C3 s3 16 22e-6
VS4 13 s4 0
L4 s4 5 15e-5
VS5 22 s5 0
R5 s5 0 47e2
VS6 11 s6 0
R6 s6 17 33e3
VS7 18 s7 0
R7 s7 7 47e-2
VS8 21 s8 0
C8 s8 12 15e-5
VS9 13 s9 0
R9 s9 14 22e0
VS10 25 s10 0
L10 s10 10 18e-3
VS11 0 s11 0
V11 e11 s11 DC 0 AC 56e1 0
RI11 e11 13 15e-2
VS12 11 s12 0
L12 s12 16 33e-2
VS13 9 s13 0
R13 s13 0 22e-2
VS14 15 s14 0
V14 e14 s14 DC 0 AC 18e0 0
RI14 e14 m14 22e-2
LI14 m14 22 39e-6
VS15 17 s15 0
L15 s15 21 82e-4
VS16 24 s16 0
R16 s16 23 22e-2
VS17 17 s17 0
L17 s17 13 10e-3
VS18 6 s18 0
R18 s18 8 12e2
VS19 16 s19 0
C19 s19 10 68e-5
VS20 19 s20 0
L20 s20 21 15e-4
VS21 28 s21 0
L21 s21 3 68e-2
VS22 6 s22 0
R22 s22 4 15e0
VS23 28 s23 0
L23 s23 22 22e-5
VS24 1 s24 0
V24 e24 s24 DC 0 AC 82e0 -120
RI24 e24 12 47e-3
VS25 8 s25 0
L25 s25 13 33e-5
VS26 26 s26 0
R26 s26 25 22e-2
VS27 0 s27 0
V27 e27 s27 DC 0 AC 12e0 0
RI27 e27 1 10e-2
VS28 24 s28 0
L28 s28 20 68e-2
VS29 23 s29 0
R29 s29 29 15e1
VS30 29 s30 0
C30 s30 19 56e-4
VS31 4 s31 0
R31 s31 21 39e-2
VS32 29 s32 0
L32 s32 17 33e-5
VS33 28 s33 0
R33 s33 2 10e0
VS34 4 s34 0
V34 e34 s34 DC 0 AC 56e1 0
RI34 e34 m34 18e-3
LI34 m34 10 82e-5
VS35 29 s35 0
L35 s35 14 27e-2
VS36 6 s36 0
L36 s36 20 15e-5
VS37 25 s37 0
R37 s37 17 12e3
VS38 8 s38 0
R38 s38 20 27e3
VS39 1 s39 0
L39 s39 6 18e-5
VS40 22 s40 0
C40 s40 5 10e-7
VS41 2 s41 0
R41 s41 13 56e3
VS42 15 s42 0
V42 e42 s42 DC 0 AC 33e-1 -120
RI42 e42 3 33e-3
VS43 2 s43 0
L43 s43 13 10e-4
VS44 28 s44 0
L44 s44 2 39e-3
VS45 17 s45 0
R45 s45 22 39e1
VS46 9 s46 0
C46 s46 1 82e-6
VS47 3 s47 0
R47 s47 9 82e0
VS48 27 s48 0
R48 s48 1 22e3
VS49 2 s49 0
R49 s49 11 33e3
VS50 1 s50 0
L50 s50 16 47e-5
VS51 18 s51 0
C51 s51 16 68e-7
VS52 10 s52 0
L52 s52 0 27e-5
.control
set numdgt=17
ac lin 1 60 60
print v(1) v(2) v(3) v(4) v(5) v(6) v(7) v(8) v(9) v(10)
print v(11) v(12) v(13) v(14) v(15) v(16) v(17) v(18) v(19) v(20)
print v(21) v(22) v(23) v(24) v(25) v(26) v(27) v(28) v(29)
print i(vs0) i(vs1) i(vs2) i(vs3) i(vs4) i(vs5) i(vs6) i(vs7) i(vs8) i(vs9)
print i(vs10) i(vs11) i(vs12) i(vs13) i(vs14) i(vs15) i(vs16) i(vs17) i(vs18) i(vs19)
print i(vs20) i(vs21) i(vs22) i(vs23) i(vs24) i(vs25) i(vs26) i(vs27) i(vs28) i(vs29)
print i(vs30) i(vs31) i(vs32) i(vs33) i(vs34) i(vs35) i(vs36) i(vs37) i(vs38) i(vs39)
print i(vs40) i(vs41) i(vs42) i(vs43) i(vs44) i(vs45) i(vs46) i(vs47) i(vs48) i(vs49)
print i(vs50) i(vs51) i(vs52)
.endc
.end
