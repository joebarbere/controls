controls oracle ac-0108
* Generated (plan F2.7, ADR 0012): do not edit; regenerate with `pnpm sim oracle regen`. ac seed 20261031 index 108 nodes 30 elements 49
.options sparse gmin=1e-12 noopac
RG1 1 0 1000000000000
RG2 2 0 1000000000000
RG3 3 0 1000000000000
RG4 4 0 1000000000000
RG5 5 0 1000000000000
RG6 6 0 1000000000000
RG7 7 0 1000000000000
RG8 8 0 1000000000000
RG9 9 0 1000000000000
RG10 10 0 1000000000000
RG11 11 0 1000000000000
RG12 12 0 1000000000000
RG13 13 0 1000000000000
RG14 14 0 1000000000000
RG15 15 0 1000000000000
RG16 16 0 1000000000000
RG17 17 0 1000000000000
RG18 18 0 1000000000000
RG19 19 0 1000000000000
RG20 20 0 1000000000000
RG21 21 0 1000000000000
RG22 22 0 1000000000000
RG23 23 0 1000000000000
RG24 24 0 1000000000000
RG25 25 0 1000000000000
RG26 26 0 1000000000000
RG27 27 0 1000000000000
RG28 28 0 1000000000000
RG29 29 0 1000000000000
VS0 26 s0 0
C0 s0 16 22e-6
VS1 11 s1 0
R1 s1 17 33e3
VS2 0 s2 0
V2 e2 s2 DC 0 AC 12e0 0
RI2 e2 1 10e-2
VS3 0 s3 0
V3 e3 s3 DC 0 AC 56e1 0
RI3 e3 13 15e-2
VS4 6 s4 0
R4 s4 8 12e2
VS5 9 s5 0
C5 s5 1 82e-6
VS6 25 s6 0
R6 s6 17 12e3
VS7 28 s7 0
L7 s7 3 68e-2
VS8 17 s8 0
L8 s8 13 10e-3
VS9 7 s9 0
L9 s9 22 33e-5
VS10 8 s10 0
R10 s10 20 27e3
VS11 22 s11 0
C11 s11 5 10e-7
VS12 1 s12 0
L12 s12 6 18e-5
VS13 1 s13 0
L13 s13 16 47e-5
VS14 6 s14 0
R14 s14 4 15e0
VS15 28 s15 0
L15 s15 2 39e-3
VS16 16 s16 0
C16 s16 10 68e-5
VS17 11 s17 0
L17 s17 16 33e-2
VS18 9 s18 0
R18 s18 0 22e-2
VS19 29 s19 0
C19 s19 10 27e-6
VS20 4 s20 0
V20 e20 s20 DC 0 AC 56e1 0
RI20 e20 10 18e-3
VS21 10 s21 0
L21 s21 0 27e-5
VS22 3 s22 0
R22 s22 9 82e0
VS23 8 s23 0
L23 s23 13 33e-5
VS24 19 s24 0
L24 s24 21 15e-4
VS25 27 s25 0
R25 s25 1 22e3
VS26 21 s26 0
C26 s26 12 15e-5
VS27 6 s27 0
L27 s27 20 15e-5
VS28 17 s28 0
L28 s28 21 82e-4
VS29 18 s29 0
R29 s29 7 47e-2
VS30 2 s30 0
R30 s30 11 33e3
VS31 29 s31 0
L31 s31 14 27e-2
VS32 1 s32 0
V32 e32 s32 DC 0 AC 82e0 -120
RI32 e32 12 47e-3
VS33 18 s33 0
C33 s33 16 68e-7
VS34 25 s34 0
L34 s34 10 18e-3
VS35 3 s35 0
R35 s35 27 22e-2
VS36 23 s36 0
R36 s36 29 15e1
VS37 17 s37 0
R37 s37 22 39e1
VS38 29 s38 0
L38 s38 17 33e-5
VS39 15 s39 0
V39 e39 s39 DC 0 AC 33e-1 -120
RI39 e39 3 33e-3
VS40 2 s40 0
R40 s40 13 56e3
VS41 28 s41 0
L41 s41 22 22e-5
VS42 2 s42 0
L42 s42 13 10e-4
VS43 28 s43 0
R43 s43 2 10e0
VS44 22 s44 0
R44 s44 0 47e2
VS45 13 s45 0
R45 s45 14 22e0
VS46 15 s46 0
V46 e46 s46 DC 0 AC 18e0 0
RI46 e46 22 22e-2
VS47 4 s47 0
R47 s47 21 39e-2
VS48 24 s48 0
R48 s48 23 22e-2
.control
set numdgt=17
ac lin 1 60 60
print v(1) v(2) v(3) v(4) v(5) v(6) v(7) v(8) v(9) v(10)
print v(11) v(12) v(13) v(14) v(15) v(16) v(17) v(18) v(19) v(20)
print v(21) v(22) v(23) v(24) v(25) v(26) v(27) v(28) v(29)
print i(vs0) i(vs1) i(vs2) i(vs3) i(vs4) i(vs5) i(vs6) i(vs7) i(vs8) i(vs9)
print i(vs10) i(vs11) i(vs12) i(vs13) i(vs14) i(vs15) i(vs16) i(vs17) i(vs18) i(vs19)
print i(vs20) i(vs21) i(vs22) i(vs23) i(vs24) i(vs25) i(vs26) i(vs27) i(vs28) i(vs29)
print i(vs30) i(vs31) i(vs32) i(vs33) i(vs34) i(vs35) i(vs36) i(vs37) i(vs38) i(vs39)
print i(vs40) i(vs41) i(vs42) i(vs43) i(vs44) i(vs45) i(vs46) i(vs47) i(vs48)
.endc
.end
