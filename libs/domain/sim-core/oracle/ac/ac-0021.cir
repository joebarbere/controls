controls oracle ac-0021
* Generated (plan F2.7, ADR 0012): do not edit; regenerate with `pnpm sim oracle regen`. ac seed 20261031 index 21 nodes 15 elements 23
.options sparse gmin=1e-12 noopac
RG1 1 0 1000000000000
RG2 2 0 1000000000000
RG3 3 0 1000000000000
RG4 4 0 1000000000000
RG5 5 0 1000000000000
RG6 6 0 1000000000000
RG7 7 0 1000000000000
RG8 8 0 1000000000000
RG9 9 0 1000000000000
RG10 10 0 1000000000000
RG11 11 0 1000000000000
RG12 12 0 1000000000000
RG13 13 0 1000000000000
RG14 14 0 1000000000000
VS0 2 s0 0
L0 s0 11 33e-4
VS1 6 s1 0
C1 s1 3 27e-5
VS2 0 s2 0
R2 s2 6 15e0
VS3 0 s3 0
C3 s3 10 68e-7
VS4 9 s4 0
L4 s4 0 15e-5
VS5 0 s5 0
V5 e5 s5 DC 0 AC 33e0 -120
RI5 e5 n5 56e-1
H5 n5 h5 VS7 68e-3
ED5 h5 12 d5 0 39e-6
F5 0 d5 VS7 1
LD5 d5 0 1
VS6 7 s6 0
C6 s6 1 39e-5
VS7 14 s7 0
V7 e7 s7 DC 0 AC 12e0 -120
RI7 e7 m7 68e-2
LI7 m7 n7 12e-7
H7 n7 h7 VS5 68e-3
ED7 h7 2 d7 0 39e-6
F7 0 d7 VS5 1
LD7 d7 0 1
VS8 5 s8 0
L8 s8 10 68e-5
VS9 12 s9 0
C9 s9 2 27e-6
VS10 14 s10 0
L10 s10 3 33e-3
VS11 4 s11 0
R11 s11 10 15e0
VS12 9 s12 0
V12 e12 s12 DC 0 AC 68e1 180
RI12 e12 13 15e-1
VS13 8 s13 0
L13 s13 3 10e-5
VS14 5 s14 0
R14 s14 2 18e-2
VS15 13 s15 0
R15 s15 4 18e-2
VS16 2 s16 0
R16 s16 7 68e-1
VS17 1 s17 0
L17 s17 10 10e-5
VS18 11 s18 0
R18 s18 4 27e1
VS19 1 s19 0
L19 s19 8 15e-4
VS20 3 s20 0
L20 s20 2 27e-3
VS21 4 s21 0
C21 s21 5 39e-5
VS22 10 s22 0
L22 s22 5 10e-4
.control
set numdgt=17
ac lin 1 60 60
print v(1) v(2) v(3) v(4) v(5) v(6) v(7) v(8) v(9) v(10)
print v(11) v(12) v(13) v(14)
print i(vs0) i(vs1) i(vs2) i(vs3) i(vs4) i(vs5) i(vs6) i(vs7) i(vs8) i(vs9)
print i(vs10) i(vs11) i(vs12) i(vs13) i(vs14) i(vs15) i(vs16) i(vs17) i(vs18) i(vs19)
print i(vs20) i(vs21) i(vs22)
.endc
.end
