controls oracle ac-0021
* Generated (plan F2.7, ADR 0012): do not edit; regenerate with `pnpm sim oracle regen`. ac seed 20261031 index 21 nodes 15 elements 23
.options sparse gmin=1e-12 noopac
RG1 1 0 1000000000000
RG2 2 0 1000000000000
RG3 3 0 1000000000000
RG4 4 0 1000000000000
RG5 5 0 1000000000000
RG6 6 0 1000000000000
RG7 7 0 1000000000000
RG8 8 0 1000000000000
RG9 9 0 1000000000000
RG10 10 0 1000000000000
RG11 11 0 1000000000000
RG12 12 0 1000000000000
RG13 13 0 1000000000000
RG14 14 0 1000000000000
VS0 1 s0 0
R0 s0 5 27e3
VS1 0 s1 0
V1 e1 s1 DC 0 AC 22e-1 120
RI1 e1 12 22e-1
VS2 14 s2 0
V2 e2 s2 DC 0 AC 12e0 -120
RI2 e2 m2 68e-2
LI2 m2 4 39e-6
VS3 3 s3 0
L3 s3 4 27e-3
VS4 9 s4 0
C4 s4 0 22e-6
VS5 8 s5 0
V5 e5 s5 DC 0 AC 33e1 120
RI5 e5 4 27e-1
VS6 11 s6 0
L6 s6 6 68e-3
VS7 13 s7 0
V7 e7 s7 DC 0 AC 82e-1 -120
RI7 e7 11 56e-3
VS8 10 s8 0
L8 s8 5 10e-4
VS9 6 s9 0
C9 s9 3 27e-5
VS10 3 s10 0
L10 s10 12 15e-5
VS11 13 s11 0
L11 s11 2 47e-4
VS12 2 s12 0
L12 s12 13 33e-3
VS13 7 s13 0
C13 s13 0 56e-7
VS14 5 s14 0
R14 s14 4 18e-2
VS15 4 s15 0
V15 e15 s15 DC 0 AC 33e0 -120
RI15 e15 7 56e-1
VS16 8 s16 0
L16 s16 6 12e-3
VS17 0 s17 0
R17 s17 10 15e0
VS18 0 s18 0
L18 s18 2 47e-4
VS19 4 s19 0
R19 s19 9 33e-2
VS20 1 s20 0
C20 s20 12 68e-5
VS21 12 s21 0
R21 s21 14 33e1
VS22 13 s22 0
R22 s22 10 33e2
.control
set numdgt=17
ac lin 1 60 60
print v(1) v(2) v(3) v(4) v(5) v(6) v(7) v(8) v(9) v(10)
print v(11) v(12) v(13) v(14)
print i(vs0) i(vs1) i(vs2) i(vs3) i(vs4) i(vs5) i(vs6) i(vs7) i(vs8) i(vs9)
print i(vs10) i(vs11) i(vs12) i(vs13) i(vs14) i(vs15) i(vs16) i(vs17) i(vs18) i(vs19)
print i(vs20) i(vs21) i(vs22)
.endc
.end
