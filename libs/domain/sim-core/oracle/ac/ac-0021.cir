controls oracle ac-0021
* Generated (plan F2.7, ADR 0012): do not edit; regenerate with `pnpm sim oracle regen`. ac seed 20261031 index 21 nodes 15 elements 17
.options sparse gmin=1e-12 noopac
RG1 1 0 1000000000000
RG2 2 0 1000000000000
RG3 3 0 1000000000000
RG4 4 0 1000000000000
RG5 5 0 1000000000000
RG6 6 0 1000000000000
RG7 7 0 1000000000000
RG8 8 0 1000000000000
RG9 9 0 1000000000000
RG10 10 0 1000000000000
RG11 11 0 1000000000000
RG12 12 0 1000000000000
RG13 13 0 1000000000000
RG14 14 0 1000000000000
VS0 1 s0 0
L0 s0 10 10e-5
VS1 5 s1 0
R1 s1 9 18e-2
VS2 0 s2 0
V2 e2 s2 DC 0 AC 68e1 180
RI2 e2 13 15e-1
VS3 2 s3 0
C3 s3 10 68e-7
VS4 12 s4 0
C4 s4 9 27e-6
VS5 14 s5 0
V5 e5 s5 DC 0 AC 12e0 -120
RI5 e5 9 68e-2
VS6 4 s6 0
C6 s6 5 39e-5
VS7 11 s7 0
R7 s7 4 27e1
VS8 0 s8 0
L8 s8 2 15e-5
VS9 4 s9 0
R9 s9 10 15e0
VS10 10 s10 0
L10 s10 5 10e-4
VS11 8 s11 0
L11 s11 3 10e-5
VS12 14 s12 0
C12 s12 9 15e-7
VS13 6 s13 0
C13 s13 3 27e-5
VS14 5 s14 0
L14 s14 10 68e-5
VS15 3 s15 0
L15 s15 9 27e-3
VS16 9 s16 0
R16 s16 7 68e-1
.control
set numdgt=17
ac lin 1 60 60
print v(1) v(2) v(3) v(4) v(5) v(6) v(7) v(8) v(9) v(10)
print v(11) v(12) v(13) v(14)
print i(vs0) i(vs1) i(vs2) i(vs3) i(vs4) i(vs5) i(vs6) i(vs7) i(vs8) i(vs9)
print i(vs10) i(vs11) i(vs12) i(vs13) i(vs14) i(vs15) i(vs16)
.endc
.end
