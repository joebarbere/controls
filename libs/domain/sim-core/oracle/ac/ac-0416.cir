controls oracle ac-0416
* Generated (plan F2.7, ADR 0012): do not edit; regenerate with `pnpm sim oracle regen`. ac seed 20261031 index 416 nodes 21 elements 32
.options sparse gmin=1e-12 noopac
RG1 1 0 1000000000000
RG2 2 0 1000000000000
RG3 3 0 1000000000000
RG4 4 0 1000000000000
RG5 5 0 1000000000000
RG6 6 0 1000000000000
RG7 7 0 1000000000000
RG8 8 0 1000000000000
RG9 9 0 1000000000000
RG10 10 0 1000000000000
RG11 11 0 1000000000000
RG12 12 0 1000000000000
RG13 13 0 1000000000000
RG14 14 0 1000000000000
RG15 15 0 1000000000000
RG16 16 0 1000000000000
RG17 17 0 1000000000000
RG18 18 0 1000000000000
RG19 19 0 1000000000000
RG20 20 0 1000000000000
VS0 16 s0 0
R0 s0 7 39e3
VS1 0 s1 0
V1 e1 s1 DC 0 AC 47e1 0
RI1 e1 16 39e-3
VS2 10 s2 0
R2 s2 5 39e3
VS3 2 s3 0
R3 s3 20 33e1
VS4 2 s4 0
L4 s4 13 15e-5
VS5 19 s5 0
V5 e5 s5 DC 0 AC 27e1 0
RI5 e5 10 56e-2
VS6 15 s6 0
L6 s6 13 12e-3
VS7 6 s7 0
R7 s7 3 12e2
VS8 14 s8 0
C8 s8 6 33e-5
VS9 6 s9 0
R9 s9 4 82e2
VS10 15 s10 0
C10 s10 7 27e-5
VS11 11 s11 0
L11 s11 10 12e-2
VS12 2 s12 0
R12 s12 15 56e0
VS13 9 s13 0
V13 e13 s13 DC 0 AC 47e0 0
RI13 e13 12 22e-3
VS14 12 s14 0
V14 e14 s14 DC 0 AC 10e0 120
RI14 e14 0 56e-3
VS15 13 s15 0
C15 s15 8 82e-4
VS16 13 s16 0
R16 s16 4 18e3
VS17 17 s17 0
R17 s17 1 18e1
VS18 15 s18 0
V18 e18 s18 DC 0 AC 12e1 180
RI18 e18 11 82e-3
VS19 18 s19 0
L19 s19 14 68e-3
VS20 16 s20 0
L20 s20 1 68e-5
VS21 10 s21 0
R21 s21 12 22e2
VS22 0 s22 0
L22 s22 11 33e-4
VS23 7 s23 0
R23 s23 20 10e2
VS24 17 s24 0
L24 s24 5 33e-3
VS25 8 s25 0
V25 e25 s25 DC 0 AC 82e0 180
RI25 e25 9 15e-2
VS26 16 s26 0
C26 s26 3 39e-4
VS27 18 s27 0
V27 e27 s27 DC 0 AC 10e0 180
RI27 e27 16 18e-1
VS28 20 s28 0
R28 s28 9 82e3
VS29 19 s29 0
R29 s29 15 39e0
VS30 6 s30 0
V30 e30 s30 DC 0 AC 56e0 -120
RI30 e30 3 15e-2
VS31 12 s31 0
R31 s31 3 18e1
.control
set numdgt=17
ac lin 1 60 60
print v(1) v(2) v(3) v(4) v(5) v(6) v(7) v(8) v(9) v(10)
print v(11) v(12) v(13) v(14) v(15) v(16) v(17) v(18) v(19) v(20)
print i(vs0) i(vs1) i(vs2) i(vs3) i(vs4) i(vs5) i(vs6) i(vs7) i(vs8) i(vs9)
print i(vs10) i(vs11) i(vs12) i(vs13) i(vs14) i(vs15) i(vs16) i(vs17) i(vs18) i(vs19)
print i(vs20) i(vs21) i(vs22) i(vs23) i(vs24) i(vs25) i(vs26) i(vs27) i(vs28) i(vs29)
print i(vs30) i(vs31)
.endc
.end
