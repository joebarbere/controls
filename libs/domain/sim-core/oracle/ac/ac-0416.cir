controls oracle ac-0416
* Generated (plan F2.7, ADR 0012): do not edit; regenerate with `pnpm sim oracle regen`. ac seed 20261031 index 416 nodes 21 elements 28
.options sparse gmin=1e-12 noopac
RG1 1 0 1000000000000
RG2 2 0 1000000000000
RG3 3 0 1000000000000
RG4 4 0 1000000000000
RG5 5 0 1000000000000
RG6 6 0 1000000000000
RG7 7 0 1000000000000
RG8 8 0 1000000000000
RG9 9 0 1000000000000
RG10 10 0 1000000000000
RG11 11 0 1000000000000
RG12 12 0 1000000000000
RG13 13 0 1000000000000
RG14 14 0 1000000000000
RG15 15 0 1000000000000
RG16 16 0 1000000000000
RG17 17 0 1000000000000
RG18 18 0 1000000000000
RG19 19 0 1000000000000
RG20 20 0 1000000000000
VS0 4 s0 0
R0 s0 8 27e1
VS1 18 s1 0
C1 s1 7 27e-5
VS2 0 s2 0
V2 e2 s2 DC 0 AC 47e0 0
RI2 e2 2 22e-3
VS3 7 s3 0
R3 s3 20 10e2
VS4 0 s4 0
C4 s4 12 33e-5
VS5 6 s5 0
R5 s5 10 82e2
VS6 16 s6 0
R6 s6 7 39e3
VS7 14 s7 0
L7 s7 13 47e-3
VS8 3 s8 0
V8 e8 s8 DC 0 AC 12e-1 120
RI8 e8 m8 56e-3
LI8 m8 18 18e-7
VS9 3 s9 0
L9 s9 12 15e-5
VS10 11 s10 0
L10 s10 13 12e-4
VS11 12 s11 0
C11 s11 5 22e-7
VS12 17 s12 0
R12 s12 9 82e0
VS13 19 s13 0
R13 s13 13 33e0
VS14 5 s14 0
C14 s14 20 82e-5
VS15 18 s15 0
V15 e15 s15 DC 0 AC 12e1 180
RI15 e15 m15 82e-3
LI15 m15 11 56e-5
VS16 2 s16 0
R16 s16 20 33e1
VS17 20 s17 0
V17 e17 s17 DC 0 AC 22e-1 -120
RI17 e17 m17 18e-1
LI17 m17 1 15e-6
VS18 1 s18 0
L18 s18 4 10e-2
VS19 19 s19 0
R19 s19 18 27e3
VS20 17 s20 0
R20 s20 8 22e-2
VS21 15 s21 0
L21 s21 13 82e-5
VS22 16 s22 0
R22 s22 17 39e-1
VS23 10 s23 0
R23 s23 9 68e-2
VS24 1 s24 0
R24 s24 13 22e-2
VS25 14 s25 0
L25 s25 20 68e-3
VS26 3 s26 0
L26 s26 6 12e-2
VS27 20 s27 0
R27 s27 15 47e0
.control
set numdgt=17
ac lin 1 60 60
print v(1) v(2) v(3) v(4) v(5) v(6) v(7) v(8) v(9) v(10)
print v(11) v(12) v(13) v(14) v(15) v(16) v(17) v(18) v(19) v(20)
print i(vs0) i(vs1) i(vs2) i(vs3) i(vs4) i(vs5) i(vs6) i(vs7) i(vs8) i(vs9)
print i(vs10) i(vs11) i(vs12) i(vs13) i(vs14) i(vs15) i(vs16) i(vs17) i(vs18) i(vs19)
print i(vs20) i(vs21) i(vs22) i(vs23) i(vs24) i(vs25) i(vs26) i(vs27)
.endc
.end
