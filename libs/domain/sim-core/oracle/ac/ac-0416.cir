controls oracle ac-0416
* Generated (plan F2.7, ADR 0012): do not edit; regenerate with `pnpm sim oracle regen`. ac seed 20261031 index 416 nodes 21 elements 27
.options sparse gmin=1e-12 noopac
RG1 1 0 1000000000000
RG2 2 0 1000000000000
RG3 3 0 1000000000000
RG4 4 0 1000000000000
RG5 5 0 1000000000000
RG6 6 0 1000000000000
RG7 7 0 1000000000000
RG8 8 0 1000000000000
RG9 9 0 1000000000000
RG10 10 0 1000000000000
RG11 11 0 1000000000000
RG12 12 0 1000000000000
RG13 13 0 1000000000000
RG14 14 0 1000000000000
RG15 15 0 1000000000000
RG16 16 0 1000000000000
RG17 17 0 1000000000000
RG18 18 0 1000000000000
RG19 19 0 1000000000000
RG20 20 0 1000000000000
VS0 0 s0 0
V0 e0 s0 DC 0 AC 12e1 180
RI0 e0 11 82e-3
VS1 6 s1 0
R1 s1 3 12e2
VS2 6 s2 0
V2 e2 s2 DC 0 AC 56e0 -120
RI2 e2 3 15e-2
VS3 15 s3 0
L3 s3 11 33e-4
VS4 9 s4 0
V4 e4 s4 DC 0 AC 47e0 0
RI4 e4 12 22e-3
VS5 2 s5 0
R5 s5 20 33e1
VS6 19 s6 0
R6 s6 0 39e0
VS7 20 s7 0
R7 s7 9 82e3
VS8 12 s8 0
V8 e8 s8 DC 0 AC 10e0 120
RI8 e8 15 56e-3
VS9 2 s9 0
L9 s9 13 15e-5
VS10 7 s10 0
R10 s10 20 10e2
VS11 6 s11 0
R11 s11 4 82e2
VS12 0 s12 0
L12 s12 13 12e-3
VS13 14 s13 0
C13 s13 6 33e-5
VS14 11 s14 0
L14 s14 10 12e-2
VS15 16 s15 0
R15 s15 7 39e3
VS16 15 s16 0
V16 e16 s16 DC 0 AC 47e1 0
RI16 e16 16 39e-3
VS17 17 s17 0
L17 s17 5 33e-3
VS18 18 s18 0
L18 s18 14 68e-3
VS19 2 s19 0
R19 s19 0 56e0
VS20 13 s20 0
C20 s20 8 82e-4
VS21 16 s21 0
C21 s21 3 39e-4
VS22 16 s22 0
L22 s22 1 68e-5
VS23 10 s23 0
R23 s23 12 22e2
VS24 0 s24 0
C24 s24 7 27e-5
VS25 12 s25 0
R25 s25 3 18e1
VS26 17 s26 0
R26 s26 1 18e1
.control
set numdgt=17
ac lin 1 60 60
print v(1) v(2) v(3) v(4) v(5) v(6) v(7) v(8) v(9) v(10)
print v(11) v(12) v(13) v(14) v(15) v(16) v(17) v(18) v(19) v(20)
print i(vs0) i(vs1) i(vs2) i(vs3) i(vs4) i(vs5) i(vs6) i(vs7) i(vs8) i(vs9)
print i(vs10) i(vs11) i(vs12) i(vs13) i(vs14) i(vs15) i(vs16) i(vs17) i(vs18) i(vs19)
print i(vs20) i(vs21) i(vs22) i(vs23) i(vs24) i(vs25) i(vs26)
.endc
.end
