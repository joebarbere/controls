controls oracle ac-0220
* Generated (plan F2.7, ADR 0012): do not edit; regenerate with `pnpm sim oracle regen`. ac seed 20261031 index 220 nodes 14 elements 22
.options sparse gmin=1e-12 noopac
RG1 1 0 1000000000000
RG2 2 0 1000000000000
RG3 3 0 1000000000000
RG4 4 0 1000000000000
RG5 5 0 1000000000000
RG6 6 0 1000000000000
RG7 7 0 1000000000000
RG8 8 0 1000000000000
RG9 9 0 1000000000000
RG10 10 0 1000000000000
RG11 11 0 1000000000000
RG12 12 0 1000000000000
RG13 13 0 1000000000000
VS0 3 s0 0
C0 s0 13 56e-4
VS1 1 s1 0
L1 s1 13 33e-3
VS2 13 s2 0
L2 s2 4 12e-5
VS3 0 s3 0
V3 e3 s3 DC 0 AC 27e0 180
RI3 e3 12 18e-2
VS4 12 s4 0
L4 s4 13 68e-3
VS5 8 s5 0
L5 s5 7 15e-4
VS6 5 s6 0
R6 s6 10 15e-1
VS7 9 s7 0
R7 s7 5 39e-2
VS8 2 s8 0
C8 s8 10 39e-5
VS9 4 s9 0
R9 s9 9 39e1
VS10 4 s10 0
C10 s10 2 56e-4
VS11 3 s11 0
C11 s11 7 22e-5
VS12 8 s12 0
C12 s12 1 33e-6
VS13 5 s13 0
C13 s13 0 27e-4
VS14 5 s14 0
R14 s14 6 68e3
VS15 4 s15 0
L15 s15 11 18e-2
VS16 5 s16 0
V16 e16 s16 DC 0 AC 15e0 180
RI16 e16 m16 18e-1
LI16 m16 4 12e-7
VS17 7 s17 0
C17 s17 5 10e-6
VS18 10 s18 0
C18 s18 6 22e-6
VS19 10 s19 0
L19 s19 12 33e-2
VS20 4 s20 0
V20 e20 s20 DC 0 AC 33e1 180
RI20 e20 m20 33e-2
LI20 m20 13 47e-7
VS21 10 s21 0
R21 s21 11 56e1
.control
set numdgt=17
ac lin 1 60 60
print v(1) v(2) v(3) v(4) v(5) v(6) v(7) v(8) v(9) v(10)
print v(11) v(12) v(13)
print i(vs0) i(vs1) i(vs2) i(vs3) i(vs4) i(vs5) i(vs6) i(vs7) i(vs8) i(vs9)
print i(vs10) i(vs11) i(vs12) i(vs13) i(vs14) i(vs15) i(vs16) i(vs17) i(vs18) i(vs19)
print i(vs20) i(vs21)
.endc
.end
