controls oracle ac-0220
* Generated (plan F2.7, ADR 0012): do not edit; regenerate with `pnpm sim oracle regen`. ac seed 20261031 index 220 nodes 14 elements 21
.options sparse gmin=1e-12 noopac
RG1 1 0 1000000000000
RG2 2 0 1000000000000
RG3 3 0 1000000000000
RG4 4 0 1000000000000
RG5 5 0 1000000000000
RG6 6 0 1000000000000
RG7 7 0 1000000000000
RG8 8 0 1000000000000
RG9 9 0 1000000000000
RG10 10 0 1000000000000
RG11 11 0 1000000000000
RG12 12 0 1000000000000
RG13 13 0 1000000000000
VS0 8 s0 0
C0 s0 11 27e-5
VS1 0 s1 0
V1 e1 s1 DC 0 AC 15e0 180
RI1 e1 5 18e-1
VS2 0 s2 0
R2 s2 6 68e3
VS3 10 s3 0
V3 e3 s3 DC 0 AC 12e0 120
RI3 e3 4 68e-1
VS4 5 s4 0
L4 s4 11 18e-2
VS5 4 s5 0
V5 e5 s5 DC 0 AC 27e0 180
RI5 e5 12 18e-2
VS6 13 s6 0
L6 s6 5 12e-5
VS7 5 s7 0
C7 s7 2 56e-4
VS8 6 s8 0
R8 s8 12 68e0
VS9 10 s9 0
C9 s9 9 10e-4
VS10 1 s10 0
R10 s10 13 10e-2
VS11 12 s11 0
L11 s11 11 39e-2
VS12 3 s12 0
R12 s12 5 39e2
VS13 0 s13 0
V13 e13 s13 DC 0 AC 33e0 180
RI13 e13 7 10e-2
VS14 10 s14 0
C14 s14 0 12e-7
VS15 3 s15 0
R15 s15 7 27e3
VS16 8 s16 0
L16 s16 10 12e-3
VS17 3 s17 0
L17 s17 13 39e-4
VS18 1 s18 0
C18 s18 13 18e-5
VS19 8 s19 0
L19 s19 7 15e-4
VS20 0 s20 0
C20 s20 4 27e-4
.control
set numdgt=17
ac lin 1 60 60
print v(1) v(2) v(3) v(4) v(5) v(6) v(7) v(8) v(9) v(10)
print v(11) v(12) v(13)
print i(vs0) i(vs1) i(vs2) i(vs3) i(vs4) i(vs5) i(vs6) i(vs7) i(vs8) i(vs9)
print i(vs10) i(vs11) i(vs12) i(vs13) i(vs14) i(vs15) i(vs16) i(vs17) i(vs18) i(vs19)
print i(vs20)
.endc
.end
