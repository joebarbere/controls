controls oracle ac-0220
* Generated (plan F2.7, ADR 0012): do not edit; regenerate with `pnpm sim oracle regen`. ac seed 20261031 index 220 nodes 14 elements 24
.options sparse gmin=1e-12 noopac
RG1 1 0 1000000000000
RG2 2 0 1000000000000
RG3 3 0 1000000000000
RG4 4 0 1000000000000
RG5 5 0 1000000000000
RG6 6 0 1000000000000
RG7 7 0 1000000000000
RG8 8 0 1000000000000
RG9 9 0 1000000000000
RG10 10 0 1000000000000
RG11 11 0 1000000000000
RG12 12 0 1000000000000
RG13 13 0 1000000000000
VS0 0 s0 0
C0 s0 5 12e-7
VS1 0 s1 0
V1 e1 s1 DC 0 AC 12e0 120
RI1 e1 m1 68e-1
LI1 m1 4 27e-6
VS2 5 s2 0
C2 s2 4 27e-4
VS3 13 s3 0
L3 s3 10 12e-5
VS4 0 s4 0
C4 s4 9 10e-4
VS5 8 s5 0
C5 s5 11 27e-5
VS6 8 s6 0
L6 s6 0 12e-3
VS7 10 s7 0
L7 s7 11 18e-2
VS8 3 s8 0
L8 s8 13 39e-4
VS9 3 s9 0
R9 s9 7 27e3
VS10 1 s10 0
C10 s10 13 18e-5
VS11 9 s11 0
C11 s11 6 22e-7
VS12 6 s12 0
L12 s12 1 47e-3
VS13 8 s13 0
L13 s13 7 15e-4
VS14 5 s14 0
V14 e14 s14 DC 0 AC 33e0 180
RI14 e14 m14 10e-2
LI14 m14 7 10e-5
VS15 3 s15 0
R15 s15 10 39e2
VS16 6 s16 0
R16 s16 12 68e0
VS17 12 s17 0
L17 s17 2 82e-4
VS18 5 s18 0
R18 s18 6 68e3
VS19 1 s19 0
R19 s19 13 10e-2
VS20 5 s20 0
V20 e20 s20 DC 0 AC 15e0 180
RI20 e20 10 18e-1
VS21 12 s21 0
L21 s21 11 39e-2
VS22 10 s22 0
C22 s22 2 56e-4
VS23 4 s23 0
V23 e23 s23 DC 0 AC 27e0 180
RI23 e23 m23 18e-2
LI23 m23 12 56e-5
.control
set numdgt=17
ac lin 1 60 60
print v(1) v(2) v(3) v(4) v(5) v(6) v(7) v(8) v(9) v(10)
print v(11) v(12) v(13)
print i(vs0) i(vs1) i(vs2) i(vs3) i(vs4) i(vs5) i(vs6) i(vs7) i(vs8) i(vs9)
print i(vs10) i(vs11) i(vs12) i(vs13) i(vs14) i(vs15) i(vs16) i(vs17) i(vs18) i(vs19)
print i(vs20) i(vs21) i(vs22) i(vs23)
.endc
.end
