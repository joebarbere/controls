controls oracle ac-0180
* Generated (plan F2.7, ADR 0012): do not edit; regenerate with `pnpm sim oracle regen`. ac seed 20261031 index 180 nodes 27 elements 41
.options sparse gmin=1e-12 noopac
RG1 1 0 1000000000000
RG2 2 0 1000000000000
RG3 3 0 1000000000000
RG4 4 0 1000000000000
RG5 5 0 1000000000000
RG6 6 0 1000000000000
RG7 7 0 1000000000000
RG8 8 0 1000000000000
RG9 9 0 1000000000000
RG10 10 0 1000000000000
RG11 11 0 1000000000000
RG12 12 0 1000000000000
RG13 13 0 1000000000000
RG14 14 0 1000000000000
RG15 15 0 1000000000000
RG16 16 0 1000000000000
RG17 17 0 1000000000000
RG18 18 0 1000000000000
RG19 19 0 1000000000000
RG20 20 0 1000000000000
RG21 21 0 1000000000000
RG22 22 0 1000000000000
RG23 23 0 1000000000000
RG24 24 0 1000000000000
RG25 25 0 1000000000000
RG26 26 0 1000000000000
VS0 23 s0 0
L0 s0 10 10e-3
VS1 11 s1 0
R1 s1 0 56e3
VS2 23 s2 0
C2 s2 24 82e-6
VS3 3 s3 0
R3 s3 2 82e-2
VS4 15 s4 0
C4 s4 14 15e-7
VS5 1 s5 0
L5 s5 12 47e-4
VS6 0 s6 0
V6 e6 s6 DC 0 AC 82e0 120
RI6 e6 m6 12e-3
LI6 m6 21 33e-6
VS7 17 s7 0
C7 s7 26 15e-5
VS8 13 s8 0
L8 s8 3 33e-2
VS9 17 s9 0
R9 s9 12 22e0
VS10 10 s10 0
R10 s10 20 68e-2
VS11 9 s11 0
R11 s11 7 15e0
VS12 6 s12 0
V12 e12 s12 DC 0 AC 22e-1 -120
RI12 e12 13 82e-2
VS13 1 s13 0
R13 s13 24 56e-2
VS14 4 s14 0
V14 e14 s14 DC 0 AC 82e1 120
RI14 e14 21 68e-3
VS15 23 s15 0
R15 s15 18 22e2
VS16 12 s16 0
C16 s16 3 15e-4
VS17 12 s17 0
L17 s17 19 10e-5
VS18 22 s18 0
L18 s18 17 27e-2
VS19 15 s19 0
C19 s19 12 15e-5
VS20 25 s20 0
V20 e20 s20 DC 0 AC 39e0 -120
RI20 e20 5 18e-1
VS21 19 s21 0
R21 s21 4 47e-2
VS22 2 s22 0
C22 s22 26 47e-5
VS23 8 s23 0
L23 s23 7 56e-2
VS24 18 s24 0
L24 s24 2 12e-2
VS25 5 s25 0
R25 s25 26 15e1
VS26 21 s26 0
V26 e26 s26 DC 0 AC 68e-1 180
RI26 e26 9 27e-3
VS27 3 s27 0
R27 s27 14 68e2
VS28 23 s28 0
R28 s28 3 10e-2
VS29 12 s29 0
C29 s29 22 39e-6
VS30 15 s30 0
C30 s30 8 18e-4
VS31 2 s31 0
V31 e31 s31 DC 0 AC 15e0 180
RI31 e31 20 15e-1
VS32 12 s32 0
L32 s32 0 47e-3
VS33 17 s33 0
R33 s33 16 15e1
VS34 26 s34 0
L34 s34 16 10e-3
VS35 11 s35 0
R35 s35 26 82e3
VS36 12 s36 0
C36 s36 4 47e-6
VS37 25 s37 0
R37 s37 21 10e1
VS38 21 s38 0
L38 s38 17 10e-2
VS39 17 s39 0
V39 e39 s39 DC 0 AC 47e1 180
RI39 e39 25 12e-3
VS40 18 s40 0
C40 s40 6 18e-7
.control
set numdgt=17
ac lin 1 60 60
print v(1) v(2) v(3) v(4) v(5) v(6) v(7) v(8) v(9) v(10)
print v(11) v(12) v(13) v(14) v(15) v(16) v(17) v(18) v(19) v(20)
print v(21) v(22) v(23) v(24) v(25) v(26)
print i(vs0) i(vs1) i(vs2) i(vs3) i(vs4) i(vs5) i(vs6) i(vs7) i(vs8) i(vs9)
print i(vs10) i(vs11) i(vs12) i(vs13) i(vs14) i(vs15) i(vs16) i(vs17) i(vs18) i(vs19)
print i(vs20) i(vs21) i(vs22) i(vs23) i(vs24) i(vs25) i(vs26) i(vs27) i(vs28) i(vs29)
print i(vs30) i(vs31) i(vs32) i(vs33) i(vs34) i(vs35) i(vs36) i(vs37) i(vs38) i(vs39)
print i(vs40)
.endc
.end
