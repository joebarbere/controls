controls oracle ac-0370
* Generated (plan F2.7, ADR 0012): do not edit; regenerate with `pnpm sim oracle regen`. ac seed 20261031 index 370 nodes 8 elements 15
.options sparse gmin=1e-12 noopac
RG1 1 0 1000000000000
RG2 2 0 1000000000000
RG3 3 0 1000000000000
RG4 4 0 1000000000000
RG5 5 0 1000000000000
RG6 6 0 1000000000000
RG7 7 0 1000000000000
VS0 2 s0 0
R0 s0 0 33e-2
VS1 1 s1 0
L1 s1 0 22e-4
VS2 1 s2 0
C2 s2 3 10e-6
VS3 0 s3 0
R3 s3 4 39e2
VS4 0 s4 0
V4 e4 s4 DC 0 AC 39e1 -120
RI4 e4 m4 10e-3
LI4 m4 5 33e-5
VS5 6 s5 0
L5 s5 2 12e-4
VS6 0 s6 0
R6 s6 3 15e2
VS7 1 s7 0
L7 s7 0 33e-5
VS8 7 s8 0
R8 s8 3 39e2
VS9 2 s9 0
R9 s9 3 10e-2
VS10 1 s10 0
C10 s10 7 33e-7
VS11 7 s11 0
C11 s11 4 56e-4
VS12 6 s12 0
R12 s12 5 82e1
VS13 0 s13 0
V13 e13 s13 DC 0 AC 82e-1 180
RI13 e13 1 27e-3
VS14 0 s14 0
C14 s14 3 39e-5
.control
set numdgt=17
ac lin 1 60 60
print v(1) v(2) v(3) v(4) v(5) v(6) v(7)
print i(vs0) i(vs1) i(vs2) i(vs3) i(vs4) i(vs5) i(vs6) i(vs7) i(vs8) i(vs9)
print i(vs10) i(vs11) i(vs12) i(vs13) i(vs14)
.endc
.end
