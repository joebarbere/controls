controls oracle ac-0088
* Generated (plan F2.7, ADR 0012): do not edit; regenerate with `pnpm sim oracle regen`. ac seed 20261031 index 88 nodes 23 elements 35
.options sparse gmin=1e-12 noopac
RG1 1 0 1000000000000
RG2 2 0 1000000000000
RG3 3 0 1000000000000
RG4 4 0 1000000000000
RG5 5 0 1000000000000
RG6 6 0 1000000000000
RG7 7 0 1000000000000
RG8 8 0 1000000000000
RG9 9 0 1000000000000
RG10 10 0 1000000000000
RG11 11 0 1000000000000
RG12 12 0 1000000000000
RG13 13 0 1000000000000
RG14 14 0 1000000000000
RG15 15 0 1000000000000
RG16 16 0 1000000000000
RG17 17 0 1000000000000
RG18 18 0 1000000000000
RG19 19 0 1000000000000
RG20 20 0 1000000000000
RG21 21 0 1000000000000
RG22 22 0 1000000000000
VS0 19 s0 0
C0 s0 4 15e-5
VS1 0 s1 0
L1 s1 18 56e-5
VS2 21 s2 0
R2 s2 22 22e3
VS3 15 s3 0
C3 s3 20 22e-4
VS4 6 s4 0
L4 s4 0 18e-2
VS5 13 s5 0
L5 s5 19 39e-2
VS6 0 s6 0
V6 e6 s6 DC 0 AC 33e0 -120
RI6 e6 22 82e-1
VS7 5 s7 0
R7 s7 6 33e3
VS8 5 s8 0
R8 s8 16 56e-1
VS9 17 s9 0
R9 s9 6 39e1
VS10 10 s10 0
V10 e10 s10 DC 0 AC 56e0 180
RI10 e10 m10 68e-2
LI10 m10 4 56e-5
VS11 19 s11 0
L11 s11 12 10e-4
VS12 7 s12 0
V12 e12 s12 DC 0 AC 12e-1 -120
RI12 e12 12 39e-2
VS13 15 s13 0
L13 s13 12 18e-4
VS14 13 s14 0
C14 s14 9 22e-4
VS15 11 s15 0
L15 s15 7 56e-4
VS16 13 s16 0
C16 s16 10 15e-4
VS17 15 s17 0
C17 s17 16 15e-5
VS18 7 s18 0
V18 e18 s18 DC 0 AC 27e1 120
RI18 e18 17 68e-3
VS19 15 s19 0
V19 e19 s19 DC 0 AC 27e0 120
RI19 e19 m19 18e-1
LI19 m19 4 18e-6
VS20 6 s20 0
V20 e20 s20 DC 0 AC 56e0 180
RI20 e20 5 33e-3
VS21 17 s21 0
C21 s21 20 12e-4
VS22 2 s22 0
R22 s22 1 68e1
VS23 5 s23 0
C23 s23 21 33e-7
VS24 13 s24 0
V24 e24 s24 DC 0 AC 15e0 180
RI24 e24 m24 82e-1
LI24 m24 1 22e-6
VS25 14 s25 0
L25 s25 22 33e-4
VS26 3 s26 0
R26 s26 21 82e-2
VS27 17 s27 0
L27 s27 3 27e-3
VS28 7 s28 0
R28 s28 17 27e0
VS29 9 s29 0
C29 s29 5 33e-6
VS30 14 s30 0
V30 e30 s30 DC 0 AC 68e1 120
RI30 e30 8 27e-1
VS31 8 s31 0
V31 e31 s31 DC 0 AC 22e0 120
RI31 e31 m31 56e-2
LI31 m31 20 18e-6
VS32 2 s32 0
C32 s32 14 33e-4
VS33 11 s33 0
V33 e33 s33 DC 0 AC 39e1 120
RI33 e33 m33 15e-3
LI33 m33 18 22e-6
VS34 18 s34 0
R34 s34 5 10e2
.control
set numdgt=17
ac lin 1 60 60
print v(1) v(2) v(3) v(4) v(5) v(6) v(7) v(8) v(9) v(10)
print v(11) v(12) v(13) v(14) v(15) v(16) v(17) v(18) v(19) v(20)
print v(21) v(22)
print i(vs0) i(vs1) i(vs2) i(vs3) i(vs4) i(vs5) i(vs6) i(vs7) i(vs8) i(vs9)
print i(vs10) i(vs11) i(vs12) i(vs13) i(vs14) i(vs15) i(vs16) i(vs17) i(vs18) i(vs19)
print i(vs20) i(vs21) i(vs22) i(vs23) i(vs24) i(vs25) i(vs26) i(vs27) i(vs28) i(vs29)
print i(vs30) i(vs31) i(vs32) i(vs33) i(vs34)
.endc
.end
