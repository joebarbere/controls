controls oracle ac-0088
* Generated (plan F2.7, ADR 0012): do not edit; regenerate with `pnpm sim oracle regen`. ac seed 20261031 index 88 nodes 23 elements 42
.options sparse gmin=1e-12 noopac
RG1 1 0 1000000000000
RG2 2 0 1000000000000
RG3 3 0 1000000000000
RG4 4 0 1000000000000
RG5 5 0 1000000000000
RG6 6 0 1000000000000
RG7 7 0 1000000000000
RG8 8 0 1000000000000
RG9 9 0 1000000000000
RG10 10 0 1000000000000
RG11 11 0 1000000000000
RG12 12 0 1000000000000
RG13 13 0 1000000000000
RG14 14 0 1000000000000
RG15 15 0 1000000000000
RG16 16 0 1000000000000
RG17 17 0 1000000000000
RG18 18 0 1000000000000
RG19 19 0 1000000000000
RG20 20 0 1000000000000
RG21 21 0 1000000000000
RG22 22 0 1000000000000
VS0 0 s0 0
V0 e0 s0 DC 0 AC 12e0 0
RI0 e0 m0 39e-3
LI0 m0 22 33e-5
VS1 22 s1 0
C1 s1 8 39e-4
VS2 6 s2 0
C2 s2 19 56e-7
VS3 17 s3 0
C3 s3 19 22e-6
VS4 13 s4 0
V4 e4 s4 DC 0 AC 15e0 180
RI4 e4 m4 82e-1
LI4 m4 1 82e-5
VS5 7 s5 0
R5 s5 12 22e0
VS6 3 s6 0
V6 e6 s6 DC 0 AC 18e-1 120
RI6 e6 m6 68e-3
LI6 m6 2 56e-7
VS7 2 s7 0
R7 s7 6 39e1
VS8 15 s8 0
C8 s8 16 15e-5
VS9 0 s9 0
L9 s9 11 33e-4
VS10 12 s10 0
R10 s10 2 39e2
VS11 19 s11 0
V11 e11 s11 DC 0 AC 39e0 -120
RI11 e11 m11 18e-2
LI11 m11 9 47e-6
VS12 17 s12 0
R12 s12 8 33e3
VS13 13 s13 0
C13 s13 10 12e-6
VS14 2 s14 0
C14 s14 4 82e-7
VS15 15 s15 0
C15 s15 10 27e-4
VS16 14 s16 0
R16 s16 0 27e-2
VS17 19 s17 0
C17 s17 4 15e-5
VS18 1 s18 0
V18 e18 s18 DC 0 AC 12e1 -120
RI18 e18 m18 10e-1
LI18 m18 8 39e-7
VS19 13 s19 0
L19 s19 19 39e-2
VS20 3 s20 0
V20 e20 s20 DC 0 AC 10e1 120
RI20 e20 m20 18e-3
LI20 m20 14 47e-7
VS21 1 s21 0
R21 s21 20 12e1
VS22 18 s22 0
R22 s22 5 10e2
VS23 5 s23 0
R23 s23 16 56e-1
VS24 6 s24 0
V24 e24 s24 DC 0 AC 56e0 180
RI24 e24 m24 33e-3
LI24 m24 5 47e-7
VS25 5 s25 0
R25 s25 6 33e3
VS26 18 s26 0
L26 s26 19 27e-2
VS27 11 s27 0
R27 s27 7 10e2
VS28 13 s28 0
V28 e28 s28 DC 0 AC 22e1 180
RI28 e28 m28 68e-3
LI28 m28 4 12e-6
VS29 9 s29 0
C29 s29 5 33e-6
VS30 8 s30 0
L30 s30 19 22e-5
VS31 5 s31 0
C31 s31 21 33e-7
VS32 2 s32 0
C32 s32 20 12e-4
VS33 7 s33 0
V33 e33 s33 DC 0 AC 27e1 120
RI33 e33 m33 68e-3
LI33 m33 2 56e-5
VS34 14 s34 0
R34 s34 11 18e-1
VS35 13 s35 0
C35 s35 9 22e-4
VS36 8 s36 0
L36 s36 0 47e-2
VS37 22 s37 0
R37 s37 11 47e-1
VS38 10 s38 0
V38 e38 s38 DC 0 AC 56e0 180
RI38 e38 15 68e-2
VS39 12 s39 0
C39 s39 15 33e-4
VS40 9 s40 0
R40 s40 18 27e0
VS41 21 s41 0
R41 s41 17 15e-2
.control
set numdgt=17
ac lin 1 60 60
print v(1) v(2) v(3) v(4) v(5) v(6) v(7) v(8) v(9) v(10)
print v(11) v(12) v(13) v(14) v(15) v(16) v(17) v(18) v(19) v(20)
print v(21) v(22)
print i(vs0) i(vs1) i(vs2) i(vs3) i(vs4) i(vs5) i(vs6) i(vs7) i(vs8) i(vs9)
print i(vs10) i(vs11) i(vs12) i(vs13) i(vs14) i(vs15) i(vs16) i(vs17) i(vs18) i(vs19)
print i(vs20) i(vs21) i(vs22) i(vs23) i(vs24) i(vs25) i(vs26) i(vs27) i(vs28) i(vs29)
print i(vs30) i(vs31) i(vs32) i(vs33) i(vs34) i(vs35) i(vs36) i(vs37) i(vs38) i(vs39)
print i(vs40) i(vs41)
.endc
.end
