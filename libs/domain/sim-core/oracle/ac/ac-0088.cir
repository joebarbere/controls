controls oracle ac-0088
* Generated (plan F2.7, ADR 0012): do not edit; regenerate with `pnpm sim oracle regen`. ac seed 20261031 index 88 nodes 23 elements 30
.options sparse gmin=1e-12 noopac
RG1 1 0 1000000000000
RG2 2 0 1000000000000
RG3 3 0 1000000000000
RG4 4 0 1000000000000
RG5 5 0 1000000000000
RG6 6 0 1000000000000
RG7 7 0 1000000000000
RG8 8 0 1000000000000
RG9 9 0 1000000000000
RG10 10 0 1000000000000
RG11 11 0 1000000000000
RG12 12 0 1000000000000
RG13 13 0 1000000000000
RG14 14 0 1000000000000
RG15 15 0 1000000000000
RG16 16 0 1000000000000
RG17 17 0 1000000000000
RG18 18 0 1000000000000
RG19 19 0 1000000000000
RG20 20 0 1000000000000
RG21 21 0 1000000000000
RG22 22 0 1000000000000
VS0 5 s0 0
R0 s0 6 33e3
VS1 5 s1 0
R1 s1 16 56e-1
VS2 0 s2 0
V2 e2 s2 DC 0 AC 33e0 -120
RI2 e2 22 82e-1
VS3 11 s3 0
L3 s3 7 56e-4
VS4 17 s4 0
L4 s4 3 27e-3
VS5 15 s5 0
C5 s5 20 22e-4
VS6 6 s6 0
V6 e6 s6 DC 0 AC 56e0 180
RI6 e6 5 33e-3
VS7 13 s7 0
C7 s7 10 15e-4
VS8 2 s8 0
R8 s8 1 68e1
VS9 0 s9 0
L9 s9 18 56e-5
VS10 14 s10 0
V10 e10 s10 DC 0 AC 68e1 120
RI10 e10 8 27e-1
VS11 7 s11 0
R11 s11 17 27e0
VS12 21 s12 0
R12 s12 22 22e3
VS13 17 s13 0
C13 s13 20 12e-4
VS14 13 s14 0
C14 s14 9 22e-4
VS15 7 s15 0
V15 e15 s15 DC 0 AC 12e-1 -120
RI15 e15 12 39e-2
VS16 13 s16 0
L16 s16 19 39e-2
VS17 18 s17 0
R17 s17 5 10e2
VS18 13 s18 0
V18 e18 s18 DC 0 AC 15e0 180
RI18 e18 1 82e-1
VS19 6 s19 0
L19 s19 0 18e-2
VS20 19 s20 0
C20 s20 4 15e-5
VS21 15 s21 0
L21 s21 12 18e-4
VS22 15 s22 0
V22 e22 s22 DC 0 AC 27e0 120
RI22 e22 4 18e-1
VS23 17 s23 0
R23 s23 6 39e1
VS24 9 s24 0
C24 s24 5 33e-6
VS25 8 s25 0
V25 e25 s25 DC 0 AC 22e0 120
RI25 e25 20 56e-2
VS26 15 s26 0
C26 s26 16 15e-5
VS27 5 s27 0
C27 s27 21 33e-7
VS28 19 s28 0
L28 s28 12 10e-4
VS29 7 s29 0
V29 e29 s29 DC 0 AC 27e1 120
RI29 e29 17 68e-3
.control
set numdgt=17
ac lin 1 60 60
print v(1) v(2) v(3) v(4) v(5) v(6) v(7) v(8) v(9) v(10)
print v(11) v(12) v(13) v(14) v(15) v(16) v(17) v(18) v(19) v(20)
print v(21) v(22)
print i(vs0) i(vs1) i(vs2) i(vs3) i(vs4) i(vs5) i(vs6) i(vs7) i(vs8) i(vs9)
print i(vs10) i(vs11) i(vs12) i(vs13) i(vs14) i(vs15) i(vs16) i(vs17) i(vs18) i(vs19)
print i(vs20) i(vs21) i(vs22) i(vs23) i(vs24) i(vs25) i(vs26) i(vs27) i(vs28) i(vs29)
.endc
.end
