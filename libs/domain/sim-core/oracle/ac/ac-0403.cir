controls oracle ac-0403
* Generated (plan F2.7, ADR 0012): do not edit; regenerate with `pnpm sim oracle regen`. ac seed 20261031 index 403 nodes 11 elements 15
.options sparse gmin=1e-12 noopac
RG1 1 0 1000000000000
RG2 2 0 1000000000000
RG3 3 0 1000000000000
RG4 4 0 1000000000000
RG5 5 0 1000000000000
RG6 6 0 1000000000000
RG7 7 0 1000000000000
RG8 8 0 1000000000000
RG9 9 0 1000000000000
RG10 10 0 1000000000000
VS0 5 s0 0
L0 s0 10 27e-5
VS1 0 s1 0
V1 e1 s1 DC 0 AC 15e0 0
RI1 e1 8 82e-1
VS2 9 s2 0
L2 s2 10 39e-3
VS3 3 s3 0
C3 s3 2 22e-6
VS4 7 s4 0
C4 s4 8 39e-5
VS5 8 s5 0
L5 s5 1 68e-5
VS6 4 s6 0
C6 s6 1 12e-6
VS7 1 s7 0
C7 s7 7 27e-5
VS8 2 s8 0
R8 s8 8 33e-2
VS9 9 s9 0
C9 s9 0 56e-5
VS10 10 s10 0
L10 s10 2 33e-4
VS11 0 s11 0
R11 s11 6 27e-1
VS12 1 s12 0
R12 s12 4 22e0
VS13 6 s13 0
R13 s13 2 15e3
VS14 1 s14 0
V14 e14 s14 DC 0 AC 18e-1 120
RI14 e14 5 22e-1
.control
set numdgt=17
ac lin 1 60 60
print v(1) v(2) v(3) v(4) v(5) v(6) v(7) v(8) v(9) v(10)
print i(vs0) i(vs1) i(vs2) i(vs3) i(vs4) i(vs5) i(vs6) i(vs7) i(vs8) i(vs9)
print i(vs10) i(vs11) i(vs12) i(vs13) i(vs14)
.endc
.end
