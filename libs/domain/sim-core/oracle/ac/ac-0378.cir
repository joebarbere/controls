controls oracle ac-0378
* Generated (plan F2.7, ADR 0012): do not edit; regenerate with `pnpm sim oracle regen`. ac seed 20261031 index 378 nodes 24 elements 40
.options sparse gmin=1e-12 noopac
RG1 1 0 1000000000000
RG2 2 0 1000000000000
RG3 3 0 1000000000000
RG4 4 0 1000000000000
RG5 5 0 1000000000000
RG6 6 0 1000000000000
RG7 7 0 1000000000000
RG8 8 0 1000000000000
RG9 9 0 1000000000000
RG10 10 0 1000000000000
RG11 11 0 1000000000000
RG12 12 0 1000000000000
RG13 13 0 1000000000000
RG14 14 0 1000000000000
RG15 15 0 1000000000000
RG16 16 0 1000000000000
RG17 17 0 1000000000000
RG18 18 0 1000000000000
RG19 19 0 1000000000000
RG20 20 0 1000000000000
RG21 21 0 1000000000000
RG22 22 0 1000000000000
RG23 23 0 1000000000000
VS0 0 s0 0
V0 e0 s0 DC 0 AC 22e-1 120
RI0 e0 9 10e-2
VS1 5 s1 0
C1 s1 1 27e-5
VS2 12 s2 0
C2 s2 9 10e-4
VS3 10 s3 0
R3 s3 5 56e3
VS4 6 s4 0
V4 e4 s4 DC 0 AC 33e0 120
RI4 e4 8 33e-3
VS5 7 s5 0
C5 s5 14 27e-5
VS6 16 s6 0
V6 e6 s6 DC 0 AC 39e0 0
RI6 e6 13 18e-3
VS7 11 s7 0
R7 s7 3 15e1
VS8 8 s8 0
L8 s8 0 18e-3
VS9 14 s9 0
C9 s9 4 10e-7
VS10 2 s10 0
L10 s10 14 68e-3
VS11 10 s11 0
L11 s11 20 15e-3
VS12 16 s12 0
V12 e12 s12 DC 0 AC 22e0 -120
RI12 e12 0 39e-1
VS13 15 s13 0
R13 s13 11 33e-1
VS14 0 s14 0
R14 s14 19 33e2
VS15 17 s15 0
R15 s15 13 47e3
VS16 21 s16 0
R16 s16 20 56e3
VS17 20 s17 0
L17 s17 23 10e-3
VS18 12 s18 0
V18 e18 s18 DC 0 AC 56e1 120
RI18 e18 m18 27e-3
LI18 m18 22 56e-5
VS19 7 s19 0
R19 s19 21 10e0
VS20 3 s20 0
V20 e20 s20 DC 0 AC 33e1 0
RI20 e20 m20 15e-3
LI20 m20 4 68e-5
VS21 18 s21 0
R21 s21 5 18e0
VS22 0 s22 0
L22 s22 10 18e-5
VS23 11 s23 0
V23 e23 s23 DC 0 AC 18e0 120
RI23 e23 m23 15e-2
LI23 m23 14 47e-6
VS24 3 s24 0
L24 s24 4 15e-3
VS25 20 s25 0
L25 s25 10 22e-4
VS26 6 s26 0
L26 s26 18 39e-5
VS27 23 s27 0
C27 s27 20 82e-6
VS28 5 s28 0
L28 s28 22 15e-2
VS29 3 s29 0
R29 s29 16 27e3
VS30 22 s30 0
R30 s30 15 22e1
VS31 12 s31 0
L31 s31 16 18e-2
VS32 4 s32 0
R32 s32 19 15e3
VS33 15 s33 0
R33 s33 9 47e-1
VS34 0 s34 0
R34 s34 22 68e-2
VS35 4 s35 0
R35 s35 23 18e1
VS36 15 s36 0
R36 s36 11 47e-1
VS37 7 s37 0
R37 s37 17 82e0
VS38 1 s38 0
C38 s38 7 18e-5
VS39 2 s39 0
L39 s39 9 22e-2
.control
set numdgt=17
ac lin 1 60 60
print v(1) v(2) v(3) v(4) v(5) v(6) v(7) v(8) v(9) v(10)
print v(11) v(12) v(13) v(14) v(15) v(16) v(17) v(18) v(19) v(20)
print v(21) v(22) v(23)
print i(vs0) i(vs1) i(vs2) i(vs3) i(vs4) i(vs5) i(vs6) i(vs7) i(vs8) i(vs9)
print i(vs10) i(vs11) i(vs12) i(vs13) i(vs14) i(vs15) i(vs16) i(vs17) i(vs18) i(vs19)
print i(vs20) i(vs21) i(vs22) i(vs23) i(vs24) i(vs25) i(vs26) i(vs27) i(vs28) i(vs29)
print i(vs30) i(vs31) i(vs32) i(vs33) i(vs34) i(vs35) i(vs36) i(vs37) i(vs38) i(vs39)
.endc
.end
