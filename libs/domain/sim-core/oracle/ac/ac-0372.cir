controls oracle ac-0372
* Generated (plan F2.7, ADR 0012): do not edit; regenerate with `pnpm sim oracle regen`. ac seed 20261031 index 372 nodes 28 elements 39
.options sparse gmin=1e-12 noopac
RG1 1 0 1000000000000
RG2 2 0 1000000000000
RG3 3 0 1000000000000
RG4 4 0 1000000000000
RG5 5 0 1000000000000
RG6 6 0 1000000000000
RG7 7 0 1000000000000
RG8 8 0 1000000000000
RG9 9 0 1000000000000
RG10 10 0 1000000000000
RG11 11 0 1000000000000
RG12 12 0 1000000000000
RG13 13 0 1000000000000
RG14 14 0 1000000000000
RG15 15 0 1000000000000
RG16 16 0 1000000000000
RG17 17 0 1000000000000
RG18 18 0 1000000000000
RG19 19 0 1000000000000
RG20 20 0 1000000000000
RG21 21 0 1000000000000
RG22 22 0 1000000000000
RG23 23 0 1000000000000
RG24 24 0 1000000000000
RG25 25 0 1000000000000
RG26 26 0 1000000000000
RG27 27 0 1000000000000
VS0 2 s0 0
L0 s0 27 12e-5
VS1 0 s1 0
V1 e1 s1 DC 0 AC 56e1 0
RI1 e1 m1 22e-3
LI1 m1 25 12e-6
VS2 10 s2 0
V2 e2 s2 DC 0 AC 12e-1 180
RI2 e2 24 82e-2
VS3 3 s3 0
V3 e3 s3 DC 0 AC 33e0 180
RI3 e3 m3 82e-3
LI3 m3 2 68e-6
VS4 19 s4 0
R4 s4 16 22e2
VS5 6 s5 0
C5 s5 25 22e-7
VS6 8 s6 0
R6 s6 27 33e-2
VS7 18 s7 0
C7 s7 21 12e-5
VS8 20 s8 0
L8 s8 4 47e-5
VS9 0 s9 0
V9 e9 s9 DC 0 AC 56e0 0
RI9 e9 m9 27e-2
LI9 m9 23 10e-5
VS10 16 s10 0
L10 s10 20 18e-3
VS11 11 s11 0
R11 s11 17 47e-1
VS12 17 s12 0
V12 e12 s12 DC 0 AC 18e-1 0
RI12 e12 9 68e-3
VS13 24 s13 0
V13 e13 s13 DC 0 AC 33e1 180
RI13 e13 8 27e-2
VS14 24 s14 0
R14 s14 14 15e-1
VS15 4 s15 0
L15 s15 0 18e-3
VS16 9 s16 0
R16 s16 2 68e3
VS17 16 s17 0
C17 s17 27 18e-7
VS18 26 s18 0
C18 s18 24 12e-6
VS19 1 s19 0
R19 s19 23 33e2
VS20 20 s20 0
V20 e20 s20 DC 0 AC 39e0 180
RI20 e20 5 27e-1
VS21 26 s21 0
L21 s21 16 12e-5
VS22 19 s22 0
R22 s22 22 33e1
VS23 14 s23 0
C23 s23 13 12e-6
VS24 10 s24 0
L24 s24 11 56e-5
VS25 18 s25 0
L25 s25 7 27e-3
VS26 17 s26 0
L26 s26 22 27e-2
VS27 7 s27 0
C27 s27 14 10e-7
VS28 24 s28 0
R28 s28 21 15e1
VS29 9 s29 0
V29 e29 s29 DC 0 AC 33e1 180
RI29 e29 15 82e-3
VS30 3 s30 0
V30 e30 s30 DC 0 AC 22e0 180
RI30 e30 m30 56e-3
LI30 m30 10 22e-6
VS31 14 s31 0
L31 s31 12 27e-2
VS32 12 s32 0
V32 e32 s32 DC 0 AC 22e1 -120
RI32 e32 m32 27e-3
LI32 m32 9 22e-7
VS33 3 s33 0
C33 s33 24 82e-7
VS34 15 s34 0
V34 e34 s34 DC 0 AC 39e0 120
RI34 e34 6 82e-1
VS35 1 s35 0
C35 s35 5 10e-4
VS36 13 s36 0
L36 s36 5 18e-4
VS37 0 s37 0
L37 s37 3 82e-4
VS38 22 s38 0
R38 s38 20 10e1
.control
set numdgt=17
ac lin 1 60 60
print v(1) v(2) v(3) v(4) v(5) v(6) v(7) v(8) v(9) v(10)
print v(11) v(12) v(13) v(14) v(15) v(16) v(17) v(18) v(19) v(20)
print v(21) v(22) v(23) v(24) v(25) v(26) v(27)
print i(vs0) i(vs1) i(vs2) i(vs3) i(vs4) i(vs5) i(vs6) i(vs7) i(vs8) i(vs9)
print i(vs10) i(vs11) i(vs12) i(vs13) i(vs14) i(vs15) i(vs16) i(vs17) i(vs18) i(vs19)
print i(vs20) i(vs21) i(vs22) i(vs23) i(vs24) i(vs25) i(vs26) i(vs27) i(vs28) i(vs29)
print i(vs30) i(vs31) i(vs32) i(vs33) i(vs34) i(vs35) i(vs36) i(vs37) i(vs38)
.endc
.end
