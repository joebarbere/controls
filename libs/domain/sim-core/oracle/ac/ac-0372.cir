controls oracle ac-0372
* Generated (plan F2.7, ADR 0012): do not edit; regenerate with `pnpm sim oracle regen`. ac seed 20261031 index 372 nodes 28 elements 42
.options sparse gmin=1e-12 noopac
RG1 1 0 1000000000000
RG2 2 0 1000000000000
RG3 3 0 1000000000000
RG4 4 0 1000000000000
RG5 5 0 1000000000000
RG6 6 0 1000000000000
RG7 7 0 1000000000000
RG8 8 0 1000000000000
RG9 9 0 1000000000000
RG10 10 0 1000000000000
RG11 11 0 1000000000000
RG12 12 0 1000000000000
RG13 13 0 1000000000000
RG14 14 0 1000000000000
RG15 15 0 1000000000000
RG16 16 0 1000000000000
RG17 17 0 1000000000000
RG18 18 0 1000000000000
RG19 19 0 1000000000000
RG20 20 0 1000000000000
RG21 21 0 1000000000000
RG22 22 0 1000000000000
RG23 23 0 1000000000000
RG24 24 0 1000000000000
RG25 25 0 1000000000000
RG26 26 0 1000000000000
RG27 27 0 1000000000000
VS0 0 s0 0
V0 e0 s0 DC 0 AC 68e1 0
RI0 e0 3 22e-3
VS1 9 s1 0
L1 s1 8 33e-3
VS2 17 s2 0
R2 s2 13 56e0
VS3 0 s3 0
V3 e3 s3 DC 0 AC 39e1 0
RI3 e3 16 27e-3
VS4 13 s4 0
V4 e4 s4 DC 0 AC 39e1 180
RI4 e4 26 68e-1
VS5 4 s5 0
L5 s5 16 56e-2
VS6 18 s6 0
R6 s6 19 15e1
VS7 27 s7 0
R7 s7 9 22e3
VS8 18 s8 0
R8 s8 5 47e2
VS9 1 s9 0
C9 s9 12 12e-6
VS10 11 s10 0
C10 s10 24 12e-6
VS11 2 s11 0
R11 s11 0 33e1
VS12 24 s12 0
L12 s12 3 22e-5
VS13 13 s13 0
V13 e13 s13 DC 0 AC 22e1 0
RI13 e13 25 39e-1
VS14 17 s14 0
L14 s14 20 56e-5
VS15 24 s15 0
L15 s15 12 18e-4
VS16 16 s16 0
V16 e16 s16 DC 0 AC 22e0 120
RI16 e16 21 27e-1
VS17 9 s17 0
R17 s17 26 82e-2
VS18 15 s18 0
V18 e18 s18 DC 0 AC 82e-1 120
RI18 e18 13 27e-2
VS19 15 s19 0
V19 e19 s19 DC 0 AC 22e1 -120
RI19 e19 3 27e-3
VS20 22 s20 0
C20 s20 15 12e-7
VS21 9 s21 0
L21 s21 16 18e-3
VS22 17 s22 0
C22 s22 0 12e-5
VS23 5 s23 0
C23 s23 1 10e-4
VS24 18 s24 0
R24 s24 25 10e0
VS25 0 s25 0
C25 s25 17 27e-4
VS26 25 s26 0
R26 s26 15 47e-1
VS27 13 s27 0
C27 s27 5 12e-6
VS28 3 s28 0
R28 s28 10 18e-2
VS29 20 s29 0
L29 s29 12 12e-3
VS30 0 s30 0
V30 e30 s30 DC 0 AC 56e1 0
RI30 e30 23 22e-3
VS31 2 s31 0
C31 s31 1 18e-7
VS32 18 s32 0
L32 s32 10 68e-4
VS33 18 s33 0
C33 s33 22 12e-7
VS34 17 s34 0
V34 e34 s34 DC 0 AC 56e1 0
RI34 e34 7 47e-2
VS35 10 s35 0
V35 e35 s35 DC 0 AC 33e0 180
RI35 e35 2 82e-3
VS36 17 s36 0
V36 e36 s36 DC 0 AC 10e-1 0
RI36 e36 12 68e-2
VS37 15 s37 0
L37 s37 3 27e-2
VS38 6 s38 0
R38 s38 20 22e2
VS39 2 s39 0
V39 e39 s39 DC 0 AC 33e-1 -120
RI39 e39 0 12e-3
VS40 2 s40 0
L40 s40 14 33e-5
VS41 24 s41 0
R41 s41 9 68e1
.control
set numdgt=17
ac lin 1 60 60
print v(1) v(2) v(3) v(4) v(5) v(6) v(7) v(8) v(9) v(10)
print v(11) v(12) v(13) v(14) v(15) v(16) v(17) v(18) v(19) v(20)
print v(21) v(22) v(23) v(24) v(25) v(26) v(27)
print i(vs0) i(vs1) i(vs2) i(vs3) i(vs4) i(vs5) i(vs6) i(vs7) i(vs8) i(vs9)
print i(vs10) i(vs11) i(vs12) i(vs13) i(vs14) i(vs15) i(vs16) i(vs17) i(vs18) i(vs19)
print i(vs20) i(vs21) i(vs22) i(vs23) i(vs24) i(vs25) i(vs26) i(vs27) i(vs28) i(vs29)
print i(vs30) i(vs31) i(vs32) i(vs33) i(vs34) i(vs35) i(vs36) i(vs37) i(vs38) i(vs39)
print i(vs40) i(vs41)
.endc
.end
