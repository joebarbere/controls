controls oracle ac-0372
* Generated (plan F2.7, ADR 0012): do not edit; regenerate with `pnpm sim oracle regen`. ac seed 20261031 index 372 nodes 28 elements 51
.options sparse gmin=1e-12 noopac
RG1 1 0 1000000000000
RG2 2 0 1000000000000
RG3 3 0 1000000000000
RG4 4 0 1000000000000
RG5 5 0 1000000000000
RG6 6 0 1000000000000
RG7 7 0 1000000000000
RG8 8 0 1000000000000
RG9 9 0 1000000000000
RG10 10 0 1000000000000
RG11 11 0 1000000000000
RG12 12 0 1000000000000
RG13 13 0 1000000000000
RG14 14 0 1000000000000
RG15 15 0 1000000000000
RG16 16 0 1000000000000
RG17 17 0 1000000000000
RG18 18 0 1000000000000
RG19 19 0 1000000000000
RG20 20 0 1000000000000
RG21 21 0 1000000000000
RG22 22 0 1000000000000
RG23 23 0 1000000000000
RG24 24 0 1000000000000
RG25 25 0 1000000000000
RG26 26 0 1000000000000
RG27 27 0 1000000000000
VS0 6 s0 0
R0 s0 20 22e2
VS1 24 s1 0
L1 s1 3 22e-5
VS2 3 s2 0
R2 s2 4 18e-2
VS3 11 s3 0
R3 s3 19 22e2
VS4 1 s4 0
C4 s4 12 12e-6
VS5 18 s5 0
R5 s5 19 15e1
VS6 0 s6 0
V6 e6 s6 DC 0 AC 12e0 120
RI6 e6 n6 18e-1
H6 n6 h6 VS8 56e-4
ED6 h6 8 d6 0 33e-6
F6 0 d6 VS8 1
LD6 d6 0 1
VS7 2 s7 0
R7 s7 10 33e1
VS8 10 s8 0
V8 e8 s8 DC 0 AC 68e1 0
RI8 e8 m8 22e-3
LI8 m8 n8 47e-7
H8 n8 h8 VS6 56e-4
ED8 h8 3 d8 0 33e-6
F8 0 d8 VS6 1
LD8 d8 0 1
VS9 16 s9 0
C9 s9 19 68e-4
VS10 17 s10 0
V10 e10 s10 DC 0 AC 10e-1 0
RI10 e10 m10 68e-2
LI10 m10 12 68e-6
VS11 11 s11 0
C11 s11 24 12e-6
VS12 2 s12 0
C12 s12 1 18e-7
VS13 9 s13 0
L13 s13 8 33e-3
VS14 13 s14 0
V14 e14 s14 DC 0 AC 22e1 0
RI14 e14 25 39e-1
VS15 22 s15 0
C15 s15 15 12e-7
VS16 13 s16 0
V16 e16 s16 DC 0 AC 39e1 180
RI16 e16 26 68e-1
VS17 24 s17 0
L17 s17 12 18e-4
VS18 17 s18 0
C18 s18 10 12e-5
VS19 6 s19 0
V19 e19 s19 DC 0 AC 39e-1 -120
RI19 e19 m19 39e-3
LI19 m19 13 68e-5
VS20 18 s20 0
R20 s20 25 10e0
VS21 18 s21 0
C21 s21 22 12e-7
VS22 5 s22 0
C22 s22 1 10e-4
VS23 15 s23 0
V23 e23 s23 DC 0 AC 22e1 -120
RI23 e23 m23 27e-3
LI23 m23 3 56e-6
VS24 9 s24 0
L24 s24 16 18e-3
VS25 16 s25 0
V25 e25 s25 DC 0 AC 22e0 120
RI25 e25 m25 27e-1
LI25 m25 21 47e-5
VS26 17 s26 0
L26 s26 20 56e-5
VS27 10 s27 0
V27 e27 s27 DC 0 AC 56e1 0
RI27 e27 23 22e-3
VS28 2 s28 0
L28 s28 14 33e-5
VS29 10 s29 0
V29 e29 s29 DC 0 AC 39e1 0
RI29 e29 m29 27e-3
LI29 m29 16 33e-5
VS30 0 s30 0
L30 s30 16 56e-2
VS31 14 s31 0
R31 s31 20 22e0
VS32 17 s32 0
V32 e32 s32 DC 0 AC 56e1 0
RI32 e32 7 47e-2
VS33 2 s33 0
V33 e33 s33 DC 0 AC 33e-1 -120
RI33 e33 10 12e-3
VS34 15 s34 0
V34 e34 s34 DC 0 AC 82e-1 120
RI34 e34 m34 27e-2
LI34 m34 13 47e-5
VS35 4 s35 0
V35 e35 s35 DC 0 AC 33e0 180
RI35 e35 2 82e-3
VS36 24 s36 0
R36 s36 9 68e1
VS37 23 s37 0
C37 s37 5 33e-6
VS38 17 s38 0
R38 s38 13 56e0
VS39 27 s39 0
R39 s39 9 22e3
VS40 25 s40 0
R40 s40 15 47e-1
VS41 18 s41 0
R41 s41 5 47e2
VS42 20 s42 0
L42 s42 12 12e-3
VS43 10 s43 0
V43 e43 s43 DC 0 AC 18e1 0
RI43 e43 7 12e-2
VS44 10 s44 0
C44 s44 17 27e-4
VS45 15 s45 0
L45 s45 3 27e-2
VS46 9 s46 0
R46 s46 26 82e-2
VS47 13 s47 0
C47 s47 5 12e-6
VS48 18 s48 0
L48 s48 4 68e-4
VS49 9 s49 0
V49 e49 s49 DC 0 AC 56e1 0
RI49 e49 21 33e-3
VS50 27 s50 0
V50 e50 s50 DC 0 AC 22e1 180
RI50 e50 m50 47e-3
LI50 m50 6 33e-5
.control
set numdgt=17
ac lin 1 60 60
print v(1) v(2) v(3) v(4) v(5) v(6) v(7) v(8) v(9) v(10)
print v(11) v(12) v(13) v(14) v(15) v(16) v(17) v(18) v(19) v(20)
print v(21) v(22) v(23) v(24) v(25) v(26) v(27)
print i(vs0) i(vs1) i(vs2) i(vs3) i(vs4) i(vs5) i(vs6) i(vs7) i(vs8) i(vs9)
print i(vs10) i(vs11) i(vs12) i(vs13) i(vs14) i(vs15) i(vs16) i(vs17) i(vs18) i(vs19)
print i(vs20) i(vs21) i(vs22) i(vs23) i(vs24) i(vs25) i(vs26) i(vs27) i(vs28) i(vs29)
print i(vs30) i(vs31) i(vs32) i(vs33) i(vs34) i(vs35) i(vs36) i(vs37) i(vs38) i(vs39)
print i(vs40) i(vs41) i(vs42) i(vs43) i(vs44) i(vs45) i(vs46) i(vs47) i(vs48) i(vs49)
print i(vs50)
.endc
.end
