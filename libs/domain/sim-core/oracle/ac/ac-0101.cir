controls oracle ac-0101
* Generated (plan F2.7, ADR 0012): do not edit; regenerate with `pnpm sim oracle regen`. ac seed 20261031 index 101 nodes 23 elements 41
.options sparse gmin=1e-12 noopac
RG1 1 0 1000000000000
RG2 2 0 1000000000000
RG3 3 0 1000000000000
RG4 4 0 1000000000000
RG5 5 0 1000000000000
RG6 6 0 1000000000000
RG7 7 0 1000000000000
RG8 8 0 1000000000000
RG9 9 0 1000000000000
RG10 10 0 1000000000000
RG11 11 0 1000000000000
RG12 12 0 1000000000000
RG13 13 0 1000000000000
RG14 14 0 1000000000000
RG15 15 0 1000000000000
RG16 16 0 1000000000000
RG17 17 0 1000000000000
RG18 18 0 1000000000000
RG19 19 0 1000000000000
RG20 20 0 1000000000000
RG21 21 0 1000000000000
RG22 22 0 1000000000000
VS0 12 s0 0
C0 s0 7 82e-6
VS1 15 s1 0
C1 s1 4 68e-7
VS2 3 s2 0
R2 s2 14 33e3
VS3 18 s3 0
C3 s3 14 39e-6
VS4 22 s4 0
L4 s4 5 39e-4
VS5 0 s5 0
V5 e5 s5 DC 0 AC 12e1 120
RI5 e5 m5 82e-1
LI5 m5 9 56e-6
VS6 3 s6 0
L6 s6 15 12e-5
VS7 11 s7 0
C7 s7 2 18e-7
VS8 2 s8 0
C8 s8 15 68e-7
VS9 18 s9 0
R9 s9 5 47e1
VS10 8 s10 0
V10 e10 s10 DC 0 AC 27e0 0
RI10 e10 16 68e-2
VS11 14 s11 0
R11 s11 10 12e1
VS12 8 s12 0
R12 s12 22 56e0
VS13 4 s13 0
L13 s13 9 47e-3
VS14 20 s14 0
L14 s14 6 56e-2
VS15 17 s15 0
C15 s15 6 33e-7
VS16 0 s16 0
R16 s16 1 15e-2
VS17 19 s17 0
V17 e17 s17 DC 0 AC 22e-1 180
RI17 e17 m17 82e-1
LI17 m17 3 10e-5
VS18 7 s18 0
R18 s18 18 68e2
VS19 15 s19 0
L19 s19 10 22e-2
VS20 15 s20 0
L20 s20 4 18e-2
VS21 10 s21 0
V21 e21 s21 DC 0 AC 22e0 -120
RI21 e21 2 10e-3
VS22 20 s22 0
C22 s22 4 56e-5
VS23 1 s23 0
L23 s23 4 15e-2
VS24 0 s24 0
V24 e24 s24 DC 0 AC 68e-1 120
RI24 e24 3 27e-2
VS25 11 s25 0
V25 e25 s25 DC 0 AC 39e-1 120
RI25 e25 19 68e-2
VS26 19 s26 0
V26 e26 s26 DC 0 AC 56e-1 120
RI26 e26 m26 39e-2
LI26 m26 21 39e-5
VS27 14 s27 0
R27 s27 6 22e3
VS28 0 s28 0
L28 s28 18 18e-5
VS29 8 s29 0
L29 s29 12 22e-3
VS30 14 s30 0
R30 s30 1 10e-1
VS31 13 s31 0
V31 e31 s31 DC 0 AC 47e-1 -120
RI31 e31 m31 39e-3
LI31 m31 16 33e-5
VS32 3 s32 0
V32 e32 s32 DC 0 AC 27e0 180
RI32 e32 22 56e-3
VS33 7 s33 0
L33 s33 4 82e-3
VS34 18 s34 0
L34 s34 13 12e-3
VS35 19 s35 0
C35 s35 6 56e-6
VS36 14 s36 0
R36 s36 12 27e0
VS37 22 s37 0
R37 s37 5 10e1
VS38 22 s38 0
C38 s38 13 56e-5
VS39 17 s39 0
L39 s39 7 22e-3
VS40 21 s40 0
L40 s40 0 68e-4
.control
set numdgt=17
ac lin 1 60 60
print v(1) v(2) v(3) v(4) v(5) v(6) v(7) v(8) v(9) v(10)
print v(11) v(12) v(13) v(14) v(15) v(16) v(17) v(18) v(19) v(20)
print v(21) v(22)
print i(vs0) i(vs1) i(vs2) i(vs3) i(vs4) i(vs5) i(vs6) i(vs7) i(vs8) i(vs9)
print i(vs10) i(vs11) i(vs12) i(vs13) i(vs14) i(vs15) i(vs16) i(vs17) i(vs18) i(vs19)
print i(vs20) i(vs21) i(vs22) i(vs23) i(vs24) i(vs25) i(vs26) i(vs27) i(vs28) i(vs29)
print i(vs30) i(vs31) i(vs32) i(vs33) i(vs34) i(vs35) i(vs36) i(vs37) i(vs38) i(vs39)
print i(vs40)
.endc
.end
