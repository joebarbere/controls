controls oracle ac-0101
* Generated (plan F2.7, ADR 0012): do not edit; regenerate with `pnpm sim oracle regen`. ac seed 20261031 index 101 nodes 23 elements 44
.options sparse gmin=1e-12 noopac
RG1 1 0 1000000000000
RG2 2 0 1000000000000
RG3 3 0 1000000000000
RG4 4 0 1000000000000
RG5 5 0 1000000000000
RG6 6 0 1000000000000
RG7 7 0 1000000000000
RG8 8 0 1000000000000
RG9 9 0 1000000000000
RG10 10 0 1000000000000
RG11 11 0 1000000000000
RG12 12 0 1000000000000
RG13 13 0 1000000000000
RG14 14 0 1000000000000
RG15 15 0 1000000000000
RG16 16 0 1000000000000
RG17 17 0 1000000000000
RG18 18 0 1000000000000
RG19 19 0 1000000000000
RG20 20 0 1000000000000
RG21 21 0 1000000000000
RG22 22 0 1000000000000
VS0 0 s0 0
V0 e0 s0 DC 0 AC 39e-1 180
RI0 e0 10 10e-3
VS1 9 s1 0
L1 s1 12 12e-3
VS2 3 s2 0
R2 s2 8 56e2
VS3 0 s3 0
R3 s3 18 22e3
VS4 11 s4 0
C4 s4 2 68e-4
VS5 7 s5 0
L5 s5 2 82e-5
VS6 5 s6 0
C6 s6 8 33e-7
VS7 15 s7 0
V7 e7 s7 DC 0 AC 27e0 0
RI7 e7 7 68e-2
VS8 16 s8 0
L8 s8 19 56e-2
VS9 0 s9 0
C9 s9 10 68e-7
VS10 0 s10 0
R10 s10 19 15e-1
VS11 0 s11 0
L11 s11 1 47e-3
VS12 21 s12 0
L12 s12 12 82e-3
VS13 13 s13 0
R13 s13 4 33e3
VS14 3 s14 0
V14 e14 s14 DC 0 AC 18e0 -120
RI14 e14 14 68e-1
VS15 19 s15 0
L15 s15 15 68e-3
VS16 12 s16 0
L16 s16 10 56e-4
VS17 13 s17 0
V17 e17 s17 DC 0 AC 56e-1 120
RI17 e17 15 10e-2
VS18 13 s18 0
L18 s18 0 56e-2
VS19 21 s19 0
L19 s19 6 22e-3
VS20 21 s20 0
R20 s20 22 68e0
VS21 11 s21 0
L21 s21 18 39e-3
VS22 14 s22 0
R22 s22 20 47e1
VS23 14 s23 0
L23 s23 12 22e-2
VS24 5 s24 0
R24 s24 11 27e3
VS25 18 s25 0
R25 s25 6 82e2
VS26 19 s26 0
R26 s26 2 18e1
VS27 19 s27 0
R27 s27 3 56e2
VS28 2 s28 0
L28 s28 21 68e-2
VS29 17 s29 0
R29 s29 9 56e3
VS30 6 s30 0
R30 s30 9 56e-1
VS31 21 s31 0
R31 s31 17 10e-1
VS32 22 s32 0
V32 e32 s32 DC 0 AC 82e0 120
RI32 e32 11 82e-3
VS33 4 s33 0
C33 s33 6 22e-4
VS34 11 s34 0
V34 e34 s34 DC 0 AC 56e0 120
RI34 e34 14 68e-1
VS35 22 s35 0
V35 e35 s35 DC 0 AC 68e-1 120
RI35 e35 3 27e-2
VS36 16 s36 0
R36 s36 6 10e-2
VS37 0 s37 0
C37 s37 19 47e-5
VS38 12 s38 0
R38 s38 5 56e-1
VS39 2 s39 0
R39 s39 0 27e3
VS40 7 s40 0
R40 s40 9 12e3
VS41 15 s41 0
C41 s41 0 15e-6
VS42 13 s42 0
C42 s42 20 47e-4
VS43 3 s43 0
R43 s43 21 56e1
.control
set numdgt=17
ac lin 1 60 60
print v(1) v(2) v(3) v(4) v(5) v(6) v(7) v(8) v(9) v(10)
print v(11) v(12) v(13) v(14) v(15) v(16) v(17) v(18) v(19) v(20)
print v(21) v(22)
print i(vs0) i(vs1) i(vs2) i(vs3) i(vs4) i(vs5) i(vs6) i(vs7) i(vs8) i(vs9)
print i(vs10) i(vs11) i(vs12) i(vs13) i(vs14) i(vs15) i(vs16) i(vs17) i(vs18) i(vs19)
print i(vs20) i(vs21) i(vs22) i(vs23) i(vs24) i(vs25) i(vs26) i(vs27) i(vs28) i(vs29)
print i(vs30) i(vs31) i(vs32) i(vs33) i(vs34) i(vs35) i(vs36) i(vs37) i(vs38) i(vs39)
print i(vs40) i(vs41) i(vs42) i(vs43)
.endc
.end
