controls oracle ac-0101
* Generated (plan F2.7, ADR 0012): do not edit; regenerate with `pnpm sim oracle regen`. ac seed 20261031 index 101 nodes 23 elements 45
.options sparse gmin=1e-12 noopac
RG1 1 0 1000000000000
RG2 2 0 1000000000000
RG3 3 0 1000000000000
RG4 4 0 1000000000000
RG5 5 0 1000000000000
RG6 6 0 1000000000000
RG7 7 0 1000000000000
RG8 8 0 1000000000000
RG9 9 0 1000000000000
RG10 10 0 1000000000000
RG11 11 0 1000000000000
RG12 12 0 1000000000000
RG13 13 0 1000000000000
RG14 14 0 1000000000000
RG15 15 0 1000000000000
RG16 16 0 1000000000000
RG17 17 0 1000000000000
RG18 18 0 1000000000000
RG19 19 0 1000000000000
RG20 20 0 1000000000000
RG21 21 0 1000000000000
RG22 22 0 1000000000000
VS0 5 s0 0
C0 s0 8 33e-7
VS1 0 s1 0
V1 e1 s1 DC 0 AC 18e0 -120
RI1 e1 n1 68e-1
H1 n1 h1 VS4 56e-3
ED1 h1 14 d1 0 10e-5
F1 0 d1 VS4 1
LD1 d1 0 1
VS2 19 s2 0
L2 s2 15 68e-3
VS3 13 s3 0
R3 s3 4 33e3
VS4 3 s4 0
V4 e4 s4 DC 0 AC 68e-1 120
RI4 e4 m4 27e-2
LI4 m4 n4 39e-5
H4 n4 h4 VS1 56e-3
ED4 h4 0 d4 0 10e-5
F4 0 d4 VS1 1
LD4 d4 0 1
VS5 22 s5 0
R5 s5 18 22e3
VS6 16 s6 0
R6 s6 6 10e-2
VS7 17 s7 0
R7 s7 9 56e3
VS8 0 s8 0
R8 s8 21 56e1
VS9 21 s9 0
L9 s9 6 22e-3
VS10 21 s10 0
L10 s10 12 82e-3
VS11 12 s11 0
R11 s11 5 56e-1
VS12 3 s12 0
V12 e12 s12 DC 0 AC 82e0 120
RI12 e12 11 82e-3
VS13 14 s13 0
L13 s13 12 22e-2
VS14 19 s14 0
R14 s14 2 18e1
VS15 7 s15 0
R15 s15 9 12e3
VS16 18 s16 0
R16 s16 6 82e2
VS17 15 s17 0
C17 s17 22 15e-6
VS18 7 s18 0
L18 s18 2 82e-5
VS19 2 s19 0
R19 s19 22 27e3
VS20 21 s20 0
R20 s20 17 10e-1
VS21 16 s21 0
L21 s21 19 56e-2
VS22 22 s22 0
L22 s22 1 47e-3
VS23 14 s23 0
R23 s23 20 47e1
VS24 22 s24 0
C24 s24 19 47e-5
VS25 13 s25 0
L25 s25 22 56e-2
VS26 5 s26 0
R26 s26 11 27e3
VS27 13 s27 0
V27 e27 s27 DC 0 AC 56e-1 120
RI27 e27 15 10e-2
VS28 11 s28 0
C28 s28 2 68e-4
VS29 4 s29 0
C29 s29 6 22e-4
VS30 16 s30 0
L30 s30 1 47e-5
VS31 2 s31 0
L31 s31 21 68e-2
VS32 6 s32 0
R32 s32 9 56e-1
VS33 11 s33 0
L33 s33 18 39e-3
VS34 19 s34 0
R34 s34 0 56e2
VS35 0 s35 0
R35 s35 8 56e2
VS36 21 s36 0
R36 s36 3 68e0
VS37 9 s37 0
L37 s37 12 12e-3
VS38 13 s38 0
C38 s38 20 47e-4
VS39 22 s39 0
V39 e39 s39 DC 0 AC 39e-1 180
RI39 e39 m39 10e-3
LI39 m39 10 18e-5
VS40 22 s40 0
R40 s40 19 15e-1
VS41 11 s41 0
V41 e41 s41 DC 0 AC 56e0 120
RI41 e41 m41 68e-1
LI41 m41 14 39e-6
VS42 12 s42 0
L42 s42 10 56e-4
VS43 22 s43 0
C43 s43 10 68e-7
VS44 15 s44 0
V44 e44 s44 DC 0 AC 27e0 0
RI44 e44 m44 68e-2
LI44 m44 7 15e-6
.control
set numdgt=17
ac lin 1 60 60
print v(1) v(2) v(3) v(4) v(5) v(6) v(7) v(8) v(9) v(10)
print v(11) v(12) v(13) v(14) v(15) v(16) v(17) v(18) v(19) v(20)
print v(21) v(22)
print i(vs0) i(vs1) i(vs2) i(vs3) i(vs4) i(vs5) i(vs6) i(vs7) i(vs8) i(vs9)
print i(vs10) i(vs11) i(vs12) i(vs13) i(vs14) i(vs15) i(vs16) i(vs17) i(vs18) i(vs19)
print i(vs20) i(vs21) i(vs22) i(vs23) i(vs24) i(vs25) i(vs26) i(vs27) i(vs28) i(vs29)
print i(vs30) i(vs31) i(vs32) i(vs33) i(vs34) i(vs35) i(vs36) i(vs37) i(vs38) i(vs39)
print i(vs40) i(vs41) i(vs42) i(vs43) i(vs44)
.endc
.end
