controls oracle ac-0141
* Generated (plan F2.7, ADR 0012): do not edit; regenerate with `pnpm sim oracle regen`. ac seed 20261031 index 141 nodes 19 elements 26
.options sparse gmin=1e-12 noopac
RG1 1 0 1000000000000
RG2 2 0 1000000000000
RG3 3 0 1000000000000
RG4 4 0 1000000000000
RG5 5 0 1000000000000
RG6 6 0 1000000000000
RG7 7 0 1000000000000
RG8 8 0 1000000000000
RG9 9 0 1000000000000
RG10 10 0 1000000000000
RG11 11 0 1000000000000
RG12 12 0 1000000000000
RG13 13 0 1000000000000
RG14 14 0 1000000000000
RG15 15 0 1000000000000
RG16 16 0 1000000000000
RG17 17 0 1000000000000
RG18 18 0 1000000000000
VS0 0 s0 0
V0 e0 s0 DC 0 AC 15e0 120
RI0 e0 14 82e-1
VS1 9 s1 0
R1 s1 6 12e-2
VS2 3 s2 0
C2 s2 11 10e-4
VS3 4 s3 0
C3 s3 10 18e-7
VS4 12 s4 0
R4 s4 15 22e-2
VS5 14 s5 0
R5 s5 8 39e0
VS6 1 s6 0
L6 s6 8 27e-2
VS7 4 s7 0
R7 s7 18 82e1
VS8 16 s8 0
V8 e8 s8 DC 0 AC 68e-1 0
RI8 e8 3 18e-3
VS9 18 s9 0
R9 s9 17 82e-1
VS10 8 s10 0
V10 e10 s10 DC 0 AC 10e-1 180
RI10 e10 13 10e-3
VS11 11 s11 0
V11 e11 s11 DC 0 AC 68e-1 -120
RI11 e11 1 15e-3
VS12 10 s12 0
C12 s12 7 27e-7
VS13 6 s13 0
R13 s13 17 12e0
VS14 18 s14 0
V14 e14 s14 DC 0 AC 15e-1 180
RI14 e14 m14 68e-1
LI14 m14 7 39e-6
VS15 1 s15 0
R15 s15 18 10e0
VS16 15 s16 0
V16 e16 s16 DC 0 AC 68e-1 0
RI16 e16 m16 18e-2
LI16 m16 13 22e-7
VS17 5 s17 0
R17 s17 17 47e-1
VS18 3 s18 0
L18 s18 2 27e-3
VS19 2 s19 0
R19 s19 18 22e-1
VS20 8 s20 0
C20 s20 4 12e-7
VS21 0 s21 0
L21 s21 13 33e-3
VS22 17 s22 0
L22 s22 16 22e-4
VS23 9 s23 0
R23 s23 1 27e1
VS24 5 s24 0
L24 s24 16 39e-2
VS25 12 s25 0
R25 s25 18 18e3
.control
set numdgt=17
ac lin 1 60 60
print v(1) v(2) v(3) v(4) v(5) v(6) v(7) v(8) v(9) v(10)
print v(11) v(12) v(13) v(14) v(15) v(16) v(17) v(18)
print i(vs0) i(vs1) i(vs2) i(vs3) i(vs4) i(vs5) i(vs6) i(vs7) i(vs8) i(vs9)
print i(vs10) i(vs11) i(vs12) i(vs13) i(vs14) i(vs15) i(vs16) i(vs17) i(vs18) i(vs19)
print i(vs20) i(vs21) i(vs22) i(vs23) i(vs24) i(vs25)
.endc
.end
