controls oracle ac-0141
* Generated (plan F2.7, ADR 0012): do not edit; regenerate with `pnpm sim oracle regen`. ac seed 20261031 index 141 nodes 19 elements 21
.options sparse gmin=1e-12 noopac
RG1 1 0 1000000000000
RG2 2 0 1000000000000
RG3 3 0 1000000000000
RG4 4 0 1000000000000
RG5 5 0 1000000000000
RG6 6 0 1000000000000
RG7 7 0 1000000000000
RG8 8 0 1000000000000
RG9 9 0 1000000000000
RG10 10 0 1000000000000
RG11 11 0 1000000000000
RG12 12 0 1000000000000
RG13 13 0 1000000000000
RG14 14 0 1000000000000
RG15 15 0 1000000000000
RG16 16 0 1000000000000
RG17 17 0 1000000000000
RG18 18 0 1000000000000
VS0 12 s0 0
R0 s0 1 27e0
VS1 17 s1 0
R1 s1 18 15e-2
VS2 7 s2 0
L2 s2 15 18e-2
VS3 11 s3 0
R3 s3 10 68e3
VS4 7 s4 0
R4 s4 12 68e-1
VS5 0 s5 0
V5 e5 s5 DC 0 AC 22e-1 120
RI5 e5 6 56e-2
VS6 4 s6 0
L6 s6 12 47e-3
VS7 5 s7 0
C7 s7 9 27e-7
VS8 9 s8 0
L8 s8 14 22e-3
VS9 15 s9 0
V9 e9 s9 DC 0 AC 39e1 180
RI9 e9 9 22e-3
VS10 8 s10 0
V10 e10 s10 DC 0 AC 10e-1 180
RI10 e10 13 10e-3
VS11 14 s11 0
R11 s11 6 68e-2
VS12 4 s12 0
L12 s12 8 12e-2
VS13 4 s13 0
R13 s13 18 82e1
VS14 15 s14 0
C14 s14 18 68e-6
VS15 9 s15 0
R15 s15 7 27e2
VS16 2 s16 0
L16 s16 9 27e-4
VS17 11 s17 0
R17 s17 18 39e1
VS18 5 s18 0
V18 e18 s18 DC 0 AC 27e0 -120
RI18 e18 16 82e-3
VS19 15 s19 0
L19 s19 8 27e-2
VS20 3 s20 0
R20 s20 0 27e2
.control
set numdgt=17
ac lin 1 60 60
print v(1) v(2) v(3) v(4) v(5) v(6) v(7) v(8) v(9) v(10)
print v(11) v(12) v(13) v(14) v(15) v(16) v(17) v(18)
print i(vs0) i(vs1) i(vs2) i(vs3) i(vs4) i(vs5) i(vs6) i(vs7) i(vs8) i(vs9)
print i(vs10) i(vs11) i(vs12) i(vs13) i(vs14) i(vs15) i(vs16) i(vs17) i(vs18) i(vs19)
print i(vs20)
.endc
.end
