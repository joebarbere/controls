controls oracle ac-0141
* Generated (plan F2.7, ADR 0012): do not edit; regenerate with `pnpm sim oracle regen`. ac seed 20261031 index 141 nodes 19 elements 27
.options sparse gmin=1e-12 noopac
RG1 1 0 1000000000000
RG2 2 0 1000000000000
RG3 3 0 1000000000000
RG4 4 0 1000000000000
RG5 5 0 1000000000000
RG6 6 0 1000000000000
RG7 7 0 1000000000000
RG8 8 0 1000000000000
RG9 9 0 1000000000000
RG10 10 0 1000000000000
RG11 11 0 1000000000000
RG12 12 0 1000000000000
RG13 13 0 1000000000000
RG14 14 0 1000000000000
RG15 15 0 1000000000000
RG16 16 0 1000000000000
RG17 17 0 1000000000000
RG18 18 0 1000000000000
VS0 17 s0 0
L0 s0 2 22e-4
VS1 2 s1 0
L1 s1 9 27e-4
VS2 14 s2 0
R2 s2 6 68e-2
VS3 4 s3 0
R3 s3 18 82e1
VS4 0 s4 0
V4 e4 s4 DC 0 AC 27e0 -120
RI4 e4 m4 82e-3
LI4 m4 n4 22e-7
H4 n4 h4 VS10 -68e-4
ED4 h4 16 d4 0 12e-6
F4 0 d4 VS10 1
LD4 d4 0 1
VS5 0 s5 0
R5 s5 10 12e0
VS6 12 s6 0
R6 s6 1 27e0
VS7 9 s7 0
L7 s7 14 22e-3
VS8 5 s8 0
L8 s8 8 27e-2
VS9 4 s9 0
L9 s9 8 12e-2
VS10 16 s10 0
V10 e10 s10 DC 0 AC 68e-1 0
RI10 e10 n10 18e-3
H10 n10 h10 VS4 -68e-4
ED10 h10 11 d10 0 12e-6
F10 0 d10 VS4 1
LD10 d10 0 1
VS11 5 s11 0
V11 e11 s11 DC 0 AC 39e1 180
RI11 e11 m11 22e-3
LI11 m11 9 15e-6
VS12 3 s12 0
R12 s12 18 18e3
VS13 7 s13 0
L13 s13 5 18e-2
VS14 11 s14 0
R14 s14 10 68e3
VS15 8 s15 0
V15 e15 s15 DC 0 AC 10e-1 180
RI15 e15 m15 10e-3
LI15 m15 13 27e-5
VS16 4 s16 0
L16 s16 12 47e-3
VS17 15 s17 0
V17 e17 s17 DC 0 AC 22e-1 120
RI17 e17 m17 56e-2
LI17 m17 6 18e-5
VS18 9 s18 0
R18 s18 7 27e2
VS19 5 s19 0
C19 s19 18 68e-6
VS20 0 s20 0
C20 s20 1 18e-7
VS21 11 s21 0
R21 s21 18 39e1
VS22 7 s22 0
R22 s22 12 68e-1
VS23 17 s23 0
R23 s23 18 15e-2
VS24 0 s24 0
C24 s24 9 27e-7
VS25 3 s25 0
R25 s25 15 27e2
VS26 13 s26 0
R26 s26 17 33e-2
.control
set numdgt=17
ac lin 1 60 60
print v(1) v(2) v(3) v(4) v(5) v(6) v(7) v(8) v(9) v(10)
print v(11) v(12) v(13) v(14) v(15) v(16) v(17) v(18)
print i(vs0) i(vs1) i(vs2) i(vs3) i(vs4) i(vs5) i(vs6) i(vs7) i(vs8) i(vs9)
print i(vs10) i(vs11) i(vs12) i(vs13) i(vs14) i(vs15) i(vs16) i(vs17) i(vs18) i(vs19)
print i(vs20) i(vs21) i(vs22) i(vs23) i(vs24) i(vs25) i(vs26)
.endc
.end
