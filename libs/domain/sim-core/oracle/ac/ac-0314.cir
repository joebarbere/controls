controls oracle ac-0314
* Generated (plan F2.7, ADR 0012): do not edit; regenerate with `pnpm sim oracle regen`. ac seed 20261031 index 314 nodes 14 elements 14
.options sparse gmin=1e-12 noopac
RG1 1 0 1000000000000
RG2 2 0 1000000000000
RG3 3 0 1000000000000
RG4 4 0 1000000000000
RG5 5 0 1000000000000
RG6 6 0 1000000000000
RG7 7 0 1000000000000
RG8 8 0 1000000000000
RG9 9 0 1000000000000
RG10 10 0 1000000000000
RG11 11 0 1000000000000
RG12 12 0 1000000000000
RG13 13 0 1000000000000
VS0 11 s0 0
L0 s0 10 10e-5
VS1 10 s1 0
R1 s1 8 22e1
VS2 13 s2 0
C2 s2 3 27e-4
VS3 7 s3 0
L3 s3 5 82e-4
VS4 4 s4 0
L4 s4 9 68e-5
VS5 2 s5 0
R5 s5 4 33e2
VS6 0 s6 0
V6 e6 s6 DC 0 AC 56e0 -120
RI6 e6 12 27e-2
VS7 3 s7 0
R7 s7 4 56e3
VS8 11 s8 0
R8 s8 0 27e0
VS9 12 s9 0
V9 e9 s9 DC 0 AC 22e0 0
RI9 e9 3 56e-2
VS10 13 s10 0
R10 s10 11 18e-2
VS11 1 s11 0
C11 s11 8 18e-5
VS12 11 s12 0
R12 s12 6 15e2
VS13 11 s13 0
L13 s13 5 47e-3
.control
set numdgt=17
ac lin 1 60 60
print v(1) v(2) v(3) v(4) v(5) v(6) v(7) v(8) v(9) v(10)
print v(11) v(12) v(13)
print i(vs0) i(vs1) i(vs2) i(vs3) i(vs4) i(vs5) i(vs6) i(vs7) i(vs8) i(vs9)
print i(vs10) i(vs11) i(vs12) i(vs13)
.endc
.end
