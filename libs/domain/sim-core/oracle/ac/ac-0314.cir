controls oracle ac-0314
* Generated (plan F2.7, ADR 0012): do not edit; regenerate with `pnpm sim oracle regen`. ac seed 20261031 index 314 nodes 14 elements 20
.options sparse gmin=1e-12 noopac
RG1 1 0 1000000000000
RG2 2 0 1000000000000
RG3 3 0 1000000000000
RG4 4 0 1000000000000
RG5 5 0 1000000000000
RG6 6 0 1000000000000
RG7 7 0 1000000000000
RG8 8 0 1000000000000
RG9 9 0 1000000000000
RG10 10 0 1000000000000
RG11 11 0 1000000000000
RG12 12 0 1000000000000
RG13 13 0 1000000000000
VS0 7 s0 0
L0 s0 5 22e-2
VS1 11 s1 0
R1 s1 5 27e0
VS2 0 s2 0
V2 e2 s2 DC 0 AC 15e0 -120
RI2 e2 m2 33e-2
LI2 m2 10 15e-6
VS3 3 s3 0
R3 s3 4 56e3
VS4 8 s4 0
R4 s4 9 27e-1
VS5 1 s5 0
C5 s5 7 12e-5
VS6 10 s6 0
R6 s6 8 22e1
VS7 2 s7 0
R7 s7 3 56e2
VS8 11 s8 0
L8 s8 2 47e-3
VS9 13 s9 0
R9 s9 11 18e-2
VS10 6 s10 0
V10 e10 s10 DC 0 AC 12e-1 0
RI10 e10 0 68e-1
VS11 11 s11 0
R11 s11 6 15e2
VS12 13 s12 0
C12 s12 3 27e-4
VS13 0 s13 0
R13 s13 4 33e2
VS14 3 s14 0
R14 s14 12 33e3
VS15 3 s15 0
V15 e15 s15 DC 0 AC 39e1 120
RI15 e15 8 39e-1
VS16 1 s16 0
L16 s16 2 18e-4
VS17 5 s17 0
V17 e17 s17 DC 0 AC 56e0 -120
RI17 e17 m17 27e-2
LI17 m17 12 68e-5
VS18 11 s18 0
L18 s18 10 10e-5
VS19 4 s19 0
L19 s19 9 68e-5
.control
set numdgt=17
ac lin 1 60 60
print v(1) v(2) v(3) v(4) v(5) v(6) v(7) v(8) v(9) v(10)
print v(11) v(12) v(13)
print i(vs0) i(vs1) i(vs2) i(vs3) i(vs4) i(vs5) i(vs6) i(vs7) i(vs8) i(vs9)
print i(vs10) i(vs11) i(vs12) i(vs13) i(vs14) i(vs15) i(vs16) i(vs17) i(vs18) i(vs19)
.endc
.end
