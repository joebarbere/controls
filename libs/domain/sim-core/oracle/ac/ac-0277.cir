controls oracle ac-0277
* Generated (plan F2.7, ADR 0012): do not edit; regenerate with `pnpm sim oracle regen`. ac seed 20261031 index 277 nodes 9 elements 12
.options sparse gmin=1e-12 noopac
RG1 1 0 1000000000000
RG2 2 0 1000000000000
RG3 3 0 1000000000000
RG4 4 0 1000000000000
RG5 5 0 1000000000000
RG6 6 0 1000000000000
RG7 7 0 1000000000000
RG8 8 0 1000000000000
VS0 1 s0 0
R0 s0 4 10e1
VS1 8 s1 0
C1 s1 7 39e-7
VS2 3 s2 0
C2 s2 5 27e-5
VS3 0 s3 0
R3 s3 3 18e1
VS4 2 s4 0
L4 s4 6 10e-3
VS5 4 s5 0
C5 s5 3 10e-5
VS6 6 s6 0
R6 s6 5 33e3
VS7 0 s7 0
V7 e7 s7 DC 0 AC 82e0 -120
RI7 e7 8 82e-2
VS8 1 s8 0
R8 s8 6 10e1
VS9 4 s9 0
C9 s9 5 39e-7
VS10 6 s10 0
V10 e10 s10 DC 0 AC 15e1 120
RI10 e10 7 15e-2
VS11 3 s11 0
L11 s11 2 56e-2
.control
set numdgt=17
ac lin 1 60 60
print v(1) v(2) v(3) v(4) v(5) v(6) v(7) v(8)
print i(vs0) i(vs1) i(vs2) i(vs3) i(vs4) i(vs5) i(vs6) i(vs7) i(vs8) i(vs9)
print i(vs10) i(vs11)
.endc
.end
