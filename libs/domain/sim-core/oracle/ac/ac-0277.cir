controls oracle ac-0277
* Generated (plan F2.7, ADR 0012): do not edit; regenerate with `pnpm sim oracle regen`. ac seed 20261031 index 277 nodes 9 elements 12
.options sparse gmin=1e-12 noopac
RG1 1 0 1000000000000
RG2 2 0 1000000000000
RG3 3 0 1000000000000
RG4 4 0 1000000000000
RG5 5 0 1000000000000
RG6 6 0 1000000000000
RG7 7 0 1000000000000
RG8 8 0 1000000000000
VS0 1 s0 0
L0 s0 3 82e-4
VS1 4 s1 0
R1 s1 5 68e-2
VS2 1 s2 0
L2 s2 4 18e-5
VS3 7 s3 0
L3 s3 1 18e-2
VS4 4 s4 0
R4 s4 6 18e1
VS5 5 s5 0
C5 s5 3 56e-4
VS6 8 s6 0
R6 s6 2 18e-1
VS7 0 s7 0
V7 e7 s7 DC 0 AC 15e-1 0
RI7 e7 1 12e-1
VS8 3 s8 0
L8 s8 7 33e-4
VS9 0 s9 0
C9 s9 1 82e-4
VS10 2 s10 0
C10 s10 6 27e-7
VS11 6 s11 0
V11 e11 s11 DC 0 AC 15e1 120
RI11 e11 4 15e-2
.control
set numdgt=17
ac lin 1 60 60
print v(1) v(2) v(3) v(4) v(5) v(6) v(7) v(8)
print i(vs0) i(vs1) i(vs2) i(vs3) i(vs4) i(vs5) i(vs6) i(vs7) i(vs8) i(vs9)
print i(vs10) i(vs11)
.endc
.end
