controls oracle ac-0277
* Generated (plan F2.7, ADR 0012): do not edit; regenerate with `pnpm sim oracle regen`. ac seed 20261031 index 277 nodes 9 elements 14
.options sparse gmin=1e-12 noopac
RG1 1 0 1000000000000
RG2 2 0 1000000000000
RG3 3 0 1000000000000
RG4 4 0 1000000000000
RG5 5 0 1000000000000
RG6 6 0 1000000000000
RG7 7 0 1000000000000
RG8 8 0 1000000000000
VS0 1 s0 0
L0 s0 3 82e-4
VS1 5 s1 0
L1 s1 8 56e-4
VS2 0 s2 0
V2 e2 s2 DC 0 AC 15e1 120
RI2 e2 6 15e-2
VS3 8 s3 0
R3 s3 2 18e-1
VS4 7 s4 0
L4 s4 1 18e-2
VS5 4 s5 0
C5 s5 1 82e-4
VS6 4 s6 0
V6 e6 s6 DC 0 AC 15e-1 0
RI6 e6 m6 12e-1
LI6 m6 1 68e-5
VS7 2 s7 0
C7 s7 0 27e-7
VS8 6 s8 0
R8 s8 5 68e-2
VS9 0 s9 0
R9 s9 4 47e3
VS10 1 s10 0
L10 s10 6 18e-5
VS11 6 s11 0
R11 s11 0 18e1
VS12 5 s12 0
C12 s12 3 56e-4
VS13 3 s13 0
L13 s13 7 33e-4
.control
set numdgt=17
ac lin 1 60 60
print v(1) v(2) v(3) v(4) v(5) v(6) v(7) v(8)
print i(vs0) i(vs1) i(vs2) i(vs3) i(vs4) i(vs5) i(vs6) i(vs7) i(vs8) i(vs9)
print i(vs10) i(vs11) i(vs12) i(vs13)
.endc
.end
