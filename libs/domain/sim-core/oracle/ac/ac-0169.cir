controls oracle ac-0169
* Generated (plan F2.7, ADR 0012): do not edit; regenerate with `pnpm sim oracle regen`. ac seed 20261031 index 169 nodes 11 elements 16
.options sparse gmin=1e-12 noopac
RG1 1 0 1000000000000
RG2 2 0 1000000000000
RG3 3 0 1000000000000
RG4 4 0 1000000000000
RG5 5 0 1000000000000
RG6 6 0 1000000000000
RG7 7 0 1000000000000
RG8 8 0 1000000000000
RG9 9 0 1000000000000
RG10 10 0 1000000000000
VS0 6 s0 0
L0 s0 2 27e-4
VS1 7 s1 0
C1 s1 3 39e-7
VS2 8 s2 0
L2 s2 0 18e-5
VS3 5 s3 0
L3 s3 1 47e-3
VS4 4 s4 0
L4 s4 10 18e-4
VS5 0 s5 0
C5 s5 9 27e-5
VS6 10 s6 0
R6 s6 3 10e2
VS7 0 s7 0
V7 e7 s7 DC 0 AC 15e-1 120
RI7 e7 m7 27e-2
LI7 m7 2 82e-5
VS8 6 s8 0
R8 s8 1 47e0
VS9 3 s9 0
C9 s9 7 18e-7
VS10 9 s10 0
V10 e10 s10 DC 0 AC 15e1 180
RI10 e10 7 82e-3
VS11 2 s11 0
L11 s11 8 47e-5
VS12 10 s12 0
C12 s12 2 33e-5
VS13 5 s13 0
C13 s13 3 10e-4
VS14 4 s14 0
R14 s14 7 12e2
VS15 8 s15 0
R15 s15 5 12e1
.control
set numdgt=17
ac lin 1 60 60
print v(1) v(2) v(3) v(4) v(5) v(6) v(7) v(8) v(9) v(10)
print i(vs0) i(vs1) i(vs2) i(vs3) i(vs4) i(vs5) i(vs6) i(vs7) i(vs8) i(vs9)
print i(vs10) i(vs11) i(vs12) i(vs13) i(vs14) i(vs15)
.endc
.end
