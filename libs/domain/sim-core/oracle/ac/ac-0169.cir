controls oracle ac-0169
* Generated (plan F2.7, ADR 0012): do not edit; regenerate with `pnpm sim oracle regen`. ac seed 20261031 index 169 nodes 11 elements 15
.options sparse gmin=1e-12 noopac
RG1 1 0 1000000000000
RG2 2 0 1000000000000
RG3 3 0 1000000000000
RG4 4 0 1000000000000
RG5 5 0 1000000000000
RG6 6 0 1000000000000
RG7 7 0 1000000000000
RG8 8 0 1000000000000
RG9 9 0 1000000000000
RG10 10 0 1000000000000
VS0 7 s0 0
C0 s0 9 39e-7
VS1 10 s1 0
C1 s1 2 33e-5
VS2 5 s2 0
C2 s2 9 10e-4
VS3 9 s3 0
C3 s3 8 15e-4
VS4 10 s4 0
R4 s4 9 10e2
VS5 5 s5 0
L5 s5 1 47e-3
VS6 4 s6 0
R6 s6 7 12e2
VS7 6 s7 0
L7 s7 2 27e-4
VS8 0 s8 0
V8 e8 s8 DC 0 AC 15e1 180
RI8 e8 7 82e-3
VS9 3 s9 0
R9 s9 0 56e0
VS10 9 s10 0
R10 s10 4 18e1
VS11 1 s11 0
C11 s11 7 82e-7
VS12 4 s12 0
C12 s12 3 47e-7
VS13 2 s13 0
L13 s13 8 47e-5
VS14 0 s14 0
L14 s14 6 12e-4
.control
set numdgt=17
ac lin 1 60 60
print v(1) v(2) v(3) v(4) v(5) v(6) v(7) v(8) v(9) v(10)
print i(vs0) i(vs1) i(vs2) i(vs3) i(vs4) i(vs5) i(vs6) i(vs7) i(vs8) i(vs9)
print i(vs10) i(vs11) i(vs12) i(vs13) i(vs14)
.endc
.end
