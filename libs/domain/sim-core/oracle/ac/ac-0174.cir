controls oracle ac-0174
* Generated (plan F2.7, ADR 0012): do not edit; regenerate with `pnpm sim oracle regen`. ac seed 20261031 index 174 nodes 30 elements 40
.options sparse gmin=1e-12 noopac
RG1 1 0 1000000000000
RG2 2 0 1000000000000
RG3 3 0 1000000000000
RG4 4 0 1000000000000
RG5 5 0 1000000000000
RG6 6 0 1000000000000
RG7 7 0 1000000000000
RG8 8 0 1000000000000
RG9 9 0 1000000000000
RG10 10 0 1000000000000
RG11 11 0 1000000000000
RG12 12 0 1000000000000
RG13 13 0 1000000000000
RG14 14 0 1000000000000
RG15 15 0 1000000000000
RG16 16 0 1000000000000
RG17 17 0 1000000000000
RG18 18 0 1000000000000
RG19 19 0 1000000000000
RG20 20 0 1000000000000
RG21 21 0 1000000000000
RG22 22 0 1000000000000
RG23 23 0 1000000000000
RG24 24 0 1000000000000
RG25 25 0 1000000000000
RG26 26 0 1000000000000
RG27 27 0 1000000000000
RG28 28 0 1000000000000
RG29 29 0 1000000000000
VS0 0 s0 0
V0 e0 s0 DC 0 AC 27e0 180
RI0 e0 5 15e-2
VS1 16 s1 0
L1 s1 8 68e-3
VS2 3 s2 0
V2 e2 s2 DC 0 AC 18e-1 180
RI2 e2 18 15e-2
VS3 14 s3 0
L3 s3 13 56e-4
VS4 22 s4 0
L4 s4 21 82e-5
VS5 29 s5 0
C5 s5 9 15e-6
VS6 28 s6 0
R6 s6 20 22e-1
VS7 12 s7 0
V7 e7 s7 DC 0 AC 82e-1 120
RI7 e7 0 33e-2
VS8 14 s8 0
L8 s8 16 68e-4
VS9 21 s9 0
R9 s9 23 56e-2
VS10 29 s10 0
C10 s10 9 82e-7
VS11 28 s11 0
L11 s11 11 39e-2
VS12 24 s12 0
L12 s12 14 15e-2
VS13 16 s13 0
V13 e13 s13 DC 0 AC 68e1 180
RI13 e13 29 22e-1
VS14 15 s14 0
R14 s14 5 27e-2
VS15 23 s15 0
C15 s15 15 47e-5
VS16 13 s16 0
R16 s16 1 22e2
VS17 12 s17 0
C17 s17 8 12e-6
VS18 16 s18 0
R18 s18 10 68e-1
VS19 0 s19 0
V19 e19 s19 DC 0 AC 10e0 -120
RI19 e19 9 10e-2
VS20 7 s20 0
R20 s20 23 12e2
VS21 3 s21 0
C21 s21 14 82e-7
VS22 0 s22 0
R22 s22 19 39e-1
VS23 11 s23 0
R23 s23 4 56e-1
VS24 6 s24 0
L24 s24 13 82e-3
VS25 9 s25 0
L25 s25 24 12e-5
VS26 4 s26 0
L26 s26 16 18e-3
VS27 13 s27 0
R27 s27 26 27e0
VS28 13 s28 0
V28 e28 s28 DC 0 AC 10e0 -120
RI28 e28 28 15e-1
VS29 27 s29 0
V29 e29 s29 DC 0 AC 47e-1 180
RI29 e29 17 47e-2
VS30 23 s30 0
C30 s30 13 12e-6
VS31 3 s31 0
R31 s31 25 56e2
VS32 27 s32 0
L32 s32 4 39e-5
VS33 29 s33 0
L33 s33 15 82e-4
VS34 15 s34 0
R34 s34 13 39e-2
VS35 18 s35 0
R35 s35 13 12e3
VS36 29 s36 0
V36 e36 s36 DC 0 AC 22e1 -120
RI36 e36 10 82e-2
VS37 27 s37 0
V37 e37 s37 DC 0 AC 22e0 -120
RI37 e37 15 12e-3
VS38 8 s38 0
C38 s38 5 39e-4
VS39 2 s39 0
V39 e39 s39 DC 0 AC 47e0 120
RI39 e39 3 15e-2
.control
set numdgt=17
ac lin 1 60 60
print v(1) v(2) v(3) v(4) v(5) v(6) v(7) v(8) v(9) v(10)
print v(11) v(12) v(13) v(14) v(15) v(16) v(17) v(18) v(19) v(20)
print v(21) v(22) v(23) v(24) v(25) v(26) v(27) v(28) v(29)
print i(vs0) i(vs1) i(vs2) i(vs3) i(vs4) i(vs5) i(vs6) i(vs7) i(vs8) i(vs9)
print i(vs10) i(vs11) i(vs12) i(vs13) i(vs14) i(vs15) i(vs16) i(vs17) i(vs18) i(vs19)
print i(vs20) i(vs21) i(vs22) i(vs23) i(vs24) i(vs25) i(vs26) i(vs27) i(vs28) i(vs29)
print i(vs30) i(vs31) i(vs32) i(vs33) i(vs34) i(vs35) i(vs36) i(vs37) i(vs38) i(vs39)
.endc
.end
