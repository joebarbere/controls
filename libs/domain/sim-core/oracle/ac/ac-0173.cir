controls oracle ac-0173
* Generated (plan F2.7, ADR 0012): do not edit; regenerate with `pnpm sim oracle regen`. ac seed 20261031 index 173 nodes 26 elements 36
.options sparse gmin=1e-12 noopac
RG1 1 0 1000000000000
RG2 2 0 1000000000000
RG3 3 0 1000000000000
RG4 4 0 1000000000000
RG5 5 0 1000000000000
RG6 6 0 1000000000000
RG7 7 0 1000000000000
RG8 8 0 1000000000000
RG9 9 0 1000000000000
RG10 10 0 1000000000000
RG11 11 0 1000000000000
RG12 12 0 1000000000000
RG13 13 0 1000000000000
RG14 14 0 1000000000000
RG15 15 0 1000000000000
RG16 16 0 1000000000000
RG17 17 0 1000000000000
RG18 18 0 1000000000000
RG19 19 0 1000000000000
RG20 20 0 1000000000000
RG21 21 0 1000000000000
RG22 22 0 1000000000000
RG23 23 0 1000000000000
RG24 24 0 1000000000000
RG25 25 0 1000000000000
VS0 22 s0 0
L0 s0 18 10e-3
VS1 2 s1 0
L1 s1 6 18e-5
VS2 9 s2 0
L2 s2 8 18e-4
VS3 0 s3 0
V3 e3 s3 DC 0 AC 15e1 0
RI3 e3 n3 10e-1
H3 n3 h3 VS11 -10e-3
ED3 h3 3 d3 0 -56e-5
F3 0 d3 VS11 1
LD3 d3 0 1
VS4 18 s4 0
L4 s4 3 12e-3
VS5 20 s5 0
L5 s5 23 56e-2
VS6 4 s6 0
R6 s6 9 56e-1
VS7 20 s7 0
R7 s7 8 12e2
VS8 8 s8 0
L8 s8 13 56e-2
VS9 7 s9 0
R9 s9 12 15e0
VS10 1 s10 0
R10 s10 16 56e1
VS11 21 s11 0
V11 e11 s11 DC 0 AC 15e-1 180
RI11 e11 m11 82e-2
LI11 m11 n11 10e-7
H11 n11 h11 VS3 -10e-3
ED11 h11 25 d11 0 -56e-5
F11 0 d11 VS3 1
LD11 d11 0 1
VS12 11 s12 0
R12 s12 4 18e0
VS13 16 s13 0
L13 s13 14 82e-4
VS14 16 s14 0
L14 s14 20 12e-3
VS15 11 s15 0
L15 s15 21 56e-5
VS16 21 s16 0
R16 s16 7 47e2
VS17 7 s17 0
R17 s17 22 22e3
VS18 14 s18 0
L18 s18 24 18e-3
VS19 3 s19 0
L19 s19 12 27e-3
VS20 24 s20 0
R20 s20 13 22e3
VS21 1 s21 0
V21 e21 s21 DC 0 AC 22e1 -120
RI21 e21 19 82e-1
VS22 15 s22 0
C22 s22 20 27e-4
VS23 18 s23 0
L23 s23 5 39e-2
VS24 16 s24 0
C24 s24 24 68e-6
VS25 18 s25 0
L25 s25 10 56e-5
VS26 17 s26 0
R26 s26 0 27e0
VS27 2 s27 0
C27 s27 16 15e-7
VS28 15 s28 0
C28 s28 11 56e-5
VS29 5 s29 0
R29 s29 21 68e3
VS30 19 s30 0
L30 s30 21 15e-5
VS31 7 s31 0
R31 s31 23 39e1
VS32 17 s32 0
R32 s32 23 47e0
VS33 10 s33 0
C33 s33 7 27e-5
VS34 25 s34 0
R34 s34 20 22e2
VS35 6 s35 0
C35 s35 4 18e-5
.control
set numdgt=17
ac lin 1 60 60
print v(1) v(2) v(3) v(4) v(5) v(6) v(7) v(8) v(9) v(10)
print v(11) v(12) v(13) v(14) v(15) v(16) v(17) v(18) v(19) v(20)
print v(21) v(22) v(23) v(24) v(25)
print i(vs0) i(vs1) i(vs2) i(vs3) i(vs4) i(vs5) i(vs6) i(vs7) i(vs8) i(vs9)
print i(vs10) i(vs11) i(vs12) i(vs13) i(vs14) i(vs15) i(vs16) i(vs17) i(vs18) i(vs19)
print i(vs20) i(vs21) i(vs22) i(vs23) i(vs24) i(vs25) i(vs26) i(vs27) i(vs28) i(vs29)
print i(vs30) i(vs31) i(vs32) i(vs33) i(vs34) i(vs35)
.endc
.end
