controls oracle ac-0173
* Generated (plan F2.7, ADR 0012): do not edit; regenerate with `pnpm sim oracle regen`. ac seed 20261031 index 173 nodes 26 elements 37
.options sparse gmin=1e-12 noopac
RG1 1 0 1000000000000
RG2 2 0 1000000000000
RG3 3 0 1000000000000
RG4 4 0 1000000000000
RG5 5 0 1000000000000
RG6 6 0 1000000000000
RG7 7 0 1000000000000
RG8 8 0 1000000000000
RG9 9 0 1000000000000
RG10 10 0 1000000000000
RG11 11 0 1000000000000
RG12 12 0 1000000000000
RG13 13 0 1000000000000
RG14 14 0 1000000000000
RG15 15 0 1000000000000
RG16 16 0 1000000000000
RG17 17 0 1000000000000
RG18 18 0 1000000000000
RG19 19 0 1000000000000
RG20 20 0 1000000000000
RG21 21 0 1000000000000
RG22 22 0 1000000000000
RG23 23 0 1000000000000
RG24 24 0 1000000000000
RG25 25 0 1000000000000
VS0 1 s0 0
R0 s0 16 56e1
VS1 15 s1 0
L1 s1 13 10e-3
VS2 14 s2 0
R2 s2 23 39e1
VS3 11 s3 0
L3 s3 21 56e-5
VS4 16 s4 0
R4 s4 15 56e-1
VS5 22 s5 0
L5 s5 9 12e-3
VS6 0 s6 0
R6 s6 18 22e3
VS7 19 s7 0
R7 s7 12 39e3
VS8 14 s8 0
R8 s8 12 15e0
VS9 4 s9 0
C9 s9 14 15e-5
VS10 20 s10 0
R10 s10 8 12e2
VS11 17 s11 0
R11 s11 7 27e0
VS12 0 s12 0
V12 e12 s12 DC 0 AC 22e0 180
RI12 e12 25 68e-1
VS13 9 s13 0
R13 s13 6 33e3
VS14 5 s14 0
R14 s14 24 10e0
VS15 16 s15 0
C15 s15 24 68e-6
VS16 8 s16 0
L16 s16 3 47e-3
VS17 2 s17 0
C17 s17 24 10e-6
VS18 11 s18 0
L18 s18 4 27e-2
VS19 8 s19 0
R19 s19 13 15e-1
VS20 0 s20 0
V20 e20 s20 DC 0 AC 68e1 -120
RI20 e20 3 82e-2
VS21 17 s21 0
R21 s21 23 47e0
VS22 10 s22 0
C22 s22 14 27e-5
VS23 0 s23 0
V23 e23 s23 DC 0 AC 27e1 180
RI23 e23 10 47e-1
VS24 5 s24 0
V24 e24 s24 DC 0 AC 39e0 -120
RI24 e24 16 18e-3
VS25 4 s25 0
C25 s25 20 47e-4
VS26 6 s26 0
R26 s26 18 33e3
VS27 19 s27 0
V27 e27 s27 DC 0 AC 27e1 0
RI27 e27 m27 18e-1
LI27 m27 15 56e-6
VS28 13 s28 0
C28 s28 7 18e-5
VS29 16 s29 0
L29 s29 20 12e-3
VS30 1 s30 0
V30 e30 s30 DC 0 AC 22e1 -120
RI30 e30 19 82e-1
VS31 25 s31 0
C31 s31 17 47e-4
VS32 20 s32 0
L32 s32 23 56e-2
VS33 2 s33 0
C33 s33 16 15e-7
VS34 21 s34 0
R34 s34 14 47e2
VS35 14 s35 0
R35 s35 22 22e3
VS36 9 s36 0
V36 e36 s36 DC 0 AC 15e-1 180
RI36 e36 m36 22e-2
LI36 m36 2 22e-6
.control
set numdgt=17
ac lin 1 60 60
print v(1) v(2) v(3) v(4) v(5) v(6) v(7) v(8) v(9) v(10)
print v(11) v(12) v(13) v(14) v(15) v(16) v(17) v(18) v(19) v(20)
print v(21) v(22) v(23) v(24) v(25)
print i(vs0) i(vs1) i(vs2) i(vs3) i(vs4) i(vs5) i(vs6) i(vs7) i(vs8) i(vs9)
print i(vs10) i(vs11) i(vs12) i(vs13) i(vs14) i(vs15) i(vs16) i(vs17) i(vs18) i(vs19)
print i(vs20) i(vs21) i(vs22) i(vs23) i(vs24) i(vs25) i(vs26) i(vs27) i(vs28) i(vs29)
print i(vs30) i(vs31) i(vs32) i(vs33) i(vs34) i(vs35) i(vs36)
.endc
.end
