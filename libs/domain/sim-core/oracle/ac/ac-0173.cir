controls oracle ac-0173
* Generated (plan F2.7, ADR 0012): do not edit; regenerate with `pnpm sim oracle regen`. ac seed 20261031 index 173 nodes 26 elements 28
.options sparse gmin=1e-12 noopac
RG1 1 0 1000000000000
RG2 2 0 1000000000000
RG3 3 0 1000000000000
RG4 4 0 1000000000000
RG5 5 0 1000000000000
RG6 6 0 1000000000000
RG7 7 0 1000000000000
RG8 8 0 1000000000000
RG9 9 0 1000000000000
RG10 10 0 1000000000000
RG11 11 0 1000000000000
RG12 12 0 1000000000000
RG13 13 0 1000000000000
RG14 14 0 1000000000000
RG15 15 0 1000000000000
RG16 16 0 1000000000000
RG17 17 0 1000000000000
RG18 18 0 1000000000000
RG19 19 0 1000000000000
RG20 20 0 1000000000000
RG21 21 0 1000000000000
RG22 22 0 1000000000000
RG23 23 0 1000000000000
RG24 24 0 1000000000000
RG25 25 0 1000000000000
VS0 0 s0 0
V0 e0 s0 DC 0 AC 15e-1 180
RI0 e0 25 82e-2
VS1 25 s1 0
R1 s1 20 22e2
VS2 18 s2 0
L2 s2 3 12e-3
VS3 20 s3 0
L3 s3 23 56e-2
VS4 24 s4 0
R4 s4 13 22e3
VS5 5 s5 0
R5 s5 0 68e3
VS6 16 s6 0
L6 s6 14 82e-4
VS7 6 s7 0
C7 s7 4 18e-5
VS8 21 s8 0
R8 s8 22 22e3
VS9 15 s9 0
C9 s9 11 56e-5
VS10 18 s10 0
L10 s10 5 39e-2
VS11 16 s11 0
L11 s11 20 12e-3
VS12 3 s12 0
L12 s12 12 27e-3
VS13 17 s13 0
R13 s13 7 27e0
VS14 21 s14 0
R14 s14 23 39e1
VS15 10 s15 0
C15 s15 21 27e-5
VS16 21 s16 0
R16 s16 12 15e0
VS17 2 s17 0
C17 s17 16 15e-7
VS18 17 s18 0
R18 s18 23 47e0
VS19 11 s19 0
L19 s19 0 56e-5
VS20 16 s20 0
C20 s20 24 68e-6
VS21 4 s21 0
R21 s21 9 56e-1
VS22 20 s22 0
R22 s22 8 12e2
VS23 1 s23 0
V23 e23 s23 DC 0 AC 22e1 -120
RI23 e23 19 82e-1
VS24 0 s24 0
R24 s24 21 47e2
VS25 8 s25 0
L25 s25 13 56e-2
VS26 11 s26 0
R26 s26 4 18e0
VS27 1 s27 0
R27 s27 16 56e1
.control
set numdgt=17
ac lin 1 60 60
print v(1) v(2) v(3) v(4) v(5) v(6) v(7) v(8) v(9) v(10)
print v(11) v(12) v(13) v(14) v(15) v(16) v(17) v(18) v(19) v(20)
print v(21) v(22) v(23) v(24) v(25)
print i(vs0) i(vs1) i(vs2) i(vs3) i(vs4) i(vs5) i(vs6) i(vs7) i(vs8) i(vs9)
print i(vs10) i(vs11) i(vs12) i(vs13) i(vs14) i(vs15) i(vs16) i(vs17) i(vs18) i(vs19)
print i(vs20) i(vs21) i(vs22) i(vs23) i(vs24) i(vs25) i(vs26) i(vs27)
.endc
.end
