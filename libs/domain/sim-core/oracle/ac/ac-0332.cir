controls oracle ac-0332
* Generated (plan F2.7, ADR 0012): do not edit; regenerate with `pnpm sim oracle regen`. ac seed 20261031 index 332 nodes 30 elements 54
.options sparse gmin=1e-12 noopac
RG1 1 0 1000000000000
RG2 2 0 1000000000000
RG3 3 0 1000000000000
RG4 4 0 1000000000000
RG5 5 0 1000000000000
RG6 6 0 1000000000000
RG7 7 0 1000000000000
RG8 8 0 1000000000000
RG9 9 0 1000000000000
RG10 10 0 1000000000000
RG11 11 0 1000000000000
RG12 12 0 1000000000000
RG13 13 0 1000000000000
RG14 14 0 1000000000000
RG15 15 0 1000000000000
RG16 16 0 1000000000000
RG17 17 0 1000000000000
RG18 18 0 1000000000000
RG19 19 0 1000000000000
RG20 20 0 1000000000000
RG21 21 0 1000000000000
RG22 22 0 1000000000000
RG23 23 0 1000000000000
RG24 24 0 1000000000000
RG25 25 0 1000000000000
RG26 26 0 1000000000000
RG27 27 0 1000000000000
RG28 28 0 1000000000000
RG29 29 0 1000000000000
VS0 5 s0 0
R0 s0 17 22e3
VS1 22 s1 0
L1 s1 11 15e-5
VS2 27 s2 0
R2 s2 2 27e2
VS3 21 s3 0
C3 s3 7 22e-6
VS4 4 s4 0
L4 s4 8 56e-4
VS5 9 s5 0
L5 s5 4 39e-2
VS6 0 s6 0
V6 e6 s6 DC 0 AC 22e-1 120
RI6 e6 n6 12e-3
H6 n6 h6 VS8 -47e-4
ED6 h6 27 d6 0 27e-5
F6 0 d6 VS8 1
LD6 d6 0 1
VS7 23 s7 0
L7 s7 28 39e-3
VS8 5 s8 0
V8 e8 s8 DC 0 AC 15e1 0
RI8 e8 n8 18e-1
H8 n8 h8 VS6 -47e-4
ED8 h8 21 d8 0 27e-5
F8 0 d8 VS6 1
LD8 d8 0 1
VS9 14 s9 0
L9 s9 13 18e-5
VS10 23 s10 0
C10 s10 11 27e-6
VS11 20 s11 0
V11 e11 s11 DC 0 AC 56e-1 180
RI11 e11 m11 12e-3
LI11 m11 27 22e-7
VS12 19 s12 0
R12 s12 17 12e0
VS13 16 s13 0
C13 s13 24 15e-7
VS14 7 s14 0
R14 s14 15 15e2
VS15 5 s15 0
R15 s15 11 56e-2
VS16 9 s16 0
R16 s16 25 33e1
VS17 12 s17 0
V17 e17 s17 DC 0 AC 47e1 120
RI17 e17 m17 27e-1
LI17 m17 16 47e-5
VS18 13 s18 0
C18 s18 22 82e-7
VS19 23 s19 0
R19 s19 18 33e2
VS20 18 s20 0
C20 s20 5 39e-6
VS21 6 s21 0
V21 e21 s21 DC 0 AC 82e-1 120
RI21 e21 m21 56e-1
LI21 m21 8 27e-5
VS22 11 s22 0
L22 s22 25 18e-4
VS23 20 s23 0
V23 e23 s23 DC 0 AC 18e0 120
RI23 e23 m23 12e-3
LI23 m23 17 15e-6
VS24 26 s24 0
V24 e24 s24 DC 0 AC 12e1 180
RI24 e24 m24 56e-3
LI24 m24 14 15e-7
VS25 3 s25 0
R25 s25 29 12e1
VS26 17 s26 0
C26 s26 9 56e-7
VS27 26 s27 0
L27 s27 5 18e-2
VS28 11 s28 0
L28 s28 21 12e-5
VS29 16 s29 0
V29 e29 s29 DC 0 AC 47e-1 120
RI29 e29 22 39e-3
VS30 22 s30 0
V30 e30 s30 DC 0 AC 10e1 120
RI30 e30 m30 68e-1
LI30 m30 1 82e-5
VS31 23 s31 0
L31 s31 28 27e-2
VS32 2 s32 0
V32 e32 s32 DC 0 AC 15e1 0
RI32 e32 m32 68e-3
LI32 m32 5 82e-7
VS33 18 s33 0
V33 e33 s33 DC 0 AC 47e1 120
RI33 e33 m33 27e-1
LI33 m33 6 47e-5
VS34 2 s34 0
V34 e34 s34 DC 0 AC 68e0 120
RI34 e34 m34 12e-3
LI34 m34 28 39e-6
VS35 11 s35 0
L35 s35 16 56e-2
VS36 14 s36 0
C36 s36 12 27e-7
VS37 21 s37 0
L37 s37 6 47e-2
VS38 0 s38 0
V38 e38 s38 DC 0 AC 10e0 120
RI38 e38 3 82e-1
VS39 29 s39 0
R39 s39 15 33e-1
VS40 12 s40 0
V40 e40 s40 DC 0 AC 82e0 180
RI40 e40 m40 22e-3
LI40 m40 13 68e-7
VS41 23 s41 0
R41 s41 10 18e-1
VS42 8 s42 0
V42 e42 s42 DC 0 AC 33e0 -120
RI42 e42 5 56e-2
VS43 4 s43 0
V43 e43 s43 DC 0 AC 47e-1 180
RI43 e43 5 18e-2
VS44 19 s44 0
V44 e44 s44 DC 0 AC 12e1 0
RI44 e44 5 68e-3
VS45 24 s45 0
V45 e45 s45 DC 0 AC 39e1 -120
RI45 e45 m45 12e-2
LI45 m45 18 22e-7
VS46 24 s46 0
R46 s46 17 47e0
VS47 29 s47 0
C47 s47 1 39e-6
VS48 10 s48 0
V48 e48 s48 DC 0 AC 56e-1 120
RI48 e48 5 12e-1
VS49 26 s49 0
V49 e49 s49 DC 0 AC 27e1 0
RI49 e49 17 33e-1
VS50 27 s50 0
L50 s50 14 15e-3
VS51 27 s51 0
V51 e51 s51 DC 0 AC 27e0 0
RI51 e51 m51 27e-3
LI51 m51 22 68e-5
VS52 6 s52 0
L52 s52 2 47e-4
VS53 15 s53 0
V53 e53 s53 DC 0 AC 22e-1 0
RI53 e53 5 56e-2
.control
set numdgt=17
ac lin 1 60 60
print v(1) v(2) v(3) v(4) v(5) v(6) v(7) v(8) v(9) v(10)
print v(11) v(12) v(13) v(14) v(15) v(16) v(17) v(18) v(19) v(20)
print v(21) v(22) v(23) v(24) v(25) v(26) v(27) v(28) v(29)
print i(vs0) i(vs1) i(vs2) i(vs3) i(vs4) i(vs5) i(vs6) i(vs7) i(vs8) i(vs9)
print i(vs10) i(vs11) i(vs12) i(vs13) i(vs14) i(vs15) i(vs16) i(vs17) i(vs18) i(vs19)
print i(vs20) i(vs21) i(vs22) i(vs23) i(vs24) i(vs25) i(vs26) i(vs27) i(vs28) i(vs29)
print i(vs30) i(vs31) i(vs32) i(vs33) i(vs34) i(vs35) i(vs36) i(vs37) i(vs38) i(vs39)
print i(vs40) i(vs41) i(vs42) i(vs43) i(vs44) i(vs45) i(vs46) i(vs47) i(vs48) i(vs49)
print i(vs50) i(vs51) i(vs52) i(vs53)
.endc
.end
