controls oracle ac-0332
* Generated (plan F2.7, ADR 0012): do not edit; regenerate with `pnpm sim oracle regen`. ac seed 20261031 index 332 nodes 30 elements 52
.options sparse gmin=1e-12 noopac
RG1 1 0 1000000000000
RG2 2 0 1000000000000
RG3 3 0 1000000000000
RG4 4 0 1000000000000
RG5 5 0 1000000000000
RG6 6 0 1000000000000
RG7 7 0 1000000000000
RG8 8 0 1000000000000
RG9 9 0 1000000000000
RG10 10 0 1000000000000
RG11 11 0 1000000000000
RG12 12 0 1000000000000
RG13 13 0 1000000000000
RG14 14 0 1000000000000
RG15 15 0 1000000000000
RG16 16 0 1000000000000
RG17 17 0 1000000000000
RG18 18 0 1000000000000
RG19 19 0 1000000000000
RG20 20 0 1000000000000
RG21 21 0 1000000000000
RG22 22 0 1000000000000
RG23 23 0 1000000000000
RG24 24 0 1000000000000
RG25 25 0 1000000000000
RG26 26 0 1000000000000
RG27 27 0 1000000000000
RG28 28 0 1000000000000
RG29 29 0 1000000000000
VS0 23 s0 0
C0 s0 11 27e-6
VS1 20 s1 0
R1 s1 17 22e3
VS2 0 s2 0
V2 e2 s2 DC 0 AC 56e-1 180
RI2 e2 27 12e-3
VS3 14 s3 0
L3 s3 13 18e-5
VS4 9 s4 0
L4 s4 4 39e-2
VS5 13 s5 0
C5 s5 22 82e-7
VS6 8 s6 0
V6 e6 s6 DC 0 AC 33e0 -120
RI6 e6 20 56e-2
VS7 20 s7 0
V7 e7 s7 DC 0 AC 15e1 0
RI7 e7 21 18e-1
VS8 21 s8 0
L8 s8 6 47e-2
VS9 4 s9 0
L9 s9 8 56e-4
VS10 24 s10 0
R10 s10 17 47e0
VS11 21 s11 0
C11 s11 7 22e-6
VS12 4 s12 0
V12 e12 s12 DC 0 AC 47e-1 180
RI12 e12 20 18e-2
VS13 14 s13 0
C13 s13 12 27e-7
VS14 2 s14 0
V14 e14 s14 DC 0 AC 15e1 0
RI14 e14 20 68e-3
VS15 26 s15 0
V15 e15 s15 DC 0 AC 12e1 180
RI15 e15 14 56e-3
VS16 24 s16 0
V16 e16 s16 DC 0 AC 39e1 -120
RI16 e16 18 12e-2
VS17 23 s17 0
L17 s17 28 27e-2
VS18 0 s18 0
V18 e18 s18 DC 0 AC 18e0 120
RI18 e18 17 12e-3
VS19 11 s19 0
L19 s19 16 56e-2
VS20 27 s20 0
L20 s20 14 15e-3
VS21 18 s21 0
C21 s21 20 39e-6
VS22 29 s22 0
C22 s22 1 39e-6
VS23 20 s23 0
R23 s23 11 56e-2
VS24 27 s24 0
R24 s24 2 27e2
VS25 22 s25 0
V25 e25 s25 DC 0 AC 10e1 120
RI25 e25 1 68e-1
VS26 16 s26 0
V26 e26 s26 DC 0 AC 47e-1 120
RI26 e26 22 39e-3
VS27 17 s27 0
C27 s27 9 56e-7
VS28 6 s28 0
L28 s28 2 47e-4
VS29 6 s29 0
V29 e29 s29 DC 0 AC 82e-1 120
RI29 e29 8 56e-1
VS30 22 s30 0
L30 s30 11 15e-5
VS31 2 s31 0
V31 e31 s31 DC 0 AC 68e0 120
RI31 e31 28 12e-3
VS32 9 s32 0
R32 s32 25 33e1
VS33 23 s33 0
L33 s33 28 39e-3
VS34 7 s34 0
R34 s34 15 15e2
VS35 12 s35 0
V35 e35 s35 DC 0 AC 47e1 120
RI35 e35 16 27e-1
VS36 19 s36 0
V36 e36 s36 DC 0 AC 12e1 0
RI36 e36 20 68e-3
VS37 16 s37 0
C37 s37 24 15e-7
VS38 5 s38 0
V38 e38 s38 DC 0 AC 10e0 120
RI38 e38 3 82e-1
VS39 5 s39 0
V39 e39 s39 DC 0 AC 22e-1 120
RI39 e39 27 12e-3
VS40 10 s40 0
V40 e40 s40 DC 0 AC 56e-1 120
RI40 e40 20 12e-1
VS41 15 s41 0
V41 e41 s41 DC 0 AC 22e-1 0
RI41 e41 20 56e-2
VS42 23 s42 0
R42 s42 18 33e2
VS43 23 s43 0
R43 s43 10 18e-1
VS44 27 s44 0
V44 e44 s44 DC 0 AC 27e0 0
RI44 e44 22 27e-3
VS45 3 s45 0
R45 s45 29 12e1
VS46 18 s46 0
V46 e46 s46 DC 0 AC 47e1 120
RI46 e46 6 27e-1
VS47 12 s47 0
V47 e47 s47 DC 0 AC 82e0 180
RI47 e47 13 22e-3
VS48 26 s48 0
V48 e48 s48 DC 0 AC 27e1 0
RI48 e48 17 33e-1
VS49 11 s49 0
L49 s49 21 12e-5
VS50 26 s50 0
L50 s50 20 18e-2
VS51 29 s51 0
R51 s51 15 33e-1
.control
set numdgt=17
ac lin 1 60 60
print v(1) v(2) v(3) v(4) v(5) v(6) v(7) v(8) v(9) v(10)
print v(11) v(12) v(13) v(14) v(15) v(16) v(17) v(18) v(19) v(20)
print v(21) v(22) v(23) v(24) v(25) v(26) v(27) v(28) v(29)
print i(vs0) i(vs1) i(vs2) i(vs3) i(vs4) i(vs5) i(vs6) i(vs7) i(vs8) i(vs9)
print i(vs10) i(vs11) i(vs12) i(vs13) i(vs14) i(vs15) i(vs16) i(vs17) i(vs18) i(vs19)
print i(vs20) i(vs21) i(vs22) i(vs23) i(vs24) i(vs25) i(vs26) i(vs27) i(vs28) i(vs29)
print i(vs30) i(vs31) i(vs32) i(vs33) i(vs34) i(vs35) i(vs36) i(vs37) i(vs38) i(vs39)
print i(vs40) i(vs41) i(vs42) i(vs43) i(vs44) i(vs45) i(vs46) i(vs47) i(vs48) i(vs49)
print i(vs50) i(vs51)
.endc
.end
