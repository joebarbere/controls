controls oracle ac-0332
* Generated (plan F2.7, ADR 0012): do not edit; regenerate with `pnpm sim oracle regen`. ac seed 20261031 index 332 nodes 30 elements 42
.options sparse gmin=1e-12 noopac
RG1 1 0 1000000000000
RG2 2 0 1000000000000
RG3 3 0 1000000000000
RG4 4 0 1000000000000
RG5 5 0 1000000000000
RG6 6 0 1000000000000
RG7 7 0 1000000000000
RG8 8 0 1000000000000
RG9 9 0 1000000000000
RG10 10 0 1000000000000
RG11 11 0 1000000000000
RG12 12 0 1000000000000
RG13 13 0 1000000000000
RG14 14 0 1000000000000
RG15 15 0 1000000000000
RG16 16 0 1000000000000
RG17 17 0 1000000000000
RG18 18 0 1000000000000
RG19 19 0 1000000000000
RG20 20 0 1000000000000
RG21 21 0 1000000000000
RG22 22 0 1000000000000
RG23 23 0 1000000000000
RG24 24 0 1000000000000
RG25 25 0 1000000000000
RG26 26 0 1000000000000
RG27 27 0 1000000000000
RG28 28 0 1000000000000
RG29 29 0 1000000000000
VS0 14 s0 0
R0 s0 3 22e2
VS1 11 s1 0
L1 s1 25 18e-4
VS2 21 s2 0
R2 s2 29 22e1
VS3 15 s3 0
R3 s3 8 33e3
VS4 1 s4 0
L4 s4 13 27e-4
VS5 4 s5 0
L5 s5 2 56e-2
VS6 16 s6 0
L6 s6 11 27e-2
VS7 4 s7 0
R7 s7 5 56e-2
VS8 24 s8 0
R8 s8 1 33e-2
VS9 19 s9 0
R9 s9 17 27e0
VS10 0 s10 0
V10 e10 s10 DC 0 AC 82e1 180
RI10 e10 m10 10e-1
LI10 m10 24 82e-5
VS11 15 s11 0
L11 s11 16 56e-4
VS12 27 s12 0
R12 s12 9 33e-1
VS13 11 s13 0
R13 s13 4 47e0
VS14 14 s14 0
C14 s14 5 68e-5
VS15 24 s15 0
R15 s15 12 27e2
VS16 27 s16 0
C16 s16 19 10e-4
VS17 18 s17 0
L17 s17 5 82e-4
VS18 14 s18 0
R18 s18 26 47e-2
VS19 12 s19 0
R19 s19 8 33e-2
VS20 15 s20 0
L20 s20 18 56e-2
VS21 29 s21 0
L21 s21 4 39e-2
VS22 4 s22 0
R22 s22 15 18e0
VS23 26 s23 0
V23 e23 s23 DC 0 AC 22e-1 120
RI23 e23 m23 12e-3
LI23 m23 27 12e-7
VS24 10 s24 0
R24 s24 0 68e0
VS25 8 s25 0
V25 e25 s25 DC 0 AC 22e0 120
RI25 e25 20 10e-3
VS26 10 s26 0
C26 s26 29 47e-4
VS27 13 s27 0
C27 s27 29 22e-6
VS28 2 s28 0
L28 s28 6 82e-2
VS29 15 s29 0
R29 s29 9 22e3
VS30 4 s30 0
V30 e30 s30 DC 0 AC 47e-1 180
RI30 e30 12 18e-2
VS31 14 s31 0
R31 s31 23 12e1
VS32 22 s32 0
V32 e32 s32 DC 0 AC 22e1 180
RI32 e32 m32 10e-1
LI32 m32 7 39e-6
VS33 17 s33 0
L33 s33 7 12e-4
VS34 24 s34 0
V34 e34 s34 DC 0 AC 12e0 180
RI34 e34 m34 56e-1
LI34 m34 28 82e-7
VS35 10 s35 0
R35 s35 28 33e1
VS36 25 s36 0
V36 e36 s36 DC 0 AC 12e-1 -120
RI36 e36 m36 47e-2
LI36 m36 22 15e-6
VS37 15 s37 0
C37 s37 23 56e-6
VS38 27 s38 0
V38 e38 s38 DC 0 AC 39e1 -120
RI38 e38 m38 12e-2
LI38 m38 21 18e-6
VS39 4 s39 0
R39 s39 17 68e-2
VS40 20 s40 0
L40 s40 6 18e-5
VS41 3 s41 0
R41 s41 25 68e3
.control
set numdgt=17
ac lin 1 60 60
print v(1) v(2) v(3) v(4) v(5) v(6) v(7) v(8) v(9) v(10)
print v(11) v(12) v(13) v(14) v(15) v(16) v(17) v(18) v(19) v(20)
print v(21) v(22) v(23) v(24) v(25) v(26) v(27) v(28) v(29)
print i(vs0) i(vs1) i(vs2) i(vs3) i(vs4) i(vs5) i(vs6) i(vs7) i(vs8) i(vs9)
print i(vs10) i(vs11) i(vs12) i(vs13) i(vs14) i(vs15) i(vs16) i(vs17) i(vs18) i(vs19)
print i(vs20) i(vs21) i(vs22) i(vs23) i(vs24) i(vs25) i(vs26) i(vs27) i(vs28) i(vs29)
print i(vs30) i(vs31) i(vs32) i(vs33) i(vs34) i(vs35) i(vs36) i(vs37) i(vs38) i(vs39)
print i(vs40) i(vs41)
.endc
.end
