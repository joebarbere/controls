controls oracle ac-0142
* Generated (plan F2.7, ADR 0012): do not edit; regenerate with `pnpm sim oracle regen`. ac seed 20261031 index 142 nodes 8 elements 11
.options sparse gmin=1e-12 noopac
RG1 1 0 1000000000000
RG2 2 0 1000000000000
RG3 3 0 1000000000000
RG4 4 0 1000000000000
RG5 5 0 1000000000000
RG6 6 0 1000000000000
RG7 7 0 1000000000000
VS0 4 s0 0
L0 s0 5 33e-3
VS1 6 s1 0
R1 s1 0 22e1
VS2 4 s2 0
L2 s2 2 39e-5
VS3 1 s3 0
R3 s3 0 47e-1
VS4 5 s4 0
C4 s4 3 18e-4
VS5 0 s5 0
V5 e5 s5 DC 0 AC 39e1 120
RI5 e5 m5 10e-2
LI5 m5 5 56e-6
VS6 2 s6 0
C6 s6 0 18e-7
VS7 6 s7 0
L7 s7 1 82e-2
VS8 5 s8 0
L8 s8 7 33e-2
VS9 3 s9 0
V9 e9 s9 DC 0 AC 56e-1 -120
RI9 e9 m9 56e-1
LI9 m9 6 33e-5
VS10 2 s10 0
R10 s10 7 22e3
.control
set numdgt=17
ac lin 1 60 60
print v(1) v(2) v(3) v(4) v(5) v(6) v(7)
print i(vs0) i(vs1) i(vs2) i(vs3) i(vs4) i(vs5) i(vs6) i(vs7) i(vs8) i(vs9)
print i(vs10)
.endc
.end
