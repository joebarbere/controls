controls oracle ac-0222
* Generated (plan F2.7, ADR 0012): do not edit; regenerate with `pnpm sim oracle regen`. ac seed 20261031 index 222 nodes 14 elements 18
.options sparse gmin=1e-12 noopac
RG1 1 0 1000000000000
RG2 2 0 1000000000000
RG3 3 0 1000000000000
RG4 4 0 1000000000000
RG5 5 0 1000000000000
RG6 6 0 1000000000000
RG7 7 0 1000000000000
RG8 8 0 1000000000000
RG9 9 0 1000000000000
RG10 10 0 1000000000000
RG11 11 0 1000000000000
RG12 12 0 1000000000000
RG13 13 0 1000000000000
VS0 11 s0 0
C0 s0 9 56e-5
VS1 0 s1 0
V1 e1 s1 DC 0 AC 27e1 180
RI1 e1 7 27e-1
VS2 5 s2 0
L2 s2 7 82e-2
VS3 0 s3 0
V3 e3 s3 DC 0 AC 39e0 0
RI3 e3 12 15e-2
VS4 3 s4 0
C4 s4 7 18e-5
VS5 7 s5 0
R5 s5 4 47e2
VS6 12 s6 0
R6 s6 6 18e-2
VS7 12 s7 0
C7 s7 2 27e-5
VS8 8 s8 0
R8 s8 7 10e3
VS9 7 s9 0
R9 s9 5 27e3
VS10 13 s10 0
C10 s10 9 39e-5
VS11 5 s11 0
V11 e11 s11 DC 0 AC 27e-1 0
RI11 e11 11 10e-2
VS12 3 s12 0
L12 s12 1 10e-4
VS13 4 s13 0
L13 s13 11 10e-2
VS14 4 s14 0
R14 s14 13 22e-2
VS15 4 s15 0
C15 s15 12 12e-5
VS16 10 s16 0
R16 s16 3 22e0
VS17 11 s17 0
L17 s17 3 27e-2
.control
set numdgt=17
ac lin 1 60 60
print v(1) v(2) v(3) v(4) v(5) v(6) v(7) v(8) v(9) v(10)
print v(11) v(12) v(13)
print i(vs0) i(vs1) i(vs2) i(vs3) i(vs4) i(vs5) i(vs6) i(vs7) i(vs8) i(vs9)
print i(vs10) i(vs11) i(vs12) i(vs13) i(vs14) i(vs15) i(vs16) i(vs17)
.endc
.end
