controls oracle ac-0222
* Generated (plan F2.7, ADR 0012): do not edit; regenerate with `pnpm sim oracle regen`. ac seed 20261031 index 222 nodes 14 elements 22
.options sparse gmin=1e-12 noopac
RG1 1 0 1000000000000
RG2 2 0 1000000000000
RG3 3 0 1000000000000
RG4 4 0 1000000000000
RG5 5 0 1000000000000
RG6 6 0 1000000000000
RG7 7 0 1000000000000
RG8 8 0 1000000000000
RG9 9 0 1000000000000
RG10 10 0 1000000000000
RG11 11 0 1000000000000
RG12 12 0 1000000000000
RG13 13 0 1000000000000
VS0 3 s0 0
C0 s0 7 18e-5
VS1 8 s1 0
R1 s1 7 10e3
VS2 7 s2 0
R2 s2 5 27e3
VS3 12 s3 0
C3 s3 2 27e-5
VS4 10 s4 0
R4 s4 3 22e0
VS5 4 s5 0
R5 s5 13 22e-2
VS6 4 s6 0
C6 s6 10 39e-4
VS7 12 s7 0
R7 s7 6 18e-2
VS8 2 s8 0
C8 s8 3 15e-5
VS9 11 s9 0
L9 s9 3 27e-2
VS10 0 s10 0
V10 e10 s10 DC 0 AC 27e1 180
RI10 e10 7 27e-1
VS11 4 s11 0
C11 s11 12 12e-5
VS12 4 s12 0
L12 s12 11 10e-2
VS13 11 s13 0
C13 s13 9 56e-5
VS14 5 s14 0
L14 s14 7 82e-2
VS15 1 s15 0
V15 e15 s15 DC 0 AC 68e-1 0
RI15 e15 4 10e-2
VS16 0 s16 0
V16 e16 s16 DC 0 AC 39e0 0
RI16 e16 12 15e-2
VS17 3 s17 0
L17 s17 1 10e-4
VS18 5 s18 0
V18 e18 s18 DC 0 AC 27e-1 0
RI18 e18 11 10e-2
VS19 8 s19 0
R19 s19 6 22e0
VS20 7 s20 0
R20 s20 4 47e2
VS21 13 s21 0
C21 s21 9 39e-5
.control
set numdgt=17
ac lin 1 60 60
print v(1) v(2) v(3) v(4) v(5) v(6) v(7) v(8) v(9) v(10)
print v(11) v(12) v(13)
print i(vs0) i(vs1) i(vs2) i(vs3) i(vs4) i(vs5) i(vs6) i(vs7) i(vs8) i(vs9)
print i(vs10) i(vs11) i(vs12) i(vs13) i(vs14) i(vs15) i(vs16) i(vs17) i(vs18) i(vs19)
print i(vs20) i(vs21)
.endc
.end
