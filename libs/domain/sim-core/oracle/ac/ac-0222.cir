controls oracle ac-0222
* Generated (plan F2.7, ADR 0012): do not edit; regenerate with `pnpm sim oracle regen`. ac seed 20261031 index 222 nodes 14 elements 26
.options sparse gmin=1e-12 noopac
RG1 1 0 1000000000000
RG2 2 0 1000000000000
RG3 3 0 1000000000000
RG4 4 0 1000000000000
RG5 5 0 1000000000000
RG6 6 0 1000000000000
RG7 7 0 1000000000000
RG8 8 0 1000000000000
RG9 9 0 1000000000000
RG10 10 0 1000000000000
RG11 11 0 1000000000000
RG12 12 0 1000000000000
RG13 13 0 1000000000000
VS0 4 s0 0
R0 s0 13 22e-2
VS1 7 s1 0
R1 s1 5 27e3
VS2 11 s2 0
C2 s2 9 56e-5
VS3 12 s3 0
R3 s3 6 18e-2
VS4 4 s4 0
C4 s4 12 12e-5
VS5 7 s5 0
R5 s5 11 12e0
VS6 3 s6 0
L6 s6 12 68e-2
VS7 0 s7 0
V7 e7 s7 DC 0 AC 27e1 180
RI7 e7 m7 27e-1
LI7 m7 7 18e-7
VS8 5 s8 0
V8 e8 s8 DC 0 AC 27e-1 0
RI8 e8 m8 10e-2
LI8 m8 11 56e-6
VS9 5 s9 0
R9 s9 1 56e3
VS10 12 s10 0
C10 s10 2 27e-5
VS11 1 s11 0
L11 s11 6 47e-3
VS12 9 s12 0
R12 s12 12 15e2
VS13 0 s13 0
L13 s13 13 10e-5
VS14 6 s14 0
V14 e14 s14 DC 0 AC 33e-1 120
RI14 e14 m14 68e-2
LI14 m14 5 15e-7
VS15 11 s15 0
R15 s15 8 12e1
VS16 11 s16 0
V16 e16 s16 DC 0 AC 10e1 180
RI16 e16 0 68e-3
VS17 2 s17 0
L17 s17 1 10e-5
VS18 3 s18 0
L18 s18 1 10e-4
VS19 6 s19 0
R19 s19 1 10e3
VS20 4 s20 0
L20 s20 11 10e-2
VS21 1 s21 0
R21 s21 10 47e2
VS22 7 s22 0
R22 s22 4 47e2
VS23 10 s23 0
R23 s23 3 22e0
VS24 8 s24 0
R24 s24 7 10e3
VS25 3 s25 0
C25 s25 7 18e-5
.control
set numdgt=17
ac lin 1 60 60
print v(1) v(2) v(3) v(4) v(5) v(6) v(7) v(8) v(9) v(10)
print v(11) v(12) v(13)
print i(vs0) i(vs1) i(vs2) i(vs3) i(vs4) i(vs5) i(vs6) i(vs7) i(vs8) i(vs9)
print i(vs10) i(vs11) i(vs12) i(vs13) i(vs14) i(vs15) i(vs16) i(vs17) i(vs18) i(vs19)
print i(vs20) i(vs21) i(vs22) i(vs23) i(vs24) i(vs25)
.endc
.end
