controls oracle ac-0074
* Generated (plan F2.7, ADR 0012): do not edit; regenerate with `pnpm sim oracle regen`. ac seed 20261031 index 74 nodes 26 elements 46
.options sparse gmin=1e-12 noopac
RG1 1 0 1000000000000
RG2 2 0 1000000000000
RG3 3 0 1000000000000
RG4 4 0 1000000000000
RG5 5 0 1000000000000
RG6 6 0 1000000000000
RG7 7 0 1000000000000
RG8 8 0 1000000000000
RG9 9 0 1000000000000
RG10 10 0 1000000000000
RG11 11 0 1000000000000
RG12 12 0 1000000000000
RG13 13 0 1000000000000
RG14 14 0 1000000000000
RG15 15 0 1000000000000
RG16 16 0 1000000000000
RG17 17 0 1000000000000
RG18 18 0 1000000000000
RG19 19 0 1000000000000
RG20 20 0 1000000000000
RG21 21 0 1000000000000
RG22 22 0 1000000000000
RG23 23 0 1000000000000
RG24 24 0 1000000000000
RG25 25 0 1000000000000
VS0 16 s0 0
C0 s0 2 33e-6
VS1 0 s1 0
V1 e1 s1 DC 0 AC 10e1 0
RI1 e1 20 33e-3
VS2 3 s2 0
L2 s2 8 22e-5
VS3 6 s3 0
R3 s3 15 68e0
VS4 14 s4 0
C4 s4 22 12e-4
VS5 17 s5 0
V5 e5 s5 DC 0 AC 39e0 0
RI5 e5 m5 22e-1
LI5 m5 7 47e-6
VS6 17 s6 0
V6 e6 s6 DC 0 AC 27e1 180
RI6 e6 m6 12e-3
LI6 m6 19 10e-7
VS7 4 s7 0
L7 s7 12 12e-5
VS8 13 s8 0
C8 s8 16 27e-6
VS9 5 s9 0
C9 s9 6 39e-5
VS10 14 s10 0
L10 s10 9 56e-2
VS11 4 s11 0
C11 s11 14 10e-5
VS12 14 s12 0
R12 s12 24 27e-2
VS13 22 s13 0
R13 s13 8 10e3
VS14 21 s14 0
R14 s14 23 39e1
VS15 2 s15 0
L15 s15 21 47e-4
VS16 10 s16 0
V16 e16 s16 DC 0 AC 10e-1 120
RI16 e16 13 82e-2
VS17 11 s17 0
L17 s17 7 33e-3
VS18 0 s18 0
V18 e18 s18 DC 0 AC 33e0 120
RI18 e18 1 10e-2
VS19 16 s19 0
R19 s19 25 27e2
VS20 5 s20 0
C20 s20 19 12e-6
VS21 11 s21 0
V21 e21 s21 DC 0 AC 10e1 -120
RI21 e21 m21 68e-1
LI21 m21 12 47e-6
VS22 25 s22 0
L22 s22 9 22e-4
VS23 23 s23 0
R23 s23 10 68e1
VS24 18 s24 0
L24 s24 24 12e-3
VS25 23 s25 0
C25 s25 15 33e-5
VS26 16 s26 0
V26 e26 s26 DC 0 AC 12e1 120
RI26 e26 m26 12e-1
LI26 m26 14 33e-7
VS27 11 s27 0
R27 s27 17 15e1
VS28 5 s28 0
R28 s28 7 39e-2
VS29 20 s29 0
L29 s29 1 68e-2
VS30 8 s30 0
V30 e30 s30 DC 0 AC 39e-1 180
RI30 e30 m30 68e-3
LI30 m30 20 33e-7
VS31 7 s31 0
C31 s31 24 33e-4
VS32 8 s32 0
L32 s32 5 12e-2
VS33 21 s33 0
L33 s33 14 33e-3
VS34 15 s34 0
R34 s34 18 33e-1
VS35 1 s35 0
L35 s35 8 68e-3
VS36 4 s36 0
R36 s36 24 18e1
VS37 0 s37 0
C37 s37 10 47e-5
VS38 6 s38 0
V38 e38 s38 DC 0 AC 47e-1 120
RI38 e38 m38 68e-3
LI38 m38 0 56e-6
VS39 3 s39 0
C39 s39 17 56e-7
VS40 6 s40 0
C40 s40 5 82e-7
VS41 18 s41 0
R41 s41 19 47e0
VS42 0 s42 0
R42 s42 14 22e-1
VS43 0 s43 0
V43 e43 s43 DC 0 AC 27e0 180
RI43 e43 14 12e-1
VS44 11 s44 0
V44 e44 s44 DC 0 AC 15e0 -120
RI44 e44 m44 22e-2
LI44 m44 7 10e-7
VS45 19 s45 0
L45 s45 0 10e-2
.control
set numdgt=17
ac lin 1 60 60
print v(1) v(2) v(3) v(4) v(5) v(6) v(7) v(8) v(9) v(10)
print v(11) v(12) v(13) v(14) v(15) v(16) v(17) v(18) v(19) v(20)
print v(21) v(22) v(23) v(24) v(25)
print i(vs0) i(vs1) i(vs2) i(vs3) i(vs4) i(vs5) i(vs6) i(vs7) i(vs8) i(vs9)
print i(vs10) i(vs11) i(vs12) i(vs13) i(vs14) i(vs15) i(vs16) i(vs17) i(vs18) i(vs19)
print i(vs20) i(vs21) i(vs22) i(vs23) i(vs24) i(vs25) i(vs26) i(vs27) i(vs28) i(vs29)
print i(vs30) i(vs31) i(vs32) i(vs33) i(vs34) i(vs35) i(vs36) i(vs37) i(vs38) i(vs39)
print i(vs40) i(vs41) i(vs42) i(vs43) i(vs44) i(vs45)
.endc
.end
