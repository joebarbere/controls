controls oracle ac-0074
* Generated (plan F2.7, ADR 0012): do not edit; regenerate with `pnpm sim oracle regen`. ac seed 20261031 index 74 nodes 26 elements 33
.options sparse gmin=1e-12 noopac
RG1 1 0 1000000000000
RG2 2 0 1000000000000
RG3 3 0 1000000000000
RG4 4 0 1000000000000
RG5 5 0 1000000000000
RG6 6 0 1000000000000
RG7 7 0 1000000000000
RG8 8 0 1000000000000
RG9 9 0 1000000000000
RG10 10 0 1000000000000
RG11 11 0 1000000000000
RG12 12 0 1000000000000
RG13 13 0 1000000000000
RG14 14 0 1000000000000
RG15 15 0 1000000000000
RG16 16 0 1000000000000
RG17 17 0 1000000000000
RG18 18 0 1000000000000
RG19 19 0 1000000000000
RG20 20 0 1000000000000
RG21 21 0 1000000000000
RG22 22 0 1000000000000
RG23 23 0 1000000000000
RG24 24 0 1000000000000
RG25 25 0 1000000000000
VS0 1 s0 0
R0 s0 15 68e0
VS1 7 s1 0
L1 s1 4 18e-3
VS2 0 s2 0
V2 e2 s2 DC 0 AC 15e1 180
RI2 e2 11 22e-1
VS3 9 s3 0
L3 s3 22 10e-3
VS4 20 s4 0
V4 e4 s4 DC 0 AC 12e-1 120
RI4 e4 13 82e-1
VS5 24 s5 0
R5 s5 15 68e0
VS6 17 s6 0
R6 s6 3 47e-2
VS7 18 s7 0
L7 s7 7 12e-4
VS8 14 s8 0
L8 s8 10 10e-2
VS9 0 s9 0
R9 s9 24 27e-2
VS10 3 s10 0
L10 s10 5 10e-3
VS11 10 s11 0
R11 s11 0 15e0
VS12 14 s12 0
V12 e12 s12 DC 0 AC 27e0 180
RI12 e12 0 12e-1
VS13 22 s13 0
R13 s13 12 15e2
VS14 17 s14 0
C14 s14 11 82e-6
VS15 4 s15 0
V15 e15 s15 DC 0 AC 82e-1 180
RI15 e15 21 47e-3
VS16 8 s16 0
L16 s16 23 47e-5
VS17 16 s17 0
V17 e17 s17 DC 0 AC 56e0 0
RI17 e17 14 68e-2
VS18 5 s18 0
C18 s18 24 82e-6
VS19 24 s19 0
R19 s19 8 12e-1
VS20 0 s20 0
L20 s20 5 10e-5
VS21 24 s21 0
R21 s21 25 56e-2
VS22 19 s22 0
L22 s22 9 22e-4
VS23 16 s23 0
R23 s23 20 56e2
VS24 22 s24 0
R24 s24 6 68e0
VS25 16 s25 0
V25 e25 s25 DC 0 AC 68e1 0
RI25 e25 12 22e-1
VS26 4 s26 0
R26 s26 24 18e1
VS27 8 s27 0
L27 s27 4 33e-3
VS28 10 s28 0
R28 s28 13 18e-2
VS29 23 s29 0
C29 s29 21 39e-5
VS30 10 s30 0
R30 s30 2 12e2
VS31 7 s31 0
L31 s31 22 15e-5
VS32 2 s32 0
C32 s32 7 12e-5
.control
set numdgt=17
ac lin 1 60 60
print v(1) v(2) v(3) v(4) v(5) v(6) v(7) v(8) v(9) v(10)
print v(11) v(12) v(13) v(14) v(15) v(16) v(17) v(18) v(19) v(20)
print v(21) v(22) v(23) v(24) v(25)
print i(vs0) i(vs1) i(vs2) i(vs3) i(vs4) i(vs5) i(vs6) i(vs7) i(vs8) i(vs9)
print i(vs10) i(vs11) i(vs12) i(vs13) i(vs14) i(vs15) i(vs16) i(vs17) i(vs18) i(vs19)
print i(vs20) i(vs21) i(vs22) i(vs23) i(vs24) i(vs25) i(vs26) i(vs27) i(vs28) i(vs29)
print i(vs30) i(vs31) i(vs32)
.endc
.end
