controls oracle ac-0074
* Generated (plan F2.7, ADR 0012): do not edit; regenerate with `pnpm sim oracle regen`. ac seed 20261031 index 74 nodes 26 elements 38
.options sparse gmin=1e-12 noopac
RG1 1 0 1000000000000
RG2 2 0 1000000000000
RG3 3 0 1000000000000
RG4 4 0 1000000000000
RG5 5 0 1000000000000
RG6 6 0 1000000000000
RG7 7 0 1000000000000
RG8 8 0 1000000000000
RG9 9 0 1000000000000
RG10 10 0 1000000000000
RG11 11 0 1000000000000
RG12 12 0 1000000000000
RG13 13 0 1000000000000
RG14 14 0 1000000000000
RG15 15 0 1000000000000
RG16 16 0 1000000000000
RG17 17 0 1000000000000
RG18 18 0 1000000000000
RG19 19 0 1000000000000
RG20 20 0 1000000000000
RG21 21 0 1000000000000
RG22 22 0 1000000000000
RG23 23 0 1000000000000
RG24 24 0 1000000000000
RG25 25 0 1000000000000
VS0 24 s0 0
R0 s0 25 56e-2
VS1 1 s1 0
R1 s1 15 68e0
VS2 24 s2 0
R2 s2 8 12e-1
VS3 7 s3 0
L3 s3 4 18e-3
VS4 1 s4 0
R4 s4 2 12e2
VS5 10 s5 0
R5 s5 2 12e2
VS6 9 s6 0
L6 s6 22 10e-3
VS7 5 s7 0
L7 s7 25 56e-3
VS8 18 s8 0
R8 s8 17 15e2
VS9 24 s9 0
R9 s9 15 68e0
VS10 0 s10 0
V10 e10 s10 DC 0 AC 56e0 0
RI10 e10 14 68e-2
VS11 17 s11 0
R11 s11 3 47e-2
VS12 10 s12 0
R12 s12 13 18e-2
VS13 0 s13 0
V13 e13 s13 DC 0 AC 68e1 0
RI13 e13 12 22e-1
VS14 23 s14 0
C14 s14 21 39e-5
VS15 4 s15 0
R15 s15 24 18e1
VS16 14 s16 0
L16 s16 10 10e-2
VS17 8 s17 0
L17 s17 23 47e-5
VS18 16 s18 0
V18 e18 s18 DC 0 AC 15e1 180
RI18 e18 11 22e-1
VS19 22 s19 0
R19 s19 6 68e0
VS20 7 s20 0
L20 s20 22 15e-5
VS21 16 s21 0
R21 s21 24 27e-2
VS22 4 s22 0
V22 e22 s22 DC 0 AC 82e-1 180
RI22 e22 21 47e-3
VS23 17 s23 0
C23 s23 11 82e-6
VS24 20 s24 0
V24 e24 s24 DC 0 AC 12e-1 120
RI24 e24 13 82e-1
VS25 5 s25 0
C25 s25 24 82e-6
VS26 0 s26 0
R26 s26 20 56e2
VS27 22 s27 0
R27 s27 12 15e2
VS28 14 s28 0
V28 e28 s28 DC 0 AC 27e0 180
RI28 e28 16 12e-1
VS29 3 s29 0
R29 s29 6 10e2
VS30 19 s30 0
C30 s30 23 27e-6
VS31 19 s31 0
L31 s31 9 22e-4
VS32 8 s32 0
L32 s32 4 33e-3
VS33 10 s33 0
R33 s33 16 15e0
VS34 2 s34 0
C34 s34 7 12e-5
VS35 16 s35 0
L35 s35 5 10e-5
VS36 3 s36 0
L36 s36 5 10e-3
VS37 18 s37 0
L37 s37 7 12e-4
.control
set numdgt=17
ac lin 1 60 60
print v(1) v(2) v(3) v(4) v(5) v(6) v(7) v(8) v(9) v(10)
print v(11) v(12) v(13) v(14) v(15) v(16) v(17) v(18) v(19) v(20)
print v(21) v(22) v(23) v(24) v(25)
print i(vs0) i(vs1) i(vs2) i(vs3) i(vs4) i(vs5) i(vs6) i(vs7) i(vs8) i(vs9)
print i(vs10) i(vs11) i(vs12) i(vs13) i(vs14) i(vs15) i(vs16) i(vs17) i(vs18) i(vs19)
print i(vs20) i(vs21) i(vs22) i(vs23) i(vs24) i(vs25) i(vs26) i(vs27) i(vs28) i(vs29)
print i(vs30) i(vs31) i(vs32) i(vs33) i(vs34) i(vs35) i(vs36) i(vs37)
.endc
.end
