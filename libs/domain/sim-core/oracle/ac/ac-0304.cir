controls oracle ac-0304
* Generated (plan F2.7, ADR 0012): do not edit; regenerate with `pnpm sim oracle regen`. ac seed 20261031 index 304 nodes 26 elements 50
.options sparse gmin=1e-12 noopac
RG1 1 0 1000000000000
RG2 2 0 1000000000000
RG3 3 0 1000000000000
RG4 4 0 1000000000000
RG5 5 0 1000000000000
RG6 6 0 1000000000000
RG7 7 0 1000000000000
RG8 8 0 1000000000000
RG9 9 0 1000000000000
RG10 10 0 1000000000000
RG11 11 0 1000000000000
RG12 12 0 1000000000000
RG13 13 0 1000000000000
RG14 14 0 1000000000000
RG15 15 0 1000000000000
RG16 16 0 1000000000000
RG17 17 0 1000000000000
RG18 18 0 1000000000000
RG19 19 0 1000000000000
RG20 20 0 1000000000000
RG21 21 0 1000000000000
RG22 22 0 1000000000000
RG23 23 0 1000000000000
RG24 24 0 1000000000000
RG25 25 0 1000000000000
VS0 3 s0 0
C0 s0 13 22e-7
VS1 13 s1 0
C1 s1 3 47e-6
VS2 2 s2 0
L2 s2 1 68e-4
VS3 2 s3 0
L3 s3 24 82e-3
VS4 0 s4 0
V4 e4 s4 DC 0 AC 68e1 180
RI4 e4 19 56e-1
VS5 5 s5 0
V5 e5 s5 DC 0 AC 12e0 0
RI5 e5 11 22e-1
VS6 5 s6 0
C6 s6 6 18e-6
VS7 14 s7 0
V7 e7 s7 DC 0 AC 10e1 180
RI7 e7 16 47e-2
VS8 17 s8 0
C8 s8 14 18e-4
VS9 15 s9 0
V9 e9 s9 DC 0 AC 10e-1 0
RI9 e9 12 18e-2
VS10 18 s10 0
V10 e10 s10 DC 0 AC 10e-1 180
RI10 e10 13 12e-3
VS11 13 s11 0
C11 s11 9 56e-7
VS12 4 s12 0
L12 s12 0 22e-5
VS13 18 s13 0
R13 s13 15 68e0
VS14 22 s14 0
C14 s14 12 39e-4
VS15 9 s15 0
R15 s15 3 10e1
VS16 13 s16 0
R16 s16 1 33e-2
VS17 1 s17 0
L17 s17 12 33e-4
VS18 18 s18 0
L18 s18 19 18e-3
VS19 5 s19 0
L19 s19 17 47e-2
VS20 24 s20 0
L20 s20 5 82e-3
VS21 23 s21 0
R21 s21 16 22e2
VS22 3 s22 0
R22 s22 0 33e-2
VS23 18 s23 0
R23 s23 0 22e-1
VS24 14 s24 0
L24 s24 2 15e-5
VS25 25 s25 0
V25 e25 s25 DC 0 AC 15e-1 180
RI25 e25 6 47e-3
VS26 4 s26 0
R26 s26 13 10e3
VS27 5 s27 0
R27 s27 19 27e0
VS28 23 s28 0
V28 e28 s28 DC 0 AC 12e-1 -120
RI28 e28 15 56e-2
VS29 11 s29 0
R29 s29 20 27e-2
VS30 19 s30 0
R30 s30 25 33e-2
VS31 15 s31 0
C31 s31 11 18e-4
VS32 23 s32 0
R32 s32 8 33e-1
VS33 22 s33 0
R33 s33 13 82e2
VS34 12 s34 0
L34 s34 8 18e-4
VS35 6 s35 0
V35 e35 s35 DC 0 AC 47e-1 0
RI35 e35 24 15e-3
VS36 19 s36 0
V36 e36 s36 DC 0 AC 39e0 -120
RI36 e36 3 18e-2
VS37 2 s37 0
R37 s37 22 22e1
VS38 14 s38 0
V38 e38 s38 DC 0 AC 82e1 0
RI38 e38 21 82e-1
VS39 25 s39 0
L39 s39 3 18e-2
VS40 13 s40 0
R40 s40 14 10e0
VS41 18 s41 0
R41 s41 7 82e-1
VS42 24 s42 0
L42 s42 13 56e-5
VS43 9 s43 0
V43 e43 s43 DC 0 AC 27e1 120
RI43 e43 17 10e-3
VS44 5 s44 0
L44 s44 20 22e-4
VS45 10 s45 0
C45 s45 23 56e-6
VS46 8 s46 0
C46 s46 12 15e-6
VS47 3 s47 0
C47 s47 7 15e-5
VS48 15 s48 0
V48 e48 s48 DC 0 AC 18e1 180
RI48 e48 17 12e-2
VS49 0 s49 0
L49 s49 24 10e-5
.control
set numdgt=17
ac lin 1 60 60
print v(1) v(2) v(3) v(4) v(5) v(6) v(7) v(8) v(9) v(10)
print v(11) v(12) v(13) v(14) v(15) v(16) v(17) v(18) v(19) v(20)
print v(21) v(22) v(23) v(24) v(25)
print i(vs0) i(vs1) i(vs2) i(vs3) i(vs4) i(vs5) i(vs6) i(vs7) i(vs8) i(vs9)
print i(vs10) i(vs11) i(vs12) i(vs13) i(vs14) i(vs15) i(vs16) i(vs17) i(vs18) i(vs19)
print i(vs20) i(vs21) i(vs22) i(vs23) i(vs24) i(vs25) i(vs26) i(vs27) i(vs28) i(vs29)
print i(vs30) i(vs31) i(vs32) i(vs33) i(vs34) i(vs35) i(vs36) i(vs37) i(vs38) i(vs39)
print i(vs40) i(vs41) i(vs42) i(vs43) i(vs44) i(vs45) i(vs46) i(vs47) i(vs48) i(vs49)
.endc
.end
