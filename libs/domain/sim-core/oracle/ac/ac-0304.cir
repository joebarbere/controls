controls oracle ac-0304
* Generated (plan F2.7, ADR 0012): do not edit; regenerate with `pnpm sim oracle regen`. ac seed 20261031 index 304 nodes 26 elements 52
.options sparse gmin=1e-12 noopac
RG1 1 0 1000000000000
RG2 2 0 1000000000000
RG3 3 0 1000000000000
RG4 4 0 1000000000000
RG5 5 0 1000000000000
RG6 6 0 1000000000000
RG7 7 0 1000000000000
RG8 8 0 1000000000000
RG9 9 0 1000000000000
RG10 10 0 1000000000000
RG11 11 0 1000000000000
RG12 12 0 1000000000000
RG13 13 0 1000000000000
RG14 14 0 1000000000000
RG15 15 0 1000000000000
RG16 16 0 1000000000000
RG17 17 0 1000000000000
RG18 18 0 1000000000000
RG19 19 0 1000000000000
RG20 20 0 1000000000000
RG21 21 0 1000000000000
RG22 22 0 1000000000000
RG23 23 0 1000000000000
RG24 24 0 1000000000000
RG25 25 0 1000000000000
VS0 0 s0 0
R0 s0 10 33e2
VS1 24 s1 0
L1 s1 5 82e-3
VS2 23 s2 0
R2 s2 16 22e2
VS3 22 s3 0
C3 s3 12 39e-4
VS4 8 s4 0
C4 s4 12 15e-6
VS5 5 s5 0
L5 s5 9 47e-2
VS6 5 s6 0
R6 s6 19 27e0
VS7 5 s7 0
L7 s7 20 22e-4
VS8 13 s8 0
C8 s8 3 47e-6
VS9 2 s9 0
R9 s9 22 22e1
VS10 0 s10 0
R10 s10 3 10e1
VS11 0 s11 0
V11 e11 s11 DC 0 AC 27e1 120
RI11 e11 n11 10e-3
H11 n11 h11 VS17 -12e-4
ED11 h11 9 d11 0 -56e-6
F11 0 d11 VS17 1
LD11 d11 0 1
VS12 2 s12 0
L12 s12 24 82e-3
VS13 22 s13 0
R13 s13 13 82e2
VS14 4 s14 0
R14 s14 13 10e3
VS15 21 s15 0
C15 s15 3 15e-7
VS16 13 s16 0
C16 s16 0 56e-7
VS17 18 s17 0
V17 e17 s17 DC 0 AC 10e-1 180
RI17 e17 n17 12e-3
H17 n17 h17 VS11 -12e-4
ED17 h17 13 d17 0 -56e-6
F17 0 d17 VS11 1
LD17 d17 0 1
VS18 12 s18 0
L18 s18 8 18e-4
VS19 18 s19 0
R19 s19 17 22e-1
VS20 17 s20 0
L20 s20 24 10e-5
VS21 3 s21 0
C21 s21 13 22e-7
VS22 3 s22 0
R22 s22 17 33e-2
VS23 10 s23 0
C23 s23 23 56e-6
VS24 25 s24 0
V24 e24 s24 DC 0 AC 15e-1 180
RI24 e24 m24 47e-3
LI24 m24 6 68e-5
VS25 14 s25 0
L25 s25 2 15e-5
VS26 14 s26 0
V26 e26 s26 DC 0 AC 82e1 0
RI26 e26 21 82e-1
VS27 3 s27 0
C27 s27 7 15e-5
VS28 14 s28 0
V28 e28 s28 DC 0 AC 10e1 180
RI28 e28 m28 47e-2
LI28 m28 16 18e-6
VS29 18 s29 0
L29 s29 19 18e-3
VS30 15 s30 0
V30 e30 s30 DC 0 AC 10e-1 0
RI30 e30 m30 18e-2
LI30 m30 12 10e-5
VS31 17 s31 0
V31 e31 s31 DC 0 AC 68e1 180
RI31 e31 m31 56e-1
LI31 m31 19 56e-7
VS32 11 s32 0
R32 s32 20 27e-2
VS33 5 s33 0
C33 s33 6 18e-6
VS34 23 s34 0
V34 e34 s34 DC 0 AC 12e-1 -120
RI34 e34 15 56e-2
VS35 6 s35 0
V35 e35 s35 DC 0 AC 47e-1 0
RI35 e35 24 15e-3
VS36 24 s36 0
L36 s36 13 56e-5
VS37 1 s37 0
L37 s37 12 33e-4
VS38 15 s38 0
V38 e38 s38 DC 0 AC 18e1 180
RI38 e38 m38 12e-2
LI38 m38 9 39e-5
VS39 18 s39 0
R39 s39 7 82e-1
VS40 15 s40 0
C40 s40 11 18e-4
VS41 13 s41 0
R41 s41 14 10e0
VS42 2 s42 0
L42 s42 1 68e-4
VS43 13 s43 0
R43 s43 1 33e-2
VS44 4 s44 0
L44 s44 17 22e-5
VS45 5 s45 0
V45 e45 s45 DC 0 AC 12e0 0
RI45 e45 11 22e-1
VS46 23 s46 0
R46 s46 8 33e-1
VS47 18 s47 0
R47 s47 15 68e0
VS48 19 s48 0
R48 s48 25 33e-2
VS49 9 s49 0
C49 s49 14 18e-4
VS50 19 s50 0
V50 e50 s50 DC 0 AC 39e0 -120
RI50 e50 m50 18e-2
LI50 m50 3 15e-6
VS51 25 s51 0
L51 s51 3 18e-2
.control
set numdgt=17
ac lin 1 60 60
print v(1) v(2) v(3) v(4) v(5) v(6) v(7) v(8) v(9) v(10)
print v(11) v(12) v(13) v(14) v(15) v(16) v(17) v(18) v(19) v(20)
print v(21) v(22) v(23) v(24) v(25)
print i(vs0) i(vs1) i(vs2) i(vs3) i(vs4) i(vs5) i(vs6) i(vs7) i(vs8) i(vs9)
print i(vs10) i(vs11) i(vs12) i(vs13) i(vs14) i(vs15) i(vs16) i(vs17) i(vs18) i(vs19)
print i(vs20) i(vs21) i(vs22) i(vs23) i(vs24) i(vs25) i(vs26) i(vs27) i(vs28) i(vs29)
print i(vs30) i(vs31) i(vs32) i(vs33) i(vs34) i(vs35) i(vs36) i(vs37) i(vs38) i(vs39)
print i(vs40) i(vs41) i(vs42) i(vs43) i(vs44) i(vs45) i(vs46) i(vs47) i(vs48) i(vs49)
print i(vs50) i(vs51)
.endc
.end
