controls oracle ac-0304
* Generated (plan F2.7, ADR 0012): do not edit; regenerate with `pnpm sim oracle regen`. ac seed 20261031 index 304 nodes 26 elements 46
.options sparse gmin=1e-12 noopac
RG1 1 0 1000000000000
RG2 2 0 1000000000000
RG3 3 0 1000000000000
RG4 4 0 1000000000000
RG5 5 0 1000000000000
RG6 6 0 1000000000000
RG7 7 0 1000000000000
RG8 8 0 1000000000000
RG9 9 0 1000000000000
RG10 10 0 1000000000000
RG11 11 0 1000000000000
RG12 12 0 1000000000000
RG13 13 0 1000000000000
RG14 14 0 1000000000000
RG15 15 0 1000000000000
RG16 16 0 1000000000000
RG17 17 0 1000000000000
RG18 18 0 1000000000000
RG19 19 0 1000000000000
RG20 20 0 1000000000000
RG21 21 0 1000000000000
RG22 22 0 1000000000000
RG23 23 0 1000000000000
RG24 24 0 1000000000000
RG25 25 0 1000000000000
VS0 20 s0 0
R0 s0 25 56e3
VS1 0 s1 0
V1 e1 s1 DC 0 AC 15e-1 180
RI1 e1 m1 47e-3
LI1 m1 24 33e-5
VS2 8 s2 0
C2 s2 16 47e-6
VS3 9 s3 0
V3 e3 s3 DC 0 AC 27e1 120
RI3 e3 8 10e-3
VS4 6 s4 0
L4 s4 10 18e-5
VS5 1 s5 0
C5 s5 15 39e-5
VS6 8 s6 0
V6 e6 s6 DC 0 AC 33e0 -120
RI6 e6 m6 82e-1
LI6 m6 15 68e-5
VS7 3 s7 0
C7 s7 12 82e-6
VS8 3 s8 0
L8 s8 17 18e-3
VS9 13 s9 0
C9 s9 14 47e-6
VS10 18 s10 0
R10 s10 8 10e1
VS11 6 s11 0
R11 s11 3 82e2
VS12 19 s12 0
C12 s12 10 15e-4
VS13 14 s13 0
R13 s13 9 18e1
VS14 10 s14 0
R14 s14 21 82e-1
VS15 17 s15 0
R15 s15 21 12e1
VS16 5 s16 0
C16 s16 12 68e-4
VS17 15 s17 0
R17 s17 7 33e-2
VS18 2 s18 0
V18 e18 s18 DC 0 AC 33e-1 120
RI18 e18 m18 33e-3
LI18 m18 8 56e-6
VS19 24 s19 0
R19 s19 17 82e-2
VS20 22 s20 0
R20 s20 15 10e-1
VS21 18 s21 0
R21 s21 20 33e2
VS22 9 s22 0
V22 e22 s22 DC 0 AC 15e1 120
RI22 e22 m22 12e-3
LI22 m22 19 39e-5
VS23 10 s23 0
C23 s23 11 82e-6
VS24 1 s24 0
L24 s24 25 22e-2
VS25 24 s25 0
L25 s25 4 27e-3
VS26 7 s26 0
C26 s26 24 18e-4
VS27 7 s27 0
C27 s27 5 39e-4
VS28 23 s28 0
L28 s28 14 15e-5
VS29 8 s29 0
L29 s29 3 18e-5
VS30 16 s30 0
C30 s30 19 18e-6
VS31 17 s31 0
C31 s31 1 39e-4
VS32 13 s32 0
L32 s32 22 82e-3
VS33 9 s33 0
L33 s33 4 82e-2
VS34 12 s34 0
C34 s34 22 15e-6
VS35 9 s35 0
R35 s35 24 15e3
VS36 5 s36 0
L36 s36 13 39e-2
VS37 7 s37 0
C37 s37 2 82e-5
VS38 9 s38 0
L38 s38 18 15e-3
VS39 8 s39 0
R39 s39 23 22e-1
VS40 5 s40 0
V40 e40 s40 DC 0 AC 56e-1 120
RI40 e40 m40 39e-3
LI40 m40 18 22e-5
VS41 18 s41 0
C41 s41 22 82e-6
VS42 10 s42 0
V42 e42 s42 DC 0 AC 12e-1 0
RI42 e42 m42 56e-1
LI42 m42 14 15e-7
VS43 13 s43 0
C43 s43 21 39e-6
VS44 17 s44 0
L44 s44 0 47e-2
VS45 8 s45 0
R45 s45 11 27e1
.control
set numdgt=17
ac lin 1 60 60
print v(1) v(2) v(3) v(4) v(5) v(6) v(7) v(8) v(9) v(10)
print v(11) v(12) v(13) v(14) v(15) v(16) v(17) v(18) v(19) v(20)
print v(21) v(22) v(23) v(24) v(25)
print i(vs0) i(vs1) i(vs2) i(vs3) i(vs4) i(vs5) i(vs6) i(vs7) i(vs8) i(vs9)
print i(vs10) i(vs11) i(vs12) i(vs13) i(vs14) i(vs15) i(vs16) i(vs17) i(vs18) i(vs19)
print i(vs20) i(vs21) i(vs22) i(vs23) i(vs24) i(vs25) i(vs26) i(vs27) i(vs28) i(vs29)
print i(vs30) i(vs31) i(vs32) i(vs33) i(vs34) i(vs35) i(vs36) i(vs37) i(vs38) i(vs39)
print i(vs40) i(vs41) i(vs42) i(vs43) i(vs44) i(vs45)
.endc
.end
