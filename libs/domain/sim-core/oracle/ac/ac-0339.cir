controls oracle ac-0339
* Generated (plan F2.7, ADR 0012): do not edit; regenerate with `pnpm sim oracle regen`. ac seed 20261031 index 339 nodes 23 elements 34
.options sparse gmin=1e-12 noopac
RG1 1 0 1000000000000
RG2 2 0 1000000000000
RG3 3 0 1000000000000
RG4 4 0 1000000000000
RG5 5 0 1000000000000
RG6 6 0 1000000000000
RG7 7 0 1000000000000
RG8 8 0 1000000000000
RG9 9 0 1000000000000
RG10 10 0 1000000000000
RG11 11 0 1000000000000
RG12 12 0 1000000000000
RG13 13 0 1000000000000
RG14 14 0 1000000000000
RG15 15 0 1000000000000
RG16 16 0 1000000000000
RG17 17 0 1000000000000
RG18 18 0 1000000000000
RG19 19 0 1000000000000
RG20 20 0 1000000000000
RG21 21 0 1000000000000
RG22 22 0 1000000000000
VS0 19 s0 0
L0 s0 6 12e-3
VS1 7 s1 0
C1 s1 16 12e-6
VS2 9 s2 0
R2 s2 14 12e-2
VS3 1 s3 0
R3 s3 9 12e-1
VS4 0 s4 0
V4 e4 s4 DC 0 AC 22e0 120
RI4 e4 13 27e-2
VS5 20 s5 0
L5 s5 21 47e-5
VS6 15 s6 0
V6 e6 s6 DC 0 AC 18e0 -120
RI6 e6 m6 12e-3
LI6 m6 11 15e-5
VS7 8 s7 0
C7 s7 12 27e-5
VS8 7 s8 0
V8 e8 s8 DC 0 AC 56e1 0
RI8 e8 m8 68e-2
LI8 m8 8 39e-7
VS9 0 s9 0
L9 s9 17 15e-3
VS10 12 s10 0
R10 s10 18 82e2
VS11 14 s11 0
V11 e11 s11 DC 0 AC 12e0 120
RI11 e11 13 47e-2
VS12 20 s12 0
C12 s12 11 47e-6
VS13 21 s13 0
C13 s13 10 68e-6
VS14 4 s14 0
V14 e14 s14 DC 0 AC 68e0 -120
RI14 e14 m14 56e-3
LI14 m14 16 12e-7
VS15 19 s15 0
L15 s15 17 10e-4
VS16 2 s16 0
L16 s16 21 22e-5
VS17 21 s17 0
L17 s17 7 82e-5
VS18 3 s18 0
R18 s18 8 18e0
VS19 18 s19 0
L19 s19 15 22e-4
VS20 1 s20 0
R20 s20 4 12e2
VS21 2 s21 0
L21 s21 22 82e-5
VS22 6 s22 0
R22 s22 8 18e3
VS23 11 s23 0
C23 s23 6 18e-5
VS24 21 s24 0
R24 s24 1 33e3
VS25 8 s25 0
L25 s25 2 22e-4
VS26 4 s26 0
C26 s26 2 10e-6
VS27 8 s27 0
R27 s27 13 47e2
VS28 9 s28 0
R28 s28 12 12e1
VS29 5 s29 0
C29 s29 10 10e-6
VS30 0 s30 0
C30 s30 22 68e-4
VS31 0 s31 0
L31 s31 18 82e-2
VS32 14 s32 0
L32 s32 3 56e-3
VS33 5 s33 0
C33 s33 4 82e-5
.control
set numdgt=17
ac lin 1 60 60
print v(1) v(2) v(3) v(4) v(5) v(6) v(7) v(8) v(9) v(10)
print v(11) v(12) v(13) v(14) v(15) v(16) v(17) v(18) v(19) v(20)
print v(21) v(22)
print i(vs0) i(vs1) i(vs2) i(vs3) i(vs4) i(vs5) i(vs6) i(vs7) i(vs8) i(vs9)
print i(vs10) i(vs11) i(vs12) i(vs13) i(vs14) i(vs15) i(vs16) i(vs17) i(vs18) i(vs19)
print i(vs20) i(vs21) i(vs22) i(vs23) i(vs24) i(vs25) i(vs26) i(vs27) i(vs28) i(vs29)
print i(vs30) i(vs31) i(vs32) i(vs33)
.endc
.end
