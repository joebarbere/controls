controls oracle ac-0339
* Generated (plan F2.7, ADR 0012): do not edit; regenerate with `pnpm sim oracle regen`. ac seed 20261031 index 339 nodes 23 elements 43
.options sparse gmin=1e-12 noopac
RG1 1 0 1000000000000
RG2 2 0 1000000000000
RG3 3 0 1000000000000
RG4 4 0 1000000000000
RG5 5 0 1000000000000
RG6 6 0 1000000000000
RG7 7 0 1000000000000
RG8 8 0 1000000000000
RG9 9 0 1000000000000
RG10 10 0 1000000000000
RG11 11 0 1000000000000
RG12 12 0 1000000000000
RG13 13 0 1000000000000
RG14 14 0 1000000000000
RG15 15 0 1000000000000
RG16 16 0 1000000000000
RG17 17 0 1000000000000
RG18 18 0 1000000000000
RG19 19 0 1000000000000
RG20 20 0 1000000000000
RG21 21 0 1000000000000
RG22 22 0 1000000000000
VS0 10 s0 0
L0 s0 4 15e-2
VS1 5 s1 0
L1 s1 6 15e-4
VS2 18 s2 0
L2 s2 20 33e-3
VS3 4 s3 0
C3 s3 2 10e-6
VS4 15 s4 0
R4 s4 21 68e-2
VS5 0 s5 0
C5 s5 12 27e-4
VS6 12 s6 0
R6 s6 22 47e-2
VS7 13 s7 0
R7 s7 11 47e2
VS8 10 s8 0
R8 s8 18 10e1
VS9 7 s9 0
R9 s9 16 39e2
VS10 15 s10 0
R10 s10 8 18e3
VS11 17 s11 0
L11 s11 5 27e-5
VS12 15 s12 0
R12 s12 3 68e-2
VS13 1 s13 0
R13 s13 15 68e-1
VS14 2 s14 0
C14 s14 18 56e-6
VS15 9 s15 0
R15 s15 6 33e2
VS16 0 s16 0
V16 e16 s16 DC 0 AC 18e0 -120
RI16 e16 11 12e-3
VS17 10 s17 0
R17 s17 15 10e-1
VS18 5 s18 0
C18 s18 6 10e-4
VS19 1 s19 0
R19 s19 21 33e-2
VS20 14 s20 0
C20 s20 4 33e-6
VS21 11 s21 0
C21 s21 15 18e-5
VS22 11 s22 0
L22 s22 18 22e-2
VS23 6 s23 0
V23 e23 s23 DC 0 AC 68e1 120
RI23 e23 22 15e-2
VS24 8 s24 0
L24 s24 2 22e-4
VS25 19 s25 0
R25 s25 21 12e1
VS26 6 s26 0
C26 s26 7 15e-7
VS27 8 s27 0
C27 s27 12 27e-5
VS28 5 s28 0
L28 s28 6 22e-3
VS29 14 s29 0
C29 s29 20 47e-6
VS30 13 s30 0
V30 e30 s30 DC 0 AC 56e0 180
RI30 e30 1 10e-1
VS31 18 s31 0
R31 s31 7 33e0
VS32 17 s32 0
V32 e32 s32 DC 0 AC 33e1 120
RI32 e32 2 82e-1
VS33 11 s33 0
R33 s33 7 18e-1
VS34 16 s34 0
V34 e34 s34 DC 0 AC 68e-1 -120
RI34 e34 18 12e-3
VS35 0 s35 0
C35 s35 22 27e-6
VS36 21 s36 0
V36 e36 s36 DC 0 AC 47e0 180
RI36 e36 22 33e-3
VS37 0 s37 0
V37 e37 s37 DC 0 AC 27e0 -120
RI37 e37 7 56e-2
VS38 3 s38 0
R38 s38 8 18e0
VS39 10 s39 0
R39 s39 12 15e3
VS40 4 s40 0
C40 s40 9 12e-6
VS41 20 s41 0
C41 s41 12 82e-5
VS42 17 s42 0
L42 s42 3 12e-3
.control
set numdgt=17
ac lin 1 60 60
print v(1) v(2) v(3) v(4) v(5) v(6) v(7) v(8) v(9) v(10)
print v(11) v(12) v(13) v(14) v(15) v(16) v(17) v(18) v(19) v(20)
print v(21) v(22)
print i(vs0) i(vs1) i(vs2) i(vs3) i(vs4) i(vs5) i(vs6) i(vs7) i(vs8) i(vs9)
print i(vs10) i(vs11) i(vs12) i(vs13) i(vs14) i(vs15) i(vs16) i(vs17) i(vs18) i(vs19)
print i(vs20) i(vs21) i(vs22) i(vs23) i(vs24) i(vs25) i(vs26) i(vs27) i(vs28) i(vs29)
print i(vs30) i(vs31) i(vs32) i(vs33) i(vs34) i(vs35) i(vs36) i(vs37) i(vs38) i(vs39)
print i(vs40) i(vs41) i(vs42)
.endc
.end
