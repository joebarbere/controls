controls oracle ac-0087
* Generated (plan F2.7, ADR 0012): do not edit; regenerate with `pnpm sim oracle regen`. ac seed 20261031 index 87 nodes 15 elements 29
.options sparse gmin=1e-12 noopac
RG1 1 0 1000000000000
RG2 2 0 1000000000000
RG3 3 0 1000000000000
RG4 4 0 1000000000000
RG5 5 0 1000000000000
RG6 6 0 1000000000000
RG7 7 0 1000000000000
RG8 8 0 1000000000000
RG9 9 0 1000000000000
RG10 10 0 1000000000000
RG11 11 0 1000000000000
RG12 12 0 1000000000000
RG13 13 0 1000000000000
RG14 14 0 1000000000000
VS0 0 s0 0
V0 e0 s0 DC 0 AC 33e0 120
RI0 e0 13 68e-2
VS1 2 s1 0
C1 s1 0 18e-5
VS2 1 s2 0
V2 e2 s2 DC 0 AC 12e0 -120
RI2 e2 0 33e-2
VS3 4 s3 0
V3 e3 s3 DC 0 AC 15e1 0
RI3 e3 14 68e-3
VS4 9 s4 0
L4 s4 4 82e-4
VS5 3 s5 0
V5 e5 s5 DC 0 AC 22e1 0
RI5 e5 10 47e-2
VS6 1 s6 0
R6 s6 8 12e2
VS7 10 s7 0
C7 s7 12 15e-7
VS8 12 s8 0
R8 s8 2 27e-1
VS9 13 s9 0
L9 s9 2 33e-4
VS10 8 s10 0
V10 e10 s10 DC 0 AC 12e0 0
RI10 e10 12 10e-1
VS11 0 s11 0
R11 s11 12 39e2
VS12 0 s12 0
V12 e12 s12 DC 0 AC 18e0 180
RI12 e12 12 22e-3
VS13 11 s13 0
L13 s13 14 68e-5
VS14 9 s14 0
L14 s14 4 56e-3
VS15 12 s15 0
L15 s15 5 82e-4
VS16 2 s16 0
R16 s16 5 68e0
VS17 3 s17 0
C17 s17 12 27e-5
VS18 2 s18 0
R18 s18 13 33e-2
VS19 13 s19 0
L19 s19 6 10e-3
VS20 7 s20 0
R20 s20 0 27e2
VS21 9 s21 0
R21 s21 12 68e3
VS22 14 s22 0
L22 s22 3 47e-5
VS23 12 s23 0
L23 s23 11 56e-5
VS24 13 s24 0
R24 s24 3 68e1
VS25 4 s25 0
L25 s25 5 15e-5
VS26 3 s26 0
C26 s26 12 82e-7
VS27 4 s27 0
C27 s27 0 18e-7
VS28 13 s28 0
C28 s28 4 56e-7
.control
set numdgt=17
ac lin 1 60 60
print v(1) v(2) v(3) v(4) v(5) v(6) v(7) v(8) v(9) v(10)
print v(11) v(12) v(13) v(14)
print i(vs0) i(vs1) i(vs2) i(vs3) i(vs4) i(vs5) i(vs6) i(vs7) i(vs8) i(vs9)
print i(vs10) i(vs11) i(vs12) i(vs13) i(vs14) i(vs15) i(vs16) i(vs17) i(vs18) i(vs19)
print i(vs20) i(vs21) i(vs22) i(vs23) i(vs24) i(vs25) i(vs26) i(vs27) i(vs28)
.endc
.end
