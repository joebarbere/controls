controls oracle ac-0087
* Generated (plan F2.7, ADR 0012): do not edit; regenerate with `pnpm sim oracle regen`. ac seed 20261031 index 87 nodes 15 elements 31
.options sparse gmin=1e-12 noopac
RG1 1 0 1000000000000
RG2 2 0 1000000000000
RG3 3 0 1000000000000
RG4 4 0 1000000000000
RG5 5 0 1000000000000
RG6 6 0 1000000000000
RG7 7 0 1000000000000
RG8 8 0 1000000000000
RG9 9 0 1000000000000
RG10 10 0 1000000000000
RG11 11 0 1000000000000
RG12 12 0 1000000000000
RG13 13 0 1000000000000
RG14 14 0 1000000000000
VS0 13 s0 0
L0 s0 6 10e-3
VS1 13 s1 0
L1 s1 5 12e-5
VS2 13 s2 0
R2 s2 11 10e2
VS3 10 s3 0
R3 s3 8 18e1
VS4 14 s4 0
R4 s4 6 68e0
VS5 9 s5 0
R5 s5 12 68e3
VS6 10 s6 0
C6 s6 12 15e-7
VS7 13 s7 0
C7 s7 4 56e-7
VS8 5 s8 0
R8 s8 0 22e1
VS9 0 s9 0
V9 e9 s9 DC 0 AC 47e1 -120
RI9 e9 4 12e-2
VS10 13 s10 0
L10 s10 0 18e-3
VS11 1 s11 0
R11 s11 8 12e2
VS12 6 s12 0
R12 s12 12 33e-1
VS13 0 s13 0
L13 s13 11 22e-5
VS14 8 s14 0
V14 e14 s14 DC 0 AC 22e0 0
RI14 e14 m14 56e-1
LI14 m14 9 12e-5
VS15 14 s15 0
L15 s15 3 47e-5
VS16 2 s16 0
R16 s16 13 33e-2
VS17 1 s17 0
V17 e17 s17 DC 0 AC 12e0 -120
RI17 e17 m17 33e-2
LI17 m17 7 10e-7
VS18 1 s18 0
R18 s18 14 68e-2
VS19 13 s19 0
R19 s19 3 68e1
VS20 0 s20 0
L20 s20 6 10e-5
VS21 3 s21 0
C21 s21 2 82e-6
VS22 11 s22 0
L22 s22 14 68e-5
VS23 8 s23 0
V23 e23 s23 DC 0 AC 12e0 0
RI23 e23 12 10e-1
VS24 7 s24 0
R24 s24 12 12e2
VS25 6 s25 0
C25 s25 4 10e-5
VS26 4 s26 0
C26 s26 7 18e-7
VS27 8 s27 0
L27 s27 4 27e-2
VS28 7 s28 0
R28 s28 12 39e2
VS29 4 s29 0
C29 s29 6 56e-5
VS30 7 s30 0
C30 s30 12 33e-6
.control
set numdgt=17
ac lin 1 60 60
print v(1) v(2) v(3) v(4) v(5) v(6) v(7) v(8) v(9) v(10)
print v(11) v(12) v(13) v(14)
print i(vs0) i(vs1) i(vs2) i(vs3) i(vs4) i(vs5) i(vs6) i(vs7) i(vs8) i(vs9)
print i(vs10) i(vs11) i(vs12) i(vs13) i(vs14) i(vs15) i(vs16) i(vs17) i(vs18) i(vs19)
print i(vs20) i(vs21) i(vs22) i(vs23) i(vs24) i(vs25) i(vs26) i(vs27) i(vs28) i(vs29)
print i(vs30)
.endc
.end
