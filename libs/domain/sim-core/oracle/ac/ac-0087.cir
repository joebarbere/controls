controls oracle ac-0087
* Generated (plan F2.7, ADR 0012): do not edit; regenerate with `pnpm sim oracle regen`. ac seed 20261031 index 87 nodes 15 elements 31
.options sparse gmin=1e-12 noopac
RG1 1 0 1000000000000
RG2 2 0 1000000000000
RG3 3 0 1000000000000
RG4 4 0 1000000000000
RG5 5 0 1000000000000
RG6 6 0 1000000000000
RG7 7 0 1000000000000
RG8 8 0 1000000000000
RG9 9 0 1000000000000
RG10 10 0 1000000000000
RG11 11 0 1000000000000
RG12 12 0 1000000000000
RG13 13 0 1000000000000
RG14 14 0 1000000000000
VS0 13 s0 0
C0 s0 4 56e-7
VS1 6 s1 0
R1 s1 11 47e3
VS2 2 s2 0
C2 s2 0 18e-5
VS3 12 s3 0
L3 s3 5 82e-4
VS4 14 s4 0
L4 s4 3 47e-5
VS5 13 s5 0
L5 s5 2 33e-4
VS6 1 s6 0
R6 s6 8 12e2
VS7 0 s7 0
V7 e7 s7 DC 0 AC 18e0 180
RI7 e7 n7 22e-3
H7 n7 h7 VS11 -10e-4
ED7 h7 12 d7 0 -18e-7
F7 0 d7 VS11 1
LD7 d7 0 1
VS8 12 s8 0
R8 s8 2 27e-1
VS9 9 s9 0
L9 s9 4 82e-4
VS10 2 s10 0
R10 s10 5 68e0
VS11 4 s11 0
V11 e11 s11 DC 0 AC 15e1 0
RI11 e11 n11 68e-3
H11 n11 h11 VS7 -10e-4
ED11 h11 14 d11 0 -18e-7
F11 0 d11 VS7 1
LD11 d11 0 1
VS12 13 s12 0
L12 s12 6 10e-3
VS13 9 s13 0
R13 s13 12 68e3
VS14 3 s14 0
C14 s14 12 27e-5
VS15 7 s15 0
R15 s15 0 27e2
VS16 4 s16 0
C16 s16 0 18e-7
VS17 9 s17 0
L17 s17 4 56e-3
VS18 1 s18 0
V18 e18 s18 DC 0 AC 12e0 -120
RI18 e18 0 33e-2
VS19 12 s19 0
L19 s19 11 56e-5
VS20 10 s20 0
C20 s20 12 15e-7
VS21 0 s21 0
V21 e21 s21 DC 0 AC 33e0 120
RI21 e21 13 68e-2
VS22 13 s22 0
R22 s22 3 68e1
VS23 8 s23 0
V23 e23 s23 DC 0 AC 12e0 0
RI23 e23 m23 10e-1
LI23 m23 12 56e-7
VS24 7 s24 0
V24 e24 s24 DC 0 AC 15e0 0
RI24 e24 12 18e-3
VS25 0 s25 0
R25 s25 12 39e2
VS26 3 s26 0
C26 s26 12 82e-7
VS27 4 s27 0
L27 s27 5 15e-5
VS28 11 s28 0
L28 s28 14 68e-5
VS29 2 s29 0
R29 s29 13 33e-2
VS30 3 s30 0
V30 e30 s30 DC 0 AC 22e1 0
RI30 e30 m30 47e-2
LI30 m30 10 39e-5
.control
set numdgt=17
ac lin 1 60 60
print v(1) v(2) v(3) v(4) v(5) v(6) v(7) v(8) v(9) v(10)
print v(11) v(12) v(13) v(14)
print i(vs0) i(vs1) i(vs2) i(vs3) i(vs4) i(vs5) i(vs6) i(vs7) i(vs8) i(vs9)
print i(vs10) i(vs11) i(vs12) i(vs13) i(vs14) i(vs15) i(vs16) i(vs17) i(vs18) i(vs19)
print i(vs20) i(vs21) i(vs22) i(vs23) i(vs24) i(vs25) i(vs26) i(vs27) i(vs28) i(vs29)
print i(vs30)
.endc
.end
