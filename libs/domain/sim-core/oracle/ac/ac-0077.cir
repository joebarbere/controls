controls oracle ac-0077
* Generated (plan F2.7, ADR 0012): do not edit; regenerate with `pnpm sim oracle regen`. ac seed 20261031 index 77 nodes 19 elements 37
.options sparse gmin=1e-12 noopac
RG1 1 0 1000000000000
RG2 2 0 1000000000000
RG3 3 0 1000000000000
RG4 4 0 1000000000000
RG5 5 0 1000000000000
RG6 6 0 1000000000000
RG7 7 0 1000000000000
RG8 8 0 1000000000000
RG9 9 0 1000000000000
RG10 10 0 1000000000000
RG11 11 0 1000000000000
RG12 12 0 1000000000000
RG13 13 0 1000000000000
RG14 14 0 1000000000000
RG15 15 0 1000000000000
RG16 16 0 1000000000000
RG17 17 0 1000000000000
RG18 18 0 1000000000000
VS0 2 s0 0
R0 s0 14 68e0
VS1 9 s1 0
C1 s1 15 22e-7
VS2 15 s2 0
R2 s2 7 10e-2
VS3 3 s3 0
R3 s3 6 27e3
VS4 5 s4 0
R4 s4 2 56e-1
VS5 3 s5 0
R5 s5 4 56e-2
VS6 11 s6 0
L6 s6 9 12e-2
VS7 5 s7 0
R7 s7 13 56e0
VS8 10 s8 0
R8 s8 3 22e2
VS9 2 s9 0
L9 s9 16 39e-3
VS10 8 s10 0
C10 s10 13 68e-6
VS11 0 s11 0
L11 s11 15 82e-4
VS12 3 s12 0
L12 s12 13 56e-3
VS13 0 s13 0
V13 e13 s13 DC 0 AC 15e1 -120
RI13 e13 m13 18e-1
LI13 m13 n13 47e-5
H13 n13 h13 VS14 -12e-3
ED13 h13 14 d13 0 27e-5
F13 0 d13 VS14 1
LD13 d13 0 1
VS14 1 s14 0
V14 e14 s14 DC 0 AC 33e-1 120
RI14 e14 m14 12e-2
LI14 m14 n14 39e-5
H14 n14 h14 VS13 -12e-3
ED14 h14 2 d14 0 27e-5
F14 0 d14 VS13 1
LD14 d14 0 1
VS15 1 s15 0
L15 s15 12 18e-2
VS16 16 s16 0
C16 s16 6 15e-6
VS17 17 s17 0
L17 s17 12 27e-4
VS18 13 s18 0
L18 s18 16 39e-3
VS19 0 s19 0
R19 s19 4 15e3
VS20 14 s20 0
V20 e20 s20 DC 0 AC 56e-1 120
RI20 e20 m20 15e-2
LI20 m20 4 47e-6
VS21 7 s21 0
R21 s21 9 39e-1
VS22 12 s22 0
C22 s22 8 18e-5
VS23 5 s23 0
R23 s23 18 82e0
VS24 8 s24 0
C24 s24 10 82e-6
VS25 1 s25 0
L25 s25 6 12e-4
VS26 9 s26 0
C26 s26 6 47e-7
VS27 16 s27 0
R27 s27 5 18e2
VS28 8 s28 0
C28 s28 18 33e-4
VS29 14 s29 0
L29 s29 7 10e-3
VS30 11 s30 0
L30 s30 10 10e-5
VS31 2 s31 0
R31 s31 11 10e2
VS32 6 s32 0
L32 s32 17 56e-3
VS33 17 s33 0
L33 s33 7 10e-5
VS34 14 s34 0
C34 s34 1 27e-4
VS35 9 s35 0
C35 s35 11 33e-4
VS36 7 s36 0
V36 e36 s36 DC 0 AC 33e1 180
RI36 e36 m36 47e-1
LI36 m36 3 56e-6
.control
set numdgt=17
ac lin 1 60 60
print v(1) v(2) v(3) v(4) v(5) v(6) v(7) v(8) v(9) v(10)
print v(11) v(12) v(13) v(14) v(15) v(16) v(17) v(18)
print i(vs0) i(vs1) i(vs2) i(vs3) i(vs4) i(vs5) i(vs6) i(vs7) i(vs8) i(vs9)
print i(vs10) i(vs11) i(vs12) i(vs13) i(vs14) i(vs15) i(vs16) i(vs17) i(vs18) i(vs19)
print i(vs20) i(vs21) i(vs22) i(vs23) i(vs24) i(vs25) i(vs26) i(vs27) i(vs28) i(vs29)
print i(vs30) i(vs31) i(vs32) i(vs33) i(vs34) i(vs35) i(vs36)
.endc
.end
