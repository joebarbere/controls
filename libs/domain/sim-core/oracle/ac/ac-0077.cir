controls oracle ac-0077
* Generated (plan F2.7, ADR 0012): do not edit; regenerate with `pnpm sim oracle regen`. ac seed 20261031 index 77 nodes 19 elements 36
.options sparse gmin=1e-12 noopac
RG1 1 0 1000000000000
RG2 2 0 1000000000000
RG3 3 0 1000000000000
RG4 4 0 1000000000000
RG5 5 0 1000000000000
RG6 6 0 1000000000000
RG7 7 0 1000000000000
RG8 8 0 1000000000000
RG9 9 0 1000000000000
RG10 10 0 1000000000000
RG11 11 0 1000000000000
RG12 12 0 1000000000000
RG13 13 0 1000000000000
RG14 14 0 1000000000000
RG15 15 0 1000000000000
RG16 16 0 1000000000000
RG17 17 0 1000000000000
RG18 18 0 1000000000000
VS0 6 s0 0
L0 s0 17 56e-3
VS1 16 s1 0
R1 s1 5 18e2
VS2 9 s2 0
C2 s2 15 22e-7
VS3 2 s3 0
R3 s3 11 10e2
VS4 0 s4 0
V4 e4 s4 DC 0 AC 15e1 -120
RI4 e4 14 18e-1
VS5 7 s5 0
R5 s5 9 39e-1
VS6 8 s6 0
C6 s6 10 82e-6
VS7 2 s7 0
L7 s7 16 39e-3
VS8 14 s8 0
L8 s8 7 10e-3
VS9 3 s9 0
R9 s9 4 56e-2
VS10 8 s10 0
C10 s10 18 33e-4
VS11 3 s11 0
R11 s11 6 27e3
VS12 9 s12 0
C12 s12 11 33e-4
VS13 5 s13 0
R13 s13 13 56e0
VS14 1 s14 0
L14 s14 12 18e-2
VS15 7 s15 0
V15 e15 s15 DC 0 AC 33e1 180
RI15 e15 3 47e-1
VS16 10 s16 0
R16 s16 3 22e2
VS17 5 s17 0
R17 s17 2 56e-1
VS18 11 s18 0
L18 s18 9 12e-2
VS19 1 s19 0
L19 s19 6 12e-4
VS20 17 s20 0
L20 s20 7 10e-5
VS21 1 s21 0
V21 e21 s21 DC 0 AC 33e-1 120
RI21 e21 2 12e-2
VS22 9 s22 0
C22 s22 6 47e-7
VS23 17 s23 0
L23 s23 12 27e-4
VS24 8 s24 0
C24 s24 13 68e-6
VS25 12 s25 0
C25 s25 8 18e-5
VS26 14 s26 0
C26 s26 1 27e-4
VS27 11 s27 0
L27 s27 10 10e-5
VS28 2 s28 0
R28 s28 14 68e0
VS29 0 s29 0
R29 s29 4 15e3
VS30 13 s30 0
L30 s30 16 39e-3
VS31 0 s31 0
L31 s31 15 82e-4
VS32 14 s32 0
V32 e32 s32 DC 0 AC 56e-1 120
RI32 e32 4 15e-2
VS33 3 s33 0
L33 s33 13 56e-3
VS34 15 s34 0
R34 s34 7 10e-2
VS35 16 s35 0
C35 s35 6 15e-6
.control
set numdgt=17
ac lin 1 60 60
print v(1) v(2) v(3) v(4) v(5) v(6) v(7) v(8) v(9) v(10)
print v(11) v(12) v(13) v(14) v(15) v(16) v(17) v(18)
print i(vs0) i(vs1) i(vs2) i(vs3) i(vs4) i(vs5) i(vs6) i(vs7) i(vs8) i(vs9)
print i(vs10) i(vs11) i(vs12) i(vs13) i(vs14) i(vs15) i(vs16) i(vs17) i(vs18) i(vs19)
print i(vs20) i(vs21) i(vs22) i(vs23) i(vs24) i(vs25) i(vs26) i(vs27) i(vs28) i(vs29)
print i(vs30) i(vs31) i(vs32) i(vs33) i(vs34) i(vs35)
.endc
.end
