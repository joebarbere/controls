controls oracle ac-0077
* Generated (plan F2.7, ADR 0012): do not edit; regenerate with `pnpm sim oracle regen`. ac seed 20261031 index 77 nodes 19 elements 28
.options sparse gmin=1e-12 noopac
RG1 1 0 1000000000000
RG2 2 0 1000000000000
RG3 3 0 1000000000000
RG4 4 0 1000000000000
RG5 5 0 1000000000000
RG6 6 0 1000000000000
RG7 7 0 1000000000000
RG8 8 0 1000000000000
RG9 9 0 1000000000000
RG10 10 0 1000000000000
RG11 11 0 1000000000000
RG12 12 0 1000000000000
RG13 13 0 1000000000000
RG14 14 0 1000000000000
RG15 15 0 1000000000000
RG16 16 0 1000000000000
RG17 17 0 1000000000000
RG18 18 0 1000000000000
VS0 0 s0 0
V0 e0 s0 DC 0 AC 22e0 120
RI0 e0 m0 82e-1
LI0 m0 3 10e-6
VS1 13 s1 0
L1 s1 5 39e-5
VS2 4 s2 0
V2 e2 s2 DC 0 AC 56e-1 120
RI2 e2 0 15e-2
VS3 0 s3 0
R3 s3 2 15e0
VS4 9 s4 0
L4 s4 2 12e-2
VS5 12 s5 0
V5 e5 s5 DC 0 AC 18e1 -120
RI5 e5 m5 56e-1
LI5 m5 3 27e-7
VS6 4 s6 0
V6 e6 s6 DC 0 AC 68e0 120
RI6 e6 7 39e-3
VS7 2 s7 0
C7 s7 16 18e-6
VS8 12 s8 0
R8 s8 11 56e1
VS9 14 s9 0
C9 s9 12 82e-6
VS10 5 s10 0
L10 s10 1 68e-5
VS11 3 s11 0
R11 s11 15 18e2
VS12 5 s12 0
V12 e12 s12 DC 0 AC 68e1 120
RI12 e12 7 18e-3
VS13 18 s13 0
R13 s13 16 82e-2
VS14 16 s14 0
R14 s14 8 27e3
VS15 13 s15 0
C15 s15 10 12e-4
VS16 5 s16 0
C16 s16 9 56e-7
VS17 0 s17 0
V17 e17 s17 DC 0 AC 47e1 180
RI17 e17 1 15e-1
VS18 14 s18 0
V18 e18 s18 DC 0 AC 12e0 180
RI18 e18 m18 10e-2
LI18 m18 7 18e-5
VS19 7 s19 0
L19 s19 4 18e-5
VS20 14 s20 0
L20 s20 10 82e-4
VS21 18 s21 0
R21 s21 17 12e1
VS22 8 s22 0
C22 s22 2 47e-7
VS23 18 s23 0
L23 s23 6 10e-5
VS24 4 s24 0
C24 s24 11 39e-5
VS25 15 s25 0
C25 s25 6 12e-7
VS26 17 s26 0
L26 s26 0 39e-3
VS27 4 s27 0
V27 e27 s27 DC 0 AC 82e-1 120
RI27 e27 6 10e-2
.control
set numdgt=17
ac lin 1 60 60
print v(1) v(2) v(3) v(4) v(5) v(6) v(7) v(8) v(9) v(10)
print v(11) v(12) v(13) v(14) v(15) v(16) v(17) v(18)
print i(vs0) i(vs1) i(vs2) i(vs3) i(vs4) i(vs5) i(vs6) i(vs7) i(vs8) i(vs9)
print i(vs10) i(vs11) i(vs12) i(vs13) i(vs14) i(vs15) i(vs16) i(vs17) i(vs18) i(vs19)
print i(vs20) i(vs21) i(vs22) i(vs23) i(vs24) i(vs25) i(vs26) i(vs27)
.endc
.end
