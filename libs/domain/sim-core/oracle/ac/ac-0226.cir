controls oracle ac-0226
* Generated (plan F2.7, ADR 0012): do not edit; regenerate with `pnpm sim oracle regen`. ac seed 20261031 index 226 nodes 6 elements 8
.options sparse gmin=1e-12 noopac
RG1 1 0 1000000000000
RG2 2 0 1000000000000
RG3 3 0 1000000000000
RG4 4 0 1000000000000
RG5 5 0 1000000000000
VS0 0 s0 0
L0 s0 3 82e-5
VS1 4 s1 0
R1 s1 3 33e-1
VS2 4 s2 0
R2 s2 1 56e-2
VS3 3 s3 0
C3 s3 5 33e-7
VS4 1 s4 0
C4 s4 5 15e-4
VS5 0 s5 0
V5 e5 s5 DC 0 AC 12e-1 120
RI5 e5 m5 82e-2
LI5 m5 1 82e-6
VS6 2 s6 0
V6 e6 s6 DC 0 AC 68e-1 120
RI6 e6 3 39e-1
VS7 5 s7 0
C7 s7 2 56e-6
.control
set numdgt=17
ac lin 1 60 60
print v(1) v(2) v(3) v(4) v(5)
print i(vs0) i(vs1) i(vs2) i(vs3) i(vs4) i(vs5) i(vs6) i(vs7)
.endc
.end
