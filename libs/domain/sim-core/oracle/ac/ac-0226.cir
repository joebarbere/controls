controls oracle ac-0226
* Generated (plan F2.7, ADR 0012): do not edit; regenerate with `pnpm sim oracle regen`. ac seed 20261031 index 226 nodes 6 elements 6
.options sparse gmin=1e-12 noopac
RG1 1 0 1000000000000
RG2 2 0 1000000000000
RG3 3 0 1000000000000
RG4 4 0 1000000000000
RG5 5 0 1000000000000
VS0 5 s0 0
L0 s0 3 82e-5
VS1 0 s1 0
L1 s1 3 12e-2
VS2 4 s2 0
R2 s2 1 56e-2
VS3 3 s3 0
C3 s3 2 33e-7
VS4 0 s4 0
V4 e4 s4 DC 0 AC 68e-1 120
RI4 e4 3 39e-1
VS5 1 s5 0
C5 s5 2 15e-4
.control
set numdgt=17
ac lin 1 60 60
print v(1) v(2) v(3) v(4) v(5)
print i(vs0) i(vs1) i(vs2) i(vs3) i(vs4) i(vs5)
.endc
.end
