controls oracle ac-0226
* Generated (plan F2.7, ADR 0012): do not edit; regenerate with `pnpm sim oracle regen`. ac seed 20261031 index 226 nodes 6 elements 9
.options sparse gmin=1e-12 noopac
RG1 1 0 1000000000000
RG2 2 0 1000000000000
RG3 3 0 1000000000000
RG4 4 0 1000000000000
RG5 5 0 1000000000000
VS0 4 s0 0
R0 s0 2 56e2
VS1 5 s1 0
L1 s1 3 82e-5
VS2 4 s2 0
R2 s2 1 56e-2
VS3 1 s3 0
R3 s3 2 39e-1
VS4 3 s4 0
C4 s4 2 33e-7
VS5 0 s5 0
C5 s5 1 33e-6
VS6 1 s6 0
C6 s6 2 15e-4
VS7 0 s7 0
V7 e7 s7 DC 0 AC 68e-1 120
RI7 e7 3 39e-1
VS8 1 s8 0
V8 e8 s8 DC 0 AC 82e0 180
RI8 e8 m8 12e-1
LI8 m8 5 68e-5
.control
set numdgt=17
ac lin 1 60 60
print v(1) v(2) v(3) v(4) v(5)
print i(vs0) i(vs1) i(vs2) i(vs3) i(vs4) i(vs5) i(vs6) i(vs7) i(vs8)
.endc
.end
