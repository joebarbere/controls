controls oracle ac-0467
* Generated (plan F2.7, ADR 0012): do not edit; regenerate with `pnpm sim oracle regen`. ac seed 20261031 index 467 nodes 16 elements 25
.options sparse gmin=1e-12 noopac
RG1 1 0 1000000000000
RG2 2 0 1000000000000
RG3 3 0 1000000000000
RG4 4 0 1000000000000
RG5 5 0 1000000000000
RG6 6 0 1000000000000
RG7 7 0 1000000000000
RG8 8 0 1000000000000
RG9 9 0 1000000000000
RG10 10 0 1000000000000
RG11 11 0 1000000000000
RG12 12 0 1000000000000
RG13 13 0 1000000000000
RG14 14 0 1000000000000
RG15 15 0 1000000000000
VS0 9 s0 0
R0 s0 8 10e-2
VS1 0 s1 0
V1 e1 s1 DC 0 AC 39e-1 120
RI1 e1 11 33e-3
VS2 5 s2 0
L2 s2 15 56e-3
VS3 11 s3 0
L3 s3 6 12e-3
VS4 10 s4 0
V4 e4 s4 DC 0 AC 10e1 180
RI4 e4 m4 12e-3
LI4 m4 0 15e-7
VS5 12 s5 0
R5 s5 1 47e-2
VS6 15 s6 0
V6 e6 s6 DC 0 AC 82e0 180
RI6 e6 m6 82e-2
LI6 m6 0 47e-7
VS7 4 s7 0
R7 s7 2 12e3
VS8 8 s8 0
C8 s8 14 82e-4
VS9 8 s9 0
C9 s9 13 56e-7
VS10 0 s10 0
V10 e10 s10 DC 0 AC 33e0 120
RI10 e10 m10 33e-1
LI10 m10 12 22e-7
VS11 15 s11 0
C11 s11 8 18e-4
VS12 2 s12 0
R12 s12 1 39e-2
VS13 9 s13 0
R13 s13 10 56e0
VS14 6 s14 0
C14 s14 15 82e-7
VS15 1 s15 0
C15 s15 0 47e-5
VS16 14 s16 0
C16 s16 1 68e-5
VS17 7 s17 0
C17 s17 4 18e-5
VS18 8 s18 0
R18 s18 7 47e3
VS19 6 s19 0
V19 e19 s19 DC 0 AC 12e-1 180
RI19 e19 m19 33e-1
LI19 m19 8 18e-7
VS20 13 s20 0
R20 s20 2 82e3
VS21 3 s21 0
C21 s21 9 18e-6
VS22 5 s22 0
R22 s22 4 12e-1
VS23 1 s23 0
L23 s23 11 33e-3
VS24 0 s24 0
L24 s24 3 82e-5
.control
set numdgt=17
ac lin 1 60 60
print v(1) v(2) v(3) v(4) v(5) v(6) v(7) v(8) v(9) v(10)
print v(11) v(12) v(13) v(14) v(15)
print i(vs0) i(vs1) i(vs2) i(vs3) i(vs4) i(vs5) i(vs6) i(vs7) i(vs8) i(vs9)
print i(vs10) i(vs11) i(vs12) i(vs13) i(vs14) i(vs15) i(vs16) i(vs17) i(vs18) i(vs19)
print i(vs20) i(vs21) i(vs22) i(vs23) i(vs24)
.endc
.end
