controls oracle ac-0158
* Generated (plan F2.7, ADR 0012): do not edit; regenerate with `pnpm sim oracle regen`. ac seed 20261031 index 158 nodes 15 elements 21
.options sparse gmin=1e-12 noopac
RG1 1 0 1000000000000
RG2 2 0 1000000000000
RG3 3 0 1000000000000
RG4 4 0 1000000000000
RG5 5 0 1000000000000
RG6 6 0 1000000000000
RG7 7 0 1000000000000
RG8 8 0 1000000000000
RG9 9 0 1000000000000
RG10 10 0 1000000000000
RG11 11 0 1000000000000
RG12 12 0 1000000000000
RG13 13 0 1000000000000
RG14 14 0 1000000000000
VS0 3 s0 0
C0 s0 4 33e-5
VS1 7 s1 0
C1 s1 2 22e-5
VS2 5 s2 0
L2 s2 10 82e-2
VS3 0 s3 0
V3 e3 s3 DC 0 AC 12e0 0
RI3 e3 12 39e-1
VS4 7 s4 0
R4 s4 9 18e1
VS5 13 s5 0
R5 s5 11 10e1
VS6 7 s6 0
V6 e6 s6 DC 0 AC 10e1 0
RI6 e6 9 18e-1
VS7 4 s7 0
V7 e7 s7 DC 0 AC 47e1 -120
RI7 e7 11 68e-2
VS8 13 s8 0
V8 e8 s8 DC 0 AC 12e-1 -120
RI8 e8 14 68e-2
VS9 12 s9 0
V9 e9 s9 DC 0 AC 47e-1 180
RI9 e9 8 82e-2
VS10 9 s10 0
C10 s10 12 82e-7
VS11 6 s11 0
V11 e11 s11 DC 0 AC 68e0 120
RI11 e11 13 15e-2
VS12 6 s12 0
V12 e12 s12 DC 0 AC 39e1 180
RI12 e12 0 12e-1
VS13 12 s13 0
R13 s13 13 27e1
VS14 7 s14 0
V14 e14 s14 DC 0 AC 10e1 0
RI14 e14 8 27e-3
VS15 8 s15 0
R15 s15 6 56e3
VS16 10 s16 0
R16 s16 11 12e2
VS17 1 s17 0
R17 s17 11 33e-1
VS18 14 s18 0
R18 s18 5 10e0
VS19 3 s19 0
L19 s19 2 33e-3
VS20 7 s20 0
R20 s20 11 33e1
.control
set numdgt=17
ac lin 1 60 60
print v(1) v(2) v(3) v(4) v(5) v(6) v(7) v(8) v(9) v(10)
print v(11) v(12) v(13) v(14)
print i(vs0) i(vs1) i(vs2) i(vs3) i(vs4) i(vs5) i(vs6) i(vs7) i(vs8) i(vs9)
print i(vs10) i(vs11) i(vs12) i(vs13) i(vs14) i(vs15) i(vs16) i(vs17) i(vs18) i(vs19)
print i(vs20)
.endc
.end
