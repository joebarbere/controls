controls oracle ac-0158
* Generated (plan F2.7, ADR 0012): do not edit; regenerate with `pnpm sim oracle regen`. ac seed 20261031 index 158 nodes 15 elements 22
.options sparse gmin=1e-12 noopac
RG1 1 0 1000000000000
RG2 2 0 1000000000000
RG3 3 0 1000000000000
RG4 4 0 1000000000000
RG5 5 0 1000000000000
RG6 6 0 1000000000000
RG7 7 0 1000000000000
RG8 8 0 1000000000000
RG9 9 0 1000000000000
RG10 10 0 1000000000000
RG11 11 0 1000000000000
RG12 12 0 1000000000000
RG13 13 0 1000000000000
RG14 14 0 1000000000000
VS0 0 s0 0
V0 e0 s0 DC 0 AC 10e1 0
RI0 e0 9 18e-1
VS1 12 s1 0
V1 e1 s1 DC 0 AC 47e-1 180
RI1 e1 m1 82e-2
LI1 m1 8 68e-7
VS2 6 s2 0
V2 e2 s2 DC 0 AC 68e0 120
RI2 e2 13 15e-2
VS3 1 s3 0
L3 s3 2 15e-5
VS4 7 s4 0
V4 e4 s4 DC 0 AC 12e0 0
RI4 e4 m4 39e-1
LI4 m4 12 82e-6
VS5 1 s5 0
R5 s5 11 33e-1
VS6 14 s6 0
R6 s6 5 10e0
VS7 13 s7 0
R7 s7 11 10e1
VS8 9 s8 0
C8 s8 12 82e-7
VS9 6 s9 0
V9 e9 s9 DC 0 AC 39e1 180
RI9 e9 m9 12e-1
LI9 m9 7 10e-7
VS10 0 s10 0
V10 e10 s10 DC 0 AC 10e1 0
RI10 e10 8 27e-3
VS11 0 s11 0
C11 s11 2 22e-5
VS12 10 s12 0
R12 s12 11 12e2
VS13 13 s13 0
V13 e13 s13 DC 0 AC 12e-1 -120
RI13 e13 m13 68e-2
LI13 m13 14 39e-5
VS14 4 s14 0
V14 e14 s14 DC 0 AC 47e1 -120
RI14 e14 m14 68e-2
LI14 m14 11 15e-6
VS15 3 s15 0
L15 s15 2 33e-3
VS16 3 s16 0
C16 s16 4 33e-5
VS17 0 s17 0
R17 s17 9 18e1
VS18 8 s18 0
R18 s18 6 56e3
VS19 12 s19 0
R19 s19 13 27e1
VS20 5 s20 0
L20 s20 10 82e-2
VS21 0 s21 0
R21 s21 11 33e1
.control
set numdgt=17
ac lin 1 60 60
print v(1) v(2) v(3) v(4) v(5) v(6) v(7) v(8) v(9) v(10)
print v(11) v(12) v(13) v(14)
print i(vs0) i(vs1) i(vs2) i(vs3) i(vs4) i(vs5) i(vs6) i(vs7) i(vs8) i(vs9)
print i(vs10) i(vs11) i(vs12) i(vs13) i(vs14) i(vs15) i(vs16) i(vs17) i(vs18) i(vs19)
print i(vs20) i(vs21)
.endc
.end
