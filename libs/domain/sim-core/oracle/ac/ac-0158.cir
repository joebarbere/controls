controls oracle ac-0158
* Generated (plan F2.7, ADR 0012): do not edit; regenerate with `pnpm sim oracle regen`. ac seed 20261031 index 158 nodes 15 elements 27
.options sparse gmin=1e-12 noopac
RG1 1 0 1000000000000
RG2 2 0 1000000000000
RG3 3 0 1000000000000
RG4 4 0 1000000000000
RG5 5 0 1000000000000
RG6 6 0 1000000000000
RG7 7 0 1000000000000
RG8 8 0 1000000000000
RG9 9 0 1000000000000
RG10 10 0 1000000000000
RG11 11 0 1000000000000
RG12 12 0 1000000000000
RG13 13 0 1000000000000
RG14 14 0 1000000000000
VS0 5 s0 0
L0 s0 10 82e-2
VS1 4 s1 0
C1 s1 2 22e-5
VS2 0 s2 0
V2 e2 s2 DC 0 AC 47e1 -120
RI2 e2 11 68e-2
VS3 12 s3 0
R3 s3 14 68e-2
VS4 6 s4 0
C4 s4 13 68e-5
VS5 1 s5 0
R5 s5 11 33e-1
VS6 11 s6 0
L6 s6 10 15e-5
VS7 10 s7 0
R7 s7 7 39e0
VS8 10 s8 0
V8 e8 s8 DC 0 AC 12e1 180
RI8 e8 m8 15e-1
LI8 m8 7 27e-6
VS9 6 s9 0
L9 s9 3 15e-3
VS10 3 s10 0
V10 e10 s10 DC 0 AC 47e1 0
RI10 e10 m10 10e-3
LI10 m10 1 15e-5
VS11 4 s11 0
V11 e11 s11 DC 0 AC 10e1 0
RI11 e11 m11 18e-1
LI11 m11 9 10e-7
VS12 3 s12 0
L12 s12 6 22e-3
VS13 12 s13 0
R13 s13 13 27e1
VS14 2 s14 0
V14 e14 s14 DC 0 AC 12e1 0
RI14 e14 14 27e-1
VS15 2 s15 0
V15 e15 s15 DC 0 AC 56e-1 0
RI15 e15 m15 47e-3
LI15 m15 7 82e-5
VS16 8 s16 0
V16 e16 s16 DC 0 AC 68e0 -120
RI16 e16 10 68e-1
VS17 3 s17 0
C17 s17 0 33e-5
VS18 0 s18 0
C18 s18 13 18e-4
VS19 1 s19 0
C19 s19 9 56e-7
VS20 3 s20 0
L20 s20 2 33e-3
VS21 8 s21 0
R21 s21 6 56e3
VS22 6 s22 0
L22 s22 5 15e-3
VS23 4 s23 0
R23 s23 11 33e1
VS24 10 s24 0
R24 s24 11 12e2
VS25 10 s25 0
V25 e25 s25 DC 0 AC 47e0 180
RI25 e25 0 15e-3
VS26 12 s26 0
R26 s26 1 82e3
.control
set numdgt=17
ac lin 1 60 60
print v(1) v(2) v(3) v(4) v(5) v(6) v(7) v(8) v(9) v(10)
print v(11) v(12) v(13) v(14)
print i(vs0) i(vs1) i(vs2) i(vs3) i(vs4) i(vs5) i(vs6) i(vs7) i(vs8) i(vs9)
print i(vs10) i(vs11) i(vs12) i(vs13) i(vs14) i(vs15) i(vs16) i(vs17) i(vs18) i(vs19)
print i(vs20) i(vs21) i(vs22) i(vs23) i(vs24) i(vs25) i(vs26)
.endc
.end
