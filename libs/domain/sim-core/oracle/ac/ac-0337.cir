controls oracle ac-0337
* Generated (plan F2.7, ADR 0012): do not edit; regenerate with `pnpm sim oracle regen`. ac seed 20261031 index 337 nodes 4 elements 7
.options sparse gmin=1e-12 noopac
RG1 1 0 1000000000000
RG2 2 0 1000000000000
RG3 3 0 1000000000000
VS0 3 s0 0
R0 s0 2 22e2
VS1 1 s1 0
L1 s1 2 12e-5
VS2 0 s2 0
V2 e2 s2 DC 0 AC 27e0 180
RI2 e2 2 12e-2
VS3 3 s3 0
R3 s3 0 68e0
VS4 1 s4 0
R4 s4 3 27e0
VS5 2 s5 0
L5 s5 1 15e-2
VS6 2 s6 0
C6 s6 0 56e-5
.control
set numdgt=17
ac lin 1 60 60
print v(1) v(2) v(3)
print i(vs0) i(vs1) i(vs2) i(vs3) i(vs4) i(vs5) i(vs6)
.endc
.end
