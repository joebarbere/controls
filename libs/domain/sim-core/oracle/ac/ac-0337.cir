controls oracle ac-0337
* Generated (plan F2.7, ADR 0012): do not edit; regenerate with `pnpm sim oracle regen`. ac seed 20261031 index 337 nodes 4 elements 5
.options sparse gmin=1e-12 noopac
RG1 1 0 1000000000000
RG2 2 0 1000000000000
RG3 3 0 1000000000000
VS0 2 s0 0
C0 s0 0 56e-5
VS1 2 s1 0
L1 s1 1 15e-2
VS2 0 s2 0
V2 e2 s2 DC 0 AC 27e0 180
RI2 e2 2 12e-2
VS3 3 s3 0
R3 s3 2 22e2
VS4 1 s4 0
L4 s4 2 12e-5
.control
set numdgt=17
ac lin 1 60 60
print v(1) v(2) v(3)
print i(vs0) i(vs1) i(vs2) i(vs3) i(vs4)
.endc
.end
