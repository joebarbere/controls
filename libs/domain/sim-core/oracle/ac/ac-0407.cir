controls oracle ac-0407
* Generated (plan F2.7, ADR 0012): do not edit; regenerate with `pnpm sim oracle regen`. ac seed 20261031 index 407 nodes 2 elements 4
.options sparse gmin=1e-12 noopac
RG1 1 0 1000000000000
VS0 1 s0 0
R0 s0 0 12e3
VS1 0 s1 0
R1 s1 1 56e-1
VS2 0 s2 0
L2 s2 1 22e-2
VS3 0 s3 0
V3 e3 s3 DC 0 AC 10e-1 0
RI3 e3 1 82e-1
.control
set numdgt=17
ac lin 1 60 60
print v(1)
print i(vs0) i(vs1) i(vs2) i(vs3)
.endc
.end
