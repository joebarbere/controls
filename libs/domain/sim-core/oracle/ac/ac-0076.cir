controls oracle ac-0076
* Generated (plan F2.7, ADR 0012): do not edit; regenerate with `pnpm sim oracle regen`. ac seed 20261031 index 76 nodes 27 elements 40
.options sparse gmin=1e-12 noopac
RG1 1 0 1000000000000
RG2 2 0 1000000000000
RG3 3 0 1000000000000
RG4 4 0 1000000000000
RG5 5 0 1000000000000
RG6 6 0 1000000000000
RG7 7 0 1000000000000
RG8 8 0 1000000000000
RG9 9 0 1000000000000
RG10 10 0 1000000000000
RG11 11 0 1000000000000
RG12 12 0 1000000000000
RG13 13 0 1000000000000
RG14 14 0 1000000000000
RG15 15 0 1000000000000
RG16 16 0 1000000000000
RG17 17 0 1000000000000
RG18 18 0 1000000000000
RG19 19 0 1000000000000
RG20 20 0 1000000000000
RG21 21 0 1000000000000
RG22 22 0 1000000000000
RG23 23 0 1000000000000
RG24 24 0 1000000000000
RG25 25 0 1000000000000
RG26 26 0 1000000000000
VS0 20 s0 0
L0 s0 25 27e-3
VS1 0 s1 0
V1 e1 s1 DC 0 AC 27e1 120
RI1 e1 n1 27e-3
H1 n1 h1 VS4 -47e-4
ED1 h1 1 d1 0 -18e-7
F1 0 d1 VS4 1
LD1 d1 0 1
VS2 21 s2 0
R2 s2 13 39e3
VS3 1 s3 0
C3 s3 24 82e-7
VS4 23 s4 0
V4 e4 s4 DC 0 AC 82e-1 120
RI4 e4 m4 33e-2
LI4 m4 n4 12e-5
H4 n4 h4 VS1 -47e-4
ED4 h4 4 d4 0 -18e-7
F4 0 d4 VS1 1
LD4 d4 0 1
VS5 6 s5 0
V5 e5 s5 DC 0 AC 56e0 -120
RI5 e5 m5 22e-2
LI5 m5 24 15e-7
VS6 7 s6 0
R6 s6 14 33e1
VS7 22 s7 0
R7 s7 18 39e2
VS8 19 s8 0
C8 s8 14 47e-4
VS9 17 s9 0
R9 s9 4 82e3
VS10 13 s10 0
V10 e10 s10 DC 0 AC 15e-1 0
RI10 e10 m10 18e-3
LI10 m10 11 39e-7
VS11 21 s11 0
L11 s11 15 33e-5
VS12 3 s12 0
L12 s12 24 56e-3
VS13 4 s13 0
V13 e13 s13 DC 0 AC 12e0 180
RI13 e13 19 18e-3
VS14 8 s14 0
L14 s14 4 22e-5
VS15 5 s15 0
L15 s15 15 18e-2
VS16 1 s16 0
R16 s16 5 33e3
VS17 25 s17 0
L17 s17 0 27e-3
VS18 15 s18 0
V18 e18 s18 DC 0 AC 56e1 0
RI18 e18 m18 82e-1
LI18 m18 7 56e-5
VS19 16 s19 0
C19 s19 1 68e-4
VS20 22 s20 0
V20 e20 s20 DC 0 AC 10e-1 0
RI20 e20 m20 18e-2
LI20 m20 23 47e-6
VS21 23 s21 0
R21 s21 24 39e0
VS22 21 s22 0
C22 s22 12 56e-4
VS23 22 s23 0
R23 s23 11 33e2
VS24 8 s24 0
C24 s24 16 27e-7
VS25 9 s25 0
C25 s25 16 10e-6
VS26 24 s26 0
R26 s26 14 68e2
VS27 5 s27 0
L27 s27 17 47e-3
VS28 10 s28 0
C28 s28 23 12e-4
VS29 17 s29 0
L29 s29 16 10e-2
VS30 10 s30 0
L30 s30 16 33e-2
VS31 26 s31 0
R31 s31 2 18e0
VS32 26 s32 0
V32 e32 s32 DC 0 AC 27e0 180
RI32 e32 19 15e-2
VS33 3 s33 0
V33 e33 s33 DC 0 AC 18e-1 0
RI33 e33 5 56e-2
VS34 12 s34 0
V34 e34 s34 DC 0 AC 15e1 180
RI34 e34 m34 12e-1
LI34 m34 2 10e-7
VS35 23 s35 0
C35 s35 15 56e-5
VS36 22 s36 0
V36 e36 s36 DC 0 AC 12e1 -120
RI36 e36 m36 68e-3
LI36 m36 20 39e-6
VS37 18 s37 0
C37 s37 6 12e-6
VS38 9 s38 0
V38 e38 s38 DC 0 AC 12e1 120
RI38 e38 m38 27e-2
LI38 m38 20 39e-7
VS39 26 s39 0
V39 e39 s39 DC 0 AC 15e1 120
RI39 e39 21 18e-1
.control
set numdgt=17
ac lin 1 60 60
print v(1) v(2) v(3) v(4) v(5) v(6) v(7) v(8) v(9) v(10)
print v(11) v(12) v(13) v(14) v(15) v(16) v(17) v(18) v(19) v(20)
print v(21) v(22) v(23) v(24) v(25) v(26)
print i(vs0) i(vs1) i(vs2) i(vs3) i(vs4) i(vs5) i(vs6) i(vs7) i(vs8) i(vs9)
print i(vs10) i(vs11) i(vs12) i(vs13) i(vs14) i(vs15) i(vs16) i(vs17) i(vs18) i(vs19)
print i(vs20) i(vs21) i(vs22) i(vs23) i(vs24) i(vs25) i(vs26) i(vs27) i(vs28) i(vs29)
print i(vs30) i(vs31) i(vs32) i(vs33) i(vs34) i(vs35) i(vs36) i(vs37) i(vs38) i(vs39)
.endc
.end
