controls oracle ac-0076
* Generated (plan F2.7, ADR 0012): do not edit; regenerate with `pnpm sim oracle regen`. ac seed 20261031 index 76 nodes 27 elements 32
.options sparse gmin=1e-12 noopac
RG1 1 0 1000000000000
RG2 2 0 1000000000000
RG3 3 0 1000000000000
RG4 4 0 1000000000000
RG5 5 0 1000000000000
RG6 6 0 1000000000000
RG7 7 0 1000000000000
RG8 8 0 1000000000000
RG9 9 0 1000000000000
RG10 10 0 1000000000000
RG11 11 0 1000000000000
RG12 12 0 1000000000000
RG13 13 0 1000000000000
RG14 14 0 1000000000000
RG15 15 0 1000000000000
RG16 16 0 1000000000000
RG17 17 0 1000000000000
RG18 18 0 1000000000000
RG19 19 0 1000000000000
RG20 20 0 1000000000000
RG21 21 0 1000000000000
RG22 22 0 1000000000000
RG23 23 0 1000000000000
RG24 24 0 1000000000000
RG25 25 0 1000000000000
RG26 26 0 1000000000000
VS0 20 s0 0
L0 s0 25 27e-3
VS1 17 s1 0
R1 s1 4 82e3
VS2 0 s2 0
V2 e2 s2 DC 0 AC 56e1 0
RI2 e2 7 82e-1
VS3 22 s3 0
R3 s3 18 39e2
VS4 3 s4 0
L4 s4 24 56e-3
VS5 21 s5 0
R5 s5 13 39e3
VS6 23 s6 0
C6 s6 0 56e-5
VS7 9 s7 0
C7 s7 16 10e-6
VS8 26 s8 0
R8 s8 2 18e0
VS9 17 s9 0
L9 s9 16 10e-2
VS10 4 s10 0
V10 e10 s10 DC 0 AC 12e0 180
RI10 e10 19 18e-3
VS11 8 s11 0
C11 s11 16 27e-7
VS12 5 s12 0
V12 e12 s12 DC 0 AC 27e1 120
RI12 e12 1 27e-3
VS13 1 s13 0
C13 s13 24 82e-7
VS14 26 s14 0
V14 e14 s14 DC 0 AC 27e0 180
RI14 e14 19 15e-2
VS15 21 s15 0
L15 s15 0 33e-5
VS16 22 s16 0
V16 e16 s16 DC 0 AC 10e-1 0
RI16 e16 23 18e-2
VS17 18 s17 0
C17 s17 6 12e-6
VS18 15 s18 0
L18 s18 17 47e-3
VS19 25 s19 0
L19 s19 5 27e-3
VS20 6 s20 0
V20 e20 s20 DC 0 AC 56e0 -120
RI20 e20 24 22e-2
VS21 1 s21 0
R21 s21 15 33e3
VS22 10 s22 0
C22 s22 23 12e-4
VS23 23 s23 0
R23 s23 24 39e0
VS24 19 s24 0
C24 s24 14 47e-4
VS25 21 s25 0
C25 s25 12 56e-4
VS26 13 s26 0
V26 e26 s26 DC 0 AC 15e-1 0
RI26 e26 11 18e-3
VS27 23 s27 0
V27 e27 s27 DC 0 AC 82e-1 120
RI27 e27 4 33e-2
VS28 26 s28 0
V28 e28 s28 DC 0 AC 15e1 120
RI28 e28 21 18e-1
VS29 22 s29 0
V29 e29 s29 DC 0 AC 12e1 -120
RI29 e29 20 68e-3
VS30 16 s30 0
C30 s30 1 68e-4
VS31 15 s31 0
L31 s31 0 18e-2
.control
set numdgt=17
ac lin 1 60 60
print v(1) v(2) v(3) v(4) v(5) v(6) v(7) v(8) v(9) v(10)
print v(11) v(12) v(13) v(14) v(15) v(16) v(17) v(18) v(19) v(20)
print v(21) v(22) v(23) v(24) v(25) v(26)
print i(vs0) i(vs1) i(vs2) i(vs3) i(vs4) i(vs5) i(vs6) i(vs7) i(vs8) i(vs9)
print i(vs10) i(vs11) i(vs12) i(vs13) i(vs14) i(vs15) i(vs16) i(vs17) i(vs18) i(vs19)
print i(vs20) i(vs21) i(vs22) i(vs23) i(vs24) i(vs25) i(vs26) i(vs27) i(vs28) i(vs29)
print i(vs30) i(vs31)
.endc
.end
