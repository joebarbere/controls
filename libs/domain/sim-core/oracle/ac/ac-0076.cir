controls oracle ac-0076
* Generated (plan F2.7, ADR 0012): do not edit; regenerate with `pnpm sim oracle regen`. ac seed 20261031 index 76 nodes 27 elements 51
.options sparse gmin=1e-12 noopac
RG1 1 0 1000000000000
RG2 2 0 1000000000000
RG3 3 0 1000000000000
RG4 4 0 1000000000000
RG5 5 0 1000000000000
RG6 6 0 1000000000000
RG7 7 0 1000000000000
RG8 8 0 1000000000000
RG9 9 0 1000000000000
RG10 10 0 1000000000000
RG11 11 0 1000000000000
RG12 12 0 1000000000000
RG13 13 0 1000000000000
RG14 14 0 1000000000000
RG15 15 0 1000000000000
RG16 16 0 1000000000000
RG17 17 0 1000000000000
RG18 18 0 1000000000000
RG19 19 0 1000000000000
RG20 20 0 1000000000000
RG21 21 0 1000000000000
RG22 22 0 1000000000000
RG23 23 0 1000000000000
RG24 24 0 1000000000000
RG25 25 0 1000000000000
RG26 26 0 1000000000000
VS0 12 s0 0
R0 s0 23 18e1
VS1 7 s1 0
C1 s1 11 33e-7
VS2 0 s2 0
V2 e2 s2 DC 0 AC 68e1 120
RI2 e2 m2 15e-2
LI2 m2 10 15e-5
VS3 0 s3 0
R3 s3 13 12e3
VS4 23 s4 0
C4 s4 17 68e-6
VS5 18 s5 0
L5 s5 26 27e-5
VS6 15 s6 0
L6 s6 0 18e-2
VS7 4 s7 0
R7 s7 15 39e2
VS8 22 s8 0
V8 e8 s8 DC 0 AC 15e-1 120
RI8 e8 m8 27e-3
LI8 m8 0 47e-6
VS9 0 s9 0
R9 s9 2 12e2
VS10 14 s10 0
V10 e10 s10 DC 0 AC 39e1 -120
RI10 e10 12 12e-1
VS11 2 s11 0
L11 s11 9 15e-4
VS12 3 s12 0
L12 s12 6 68e-4
VS13 3 s13 0
L13 s13 8 39e-4
VS14 5 s14 0
L14 s14 25 10e-4
VS15 11 s15 0
V15 e15 s15 DC 0 AC 82e0 120
RI15 e15 m15 39e-3
LI15 m15 16 10e-6
VS16 8 s16 0
V16 e16 s16 DC 0 AC 12e-1 -120
RI16 e16 18 82e-2
VS17 0 s17 0
V17 e17 s17 DC 0 AC 12e-1 0
RI17 e17 9 15e-2
VS18 18 s18 0
L18 s18 7 22e-4
VS19 17 s19 0
R19 s19 19 18e2
VS20 17 s20 0
R20 s20 1 82e3
VS21 24 s21 0
L21 s21 6 82e-2
VS22 16 s22 0
R22 s22 7 12e1
VS23 14 s23 0
C23 s23 20 12e-5
VS24 23 s24 0
V24 e24 s24 DC 0 AC 82e-1 120
RI24 e24 4 33e-2
VS25 11 s25 0
C25 s25 7 15e-6
VS26 7 s26 0
V26 e26 s26 DC 0 AC 47e0 -120
RI26 e26 m26 27e-1
LI26 m26 23 27e-7
VS27 6 s27 0
R27 s27 3 33e-1
VS28 15 s28 0
V28 e28 s28 DC 0 AC 33e1 -120
RI28 e28 m28 82e-3
LI28 m28 13 27e-7
VS29 2 s29 0
L29 s29 15 12e-3
VS30 20 s30 0
R30 s30 21 27e3
VS31 26 s31 0
V31 e31 s31 DC 0 AC 22e-1 0
RI31 e31 5 39e-2
VS32 4 s32 0
C32 s32 3 68e-4
VS33 1 s33 0
L33 s33 15 33e-4
VS34 0 s34 0
R34 s34 6 12e-1
VS35 4 s35 0
C35 s35 18 12e-6
VS36 10 s36 0
L36 s36 3 33e-4
VS37 15 s37 0
R37 s37 9 12e-2
VS38 24 s38 0
C38 s38 23 47e-4
VS39 22 s39 0
R39 s39 7 68e3
VS40 16 s40 0
R40 s40 25 10e-1
VS41 1 s41 0
V41 e41 s41 DC 0 AC 15e1 180
RI41 e41 m41 33e-1
LI41 m41 19 39e-6
VS42 18 s42 0
C42 s42 6 27e-4
VS43 5 s43 0
L43 s43 24 10e-5
VS44 0 s44 0
L44 s44 21 10e-4
VS45 23 s45 0
C45 s45 0 56e-5
VS46 14 s46 0
R46 s46 1 39e0
VS47 2 s47 0
C47 s47 13 12e-6
VS48 16 s48 0
C48 s48 9 10e-5
VS49 0 s49 0
L49 s49 6 15e-4
VS50 9 s50 0
R50 s50 4 22e3
.control
set numdgt=17
ac lin 1 60 60
print v(1) v(2) v(3) v(4) v(5) v(6) v(7) v(8) v(9) v(10)
print v(11) v(12) v(13) v(14) v(15) v(16) v(17) v(18) v(19) v(20)
print v(21) v(22) v(23) v(24) v(25) v(26)
print i(vs0) i(vs1) i(vs2) i(vs3) i(vs4) i(vs5) i(vs6) i(vs7) i(vs8) i(vs9)
print i(vs10) i(vs11) i(vs12) i(vs13) i(vs14) i(vs15) i(vs16) i(vs17) i(vs18) i(vs19)
print i(vs20) i(vs21) i(vs22) i(vs23) i(vs24) i(vs25) i(vs26) i(vs27) i(vs28) i(vs29)
print i(vs30) i(vs31) i(vs32) i(vs33) i(vs34) i(vs35) i(vs36) i(vs37) i(vs38) i(vs39)
print i(vs40) i(vs41) i(vs42) i(vs43) i(vs44) i(vs45) i(vs46) i(vs47) i(vs48) i(vs49)
print i(vs50)
.endc
.end
