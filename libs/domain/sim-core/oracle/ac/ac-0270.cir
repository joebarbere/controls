controls oracle ac-0270
* Generated (plan F2.7, ADR 0012): do not edit; regenerate with `pnpm sim oracle regen`. ac seed 20261031 index 270 nodes 7 elements 10
.options sparse gmin=1e-12 noopac
RG1 1 0 1000000000000
RG2 2 0 1000000000000
RG3 3 0 1000000000000
RG4 4 0 1000000000000
RG5 5 0 1000000000000
RG6 6 0 1000000000000
VS0 3 s0 0
L0 s0 2 68e-5
VS1 1 s1 0
C1 s1 3 39e-5
VS2 0 s2 0
R2 s2 5 15e-2
VS3 5 s3 0
L3 s3 2 22e-5
VS4 6 s4 0
C4 s4 1 33e-5
VS5 1 s5 0
L5 s5 4 12e-4
VS6 4 s6 0
L6 s6 6 56e-4
VS7 0 s7 0
V7 e7 s7 DC 0 AC 10e0 -120
RI7 e7 2 56e-1
VS8 3 s8 0
R8 s8 2 47e2
VS9 3 s9 0
R9 s9 0 12e-1
.control
set numdgt=17
ac lin 1 60 60
print v(1) v(2) v(3) v(4) v(5) v(6)
print i(vs0) i(vs1) i(vs2) i(vs3) i(vs4) i(vs5) i(vs6) i(vs7) i(vs8) i(vs9)
.endc
.end
