controls oracle ac-0208
* Generated (plan F2.7, ADR 0012): do not edit; regenerate with `pnpm sim oracle regen`. ac seed 20261031 index 208 nodes 27 elements 38
.options sparse gmin=1e-12 noopac
RG1 1 0 1000000000000
RG2 2 0 1000000000000
RG3 3 0 1000000000000
RG4 4 0 1000000000000
RG5 5 0 1000000000000
RG6 6 0 1000000000000
RG7 7 0 1000000000000
RG8 8 0 1000000000000
RG9 9 0 1000000000000
RG10 10 0 1000000000000
RG11 11 0 1000000000000
RG12 12 0 1000000000000
RG13 13 0 1000000000000
RG14 14 0 1000000000000
RG15 15 0 1000000000000
RG16 16 0 1000000000000
RG17 17 0 1000000000000
RG18 18 0 1000000000000
RG19 19 0 1000000000000
RG20 20 0 1000000000000
RG21 21 0 1000000000000
RG22 22 0 1000000000000
RG23 23 0 1000000000000
RG24 24 0 1000000000000
RG25 25 0 1000000000000
RG26 26 0 1000000000000
VS0 1 s0 0
L0 s0 16 33e-3
VS1 17 s1 0
R1 s1 24 18e1
VS2 6 s2 0
C2 s2 18 39e-6
VS3 0 s3 0
V3 e3 s3 DC 0 AC 68e0 -120
RI3 e3 12 27e-1
VS4 6 s4 0
R4 s4 8 10e3
VS5 14 s5 0
R5 s5 22 10e0
VS6 8 s6 0
R6 s6 10 18e3
VS7 4 s7 0
R7 s7 11 18e-2
VS8 3 s8 0
L8 s8 20 39e-5
VS9 5 s9 0
V9 e9 s9 DC 0 AC 22e0 120
RI9 e9 m9 39e-3
LI9 m9 25 47e-7
VS10 20 s10 0
C10 s10 10 56e-4
VS11 7 s11 0
V11 e11 s11 DC 0 AC 39e0 -120
RI11 e11 m11 47e-2
LI11 m11 11 33e-6
VS12 20 s12 0
V12 e12 s12 DC 0 AC 22e1 120
RI12 e12 m12 56e-2
LI12 m12 15 22e-5
VS13 18 s13 0
L13 s13 2 10e-5
VS14 7 s14 0
L14 s14 22 47e-5
VS15 14 s15 0
C15 s15 26 56e-7
VS16 13 s16 0
C16 s16 16 68e-5
VS17 12 s17 0
V17 e17 s17 DC 0 AC 82e1 120
RI17 e17 m17 39e-1
LI17 m17 3 82e-7
VS18 14 s18 0
R18 s18 11 10e3
VS19 16 s19 0
C19 s19 12 47e-6
VS20 11 s20 0
R20 s20 2 12e-2
VS21 13 s21 0
L21 s21 23 12e-5
VS22 6 s22 0
R22 s22 24 82e-1
VS23 23 s23 0
C23 s23 19 15e-4
VS24 5 s24 0
V24 e24 s24 DC 0 AC 33e1 0
RI24 e24 16 82e-2
VS25 7 s25 0
R25 s25 10 56e1
VS26 25 s26 0
L26 s26 18 82e-2
VS27 0 s27 0
V27 e27 s27 DC 0 AC 12e-1 120
RI27 e27 m27 22e-2
LI27 m27 9 18e-6
VS28 17 s28 0
C28 s28 11 27e-6
VS29 25 s29 0
C29 s29 21 68e-7
VS30 19 s30 0
L30 s30 17 22e-2
VS31 13 s31 0
L31 s31 17 18e-2
VS32 21 s32 0
C32 s32 15 68e-7
VS33 26 s33 0
R33 s33 17 10e3
VS34 6 s34 0
L34 s34 9 68e-3
VS35 22 s35 0
R35 s35 1 27e2
VS36 20 s36 0
V36 e36 s36 DC 0 AC 47e1 180
RI36 e36 4 39e-2
VS37 18 s37 0
L37 s37 23 82e-4
.control
set numdgt=17
ac lin 1 60 60
print v(1) v(2) v(3) v(4) v(5) v(6) v(7) v(8) v(9) v(10)
print v(11) v(12) v(13) v(14) v(15) v(16) v(17) v(18) v(19) v(20)
print v(21) v(22) v(23) v(24) v(25) v(26)
print i(vs0) i(vs1) i(vs2) i(vs3) i(vs4) i(vs5) i(vs6) i(vs7) i(vs8) i(vs9)
print i(vs10) i(vs11) i(vs12) i(vs13) i(vs14) i(vs15) i(vs16) i(vs17) i(vs18) i(vs19)
print i(vs20) i(vs21) i(vs22) i(vs23) i(vs24) i(vs25) i(vs26) i(vs27) i(vs28) i(vs29)
print i(vs30) i(vs31) i(vs32) i(vs33) i(vs34) i(vs35) i(vs36) i(vs37)
.endc
.end
