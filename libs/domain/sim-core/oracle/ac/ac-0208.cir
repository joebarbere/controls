controls oracle ac-0208
* Generated (plan F2.7, ADR 0012): do not edit; regenerate with `pnpm sim oracle regen`. ac seed 20261031 index 208 nodes 27 elements 41
.options sparse gmin=1e-12 noopac
RG1 1 0 1000000000000
RG2 2 0 1000000000000
RG3 3 0 1000000000000
RG4 4 0 1000000000000
RG5 5 0 1000000000000
RG6 6 0 1000000000000
RG7 7 0 1000000000000
RG8 8 0 1000000000000
RG9 9 0 1000000000000
RG10 10 0 1000000000000
RG11 11 0 1000000000000
RG12 12 0 1000000000000
RG13 13 0 1000000000000
RG14 14 0 1000000000000
RG15 15 0 1000000000000
RG16 16 0 1000000000000
RG17 17 0 1000000000000
RG18 18 0 1000000000000
RG19 19 0 1000000000000
RG20 20 0 1000000000000
RG21 21 0 1000000000000
RG22 22 0 1000000000000
RG23 23 0 1000000000000
RG24 24 0 1000000000000
RG25 25 0 1000000000000
RG26 26 0 1000000000000
VS0 26 s0 0
C0 s0 19 47e-4
VS1 25 s1 0
R1 s1 5 18e-2
VS2 2 s2 0
R2 s2 5 18e0
VS3 2 s3 0
L3 s3 12 10e-5
VS4 17 s4 0
C4 s4 11 27e-6
VS5 13 s5 0
C5 s5 1 68e-5
VS6 17 s6 0
R6 s6 8 82e-2
VS7 0 s7 0
V7 e7 s7 DC 0 AC 39e0 120
RI7 e7 21 47e-2
VS8 15 s8 0
R8 s8 21 33e-2
VS9 1 s9 0
C9 s9 12 47e-6
VS10 18 s10 0
L10 s10 23 82e-4
VS11 21 s11 0
L11 s11 20 82e-5
VS12 20 s12 0
L12 s12 16 12e-2
VS13 7 s13 0
L13 s13 4 68e-5
VS14 7 s14 0
V14 e14 s14 DC 0 AC 39e0 -120
RI14 e14 m14 47e-2
LI14 m14 11 15e-5
VS15 4 s15 0
R15 s15 1 27e1
VS16 21 s16 0
R16 s16 10 18e1
VS17 0 s17 0
L17 s17 1 33e-3
VS18 13 s18 0
L18 s18 23 12e-5
VS19 24 s19 0
R19 s19 16 39e-2
VS20 3 s20 0
R20 s20 24 68e3
VS21 11 s21 0
V21 e21 s21 DC 0 AC 22e1 120
RI21 e21 m21 39e-3
LI21 m21 19 18e-6
VS22 23 s22 0
V22 e22 s22 DC 0 AC 39e-1 180
RI22 e22 m22 33e-1
LI22 m22 22 39e-5
VS23 14 s23 0
R23 s23 11 10e3
VS24 9 s24 0
R24 s24 14 39e3
VS25 18 s25 0
L25 s25 2 10e-5
VS26 13 s26 0
L26 s26 17 18e-2
VS27 19 s27 0
V27 e27 s27 DC 0 AC 56e0 0
RI27 e27 14 22e-2
VS28 18 s28 0
C28 s28 16 56e-6
VS29 22 s29 0
R29 s29 9 56e2
VS30 23 s30 0
V30 e30 s30 DC 0 AC 15e0 -120
RI30 e30 26 10e-3
VS31 25 s31 0
L31 s31 18 82e-2
VS32 10 s32 0
V32 e32 s32 DC 0 AC 27e1 120
RI32 e32 m32 68e-1
LI32 m32 11 18e-6
VS33 8 s33 0
V33 e33 s33 DC 0 AC 12e-1 180
RI33 e33 2 10e-2
VS34 26 s34 0
R34 s34 3 18e2
VS35 6 s35 0
C35 s35 18 39e-6
VS36 22 s36 0
R36 s36 20 10e2
VS37 20 s37 0
L37 s37 14 39e-3
VS38 12 s38 0
R38 s38 6 10e-2
VS39 24 s39 0
V39 e39 s39 DC 0 AC 56e1 120
RI39 e39 2 56e-3
VS40 4 s40 0
V40 e40 s40 DC 0 AC 68e1 120
RI40 e40 15 10e-3
.control
set numdgt=17
ac lin 1 60 60
print v(1) v(2) v(3) v(4) v(5) v(6) v(7) v(8) v(9) v(10)
print v(11) v(12) v(13) v(14) v(15) v(16) v(17) v(18) v(19) v(20)
print v(21) v(22) v(23) v(24) v(25) v(26)
print i(vs0) i(vs1) i(vs2) i(vs3) i(vs4) i(vs5) i(vs6) i(vs7) i(vs8) i(vs9)
print i(vs10) i(vs11) i(vs12) i(vs13) i(vs14) i(vs15) i(vs16) i(vs17) i(vs18) i(vs19)
print i(vs20) i(vs21) i(vs22) i(vs23) i(vs24) i(vs25) i(vs26) i(vs27) i(vs28) i(vs29)
print i(vs30) i(vs31) i(vs32) i(vs33) i(vs34) i(vs35) i(vs36) i(vs37) i(vs38) i(vs39)
print i(vs40)
.endc
.end
