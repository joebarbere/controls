controls oracle ac-0208
* Generated (plan F2.7, ADR 0012): do not edit; regenerate with `pnpm sim oracle regen`. ac seed 20261031 index 208 nodes 27 elements 27
.options sparse gmin=1e-12 noopac
RG1 1 0 1000000000000
RG2 2 0 1000000000000
RG3 3 0 1000000000000
RG4 4 0 1000000000000
RG5 5 0 1000000000000
RG6 6 0 1000000000000
RG7 7 0 1000000000000
RG8 8 0 1000000000000
RG9 9 0 1000000000000
RG10 10 0 1000000000000
RG11 11 0 1000000000000
RG12 12 0 1000000000000
RG13 13 0 1000000000000
RG14 14 0 1000000000000
RG15 15 0 1000000000000
RG16 16 0 1000000000000
RG17 17 0 1000000000000
RG18 18 0 1000000000000
RG19 19 0 1000000000000
RG20 20 0 1000000000000
RG21 21 0 1000000000000
RG22 22 0 1000000000000
RG23 23 0 1000000000000
RG24 24 0 1000000000000
RG25 25 0 1000000000000
RG26 26 0 1000000000000
VS0 6 s0 0
L0 s0 9 68e-3
VS1 16 s1 0
C1 s1 12 47e-6
VS2 18 s2 0
L2 s2 23 82e-4
VS3 25 s3 0
C3 s3 21 68e-7
VS4 1 s4 0
L4 s4 16 33e-3
VS5 7 s5 0
R5 s5 10 56e1
VS6 6 s6 0
C6 s6 18 39e-6
VS7 8 s7 0
R7 s7 10 18e3
VS8 3 s8 0
L8 s8 20 39e-5
VS9 14 s9 0
C9 s9 26 56e-7
VS10 0 s10 0
V10 e10 s10 DC 0 AC 12e-1 120
RI10 e10 9 22e-2
VS11 13 s11 0
L11 s11 23 12e-5
VS12 13 s12 0
C12 s12 16 68e-5
VS13 25 s13 0
L13 s13 18 82e-2
VS14 7 s14 0
L14 s14 22 47e-5
VS15 11 s15 0
L15 s15 7 68e-4
VS16 18 s16 0
L16 s16 2 10e-5
VS17 13 s17 0
L17 s17 17 18e-2
VS18 17 s18 0
C18 s18 11 27e-6
VS19 5 s19 0
V19 e19 s19 DC 0 AC 22e0 120
RI19 e19 25 39e-3
VS20 14 s20 0
R20 s20 11 10e3
VS21 6 s21 0
R21 s21 24 82e-1
VS22 23 s22 0
C22 s22 19 15e-4
VS23 4 s23 0
R23 s23 11 18e-2
VS24 7 s24 0
V24 e24 s24 DC 0 AC 39e0 -120
RI24 e24 11 47e-2
VS25 12 s25 0
V25 e25 s25 DC 0 AC 82e1 120
RI25 e25 3 39e-1
VS26 21 s26 0
C26 s26 15 68e-7
.control
set numdgt=17
ac lin 1 60 60
print v(1) v(2) v(3) v(4) v(5) v(6) v(7) v(8) v(9) v(10)
print v(11) v(12) v(13) v(14) v(15) v(16) v(17) v(18) v(19) v(20)
print v(21) v(22) v(23) v(24) v(25) v(26)
print i(vs0) i(vs1) i(vs2) i(vs3) i(vs4) i(vs5) i(vs6) i(vs7) i(vs8) i(vs9)
print i(vs10) i(vs11) i(vs12) i(vs13) i(vs14) i(vs15) i(vs16) i(vs17) i(vs18) i(vs19)
print i(vs20) i(vs21) i(vs22) i(vs23) i(vs24) i(vs25) i(vs26)
.endc
.end
