controls oracle ac-0327
* Generated (plan F2.7, ADR 0012): do not edit; regenerate with `pnpm sim oracle regen`. ac seed 20261031 index 327 nodes 21 elements 37
.options sparse gmin=1e-12 noopac
RG1 1 0 1000000000000
RG2 2 0 1000000000000
RG3 3 0 1000000000000
RG4 4 0 1000000000000
RG5 5 0 1000000000000
RG6 6 0 1000000000000
RG7 7 0 1000000000000
RG8 8 0 1000000000000
RG9 9 0 1000000000000
RG10 10 0 1000000000000
RG11 11 0 1000000000000
RG12 12 0 1000000000000
RG13 13 0 1000000000000
RG14 14 0 1000000000000
RG15 15 0 1000000000000
RG16 16 0 1000000000000
RG17 17 0 1000000000000
RG18 18 0 1000000000000
RG19 19 0 1000000000000
RG20 20 0 1000000000000
VS0 16 s0 0
R0 s0 17 15e1
VS1 0 s1 0
V1 e1 s1 DC 0 AC 39e0 -120
RI1 e1 m1 56e-3
LI1 m1 n1 33e-7
H1 n1 h1 VS3 -27e-4
ED1 h1 18 d1 0 -18e-7
F1 0 d1 VS3 1
LD1 d1 0 1
VS2 7 s2 0
C2 s2 0 82e-7
VS3 8 s3 0
V3 e3 s3 DC 0 AC 33e0 -120
RI3 e3 m3 10e-1
LI3 m3 n3 39e-7
H3 n3 h3 VS1 -27e-4
ED3 h3 14 d3 0 -18e-7
F3 0 d3 VS1 1
LD3 d3 0 1
VS4 0 s4 0
R4 s4 11 27e1
VS5 19 s5 0
V5 e5 s5 DC 0 AC 15e1 -120
RI5 e5 m5 27e-2
LI5 m5 4 10e-5
VS6 19 s6 0
R6 s6 8 15e1
VS7 12 s7 0
V7 e7 s7 DC 0 AC 47e0 120
RI7 e7 m7 56e-1
LI7 m7 1 56e-6
VS8 3 s8 0
R8 s8 15 22e3
VS9 5 s9 0
R9 s9 9 56e-1
VS10 15 s10 0
L10 s10 12 33e-3
VS11 14 s11 0
V11 e11 s11 DC 0 AC 22e0 -120
RI11 e11 m11 82e-3
LI11 m11 5 56e-5
VS12 20 s12 0
C12 s12 4 10e-4
VS13 13 s13 0
C13 s13 7 68e-5
VS14 15 s14 0
C14 s14 6 82e-6
VS15 17 s15 0
R15 s15 2 18e3
VS16 14 s16 0
L16 s16 5 68e-5
VS17 10 s17 0
V17 e17 s17 DC 0 AC 10e-1 180
RI17 e17 m17 39e-3
LI17 m17 4 68e-5
VS18 8 s18 0
V18 e18 s18 DC 0 AC 22e-1 0
RI18 e18 10 56e-2
VS19 19 s19 0
R19 s19 11 33e-1
VS20 7 s20 0
L20 s20 9 10e-3
VS21 1 s21 0
R21 s21 13 39e3
VS22 16 s22 0
R22 s22 6 82e3
VS23 11 s23 0
R23 s23 4 39e-2
VS24 6 s24 0
C24 s24 2 10e-6
VS25 8 s25 0
R25 s25 15 18e-2
VS26 3 s26 0
L26 s26 7 10e-5
VS27 12 s27 0
R27 s27 6 18e0
VS28 11 s28 0
R28 s28 6 10e0
VS29 1 s29 0
R29 s29 9 22e1
VS30 9 s30 0
C30 s30 17 39e-4
VS31 13 s31 0
R31 s31 1 82e-2
VS32 0 s32 0
L32 s32 4 22e-5
VS33 7 s33 0
L33 s33 8 22e-3
VS34 20 s34 0
R34 s34 1 15e3
VS35 18 s35 0
L35 s35 9 12e-5
VS36 13 s36 0
R36 s36 12 27e1
.control
set numdgt=17
ac lin 1 60 60
print v(1) v(2) v(3) v(4) v(5) v(6) v(7) v(8) v(9) v(10)
print v(11) v(12) v(13) v(14) v(15) v(16) v(17) v(18) v(19) v(20)
print i(vs0) i(vs1) i(vs2) i(vs3) i(vs4) i(vs5) i(vs6) i(vs7) i(vs8) i(vs9)
print i(vs10) i(vs11) i(vs12) i(vs13) i(vs14) i(vs15) i(vs16) i(vs17) i(vs18) i(vs19)
print i(vs20) i(vs21) i(vs22) i(vs23) i(vs24) i(vs25) i(vs26) i(vs27) i(vs28) i(vs29)
print i(vs30) i(vs31) i(vs32) i(vs33) i(vs34) i(vs35) i(vs36)
.endc
.end
