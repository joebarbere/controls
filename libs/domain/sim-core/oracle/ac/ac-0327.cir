controls oracle ac-0327
* Generated (plan F2.7, ADR 0012): do not edit; regenerate with `pnpm sim oracle regen`. ac seed 20261031 index 327 nodes 21 elements 34
.options sparse gmin=1e-12 noopac
RG1 1 0 1000000000000
RG2 2 0 1000000000000
RG3 3 0 1000000000000
RG4 4 0 1000000000000
RG5 5 0 1000000000000
RG6 6 0 1000000000000
RG7 7 0 1000000000000
RG8 8 0 1000000000000
RG9 9 0 1000000000000
RG10 10 0 1000000000000
RG11 11 0 1000000000000
RG12 12 0 1000000000000
RG13 13 0 1000000000000
RG14 14 0 1000000000000
RG15 15 0 1000000000000
RG16 16 0 1000000000000
RG17 17 0 1000000000000
RG18 18 0 1000000000000
RG19 19 0 1000000000000
RG20 20 0 1000000000000
VS0 0 s0 0
V0 e0 s0 DC 0 AC 15e1 -120
RI0 e0 4 27e-2
VS1 13 s1 0
C1 s1 19 68e-5
VS2 16 s2 0
R2 s2 6 82e3
VS3 14 s3 0
L3 s3 5 68e-5
VS4 16 s4 0
R4 s4 17 15e1
VS5 19 s5 0
C5 s5 7 82e-7
VS6 5 s6 0
R6 s6 9 56e-1
VS7 13 s7 0
R7 s7 1 82e-2
VS8 15 s8 0
L8 s8 12 33e-3
VS9 7 s9 0
L9 s9 4 22e-5
VS10 11 s10 0
R10 s10 4 39e-2
VS11 19 s11 0
L11 s11 8 22e-3
VS12 7 s12 0
V12 e12 s12 DC 0 AC 39e0 -120
RI12 e12 18 56e-3
VS13 10 s13 0
V13 e13 s13 DC 0 AC 10e-1 180
RI13 e13 4 39e-3
VS14 12 s14 0
V14 e14 s14 DC 0 AC 47e0 120
RI14 e14 1 56e-1
VS15 11 s15 0
R15 s15 6 10e0
VS16 19 s16 0
L16 s16 9 10e-3
VS17 1 s17 0
R17 s17 13 39e3
VS18 13 s18 0
R18 s18 12 27e1
VS19 3 s19 0
L19 s19 19 10e-5
VS20 20 s20 0
R20 s20 1 15e3
VS21 1 s21 0
R21 s21 9 22e1
VS22 7 s22 0
R22 s22 11 27e1
VS23 12 s23 0
R23 s23 6 18e0
VS24 8 s24 0
R24 s24 15 18e-2
VS25 0 s25 0
R25 s25 8 15e1
VS26 6 s26 0
C26 s26 2 10e-6
VS27 0 s27 0
R27 s27 11 33e-1
VS28 20 s28 0
C28 s28 4 10e-4
VS29 14 s29 0
V29 e29 s29 DC 0 AC 22e0 -120
RI29 e29 5 82e-3
VS30 9 s30 0
C30 s30 17 39e-4
VS31 17 s31 0
R31 s31 2 18e3
VS32 15 s32 0
C32 s32 6 82e-6
VS33 3 s33 0
R33 s33 15 22e3
.control
set numdgt=17
ac lin 1 60 60
print v(1) v(2) v(3) v(4) v(5) v(6) v(7) v(8) v(9) v(10)
print v(11) v(12) v(13) v(14) v(15) v(16) v(17) v(18) v(19) v(20)
print i(vs0) i(vs1) i(vs2) i(vs3) i(vs4) i(vs5) i(vs6) i(vs7) i(vs8) i(vs9)
print i(vs10) i(vs11) i(vs12) i(vs13) i(vs14) i(vs15) i(vs16) i(vs17) i(vs18) i(vs19)
print i(vs20) i(vs21) i(vs22) i(vs23) i(vs24) i(vs25) i(vs26) i(vs27) i(vs28) i(vs29)
print i(vs30) i(vs31) i(vs32) i(vs33)
.endc
.end
