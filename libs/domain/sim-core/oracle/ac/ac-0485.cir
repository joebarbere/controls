controls oracle ac-0485
* Generated (plan F2.7, ADR 0012): do not edit; regenerate with `pnpm sim oracle regen`. ac seed 20261031 index 485 nodes 30 elements 43
.options sparse gmin=1e-12 noopac
RG1 1 0 1000000000000
RG2 2 0 1000000000000
RG3 3 0 1000000000000
RG4 4 0 1000000000000
RG5 5 0 1000000000000
RG6 6 0 1000000000000
RG7 7 0 1000000000000
RG8 8 0 1000000000000
RG9 9 0 1000000000000
RG10 10 0 1000000000000
RG11 11 0 1000000000000
RG12 12 0 1000000000000
RG13 13 0 1000000000000
RG14 14 0 1000000000000
RG15 15 0 1000000000000
RG16 16 0 1000000000000
RG17 17 0 1000000000000
RG18 18 0 1000000000000
RG19 19 0 1000000000000
RG20 20 0 1000000000000
RG21 21 0 1000000000000
RG22 22 0 1000000000000
RG23 23 0 1000000000000
RG24 24 0 1000000000000
RG25 25 0 1000000000000
RG26 26 0 1000000000000
RG27 27 0 1000000000000
RG28 28 0 1000000000000
RG29 29 0 1000000000000
VS0 26 s0 0
R0 s0 15 12e2
VS1 13 s1 0
L1 s1 27 15e-5
VS2 11 s2 0
C2 s2 21 12e-6
VS3 1 s3 0
L3 s3 5 10e-4
VS4 22 s4 0
R4 s4 29 15e-1
VS5 0 s5 0
V5 e5 s5 DC 0 AC 82e-1 0
RI5 e5 m5 27e-2
LI5 m5 7 27e-5
VS6 21 s6 0
C6 s6 9 68e-6
VS7 16 s7 0
R7 s7 22 56e0
VS8 15 s8 0
L8 s8 25 33e-5
VS9 28 s9 0
R9 s9 10 56e1
VS10 1 s10 0
L10 s10 19 10e-4
VS11 24 s11 0
L11 s11 9 22e-2
VS12 0 s12 0
L12 s12 20 10e-4
VS13 14 s13 0
R13 s13 29 27e1
VS14 23 s14 0
L14 s14 14 56e-2
VS15 23 s15 0
C15 s15 5 15e-5
VS16 11 s16 0
R16 s16 17 47e-1
VS17 5 s17 0
V17 e17 s17 DC 0 AC 10e-1 -120
RI17 e17 m17 56e-2
LI17 m17 25 27e-7
VS18 13 s18 0
L18 s18 12 18e-5
VS19 3 s19 0
V19 e19 s19 DC 0 AC 82e-1 120
RI19 e19 23 22e-1
VS20 20 s20 0
V20 e20 s20 DC 0 AC 15e0 -120
RI20 e20 28 10e-3
VS21 8 s21 0
L21 s21 21 47e-4
VS22 2 s22 0
R22 s22 23 33e2
VS23 12 s23 0
L23 s23 24 82e-5
VS24 3 s24 0
R24 s24 16 68e-1
VS25 16 s25 0
V25 e25 s25 DC 0 AC 33e0 120
RI25 e25 m25 10e-3
LI25 m25 8 33e-6
VS26 28 s26 0
L26 s26 4 15e-5
VS27 8 s27 0
L27 s27 5 15e-2
VS28 6 s28 0
R28 s28 7 15e3
VS29 8 s29 0
C29 s29 17 82e-7
VS30 23 s30 0
V30 e30 s30 DC 0 AC 15e0 120
RI30 e30 m30 33e-3
LI30 m30 21 27e-7
VS31 19 s31 0
L31 s31 23 68e-3
VS32 28 s32 0
R32 s32 16 22e0
VS33 4 s33 0
V33 e33 s33 DC 0 AC 33e1 180
RI33 e33 15 27e-1
VS34 27 s34 0
R34 s34 18 27e3
VS35 20 s35 0
V35 e35 s35 DC 0 AC 39e-1 -120
RI35 e35 m35 68e-3
LI35 m35 10 33e-7
VS36 0 s36 0
R36 s36 12 15e-1
VS37 26 s37 0
C37 s37 13 18e-7
VS38 7 s38 0
R38 s38 25 12e1
VS39 2 s39 0
L39 s39 27 68e-5
VS40 27 s40 0
R40 s40 21 39e2
VS41 23 s41 0
R41 s41 18 82e3
VS42 6 s42 0
C42 s42 21 12e-6
.control
set numdgt=17
ac lin 1 60 60
print v(1) v(2) v(3) v(4) v(5) v(6) v(7) v(8) v(9) v(10)
print v(11) v(12) v(13) v(14) v(15) v(16) v(17) v(18) v(19) v(20)
print v(21) v(22) v(23) v(24) v(25) v(26) v(27) v(28) v(29)
print i(vs0) i(vs1) i(vs2) i(vs3) i(vs4) i(vs5) i(vs6) i(vs7) i(vs8) i(vs9)
print i(vs10) i(vs11) i(vs12) i(vs13) i(vs14) i(vs15) i(vs16) i(vs17) i(vs18) i(vs19)
print i(vs20) i(vs21) i(vs22) i(vs23) i(vs24) i(vs25) i(vs26) i(vs27) i(vs28) i(vs29)
print i(vs30) i(vs31) i(vs32) i(vs33) i(vs34) i(vs35) i(vs36) i(vs37) i(vs38) i(vs39)
print i(vs40) i(vs41) i(vs42)
.endc
.end
