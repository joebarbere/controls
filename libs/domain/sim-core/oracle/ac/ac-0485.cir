controls oracle ac-0485
* Generated (plan F2.7, ADR 0012): do not edit; regenerate with `pnpm sim oracle regen`. ac seed 20261031 index 485 nodes 30 elements 53
.options sparse gmin=1e-12 noopac
RG1 1 0 1000000000000
RG2 2 0 1000000000000
RG3 3 0 1000000000000
RG4 4 0 1000000000000
RG5 5 0 1000000000000
RG6 6 0 1000000000000
RG7 7 0 1000000000000
RG8 8 0 1000000000000
RG9 9 0 1000000000000
RG10 10 0 1000000000000
RG11 11 0 1000000000000
RG12 12 0 1000000000000
RG13 13 0 1000000000000
RG14 14 0 1000000000000
RG15 15 0 1000000000000
RG16 16 0 1000000000000
RG17 17 0 1000000000000
RG18 18 0 1000000000000
RG19 19 0 1000000000000
RG20 20 0 1000000000000
RG21 21 0 1000000000000
RG22 22 0 1000000000000
RG23 23 0 1000000000000
RG24 24 0 1000000000000
RG25 25 0 1000000000000
RG26 26 0 1000000000000
RG27 27 0 1000000000000
RG28 28 0 1000000000000
RG29 29 0 1000000000000
VS0 5 s0 0
C0 s0 0 27e-5
VS1 0 s1 0
V1 e1 s1 DC 0 AC 18e1 -120
RI1 e1 17 22e-1
VS2 12 s2 0
R2 s2 9 68e-2
VS3 6 s3 0
L3 s3 14 22e-4
VS4 27 s4 0
R4 s4 11 56e0
VS5 18 s5 0
V5 e5 s5 DC 0 AC 33e-1 120
RI5 e5 20 33e-3
VS6 16 s6 0
R6 s6 15 22e1
VS7 5 s7 0
R7 s7 12 22e2
VS8 28 s8 0
R8 s8 6 82e3
VS9 0 s9 0
V9 e9 s9 DC 0 AC 15e0 -120
RI9 e9 1 22e-2
VS10 0 s10 0
C10 s10 6 10e-7
VS11 29 s11 0
L11 s11 1 12e-4
VS12 20 s12 0
C12 s12 12 33e-7
VS13 2 s13 0
R13 s13 17 56e0
VS14 27 s14 0
R14 s14 6 15e0
VS15 13 s15 0
V15 e15 s15 DC 0 AC 82e-1 0
RI15 e15 0 10e-2
VS16 24 s16 0
R16 s16 9 82e2
VS17 23 s17 0
R17 s17 21 47e2
VS18 0 s18 0
R18 s18 4 18e3
VS19 23 s19 0
R19 s19 0 18e3
VS20 9 s20 0
R20 s20 19 27e-2
VS21 18 s21 0
R21 s21 13 27e-2
VS22 17 s22 0
C22 s22 23 18e-7
VS23 12 s23 0
R23 s23 0 22e-2
VS24 21 s24 0
V24 e24 s24 DC 0 AC 15e0 120
RI24 e24 22 82e-1
VS25 12 s25 0
L25 s25 18 18e-5
VS26 8 s26 0
R26 s26 5 47e0
VS27 6 s27 0
C27 s27 10 27e-4
VS28 13 s28 0
L28 s28 19 68e-2
VS29 24 s29 0
L29 s29 7 56e-3
VS30 27 s30 0
V30 e30 s30 DC 0 AC 82e-1 0
RI30 e30 23 27e-2
VS31 6 s31 0
R31 s31 24 82e-1
VS32 15 s32 0
R32 s32 20 68e-1
VS33 28 s33 0
R33 s33 21 12e-2
VS34 0 s34 0
L34 s34 8 47e-4
VS35 9 s35 0
C35 s35 6 33e-5
VS36 8 s36 0
C36 s36 16 18e-4
VS37 14 s37 0
L37 s37 25 56e-2
VS38 1 s38 0
R38 s38 22 12e3
VS39 20 s39 0
R39 s39 4 33e2
VS40 3 s40 0
L40 s40 25 68e-5
VS41 8 s41 0
C41 s41 9 68e-6
VS42 15 s42 0
R42 s42 3 47e2
VS43 7 s43 0
R43 s43 29 12e1
VS44 7 s44 0
R44 s44 26 15e-1
VS45 0 s45 0
C45 s45 23 39e-4
VS46 1 s46 0
R46 s46 8 47e1
VS47 16 s47 0
V47 e47 s47 DC 0 AC 33e0 120
RI47 e47 0 10e-3
VS48 7 s48 0
C48 s48 16 39e-6
VS49 20 s49 0
R49 s49 17 39e2
VS50 9 s50 0
L50 s50 14 15e-5
VS51 12 s51 0
R51 s51 0 15e0
VS52 2 s52 0
C52 s52 13 12e-6
.control
set numdgt=17
ac lin 1 60 60
print v(1) v(2) v(3) v(4) v(5) v(6) v(7) v(8) v(9) v(10)
print v(11) v(12) v(13) v(14) v(15) v(16) v(17) v(18) v(19) v(20)
print v(21) v(22) v(23) v(24) v(25) v(26) v(27) v(28) v(29)
print i(vs0) i(vs1) i(vs2) i(vs3) i(vs4) i(vs5) i(vs6) i(vs7) i(vs8) i(vs9)
print i(vs10) i(vs11) i(vs12) i(vs13) i(vs14) i(vs15) i(vs16) i(vs17) i(vs18) i(vs19)
print i(vs20) i(vs21) i(vs22) i(vs23) i(vs24) i(vs25) i(vs26) i(vs27) i(vs28) i(vs29)
print i(vs30) i(vs31) i(vs32) i(vs33) i(vs34) i(vs35) i(vs36) i(vs37) i(vs38) i(vs39)
print i(vs40) i(vs41) i(vs42) i(vs43) i(vs44) i(vs45) i(vs46) i(vs47) i(vs48) i(vs49)
print i(vs50) i(vs51) i(vs52)
.endc
.end
