controls oracle ac-0485
* Generated (plan F2.7, ADR 0012): do not edit; regenerate with `pnpm sim oracle regen`. ac seed 20261031 index 485 nodes 30 elements 56
.options sparse gmin=1e-12 noopac
RG1 1 0 1000000000000
RG2 2 0 1000000000000
RG3 3 0 1000000000000
RG4 4 0 1000000000000
RG5 5 0 1000000000000
RG6 6 0 1000000000000
RG7 7 0 1000000000000
RG8 8 0 1000000000000
RG9 9 0 1000000000000
RG10 10 0 1000000000000
RG11 11 0 1000000000000
RG12 12 0 1000000000000
RG13 13 0 1000000000000
RG14 14 0 1000000000000
RG15 15 0 1000000000000
RG16 16 0 1000000000000
RG17 17 0 1000000000000
RG18 18 0 1000000000000
RG19 19 0 1000000000000
RG20 20 0 1000000000000
RG21 21 0 1000000000000
RG22 22 0 1000000000000
RG23 23 0 1000000000000
RG24 24 0 1000000000000
RG25 25 0 1000000000000
RG26 26 0 1000000000000
RG27 27 0 1000000000000
RG28 28 0 1000000000000
RG29 29 0 1000000000000
VS0 12 s0 0
R0 s0 0 15e0
VS1 9 s1 0
L1 s1 14 15e-5
VS2 15 s2 0
R2 s2 20 68e-1
VS3 20 s3 0
R3 s3 4 33e2
VS4 23 s4 0
R4 s4 0 18e3
VS5 8 s5 0
R5 s5 5 47e0
VS6 12 s6 0
R6 s6 9 68e-2
VS7 12 s7 0
R7 s7 0 22e-2
VS8 12 s8 0
L8 s8 18 18e-5
VS9 6 s9 0
C9 s9 10 27e-4
VS10 5 s10 0
C10 s10 0 27e-5
VS11 18 s11 0
R11 s11 13 27e-2
VS12 7 s12 0
R12 s12 26 15e-1
VS13 0 s13 0
V13 e13 s13 DC 0 AC 15e0 -120
RI13 e13 1 22e-2
VS14 9 s14 0
C14 s14 6 33e-5
VS15 8 s15 0
C15 s15 16 18e-4
VS16 0 s16 0
R16 s16 4 18e3
VS17 24 s17 0
L17 s17 7 56e-3
VS18 7 s18 0
C18 s18 16 39e-6
VS19 16 s19 0
V19 e19 s19 DC 0 AC 33e0 120
RI19 e19 0 10e-3
VS20 0 s20 0
C20 s20 6 10e-7
VS21 5 s21 0
R21 s21 12 22e2
VS22 0 s22 0
C22 s22 23 39e-4
VS23 23 s23 0
R23 s23 21 47e2
VS24 1 s24 0
R24 s24 22 12e3
VS25 27 s25 0
V25 e25 s25 DC 0 AC 82e-1 0
RI25 e25 23 27e-2
VS26 28 s26 0
R26 s26 21 12e-2
VS27 27 s27 0
R27 s27 6 15e0
VS28 18 s28 0
V28 e28 s28 DC 0 AC 33e-1 120
RI28 e28 20 33e-3
VS29 16 s29 0
R29 s29 15 22e1
VS30 20 s30 0
R30 s30 17 39e2
VS31 13 s31 0
V31 e31 s31 DC 0 AC 82e-1 0
RI31 e31 0 10e-2
VS32 19 s32 0
L32 s32 26 82e-5
VS33 6 s33 0
R33 s33 24 82e-1
VS34 29 s34 0
L34 s34 1 12e-4
VS35 3 s35 0
R35 s35 11 18e-2
VS36 21 s36 0
V36 e36 s36 DC 0 AC 15e0 120
RI36 e36 22 82e-1
VS37 1 s37 0
R37 s37 8 47e1
VS38 6 s38 0
L38 s38 14 22e-4
VS39 13 s39 0
L39 s39 19 68e-2
VS40 10 s40 0
R40 s40 1 22e0
VS41 9 s41 0
R41 s41 19 27e-2
VS42 24 s42 0
R42 s42 9 82e2
VS43 15 s43 0
R43 s43 3 47e2
VS44 17 s44 0
C44 s44 23 18e-7
VS45 7 s45 0
R45 s45 29 12e1
VS46 2 s46 0
C46 s46 13 12e-6
VS47 8 s47 0
C47 s47 9 68e-6
VS48 27 s48 0
R48 s48 11 56e0
VS49 28 s49 0
R49 s49 6 82e3
VS50 20 s50 0
C50 s50 12 33e-7
VS51 3 s51 0
L51 s51 25 68e-5
VS52 0 s52 0
V52 e52 s52 DC 0 AC 18e1 -120
RI52 e52 17 22e-1
VS53 2 s53 0
R53 s53 17 56e0
VS54 14 s54 0
L54 s54 25 56e-2
VS55 0 s55 0
L55 s55 8 47e-4
.control
set numdgt=17
ac lin 1 60 60
print v(1) v(2) v(3) v(4) v(5) v(6) v(7) v(8) v(9) v(10)
print v(11) v(12) v(13) v(14) v(15) v(16) v(17) v(18) v(19) v(20)
print v(21) v(22) v(23) v(24) v(25) v(26) v(27) v(28) v(29)
print i(vs0) i(vs1) i(vs2) i(vs3) i(vs4) i(vs5) i(vs6) i(vs7) i(vs8) i(vs9)
print i(vs10) i(vs11) i(vs12) i(vs13) i(vs14) i(vs15) i(vs16) i(vs17) i(vs18) i(vs19)
print i(vs20) i(vs21) i(vs22) i(vs23) i(vs24) i(vs25) i(vs26) i(vs27) i(vs28) i(vs29)
print i(vs30) i(vs31) i(vs32) i(vs33) i(vs34) i(vs35) i(vs36) i(vs37) i(vs38) i(vs39)
print i(vs40) i(vs41) i(vs42) i(vs43) i(vs44) i(vs45) i(vs46) i(vs47) i(vs48) i(vs49)
print i(vs50) i(vs51) i(vs52) i(vs53) i(vs54) i(vs55)
.endc
.end
