controls oracle ac-0292
* Generated (plan F2.7, ADR 0012): do not edit; regenerate with `pnpm sim oracle regen`. ac seed 20261031 index 292 nodes 27 elements 45
.options sparse gmin=1e-12 noopac
RG1 1 0 1000000000000
RG2 2 0 1000000000000
RG3 3 0 1000000000000
RG4 4 0 1000000000000
RG5 5 0 1000000000000
RG6 6 0 1000000000000
RG7 7 0 1000000000000
RG8 8 0 1000000000000
RG9 9 0 1000000000000
RG10 10 0 1000000000000
RG11 11 0 1000000000000
RG12 12 0 1000000000000
RG13 13 0 1000000000000
RG14 14 0 1000000000000
RG15 15 0 1000000000000
RG16 16 0 1000000000000
RG17 17 0 1000000000000
RG18 18 0 1000000000000
RG19 19 0 1000000000000
RG20 20 0 1000000000000
RG21 21 0 1000000000000
RG22 22 0 1000000000000
RG23 23 0 1000000000000
RG24 24 0 1000000000000
RG25 25 0 1000000000000
RG26 26 0 1000000000000
VS0 1 s0 0
C0 s0 3 15e-7
VS1 26 s1 0
R1 s1 20 47e-1
VS2 0 s2 0
V2 e2 s2 DC 0 AC 33e1 0
RI2 e2 m2 12e-3
LI2 m2 19 10e-5
VS3 8 s3 0
R3 s3 1 12e2
VS4 10 s4 0
C4 s4 4 15e-5
VS5 23 s5 0
R5 s5 13 12e3
VS6 14 s6 0
L6 s6 10 33e-5
VS7 24 s7 0
R7 s7 1 33e0
VS8 9 s8 0
V8 e8 s8 DC 0 AC 22e0 -120
RI8 e8 11 27e-1
VS9 26 s9 0
R9 s9 14 33e1
VS10 21 s10 0
C10 s10 2 82e-7
VS11 19 s11 0
R11 s11 4 68e2
VS12 19 s12 0
R12 s12 3 15e0
VS13 25 s13 0
C13 s13 19 15e-4
VS14 17 s14 0
C14 s14 9 39e-4
VS15 0 s15 0
V15 e15 s15 DC 0 AC 12e1 180
RI15 e15 12 15e-3
VS16 10 s16 0
V16 e16 s16 DC 0 AC 82e0 180
RI16 e16 m16 33e-1
LI16 m16 17 56e-6
VS17 3 s17 0
C17 s17 5 39e-7
VS18 19 s18 0
R18 s18 12 56e-2
VS19 2 s19 0
L19 s19 1 39e-3
VS20 16 s20 0
C20 s20 2 82e-7
VS21 23 s21 0
V21 e21 s21 DC 0 AC 18e0 120
RI21 e21 m21 15e-1
LI21 m21 19 39e-7
VS22 21 s22 0
C22 s22 7 56e-6
VS23 7 s23 0
L23 s23 25 56e-5
VS24 18 s24 0
C24 s24 13 39e-6
VS25 4 s25 0
R25 s25 26 18e3
VS26 18 s26 0
L26 s26 26 68e-4
VS27 10 s27 0
L27 s27 6 22e-2
VS28 23 s28 0
L28 s28 13 22e-2
VS29 25 s29 0
V29 e29 s29 DC 0 AC 82e0 180
RI29 e29 m29 56e-1
LI29 m29 15 12e-5
VS30 21 s30 0
R30 s30 26 27e-1
VS31 0 s31 0
C31 s31 4 56e-4
VS32 24 s32 0
L32 s32 13 47e-4
VS33 16 s33 0
R33 s33 25 39e0
VS34 3 s34 0
R34 s34 2 12e2
VS35 10 s35 0
R35 s35 11 15e2
VS36 20 s36 0
L36 s36 13 68e-2
VS37 8 s37 0
C37 s37 25 68e-7
VS38 22 s38 0
R38 s38 19 82e-2
VS39 5 s39 0
C39 s39 17 39e-5
VS40 25 s40 0
V40 e40 s40 DC 0 AC 22e1 120
RI40 e40 0 27e-1
VS41 10 s41 0
V41 e41 s41 DC 0 AC 15e0 180
RI41 e41 m41 47e-3
LI41 m41 25 22e-5
VS42 22 s42 0
L42 s42 15 22e-2
VS43 1 s43 0
R43 s43 9 47e-1
VS44 6 s44 0
R44 s44 3 18e-2
.control
set numdgt=17
ac lin 1 60 60
print v(1) v(2) v(3) v(4) v(5) v(6) v(7) v(8) v(9) v(10)
print v(11) v(12) v(13) v(14) v(15) v(16) v(17) v(18) v(19) v(20)
print v(21) v(22) v(23) v(24) v(25) v(26)
print i(vs0) i(vs1) i(vs2) i(vs3) i(vs4) i(vs5) i(vs6) i(vs7) i(vs8) i(vs9)
print i(vs10) i(vs11) i(vs12) i(vs13) i(vs14) i(vs15) i(vs16) i(vs17) i(vs18) i(vs19)
print i(vs20) i(vs21) i(vs22) i(vs23) i(vs24) i(vs25) i(vs26) i(vs27) i(vs28) i(vs29)
print i(vs30) i(vs31) i(vs32) i(vs33) i(vs34) i(vs35) i(vs36) i(vs37) i(vs38) i(vs39)
print i(vs40) i(vs41) i(vs42) i(vs43) i(vs44)
.endc
.end
