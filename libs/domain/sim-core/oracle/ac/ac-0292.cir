controls oracle ac-0292
* Generated (plan F2.7, ADR 0012): do not edit; regenerate with `pnpm sim oracle regen`. ac seed 20261031 index 292 nodes 27 elements 37
.options sparse gmin=1e-12 noopac
RG1 1 0 1000000000000
RG2 2 0 1000000000000
RG3 3 0 1000000000000
RG4 4 0 1000000000000
RG5 5 0 1000000000000
RG6 6 0 1000000000000
RG7 7 0 1000000000000
RG8 8 0 1000000000000
RG9 9 0 1000000000000
RG10 10 0 1000000000000
RG11 11 0 1000000000000
RG12 12 0 1000000000000
RG13 13 0 1000000000000
RG14 14 0 1000000000000
RG15 15 0 1000000000000
RG16 16 0 1000000000000
RG17 17 0 1000000000000
RG18 18 0 1000000000000
RG19 19 0 1000000000000
RG20 20 0 1000000000000
RG21 21 0 1000000000000
RG22 22 0 1000000000000
RG23 23 0 1000000000000
RG24 24 0 1000000000000
RG25 25 0 1000000000000
RG26 26 0 1000000000000
VS0 0 s0 0
V0 e0 s0 DC 0 AC 15e0 120
RI0 e0 n0 18e-2
H0 n0 h0 VS2 -10e-4
ED0 h0 12 d0 0 15e-6
F0 0 d0 VS2 1
LD0 d0 0 1
VS1 22 s1 0
L1 s1 15 22e-2
VS2 6 s2 0
V2 e2 s2 DC 0 AC 18e1 120
RI2 e2 n2 27e-3
H2 n2 h2 VS0 -10e-4
ED2 h2 25 d2 0 15e-6
F2 0 d2 VS0 1
LD2 d2 0 1
VS3 13 s3 0
L3 s3 2 47e-4
VS4 16 s4 0
C4 s4 2 82e-7
VS5 18 s5 0
L5 s5 26 68e-4
VS6 5 s6 0
L6 s6 15 22e-3
VS7 22 s7 0
R7 s7 11 39e3
VS8 21 s8 0
C8 s8 13 15e-4
VS9 23 s9 0
V9 e9 s9 DC 0 AC 18e0 120
RI9 e9 19 15e-1
VS10 4 s10 0
R10 s10 19 33e2
VS11 3 s11 0
C11 s11 18 82e-4
VS12 19 s12 0
R12 s12 3 15e0
VS13 8 s13 0
C13 s13 3 18e-5
VS14 22 s14 0
R14 s14 19 82e-2
VS15 12 s15 0
C15 s15 24 12e-4
VS16 12 s16 0
R16 s16 9 39e3
VS17 12 s17 0
L17 s17 25 18e-5
VS18 10 s18 0
R18 s18 11 15e2
VS19 17 s19 0
C19 s19 9 18e-5
VS20 8 s20 0
R20 s20 1 12e2
VS21 23 s21 0
R21 s21 1 27e0
VS22 10 s22 0
V22 e22 s22 DC 0 AC 15e-1 -120
RI22 e22 m22 68e-3
LI22 m22 8 33e-7
VS23 16 s23 0
V23 e23 s23 DC 0 AC 68e0 180
RI23 e23 14 33e-3
VS24 3 s24 0
C24 s24 6 47e-6
VS25 21 s25 0
L25 s25 8 33e-4
VS26 20 s26 0
C26 s26 19 56e-4
VS27 10 s27 0
V27 e27 s27 DC 0 AC 15e0 180
RI27 e27 7 47e-3
VS28 10 s28 0
C28 s28 4 15e-5
VS29 3 s29 0
C29 s29 5 39e-7
VS30 26 s30 0
R30 s30 20 47e-1
VS31 10 s31 0
V31 e31 s31 DC 0 AC 82e0 180
RI31 e31 17 33e-1
VS32 24 s32 0
R32 s32 1 33e0
VS33 7 s33 0
L33 s33 16 22e-5
VS34 26 s34 0
R34 s34 14 33e1
VS35 3 s35 0
R35 s35 21 82e-2
VS36 0 s36 0
L36 s36 7 56e-5
.control
set numdgt=17
ac lin 1 60 60
print v(1) v(2) v(3) v(4) v(5) v(6) v(7) v(8) v(9) v(10)
print v(11) v(12) v(13) v(14) v(15) v(16) v(17) v(18) v(19) v(20)
print v(21) v(22) v(23) v(24) v(25) v(26)
print i(vs0) i(vs1) i(vs2) i(vs3) i(vs4) i(vs5) i(vs6) i(vs7) i(vs8) i(vs9)
print i(vs10) i(vs11) i(vs12) i(vs13) i(vs14) i(vs15) i(vs16) i(vs17) i(vs18) i(vs19)
print i(vs20) i(vs21) i(vs22) i(vs23) i(vs24) i(vs25) i(vs26) i(vs27) i(vs28) i(vs29)
print i(vs30) i(vs31) i(vs32) i(vs33) i(vs34) i(vs35) i(vs36)
.endc
.end
