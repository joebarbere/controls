controls oracle ac-0292
* Generated (plan F2.7, ADR 0012): do not edit; regenerate with `pnpm sim oracle regen`. ac seed 20261031 index 292 nodes 27 elements 29
.options sparse gmin=1e-12 noopac
RG1 1 0 1000000000000
RG2 2 0 1000000000000
RG3 3 0 1000000000000
RG4 4 0 1000000000000
RG5 5 0 1000000000000
RG6 6 0 1000000000000
RG7 7 0 1000000000000
RG8 8 0 1000000000000
RG9 9 0 1000000000000
RG10 10 0 1000000000000
RG11 11 0 1000000000000
RG12 12 0 1000000000000
RG13 13 0 1000000000000
RG14 14 0 1000000000000
RG15 15 0 1000000000000
RG16 16 0 1000000000000
RG17 17 0 1000000000000
RG18 18 0 1000000000000
RG19 19 0 1000000000000
RG20 20 0 1000000000000
RG21 21 0 1000000000000
RG22 22 0 1000000000000
RG23 23 0 1000000000000
RG24 24 0 1000000000000
RG25 25 0 1000000000000
RG26 26 0 1000000000000
VS0 0 s0 0
V0 e0 s0 DC 0 AC 18e0 120
RI0 e0 19 15e-1
VS1 10 s1 0
V1 e1 s1 DC 0 AC 15e0 180
RI1 e1 23 47e-3
VS2 3 s2 0
C2 s2 6 47e-6
VS3 24 s3 0
R3 s3 1 33e0
VS4 8 s4 0
R4 s4 1 12e2
VS5 3 s5 0
R5 s5 21 82e-2
VS6 3 s6 0
C6 s6 18 82e-4
VS7 12 s7 0
C7 s7 24 12e-4
VS8 16 s8 0
V8 e8 s8 DC 0 AC 68e0 180
RI8 e8 14 33e-3
VS9 10 s9 0
V9 e9 s9 DC 0 AC 82e0 180
RI9 e9 17 33e-1
VS10 22 s10 0
R10 s10 19 82e-2
VS11 23 s11 0
L11 s11 16 22e-5
VS12 3 s12 0
C12 s12 5 39e-7
VS13 7 s13 0
L13 s13 23 56e-5
VS14 10 s14 0
C14 s14 4 15e-5
VS15 8 s15 0
C15 s15 3 18e-5
VS16 16 s16 0
C16 s16 2 82e-7
VS17 17 s17 0
C17 s17 9 18e-5
VS18 0 s18 0
R18 s18 1 27e0
VS19 22 s19 0
L19 s19 15 22e-2
VS20 12 s20 0
R20 s20 9 39e3
VS21 19 s21 0
R21 s21 3 15e0
VS22 26 s22 0
R22 s22 14 33e1
VS23 12 s23 0
L23 s23 25 18e-5
VS24 10 s24 0
V24 e24 s24 DC 0 AC 15e-1 -120
RI24 e24 8 68e-3
VS25 10 s25 0
R25 s25 11 15e2
VS26 26 s26 0
R26 s26 20 47e-1
VS27 13 s27 0
L27 s27 2 47e-4
VS28 18 s28 0
L28 s28 26 68e-4
.control
set numdgt=17
ac lin 1 60 60
print v(1) v(2) v(3) v(4) v(5) v(6) v(7) v(8) v(9) v(10)
print v(11) v(12) v(13) v(14) v(15) v(16) v(17) v(18) v(19) v(20)
print v(21) v(22) v(23) v(24) v(25) v(26)
print i(vs0) i(vs1) i(vs2) i(vs3) i(vs4) i(vs5) i(vs6) i(vs7) i(vs8) i(vs9)
print i(vs10) i(vs11) i(vs12) i(vs13) i(vs14) i(vs15) i(vs16) i(vs17) i(vs18) i(vs19)
print i(vs20) i(vs21) i(vs22) i(vs23) i(vs24) i(vs25) i(vs26) i(vs27) i(vs28)
.endc
.end
