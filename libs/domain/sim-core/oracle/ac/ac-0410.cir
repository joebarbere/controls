controls oracle ac-0410
* Generated (plan F2.7, ADR 0012): do not edit; regenerate with `pnpm sim oracle regen`. ac seed 20261031 index 410 nodes 12 elements 17
.options sparse gmin=1e-12 noopac
RG1 1 0 1000000000000
RG2 2 0 1000000000000
RG3 3 0 1000000000000
RG4 4 0 1000000000000
RG5 5 0 1000000000000
RG6 6 0 1000000000000
RG7 7 0 1000000000000
RG8 8 0 1000000000000
RG9 9 0 1000000000000
RG10 10 0 1000000000000
RG11 11 0 1000000000000
VS0 7 s0 0
R0 s0 3 18e-2
VS1 8 s1 0
R1 s1 4 15e0
VS2 2 s2 0
C2 s2 11 39e-4
VS3 8 s3 0
C3 s3 3 15e-6
VS4 3 s4 0
R4 s4 6 56e3
VS5 0 s5 0
V5 e5 s5 DC 0 AC 15e1 0
RI5 e5 m5 82e-2
LI5 m5 10 12e-6
VS6 1 s6 0
R6 s6 5 68e3
VS7 10 s7 0
C7 s7 9 27e-5
VS8 5 s8 0
C8 s8 3 22e-6
VS9 4 s9 0
R9 s9 8 15e3
VS10 10 s10 0
V10 e10 s10 DC 0 AC 82e1 180
RI10 e10 m10 10e-2
LI10 m10 2 33e-7
VS11 2 s11 0
C11 s11 4 22e-4
VS12 5 s12 0
C12 s12 11 56e-6
VS13 7 s13 0
R13 s13 2 10e3
VS14 1 s14 0
R14 s14 6 10e3
VS15 9 s15 0
V15 e15 s15 DC 0 AC 12e-1 0
RI15 e15 5 18e-2
VS16 6 s16 0
V16 e16 s16 DC 0 AC 68e0 120
RI16 e16 m16 56e-1
LI16 m16 0 10e-5
.control
set numdgt=17
ac lin 1 60 60
print v(1) v(2) v(3) v(4) v(5) v(6) v(7) v(8) v(9) v(10)
print v(11)
print i(vs0) i(vs1) i(vs2) i(vs3) i(vs4) i(vs5) i(vs6) i(vs7) i(vs8) i(vs9)
print i(vs10) i(vs11) i(vs12) i(vs13) i(vs14) i(vs15) i(vs16)
.endc
.end
