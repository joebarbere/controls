controls oracle ac-0410
* Generated (plan F2.7, ADR 0012): do not edit; regenerate with `pnpm sim oracle regen`. ac seed 20261031 index 410 nodes 12 elements 22
.options sparse gmin=1e-12 noopac
RG1 1 0 1000000000000
RG2 2 0 1000000000000
RG3 3 0 1000000000000
RG4 4 0 1000000000000
RG5 5 0 1000000000000
RG6 6 0 1000000000000
RG7 7 0 1000000000000
RG8 8 0 1000000000000
RG9 9 0 1000000000000
RG10 10 0 1000000000000
RG11 11 0 1000000000000
VS0 11 s0 0
R0 s0 6 56e3
VS1 2 s1 0
R1 s1 9 22e3
VS2 0 s2 0
V2 e2 s2 DC 0 AC 22e-1 120
RI2 e2 m2 56e-1
LI2 m2 n2 27e-7
H2 n2 h2 VS3 -82e-4
ED2 h2 7 d2 0 -39e-6
F2 0 d2 VS3 1
LD2 d2 0 1
VS3 5 s3 0
V3 e3 s3 DC 0 AC 18e-1 120
RI3 e3 m3 12e-3
LI3 m3 n3 68e-7
H3 n3 h3 VS2 -82e-4
ED3 h3 0 d3 0 -39e-6
F3 0 d3 VS2 1
LD3 d3 0 1
VS4 5 s4 0
C4 s4 11 22e-6
VS5 6 s5 0
V5 e5 s5 DC 0 AC 68e0 120
RI5 e5 3 56e-1
VS6 10 s6 0
V6 e6 s6 DC 0 AC 68e-1 0
RI6 e6 m6 15e-1
LI6 m6 3 39e-7
VS7 5 s7 0
R7 s7 11 82e1
VS8 11 s8 0
R8 s8 7 68e0
VS9 6 s9 0
L9 s9 0 56e-5
VS10 6 s10 0
C10 s10 10 56e-4
VS11 8 s11 0
V11 e11 s11 DC 0 AC 22e1 120
RI11 e11 m11 22e-2
LI11 m11 3 22e-6
VS12 5 s12 0
L12 s12 8 33e-2
VS13 2 s13 0
R13 s13 1 15e0
VS14 2 s14 0
R14 s14 1 56e3
VS15 7 s15 0
V15 e15 s15 DC 0 AC 47e0 180
RI15 e15 m15 82e-3
LI15 m15 4 27e-7
VS16 4 s16 0
V16 e16 s16 DC 0 AC 56e-1 0
RI16 e16 m16 12e-2
LI16 m16 2 56e-7
VS17 1 s17 0
C17 s17 7 68e-4
VS18 9 s18 0
L18 s18 7 56e-4
VS19 2 s19 0
L19 s19 11 10e-2
VS20 4 s20 0
R20 s20 5 68e3
VS21 6 s21 0
V21 e21 s21 DC 0 AC 18e0 0
RI21 e21 m21 56e-1
LI21 m21 8 15e-6
.control
set numdgt=17
ac lin 1 60 60
print v(1) v(2) v(3) v(4) v(5) v(6) v(7) v(8) v(9) v(10)
print v(11)
print i(vs0) i(vs1) i(vs2) i(vs3) i(vs4) i(vs5) i(vs6) i(vs7) i(vs8) i(vs9)
print i(vs10) i(vs11) i(vs12) i(vs13) i(vs14) i(vs15) i(vs16) i(vs17) i(vs18) i(vs19)
print i(vs20) i(vs21)
.endc
.end
