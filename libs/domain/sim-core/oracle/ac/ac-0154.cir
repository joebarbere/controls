controls oracle ac-0154
* Generated (plan F2.7, ADR 0012): do not edit; regenerate with `pnpm sim oracle regen`. ac seed 20261031 index 154 nodes 30 elements 47
.options sparse gmin=1e-12 noopac
RG1 1 0 1000000000000
RG2 2 0 1000000000000
RG3 3 0 1000000000000
RG4 4 0 1000000000000
RG5 5 0 1000000000000
RG6 6 0 1000000000000
RG7 7 0 1000000000000
RG8 8 0 1000000000000
RG9 9 0 1000000000000
RG10 10 0 1000000000000
RG11 11 0 1000000000000
RG12 12 0 1000000000000
RG13 13 0 1000000000000
RG14 14 0 1000000000000
RG15 15 0 1000000000000
RG16 16 0 1000000000000
RG17 17 0 1000000000000
RG18 18 0 1000000000000
RG19 19 0 1000000000000
RG20 20 0 1000000000000
RG21 21 0 1000000000000
RG22 22 0 1000000000000
RG23 23 0 1000000000000
RG24 24 0 1000000000000
RG25 25 0 1000000000000
RG26 26 0 1000000000000
RG27 27 0 1000000000000
RG28 28 0 1000000000000
RG29 29 0 1000000000000
VS0 9 s0 0
C0 s0 28 15e-7
VS1 17 s1 0
R1 s1 7 18e0
VS2 19 s2 0
L2 s2 29 33e-5
VS3 9 s3 0
R3 s3 26 12e0
VS4 0 s4 0
V4 e4 s4 DC 0 AC 56e-1 180
RI4 e4 3 27e-2
VS5 27 s5 0
R5 s5 4 27e-1
VS6 8 s6 0
V6 e6 s6 DC 0 AC 33e0 0
RI6 e6 10 15e-3
VS7 24 s7 0
C7 s7 14 33e-4
VS8 6 s8 0
C8 s8 22 56e-6
VS9 10 s9 0
R9 s9 25 82e1
VS10 13 s10 0
R10 s10 12 15e1
VS11 23 s11 0
V11 e11 s11 DC 0 AC 47e1 120
RI11 e11 14 15e-3
VS12 13 s12 0
L12 s12 1 15e-3
VS13 8 s13 0
L13 s13 4 33e-4
VS14 18 s14 0
L14 s14 25 56e-3
VS15 10 s15 0
R15 s15 1 82e-2
VS16 22 s16 0
C16 s16 2 33e-4
VS17 12 s17 0
L17 s17 5 22e-3
VS18 7 s18 0
R18 s18 20 68e-1
VS19 27 s19 0
V19 e19 s19 DC 0 AC 82e-1 0
RI19 e19 14 82e-3
VS20 11 s20 0
C20 s20 1 56e-5
VS21 25 s21 0
V21 e21 s21 DC 0 AC 15e1 0
RI21 e21 9 68e-3
VS22 14 s22 0
L22 s22 20 22e-3
VS23 21 s23 0
V23 e23 s23 DC 0 AC 10e1 180
RI23 e23 22 39e-2
VS24 19 s24 0
L24 s24 29 27e-2
VS25 27 s25 0
V25 e25 s25 DC 0 AC 56e1 180
RI25 e25 8 27e-2
VS26 16 s26 0
L26 s26 15 33e-4
VS27 22 s27 0
C27 s27 11 82e-7
VS28 16 s28 0
C28 s28 27 27e-5
VS29 15 s29 0
V29 e29 s29 DC 0 AC 15e0 180
RI29 e29 7 56e-3
VS30 22 s30 0
R30 s30 17 22e2
VS31 10 s31 0
L31 s31 22 15e-3
VS32 22 s32 0
V32 e32 s32 DC 0 AC 15e1 180
RI32 e32 19 68e-1
VS33 8 s33 0
R33 s33 12 27e3
VS34 16 s34 0
R34 s34 24 22e0
VS35 24 s35 0
R35 s35 5 12e-2
VS36 0 s36 0
C36 s36 4 10e-7
VS37 26 s37 0
C37 s37 14 10e-4
VS38 25 s38 0
C38 s38 28 68e-5
VS39 24 s39 0
L39 s39 0 10e-3
VS40 15 s40 0
V40 e40 s40 DC 0 AC 68e0 180
RI40 e40 11 10e-1
VS41 10 s41 0
R41 s41 22 68e1
VS42 26 s42 0
C42 s42 20 22e-6
VS43 29 s43 0
R43 s43 23 10e1
VS44 12 s44 0
C44 s44 9 68e-6
VS45 2 s45 0
C45 s45 18 22e-6
VS46 21 s46 0
L46 s46 26 12e-3
.control
set numdgt=17
ac lin 1 60 60
print v(1) v(2) v(3) v(4) v(5) v(6) v(7) v(8) v(9) v(10)
print v(11) v(12) v(13) v(14) v(15) v(16) v(17) v(18) v(19) v(20)
print v(21) v(22) v(23) v(24) v(25) v(26) v(27) v(28) v(29)
print i(vs0) i(vs1) i(vs2) i(vs3) i(vs4) i(vs5) i(vs6) i(vs7) i(vs8) i(vs9)
print i(vs10) i(vs11) i(vs12) i(vs13) i(vs14) i(vs15) i(vs16) i(vs17) i(vs18) i(vs19)
print i(vs20) i(vs21) i(vs22) i(vs23) i(vs24) i(vs25) i(vs26) i(vs27) i(vs28) i(vs29)
print i(vs30) i(vs31) i(vs32) i(vs33) i(vs34) i(vs35) i(vs36) i(vs37) i(vs38) i(vs39)
print i(vs40) i(vs41) i(vs42) i(vs43) i(vs44) i(vs45) i(vs46)
.endc
.end
