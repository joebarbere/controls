controls oracle ac-0154
* Generated (plan F2.7, ADR 0012): do not edit; regenerate with `pnpm sim oracle regen`. ac seed 20261031 index 154 nodes 30 elements 49
.options sparse gmin=1e-12 noopac
RG1 1 0 1000000000000
RG2 2 0 1000000000000
RG3 3 0 1000000000000
RG4 4 0 1000000000000
RG5 5 0 1000000000000
RG6 6 0 1000000000000
RG7 7 0 1000000000000
RG8 8 0 1000000000000
RG9 9 0 1000000000000
RG10 10 0 1000000000000
RG11 11 0 1000000000000
RG12 12 0 1000000000000
RG13 13 0 1000000000000
RG14 14 0 1000000000000
RG15 15 0 1000000000000
RG16 16 0 1000000000000
RG17 17 0 1000000000000
RG18 18 0 1000000000000
RG19 19 0 1000000000000
RG20 20 0 1000000000000
RG21 21 0 1000000000000
RG22 22 0 1000000000000
RG23 23 0 1000000000000
RG24 24 0 1000000000000
RG25 25 0 1000000000000
RG26 26 0 1000000000000
RG27 27 0 1000000000000
RG28 28 0 1000000000000
RG29 29 0 1000000000000
VS0 27 s0 0
C0 s0 2 33e-4
VS1 10 s1 0
R1 s1 27 68e1
VS2 7 s2 0
R2 s2 20 68e-1
VS3 24 s3 0
R3 s3 5 12e-2
VS4 16 s4 0
L4 s4 15 33e-4
VS5 12 s5 0
L5 s5 5 22e-3
VS6 0 s6 0
V6 e6 s6 DC 0 AC 82e-1 0
RI6 e6 m6 82e-3
LI6 m6 n6 56e-7
H6 n6 h6 VS8 15e-4
ED6 h6 14 d6 0 15e-7
F6 0 d6 VS8 1
LD6 d6 0 1
VS7 10 s7 0
L7 s7 27 15e-3
VS8 0 s8 0
V8 e8 s8 DC 0 AC 56e1 180
RI8 e8 m8 27e-2
LI8 m8 n8 56e-6
H8 n8 h8 VS6 15e-4
ED8 h8 8 d8 0 15e-7
F8 0 d8 VS6 1
LD8 d8 0 1
VS9 24 s9 0
C9 s9 14 33e-4
VS10 2 s10 0
C10 s10 18 22e-6
VS11 27 s11 0
R11 s11 17 22e2
VS12 17 s12 0
R12 s12 7 18e0
VS13 14 s13 0
L13 s13 20 22e-3
VS14 27 s14 0
C14 s14 11 82e-7
VS15 26 s15 0
C15 s15 14 10e-4
VS16 27 s16 0
V16 e16 s16 DC 0 AC 15e1 180
RI16 e16 19 68e-1
VS17 8 s17 0
V17 e17 s17 DC 0 AC 33e0 0
RI17 e17 m17 15e-3
LI17 m17 10 15e-5
VS18 9 s18 0
R18 s18 26 12e0
VS19 22 s19 0
C19 s19 4 10e-7
VS20 24 s20 0
L20 s20 22 10e-3
VS21 6 s21 0
R21 s21 17 12e2
VS22 6 s22 0
C22 s22 27 56e-6
VS23 16 s23 0
C23 s23 0 27e-5
VS24 25 s24 0
V24 e24 s24 DC 0 AC 15e1 0
RI24 e24 9 68e-3
VS25 16 s25 0
R25 s25 24 22e0
VS26 23 s26 0
V26 e26 s26 DC 0 AC 47e1 120
RI26 e26 14 15e-3
VS27 8 s27 0
L27 s27 4 33e-4
VS28 21 s28 0
V28 e28 s28 DC 0 AC 10e1 180
RI28 e28 27 39e-2
VS29 19 s29 0
L29 s29 29 27e-2
VS30 19 s30 0
L30 s30 29 33e-5
VS31 10 s31 0
R31 s31 25 82e1
VS32 25 s32 0
C32 s32 28 68e-5
VS33 29 s33 0
R33 s33 23 10e1
VS34 12 s34 0
C34 s34 9 68e-6
VS35 9 s35 0
C35 s35 28 15e-7
VS36 26 s36 0
C36 s36 20 22e-6
VS37 21 s37 0
L37 s37 26 12e-3
VS38 0 s38 0
R38 s38 4 27e-1
VS39 13 s39 0
R39 s39 12 15e1
VS40 3 s40 0
R40 s40 18 47e-2
VS41 11 s41 0
C41 s41 1 56e-5
VS42 15 s42 0
V42 e42 s42 DC 0 AC 68e0 180
RI42 e42 m42 10e-1
LI42 m42 11 12e-5
VS43 10 s43 0
R43 s43 1 82e-2
VS44 22 s44 0
V44 e44 s44 DC 0 AC 56e-1 180
RI44 e44 m44 27e-2
LI44 m44 3 39e-6
VS45 13 s45 0
L45 s45 1 15e-3
VS46 15 s46 0
V46 e46 s46 DC 0 AC 15e0 180
RI46 e46 m46 56e-3
LI46 m46 7 33e-5
VS47 18 s47 0
L47 s47 25 56e-3
VS48 8 s48 0
R48 s48 12 27e3
.control
set numdgt=17
ac lin 1 60 60
print v(1) v(2) v(3) v(4) v(5) v(6) v(7) v(8) v(9) v(10)
print v(11) v(12) v(13) v(14) v(15) v(16) v(17) v(18) v(19) v(20)
print v(21) v(22) v(23) v(24) v(25) v(26) v(27) v(28) v(29)
print i(vs0) i(vs1) i(vs2) i(vs3) i(vs4) i(vs5) i(vs6) i(vs7) i(vs8) i(vs9)
print i(vs10) i(vs11) i(vs12) i(vs13) i(vs14) i(vs15) i(vs16) i(vs17) i(vs18) i(vs19)
print i(vs20) i(vs21) i(vs22) i(vs23) i(vs24) i(vs25) i(vs26) i(vs27) i(vs28) i(vs29)
print i(vs30) i(vs31) i(vs32) i(vs33) i(vs34) i(vs35) i(vs36) i(vs37) i(vs38) i(vs39)
print i(vs40) i(vs41) i(vs42) i(vs43) i(vs44) i(vs45) i(vs46) i(vs47) i(vs48)
.endc
.end
