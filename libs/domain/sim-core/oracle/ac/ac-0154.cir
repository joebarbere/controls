controls oracle ac-0154
* Generated (plan F2.7, ADR 0012): do not edit; regenerate with `pnpm sim oracle regen`. ac seed 20261031 index 154 nodes 30 elements 55
.options sparse gmin=1e-12 noopac
RG1 1 0 1000000000000
RG2 2 0 1000000000000
RG3 3 0 1000000000000
RG4 4 0 1000000000000
RG5 5 0 1000000000000
RG6 6 0 1000000000000
RG7 7 0 1000000000000
RG8 8 0 1000000000000
RG9 9 0 1000000000000
RG10 10 0 1000000000000
RG11 11 0 1000000000000
RG12 12 0 1000000000000
RG13 13 0 1000000000000
RG14 14 0 1000000000000
RG15 15 0 1000000000000
RG16 16 0 1000000000000
RG17 17 0 1000000000000
RG18 18 0 1000000000000
RG19 19 0 1000000000000
RG20 20 0 1000000000000
RG21 21 0 1000000000000
RG22 22 0 1000000000000
RG23 23 0 1000000000000
RG24 24 0 1000000000000
RG25 25 0 1000000000000
RG26 26 0 1000000000000
RG27 27 0 1000000000000
RG28 28 0 1000000000000
RG29 29 0 1000000000000
VS0 0 s0 0
V0 e0 s0 DC 0 AC 15e1 180
RI0 e0 m0 68e-1
LI0 m0 19 12e-5
VS1 0 s1 0
L1 s1 23 56e-5
VS2 17 s2 0
R2 s2 7 18e0
VS3 18 s3 0
C3 s3 14 68e-4
VS4 0 s4 0
C4 s4 2 33e-4
VS5 7 s5 0
R5 s5 20 68e-1
VS6 12 s6 0
C6 s6 25 82e-5
VS7 12 s7 0
L7 s7 18 68e-5
VS8 28 s8 0
R8 s8 18 12e3
VS9 10 s9 0
L9 s9 25 33e-2
VS10 24 s10 0
V10 e10 s10 DC 0 AC 47e-1 180
RI10 e10 19 33e-1
VS11 11 s11 0
C11 s11 25 47e-4
VS12 12 s12 0
R12 s12 29 22e1
VS13 20 s13 0
C13 s13 28 18e-6
VS14 22 s14 0
R14 s14 16 56e3
VS15 22 s15 0
C15 s15 4 10e-7
VS16 0 s16 0
R16 s16 17 22e2
VS17 7 s17 0
L17 s17 15 22e-4
VS18 3 s18 0
V18 e18 s18 DC 0 AC 15e1 180
RI18 e18 m18 10e-1
LI18 m18 20 68e-5
VS19 28 s19 0
L19 s19 27 22e-2
VS20 6 s20 0
V20 e20 s20 DC 0 AC 18e-1 120
RI20 e20 4 15e-3
VS21 28 s21 0
C21 s21 16 18e-6
VS22 20 s22 0
L22 s22 7 15e-3
VS23 16 s23 0
C23 s23 7 15e-5
VS24 19 s24 0
L24 s24 29 27e-2
VS25 26 s25 0
R25 s25 4 27e2
VS26 25 s26 0
C26 s26 28 68e-5
VS27 9 s27 0
R27 s27 0 47e0
VS28 7 s28 0
C28 s28 24 82e-6
VS29 27 s29 0
R29 s29 28 18e0
VS30 14 s30 0
L30 s30 20 22e-3
VS31 8 s31 0
R31 s31 12 27e3
VS32 6 s32 0
C32 s32 0 56e-6
VS33 5 s33 0
V33 e33 s33 DC 0 AC 18e1 -120
RI33 e33 3 47e-1
VS34 18 s34 0
L34 s34 28 47e-2
VS35 27 s35 0
V35 e35 s35 DC 0 AC 82e-1 0
RI35 e35 14 82e-3
VS36 17 s36 0
C36 s36 2 22e-6
VS37 8 s37 0
L37 s37 4 33e-4
VS38 8 s38 0
R38 s38 20 82e2
VS39 11 s39 0
C39 s39 7 15e-6
VS40 1 s40 0
C40 s40 26 56e-6
VS41 16 s41 0
C41 s41 4 15e-5
VS42 10 s42 0
R42 s42 1 82e-2
VS43 25 s43 0
C43 s43 8 15e-6
VS44 21 s44 0
V44 e44 s44 DC 0 AC 33e-1 0
RI44 e44 m44 56e-3
LI44 m44 7 12e-6
VS45 12 s45 0
L45 s45 15 68e-5
VS46 19 s46 0
L46 s46 13 39e-5
VS47 12 s47 0
C47 s47 1 12e-4
VS48 5 s48 0
C48 s48 25 47e-7
VS49 12 s49 0
C49 s49 9 68e-6
VS50 16 s50 0
L50 s50 23 27e-4
VS51 13 s51 0
R51 s51 21 82e-1
VS52 20 s52 0
R52 s52 4 10e2
VS53 20 s53 0
C53 s53 13 68e-7
VS54 10 s54 0
R54 s54 0 68e1
.control
set numdgt=17
ac lin 1 60 60
print v(1) v(2) v(3) v(4) v(5) v(6) v(7) v(8) v(9) v(10)
print v(11) v(12) v(13) v(14) v(15) v(16) v(17) v(18) v(19) v(20)
print v(21) v(22) v(23) v(24) v(25) v(26) v(27) v(28) v(29)
print i(vs0) i(vs1) i(vs2) i(vs3) i(vs4) i(vs5) i(vs6) i(vs7) i(vs8) i(vs9)
print i(vs10) i(vs11) i(vs12) i(vs13) i(vs14) i(vs15) i(vs16) i(vs17) i(vs18) i(vs19)
print i(vs20) i(vs21) i(vs22) i(vs23) i(vs24) i(vs25) i(vs26) i(vs27) i(vs28) i(vs29)
print i(vs30) i(vs31) i(vs32) i(vs33) i(vs34) i(vs35) i(vs36) i(vs37) i(vs38) i(vs39)
print i(vs40) i(vs41) i(vs42) i(vs43) i(vs44) i(vs45) i(vs46) i(vs47) i(vs48) i(vs49)
print i(vs50) i(vs51) i(vs52) i(vs53) i(vs54)
.endc
.end
