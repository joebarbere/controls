controls oracle ac-0224
* Generated (plan F2.7, ADR 0012): do not edit; regenerate with `pnpm sim oracle regen`. ac seed 20261031 index 224 nodes 16 elements 22
.options sparse gmin=1e-12 noopac
RG1 1 0 1000000000000
RG2 2 0 1000000000000
RG3 3 0 1000000000000
RG4 4 0 1000000000000
RG5 5 0 1000000000000
RG6 6 0 1000000000000
RG7 7 0 1000000000000
RG8 8 0 1000000000000
RG9 9 0 1000000000000
RG10 10 0 1000000000000
RG11 11 0 1000000000000
RG12 12 0 1000000000000
RG13 13 0 1000000000000
RG14 14 0 1000000000000
RG15 15 0 1000000000000
VS0 14 s0 0
L0 s0 10 33e-4
VS1 13 s1 0
L1 s1 1 56e-4
VS2 6 s2 0
L2 s2 7 33e-4
VS3 6 s3 0
L3 s3 10 27e-5
VS4 7 s4 0
R4 s4 1 10e0
VS5 7 s5 0
R5 s5 13 27e-1
VS6 12 s6 0
C6 s6 15 10e-5
VS7 11 s7 0
L7 s7 8 15e-2
VS8 10 s8 0
L8 s8 8 22e-4
VS9 4 s9 0
L9 s9 12 33e-4
VS10 0 s10 0
R10 s10 11 56e2
VS11 14 s11 0
R11 s11 5 22e2
VS12 0 s12 0
V12 e12 s12 DC 0 AC 27e1 180
RI12 e12 m12 82e-1
LI12 m12 11 18e-7
VS13 8 s13 0
R13 s13 7 27e0
VS14 14 s14 0
R14 s14 2 56e-1
VS15 4 s15 0
V15 e15 s15 DC 0 AC 82e0 180
RI15 e15 8 12e-1
VS16 9 s16 0
R16 s16 15 15e3
VS17 3 s17 0
L17 s17 7 33e-4
VS18 3 s18 0
L18 s18 5 82e-4
VS19 7 s19 0
V19 e19 s19 DC 0 AC 56e0 180
RI19 e19 m19 68e-3
LI19 m19 2 33e-7
VS20 13 s20 0
C20 s20 9 10e-7
VS21 13 s21 0
C21 s21 0 15e-4
.control
set numdgt=17
ac lin 1 60 60
print v(1) v(2) v(3) v(4) v(5) v(6) v(7) v(8) v(9) v(10)
print v(11) v(12) v(13) v(14) v(15)
print i(vs0) i(vs1) i(vs2) i(vs3) i(vs4) i(vs5) i(vs6) i(vs7) i(vs8) i(vs9)
print i(vs10) i(vs11) i(vs12) i(vs13) i(vs14) i(vs15) i(vs16) i(vs17) i(vs18) i(vs19)
print i(vs20) i(vs21)
.endc
.end
