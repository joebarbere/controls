controls oracle ac-0224
* Generated (plan F2.7, ADR 0012): do not edit; regenerate with `pnpm sim oracle regen`. ac seed 20261031 index 224 nodes 16 elements 30
.options sparse gmin=1e-12 noopac
RG1 1 0 1000000000000
RG2 2 0 1000000000000
RG3 3 0 1000000000000
RG4 4 0 1000000000000
RG5 5 0 1000000000000
RG6 6 0 1000000000000
RG7 7 0 1000000000000
RG8 8 0 1000000000000
RG9 9 0 1000000000000
RG10 10 0 1000000000000
RG11 11 0 1000000000000
RG12 12 0 1000000000000
RG13 13 0 1000000000000
RG14 14 0 1000000000000
RG15 15 0 1000000000000
VS0 0 s0 0
V0 e0 s0 DC 0 AC 39e-1 180
RI0 e0 11 56e-1
VS1 1 s1 0
R1 s1 9 56e1
VS2 8 s2 0
R2 s2 7 27e0
VS3 15 s3 0
V3 e3 s3 DC 0 AC 47e1 -120
RI3 e3 10 68e-2
VS4 8 s4 0
C4 s4 11 15e-7
VS5 7 s5 0
R5 s5 8 12e3
VS6 3 s6 0
L6 s6 7 33e-4
VS7 6 s7 0
L7 s7 7 33e-4
VS8 8 s8 0
C8 s8 4 33e-6
VS9 10 s9 0
L9 s9 11 39e-4
VS10 2 s10 0
R10 s10 13 82e0
VS11 12 s11 0
L11 s11 3 22e-3
VS12 13 s12 0
V12 e12 s12 DC 0 AC 15e-1 0
RI12 e12 12 12e-2
VS13 10 s13 0
L13 s13 8 22e-4
VS14 9 s14 0
V14 e14 s14 DC 0 AC 82e1 180
RI14 e14 m14 82e-2
LI14 m14 6 22e-6
VS15 1 s15 0
L15 s15 11 68e-3
VS16 2 s16 0
C16 s16 12 10e-4
VS17 4 s17 0
V17 e17 s17 DC 0 AC 82e0 180
RI17 e17 m17 12e-1
LI17 m17 8 82e-7
VS18 0 s18 0
L18 s18 11 12e-4
VS19 3 s19 0
L19 s19 5 82e-4
VS20 9 s20 0
R20 s20 15 15e3
VS21 4 s21 0
C21 s21 2 15e-6
VS22 13 s22 0
V22 e22 s22 DC 0 AC 82e-1 0
RI22 e22 m22 15e-3
LI22 m22 1 47e-6
VS23 7 s23 0
R23 s23 13 27e-1
VS24 13 s24 0
L24 s24 0 22e-5
VS25 14 s25 0
R25 s25 11 56e2
VS26 13 s26 0
C26 s26 14 15e-4
VS27 13 s27 0
R27 s27 5 18e3
VS28 11 s28 0
V28 e28 s28 DC 0 AC 39e-1 0
RI28 e28 4 56e-3
VS29 13 s29 0
C29 s29 9 10e-7
.control
set numdgt=17
ac lin 1 60 60
print v(1) v(2) v(3) v(4) v(5) v(6) v(7) v(8) v(9) v(10)
print v(11) v(12) v(13) v(14) v(15)
print i(vs0) i(vs1) i(vs2) i(vs3) i(vs4) i(vs5) i(vs6) i(vs7) i(vs8) i(vs9)
print i(vs10) i(vs11) i(vs12) i(vs13) i(vs14) i(vs15) i(vs16) i(vs17) i(vs18) i(vs19)
print i(vs20) i(vs21) i(vs22) i(vs23) i(vs24) i(vs25) i(vs26) i(vs27) i(vs28) i(vs29)
.endc
.end
