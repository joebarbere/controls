controls oracle ac-0224
* Generated (plan F2.7, ADR 0012): do not edit; regenerate with `pnpm sim oracle regen`. ac seed 20261031 index 224 nodes 16 elements 26
.options sparse gmin=1e-12 noopac
RG1 1 0 1000000000000
RG2 2 0 1000000000000
RG3 3 0 1000000000000
RG4 4 0 1000000000000
RG5 5 0 1000000000000
RG6 6 0 1000000000000
RG7 7 0 1000000000000
RG8 8 0 1000000000000
RG9 9 0 1000000000000
RG10 10 0 1000000000000
RG11 11 0 1000000000000
RG12 12 0 1000000000000
RG13 13 0 1000000000000
RG14 14 0 1000000000000
RG15 15 0 1000000000000
VS0 0 s0 0
L0 s0 11 12e-4
VS1 0 s1 0
V1 e1 s1 DC 0 AC 39e-1 180
RI1 e1 11 56e-1
VS2 13 s2 0
V2 e2 s2 DC 0 AC 82e-1 0
RI2 e2 1 15e-3
VS3 12 s3 0
L3 s3 3 22e-3
VS4 7 s4 0
R4 s4 8 12e3
VS5 6 s5 0
L5 s5 7 33e-4
VS6 1 s6 0
R6 s6 9 56e1
VS7 13 s7 0
C7 s7 14 15e-4
VS8 4 s8 0
C8 s8 2 15e-6
VS9 2 s9 0
C9 s9 12 10e-4
VS10 8 s10 0
C10 s10 4 33e-6
VS11 4 s11 0
V11 e11 s11 DC 0 AC 82e0 180
RI11 e11 8 12e-1
VS12 14 s12 0
R12 s12 11 56e2
VS13 7 s13 0
R13 s13 13 27e-1
VS14 8 s14 0
R14 s14 7 27e0
VS15 1 s15 0
L15 s15 11 68e-3
VS16 11 s16 0
V16 e16 s16 DC 0 AC 39e-1 0
RI16 e16 4 56e-3
VS17 9 s17 0
R17 s17 15 15e3
VS18 8 s18 0
C18 s18 11 15e-7
VS19 13 s19 0
V19 e19 s19 DC 0 AC 15e-1 0
RI19 e19 12 12e-2
VS20 2 s20 0
R20 s20 13 82e0
VS21 3 s21 0
L21 s21 7 33e-4
VS22 3 s22 0
L22 s22 5 82e-4
VS23 10 s23 0
L23 s23 8 22e-4
VS24 13 s24 0
C24 s24 9 10e-7
VS25 13 s25 0
L25 s25 0 22e-5
.control
set numdgt=17
ac lin 1 60 60
print v(1) v(2) v(3) v(4) v(5) v(6) v(7) v(8) v(9) v(10)
print v(11) v(12) v(13) v(14) v(15)
print i(vs0) i(vs1) i(vs2) i(vs3) i(vs4) i(vs5) i(vs6) i(vs7) i(vs8) i(vs9)
print i(vs10) i(vs11) i(vs12) i(vs13) i(vs14) i(vs15) i(vs16) i(vs17) i(vs18) i(vs19)
print i(vs20) i(vs21) i(vs22) i(vs23) i(vs24) i(vs25)
.endc
.end
