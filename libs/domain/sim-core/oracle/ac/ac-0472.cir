controls oracle ac-0472
* Generated (plan F2.7, ADR 0012): do not edit; regenerate with `pnpm sim oracle regen`. ac seed 20261031 index 472 nodes 23 elements 32
.options sparse gmin=1e-12 noopac
RG1 1 0 1000000000000
RG2 2 0 1000000000000
RG3 3 0 1000000000000
RG4 4 0 1000000000000
RG5 5 0 1000000000000
RG6 6 0 1000000000000
RG7 7 0 1000000000000
RG8 8 0 1000000000000
RG9 9 0 1000000000000
RG10 10 0 1000000000000
RG11 11 0 1000000000000
RG12 12 0 1000000000000
RG13 13 0 1000000000000
RG14 14 0 1000000000000
RG15 15 0 1000000000000
RG16 16 0 1000000000000
RG17 17 0 1000000000000
RG18 18 0 1000000000000
RG19 19 0 1000000000000
RG20 20 0 1000000000000
RG21 21 0 1000000000000
RG22 22 0 1000000000000
VS0 11 s0 0
L0 s0 14 39e-4
VS1 7 s1 0
C1 s1 6 56e-7
VS2 4 s2 0
R2 s2 10 27e2
VS3 20 s3 0
C3 s3 22 33e-4
VS4 21 s4 0
C4 s4 10 68e-5
VS5 11 s5 0
R5 s5 18 68e-1
VS6 11 s6 0
R6 s6 12 56e0
VS7 16 s7 0
C7 s7 10 68e-5
VS8 11 s8 0
L8 s8 17 82e-3
VS9 21 s9 0
L9 s9 22 27e-2
VS10 0 s10 0
V10 e10 s10 DC 0 AC 10e-1 0
RI10 e10 11 47e-1
VS11 22 s11 0
R11 s11 8 47e-1
VS12 1 s12 0
R12 s12 13 27e0
VS13 17 s13 0
R13 s13 12 10e0
VS14 12 s14 0
V14 e14 s14 DC 0 AC 56e1 0
RI14 e14 5 56e-3
VS15 22 s15 0
L15 s15 1 33e-3
VS16 12 s16 0
C16 s16 18 18e-6
VS17 12 s17 0
C17 s17 5 27e-4
VS18 9 s18 0
R18 s18 21 10e2
VS19 16 s19 0
C19 s19 17 18e-4
VS20 18 s20 0
V20 e20 s20 DC 0 AC 22e-1 180
RI20 e20 8 15e-1
VS21 11 s21 0
R21 s21 21 15e0
VS22 12 s22 0
R22 s22 6 68e-2
VS23 11 s23 0
C23 s23 15 47e-5
VS24 12 s24 0
V24 e24 s24 DC 0 AC 56e0 180
RI24 e24 3 10e-1
VS25 19 s25 0
R25 s25 3 33e-1
VS26 19 s26 0
R26 s26 14 47e-1
VS27 10 s27 0
L27 s27 2 68e-3
VS28 3 s28 0
R28 s28 0 39e-1
VS29 20 s29 0
V29 e29 s29 DC 0 AC 33e1 -120
RI29 e29 6 10e-3
VS30 14 s30 0
C30 s30 21 22e-5
VS31 4 s31 0
R31 s31 15 10e3
.control
set numdgt=17
ac lin 1 60 60
print v(1) v(2) v(3) v(4) v(5) v(6) v(7) v(8) v(9) v(10)
print v(11) v(12) v(13) v(14) v(15) v(16) v(17) v(18) v(19) v(20)
print v(21) v(22)
print i(vs0) i(vs1) i(vs2) i(vs3) i(vs4) i(vs5) i(vs6) i(vs7) i(vs8) i(vs9)
print i(vs10) i(vs11) i(vs12) i(vs13) i(vs14) i(vs15) i(vs16) i(vs17) i(vs18) i(vs19)
print i(vs20) i(vs21) i(vs22) i(vs23) i(vs24) i(vs25) i(vs26) i(vs27) i(vs28) i(vs29)
print i(vs30) i(vs31)
.endc
.end
