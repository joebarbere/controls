controls oracle ac-0472
* Generated (plan F2.7, ADR 0012): do not edit; regenerate with `pnpm sim oracle regen`. ac seed 20261031 index 472 nodes 23 elements 37
.options sparse gmin=1e-12 noopac
RG1 1 0 1000000000000
RG2 2 0 1000000000000
RG3 3 0 1000000000000
RG4 4 0 1000000000000
RG5 5 0 1000000000000
RG6 6 0 1000000000000
RG7 7 0 1000000000000
RG8 8 0 1000000000000
RG9 9 0 1000000000000
RG10 10 0 1000000000000
RG11 11 0 1000000000000
RG12 12 0 1000000000000
RG13 13 0 1000000000000
RG14 14 0 1000000000000
RG15 15 0 1000000000000
RG16 16 0 1000000000000
RG17 17 0 1000000000000
RG18 18 0 1000000000000
RG19 19 0 1000000000000
RG20 20 0 1000000000000
RG21 21 0 1000000000000
RG22 22 0 1000000000000
VS0 0 s0 0
R0 s0 21 10e2
VS1 11 s1 0
L1 s1 14 39e-4
VS2 1 s2 0
R2 s2 7 27e2
VS3 15 s3 0
R3 s3 19 27e0
VS4 21 s4 0
C4 s4 16 18e-4
VS5 17 s5 0
L5 s5 20 33e-3
VS6 11 s6 0
C6 s6 9 56e-4
VS7 4 s7 0
R7 s7 6 68e-2
VS8 11 s8 0
C8 s8 5 56e-7
VS9 3 s9 0
L9 s9 21 12e-4
VS10 0 s10 0
C10 s10 12 33e-5
VS11 17 s11 0
R11 s11 10 33e0
VS12 19 s12 0
C12 s12 14 27e-6
VS13 0 s13 0
V13 e13 s13 DC 0 AC 12e1 -120
RI13 e13 m13 47e-1
LI13 m13 1 39e-5
VS14 11 s14 0
C14 s14 3 39e-5
VS15 21 s15 0
R15 s15 9 27e1
VS16 11 s16 0
R16 s16 4 56e0
VS17 22 s17 0
L17 s17 17 39e-4
VS18 8 s18 0
V18 e18 s18 DC 0 AC 82e1 0
RI18 e18 m18 39e-1
LI18 m18 3 39e-7
VS19 11 s19 0
R19 s19 21 15e0
VS20 13 s20 0
V20 e20 s20 DC 0 AC 82e1 120
RI20 e20 m20 15e-1
LI20 m20 22 56e-6
VS21 7 s21 0
R21 s21 2 33e-1
VS22 6 s22 0
V22 e22 s22 DC 0 AC 12e-1 180
RI22 e22 m22 82e-1
LI22 m22 4 27e-6
VS23 20 s23 0
C23 s23 18 22e-5
VS24 18 s24 0
C24 s24 6 56e-7
VS25 21 s25 0
C25 s25 10 68e-5
VS26 21 s26 0
V26 e26 s26 DC 0 AC 68e0 180
RI26 e26 m26 15e-2
LI26 m26 15 33e-6
VS27 21 s27 0
L27 s27 14 68e-5
VS28 12 s28 0
V28 e28 s28 DC 0 AC 10e-1 0
RI28 e28 11 47e-1
VS29 2 s29 0
C29 s29 8 15e-4
VS30 10 s30 0
R30 s30 5 22e0
VS31 13 s31 0
C31 s31 0 10e-6
VS32 12 s32 0
C32 s32 2 18e-7
VS33 17 s33 0
C33 s33 6 82e-7
VS34 8 s34 0
V34 e34 s34 DC 0 AC 10e-1 -120
RI34 e34 m34 33e-3
LI34 m34 7 68e-5
VS35 21 s35 0
L35 s35 20 10e-5
VS36 22 s36 0
R36 s36 16 22e-2
.control
set numdgt=17
ac lin 1 60 60
print v(1) v(2) v(3) v(4) v(5) v(6) v(7) v(8) v(9) v(10)
print v(11) v(12) v(13) v(14) v(15) v(16) v(17) v(18) v(19) v(20)
print v(21) v(22)
print i(vs0) i(vs1) i(vs2) i(vs3) i(vs4) i(vs5) i(vs6) i(vs7) i(vs8) i(vs9)
print i(vs10) i(vs11) i(vs12) i(vs13) i(vs14) i(vs15) i(vs16) i(vs17) i(vs18) i(vs19)
print i(vs20) i(vs21) i(vs22) i(vs23) i(vs24) i(vs25) i(vs26) i(vs27) i(vs28) i(vs29)
print i(vs30) i(vs31) i(vs32) i(vs33) i(vs34) i(vs35) i(vs36)
.endc
.end
