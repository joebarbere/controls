controls oracle ac-0472
* Generated (plan F2.7, ADR 0012): do not edit; regenerate with `pnpm sim oracle regen`. ac seed 20261031 index 472 nodes 23 elements 36
.options sparse gmin=1e-12 noopac
RG1 1 0 1000000000000
RG2 2 0 1000000000000
RG3 3 0 1000000000000
RG4 4 0 1000000000000
RG5 5 0 1000000000000
RG6 6 0 1000000000000
RG7 7 0 1000000000000
RG8 8 0 1000000000000
RG9 9 0 1000000000000
RG10 10 0 1000000000000
RG11 11 0 1000000000000
RG12 12 0 1000000000000
RG13 13 0 1000000000000
RG14 14 0 1000000000000
RG15 15 0 1000000000000
RG16 16 0 1000000000000
RG17 17 0 1000000000000
RG18 18 0 1000000000000
RG19 19 0 1000000000000
RG20 20 0 1000000000000
RG21 21 0 1000000000000
RG22 22 0 1000000000000
VS0 10 s0 0
L0 s0 2 68e-3
VS1 0 s1 0
V1 e1 s1 DC 0 AC 56e1 0
RI1 e1 n1 56e-3
H1 n1 h1 VS6 -10e-4
ED1 h1 5 d1 0 -47e-7
F1 0 d1 VS6 1
LD1 d1 0 1
VS2 20 s2 0
C2 s2 22 33e-4
VS3 11 s3 0
L3 s3 14 39e-4
VS4 19 s4 0
R4 s4 14 47e-1
VS5 11 s5 0
R5 s5 21 15e0
VS6 20 s6 0
V6 e6 s6 DC 0 AC 33e1 -120
RI6 e6 n6 10e-3
H6 n6 h6 VS1 -10e-4
ED6 h6 6 d6 0 -47e-7
F6 0 d6 VS1 1
LD6 d6 0 1
VS7 11 s7 0
R7 s7 0 56e0
VS8 0 s8 0
V8 e8 s8 DC 0 AC 56e0 180
RI8 e8 3 10e-1
VS9 19 s9 0
R9 s9 3 33e-1
VS10 7 s10 0
C10 s10 6 56e-7
VS11 22 s11 0
R11 s11 8 47e-1
VS12 16 s12 0
C12 s12 17 18e-4
VS13 11 s13 0
R13 s13 18 68e-1
VS14 1 s14 0
R14 s14 13 27e0
VS15 16 s15 0
C15 s15 10 68e-5
VS16 21 s16 0
C16 s16 10 68e-5
VS17 21 s17 0
L17 s17 22 27e-2
VS18 12 s18 0
V18 e18 s18 DC 0 AC 18e0 0
RI18 e18 m18 56e-1
LI18 m18 7 39e-5
VS19 11 s19 0
L19 s19 17 82e-3
VS20 14 s20 0
C20 s20 21 22e-5
VS21 0 s21 0
R21 s21 6 68e-2
VS22 3 s22 0
R22 s22 12 39e-1
VS23 22 s23 0
L23 s23 1 33e-3
VS24 4 s24 0
R24 s24 10 27e2
VS25 4 s25 0
R25 s25 15 10e3
VS26 17 s26 0
R26 s26 0 10e0
VS27 20 s27 0
L27 s27 2 27e-2
VS28 0 s28 0
C28 s28 18 18e-6
VS29 9 s29 0
L29 s29 5 10e-5
VS30 13 s30 0
R30 s30 6 18e-2
VS31 9 s31 0
R31 s31 21 10e2
VS32 11 s32 0
C32 s32 15 47e-5
VS33 0 s33 0
C33 s33 5 27e-4
VS34 12 s34 0
V34 e34 s34 DC 0 AC 10e-1 0
RI34 e34 11 47e-1
VS35 18 s35 0
V35 e35 s35 DC 0 AC 22e-1 180
RI35 e35 8 15e-1
.control
set numdgt=17
ac lin 1 60 60
print v(1) v(2) v(3) v(4) v(5) v(6) v(7) v(8) v(9) v(10)
print v(11) v(12) v(13) v(14) v(15) v(16) v(17) v(18) v(19) v(20)
print v(21) v(22)
print i(vs0) i(vs1) i(vs2) i(vs3) i(vs4) i(vs5) i(vs6) i(vs7) i(vs8) i(vs9)
print i(vs10) i(vs11) i(vs12) i(vs13) i(vs14) i(vs15) i(vs16) i(vs17) i(vs18) i(vs19)
print i(vs20) i(vs21) i(vs22) i(vs23) i(vs24) i(vs25) i(vs26) i(vs27) i(vs28) i(vs29)
print i(vs30) i(vs31) i(vs32) i(vs33) i(vs34) i(vs35)
.endc
.end
