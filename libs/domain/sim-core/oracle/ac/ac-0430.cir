controls oracle ac-0430
* Generated (plan F2.7, ADR 0012): do not edit; regenerate with `pnpm sim oracle regen`. ac seed 20261031 index 430 nodes 9 elements 17
.options sparse gmin=1e-12 noopac
RG1 1 0 1000000000000
RG2 2 0 1000000000000
RG3 3 0 1000000000000
RG4 4 0 1000000000000
RG5 5 0 1000000000000
RG6 6 0 1000000000000
RG7 7 0 1000000000000
RG8 8 0 1000000000000
VS0 7 s0 0
R0 s0 4 22e-2
VS1 7 s1 0
L1 s1 1 39e-5
VS2 1 s2 0
C2 s2 8 47e-5
VS3 4 s3 0
L3 s3 1 39e-4
VS4 0 s4 0
V4 e4 s4 DC 0 AC 10e-1 -120
RI4 e4 6 68e-1
VS5 2 s5 0
L5 s5 3 68e-3
VS6 2 s6 0
C6 s6 1 39e-6
VS7 6 s7 0
R7 s7 5 39e-1
VS8 8 s8 0
L8 s8 4 82e-5
VS9 7 s9 0
R9 s9 8 18e3
VS10 0 s10 0
R10 s10 4 15e-1
VS11 0 s11 0
C11 s11 7 10e-4
VS12 0 s12 0
C12 s12 5 22e-4
VS13 3 s13 0
R13 s13 5 15e3
VS14 3 s14 0
C14 s14 7 10e-4
VS15 4 s15 0
R15 s15 2 27e1
VS16 6 s16 0
L16 s16 3 68e-4
.control
set numdgt=17
ac lin 1 60 60
print v(1) v(2) v(3) v(4) v(5) v(6) v(7) v(8)
print i(vs0) i(vs1) i(vs2) i(vs3) i(vs4) i(vs5) i(vs6) i(vs7) i(vs8) i(vs9)
print i(vs10) i(vs11) i(vs12) i(vs13) i(vs14) i(vs15) i(vs16)
.endc
.end
