controls oracle ac-0430
* Generated (plan F2.7, ADR 0012): do not edit; regenerate with `pnpm sim oracle regen`. ac seed 20261031 index 430 nodes 9 elements 19
.options sparse gmin=1e-12 noopac
RG1 1 0 1000000000000
RG2 2 0 1000000000000
RG3 3 0 1000000000000
RG4 4 0 1000000000000
RG5 5 0 1000000000000
RG6 6 0 1000000000000
RG7 7 0 1000000000000
RG8 8 0 1000000000000
VS0 3 s0 0
C0 s0 6 10e-4
VS1 7 s1 0
L1 s1 8 39e-5
VS2 1 s2 0
C2 s2 8 47e-5
VS3 0 s3 0
L3 s3 3 68e-4
VS4 0 s4 0
L4 s4 4 47e-2
VS5 0 s5 0
V5 e5 s5 DC 0 AC 82e1 0
RI5 e5 6 18e-1
VS6 0 s6 0
C6 s6 1 22e-5
VS7 3 s7 0
C7 s7 1 27e-6
VS8 6 s8 0
L8 s8 1 39e-5
VS9 5 s9 0
L9 s9 3 22e-5
VS10 4 s10 0
L10 s10 1 39e-4
VS11 7 s11 0
R11 s11 6 12e-1
VS12 3 s12 0
R12 s12 5 15e3
VS13 2 s13 0
C13 s13 1 39e-6
VS14 2 s14 0
C14 s14 6 10e-7
VS15 0 s15 0
C15 s15 7 12e-7
VS16 7 s16 0
C16 s16 6 10e-4
VS17 7 s17 0
V17 e17 s17 DC 0 AC 10e-1 -120
RI17 e17 0 68e-1
VS18 5 s18 0
C18 s18 1 22e-5
.control
set numdgt=17
ac lin 1 60 60
print v(1) v(2) v(3) v(4) v(5) v(6) v(7) v(8)
print i(vs0) i(vs1) i(vs2) i(vs3) i(vs4) i(vs5) i(vs6) i(vs7) i(vs8) i(vs9)
print i(vs10) i(vs11) i(vs12) i(vs13) i(vs14) i(vs15) i(vs16) i(vs17) i(vs18)
.endc
.end
