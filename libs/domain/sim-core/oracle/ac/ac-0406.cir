controls oracle ac-0406
* Generated (plan F2.7, ADR 0012): do not edit; regenerate with `pnpm sim oracle regen`. ac seed 20261031 index 406 nodes 15 elements 23
.options sparse gmin=1e-12 noopac
RG1 1 0 1000000000000
RG2 2 0 1000000000000
RG3 3 0 1000000000000
RG4 4 0 1000000000000
RG5 5 0 1000000000000
RG6 6 0 1000000000000
RG7 7 0 1000000000000
RG8 8 0 1000000000000
RG9 9 0 1000000000000
RG10 10 0 1000000000000
RG11 11 0 1000000000000
RG12 12 0 1000000000000
RG13 13 0 1000000000000
RG14 14 0 1000000000000
VS0 2 s0 0
R0 s0 3 18e-1
VS1 3 s1 0
R1 s1 7 27e2
VS2 11 s2 0
C2 s2 2 56e-6
VS3 1 s3 0
R3 s3 11 56e-1
VS4 0 s4 0
V4 e4 s4 DC 0 AC 18e1 120
RI4 e4 2 47e-1
VS5 3 s5 0
C5 s5 12 33e-4
VS6 0 s6 0
C6 s6 14 15e-7
VS7 1 s7 0
R7 s7 6 27e2
VS8 7 s8 0
R8 s8 9 10e3
VS9 3 s9 0
R9 s9 4 22e0
VS10 3 s10 0
C10 s10 1 82e-7
VS11 1 s11 0
C11 s11 8 27e-5
VS12 3 s12 0
L12 s12 13 10e-2
VS13 5 s13 0
R13 s13 6 39e3
VS14 11 s14 0
L14 s14 7 22e-4
VS15 12 s15 0
V15 e15 s15 DC 0 AC 82e-1 180
RI15 e15 0 82e-2
VS16 7 s16 0
L16 s16 10 15e-5
VS17 8 s17 0
C17 s17 10 12e-6
VS18 9 s18 0
V18 e18 s18 DC 0 AC 56e0 0
RI18 e18 14 56e-1
VS19 14 s19 0
R19 s19 5 82e1
VS20 5 s20 0
R20 s20 12 68e0
VS21 13 s21 0
R21 s21 0 12e1
VS22 13 s22 0
L22 s22 0 39e-3
.control
set numdgt=17
ac lin 1 60 60
print v(1) v(2) v(3) v(4) v(5) v(6) v(7) v(8) v(9) v(10)
print v(11) v(12) v(13) v(14)
print i(vs0) i(vs1) i(vs2) i(vs3) i(vs4) i(vs5) i(vs6) i(vs7) i(vs8) i(vs9)
print i(vs10) i(vs11) i(vs12) i(vs13) i(vs14) i(vs15) i(vs16) i(vs17) i(vs18) i(vs19)
print i(vs20) i(vs21) i(vs22)
.endc
.end
