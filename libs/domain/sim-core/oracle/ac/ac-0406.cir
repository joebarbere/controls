controls oracle ac-0406
* Generated (plan F2.7, ADR 0012): do not edit; regenerate with `pnpm sim oracle regen`. ac seed 20261031 index 406 nodes 15 elements 24
.options sparse gmin=1e-12 noopac
RG1 1 0 1000000000000
RG2 2 0 1000000000000
RG3 3 0 1000000000000
RG4 4 0 1000000000000
RG5 5 0 1000000000000
RG6 6 0 1000000000000
RG7 7 0 1000000000000
RG8 8 0 1000000000000
RG9 9 0 1000000000000
RG10 10 0 1000000000000
RG11 11 0 1000000000000
RG12 12 0 1000000000000
RG13 13 0 1000000000000
RG14 14 0 1000000000000
VS0 1 s0 0
C0 s0 8 27e-5
VS1 11 s1 0
L1 s1 12 22e-4
VS2 3 s2 0
R2 s2 12 27e2
VS3 3 s3 0
R3 s3 4 22e0
VS4 3 s4 0
C4 s4 0 33e-4
VS5 13 s5 0
R5 s5 7 12e1
VS6 6 s6 0
L6 s6 4 15e-3
VS7 5 s7 0
R7 s7 0 68e0
VS8 0 s8 0
V8 e8 s8 DC 0 AC 82e-1 180
RI8 e8 m8 82e-2
LI8 m8 n8 27e-5
H8 n8 h8 VS15 -22e-3
ED8 h8 7 d8 0 -22e-6
F8 0 d8 VS15 1
LD8 d8 0 1
VS9 12 s9 0
L9 s9 10 15e-5
VS10 5 s10 0
R10 s10 6 39e3
VS11 3 s11 0
C11 s11 1 82e-7
VS12 2 s12 0
R12 s12 3 18e-1
VS13 1 s13 0
R13 s13 11 56e-1
VS14 1 s14 0
R14 s14 6 27e2
VS15 7 s15 0
V15 e15 s15 DC 0 AC 18e1 120
RI15 e15 n15 47e-1
H15 n15 h15 VS8 -22e-3
ED15 h15 2 d15 0 -22e-6
F15 0 d15 VS8 1
LD15 d15 0 1
VS16 14 s16 0
R16 s16 5 82e1
VS17 7 s17 0
C17 s17 14 15e-7
VS18 12 s18 0
R18 s18 9 10e3
VS19 11 s19 0
C19 s19 2 56e-6
VS20 8 s20 0
C20 s20 10 12e-6
VS21 13 s21 0
L21 s21 7 39e-3
VS22 3 s22 0
L22 s22 13 10e-2
VS23 9 s23 0
V23 e23 s23 DC 0 AC 56e0 0
RI23 e23 14 56e-1
.control
set numdgt=17
ac lin 1 60 60
print v(1) v(2) v(3) v(4) v(5) v(6) v(7) v(8) v(9) v(10)
print v(11) v(12) v(13) v(14)
print i(vs0) i(vs1) i(vs2) i(vs3) i(vs4) i(vs5) i(vs6) i(vs7) i(vs8) i(vs9)
print i(vs10) i(vs11) i(vs12) i(vs13) i(vs14) i(vs15) i(vs16) i(vs17) i(vs18) i(vs19)
print i(vs20) i(vs21) i(vs22) i(vs23)
.endc
.end
