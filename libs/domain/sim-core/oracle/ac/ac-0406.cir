controls oracle ac-0406
* Generated (plan F2.7, ADR 0012): do not edit; regenerate with `pnpm sim oracle regen`. ac seed 20261031 index 406 nodes 15 elements 27
.options sparse gmin=1e-12 noopac
RG1 1 0 1000000000000
RG2 2 0 1000000000000
RG3 3 0 1000000000000
RG4 4 0 1000000000000
RG5 5 0 1000000000000
RG6 6 0 1000000000000
RG7 7 0 1000000000000
RG8 8 0 1000000000000
RG9 9 0 1000000000000
RG10 10 0 1000000000000
RG11 11 0 1000000000000
RG12 12 0 1000000000000
RG13 13 0 1000000000000
RG14 14 0 1000000000000
VS0 1 s0 0
R0 s0 9 10e3
VS1 3 s1 0
R1 s1 1 27e2
VS2 3 s2 0
R2 s2 4 22e0
VS3 0 s3 0
V3 e3 s3 DC 0 AC 15e1 120
RI3 e3 11 27e-3
VS4 7 s4 0
V4 e4 s4 DC 0 AC 18e1 120
RI4 e4 m4 47e-1
LI4 m4 2 68e-7
VS5 13 s5 0
C5 s5 6 47e-7
VS6 9 s6 0
R6 s6 14 56e0
VS7 6 s7 0
R7 s7 13 39e0
VS8 11 s8 0
V8 e8 s8 DC 0 AC 33e-1 180
RI8 e8 10 10e-2
VS9 13 s9 0
L9 s9 6 15e-2
VS10 12 s10 0
L10 s10 5 12e-3
VS11 12 s11 0
V11 e11 s11 DC 0 AC 82e-1 180
RI11 e11 m11 82e-2
LI11 m11 7 10e-6
VS12 1 s12 0
R12 s12 8 47e2
VS13 10 s13 0
L13 s13 7 39e-4
VS14 14 s14 0
L14 s14 13 18e-5
VS15 10 s15 0
R15 s15 0 39e-2
VS16 9 s16 0
C16 s16 11 68e-6
VS17 3 s17 0
C17 s17 0 82e-7
VS18 7 s18 0
C18 s18 14 56e-4
VS19 0 s19 0
R19 s19 6 27e2
VS20 2 s20 0
R20 s20 3 18e-1
VS21 13 s21 0
R21 s21 6 68e0
VS22 10 s22 0
V22 e22 s22 DC 0 AC 18e-1 120
RI22 e22 14 39e-1
VS23 0 s23 0
C23 s23 8 27e-5
VS24 4 s24 0
V24 e24 s24 DC 0 AC 18e1 120
RI24 e24 9 10e-2
VS25 4 s25 0
R25 s25 5 22e3
VS26 10 s26 0
C26 s26 0 33e-7
.control
set numdgt=17
ac lin 1 60 60
print v(1) v(2) v(3) v(4) v(5) v(6) v(7) v(8) v(9) v(10)
print v(11) v(12) v(13) v(14)
print i(vs0) i(vs1) i(vs2) i(vs3) i(vs4) i(vs5) i(vs6) i(vs7) i(vs8) i(vs9)
print i(vs10) i(vs11) i(vs12) i(vs13) i(vs14) i(vs15) i(vs16) i(vs17) i(vs18) i(vs19)
print i(vs20) i(vs21) i(vs22) i(vs23) i(vs24) i(vs25) i(vs26)
.endc
.end
