controls oracle ac-0194
* Generated (plan F2.7, ADR 0012): do not edit; regenerate with `pnpm sim oracle regen`. ac seed 20261031 index 194 nodes 17 elements 29
.options sparse gmin=1e-12 noopac
RG1 1 0 1000000000000
RG2 2 0 1000000000000
RG3 3 0 1000000000000
RG4 4 0 1000000000000
RG5 5 0 1000000000000
RG6 6 0 1000000000000
RG7 7 0 1000000000000
RG8 8 0 1000000000000
RG9 9 0 1000000000000
RG10 10 0 1000000000000
RG11 11 0 1000000000000
RG12 12 0 1000000000000
RG13 13 0 1000000000000
RG14 14 0 1000000000000
RG15 15 0 1000000000000
RG16 16 0 1000000000000
VS0 2 s0 0
R0 s0 13 27e3
VS1 0 s1 0
R1 s1 2 18e0
VS2 0 s2 0
V2 e2 s2 DC 0 AC 18e0 -120
RI2 e2 7 68e-1
VS3 8 s3 0
R3 s3 14 47e0
VS4 8 s4 0
R4 s4 3 22e3
VS5 16 s5 0
L5 s5 6 47e-5
VS6 1 s6 0
C6 s6 9 15e-6
VS7 12 s7 0
R7 s7 8 18e1
VS8 4 s8 0
V8 e8 s8 DC 0 AC 18e1 0
RI8 e8 9 15e-1
VS9 6 s9 0
L9 s9 11 68e-2
VS10 7 s10 0
L10 s10 9 39e-5
VS11 11 s11 0
R11 s11 7 22e2
VS12 3 s12 0
C12 s12 2 27e-5
VS13 13 s13 0
V13 e13 s13 DC 0 AC 47e-1 180
RI13 e13 14 10e-3
VS14 13 s14 0
R14 s14 12 33e1
VS15 10 s15 0
L15 s15 7 82e-5
VS16 13 s16 0
C16 s16 5 33e-6
VS17 4 s17 0
C17 s17 13 10e-4
VS18 10 s18 0
C18 s18 14 27e-6
VS19 8 s19 0
R19 s19 14 39e0
VS20 10 s20 0
V20 e20 s20 DC 0 AC 10e1 -120
RI20 e20 7 12e-2
VS21 13 s21 0
V21 e21 s21 DC 0 AC 39e0 -120
RI21 e21 14 27e-3
VS22 13 s22 0
L22 s22 7 47e-3
VS23 7 s23 0
L23 s23 15 33e-4
VS24 9 s24 0
R24 s24 8 56e-1
VS25 10 s25 0
C25 s25 5 10e-7
VS26 0 s26 0
R26 s26 13 18e3
VS27 12 s27 0
C27 s27 7 47e-5
VS28 5 s28 0
R28 s28 0 47e1
.control
set numdgt=17
ac lin 1 60 60
print v(1) v(2) v(3) v(4) v(5) v(6) v(7) v(8) v(9) v(10)
print v(11) v(12) v(13) v(14) v(15) v(16)
print i(vs0) i(vs1) i(vs2) i(vs3) i(vs4) i(vs5) i(vs6) i(vs7) i(vs8) i(vs9)
print i(vs10) i(vs11) i(vs12) i(vs13) i(vs14) i(vs15) i(vs16) i(vs17) i(vs18) i(vs19)
print i(vs20) i(vs21) i(vs22) i(vs23) i(vs24) i(vs25) i(vs26) i(vs27) i(vs28)
.endc
.end
