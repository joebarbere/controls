controls oracle ac-0194
* Generated (plan F2.7, ADR 0012): do not edit; regenerate with `pnpm sim oracle regen`. ac seed 20261031 index 194 nodes 17 elements 24
.options sparse gmin=1e-12 noopac
RG1 1 0 1000000000000
RG2 2 0 1000000000000
RG3 3 0 1000000000000
RG4 4 0 1000000000000
RG5 5 0 1000000000000
RG6 6 0 1000000000000
RG7 7 0 1000000000000
RG8 8 0 1000000000000
RG9 9 0 1000000000000
RG10 10 0 1000000000000
RG11 11 0 1000000000000
RG12 12 0 1000000000000
RG13 13 0 1000000000000
RG14 14 0 1000000000000
RG15 15 0 1000000000000
RG16 16 0 1000000000000
VS0 0 s0 0
V0 e0 s0 DC 0 AC 18e-1 -120
RI0 e0 3 27e-2
VS1 0 s1 0
R1 s1 12 18e0
VS2 5 s2 0
L2 s2 1 27e-2
VS3 9 s3 0
C3 s3 5 47e-5
VS4 16 s4 0
C4 s4 15 33e-5
VS5 7 s5 0
L5 s5 10 39e-5
VS6 15 s6 0
C6 s6 10 15e-6
VS7 0 s7 0
R7 s7 11 56e1
VS8 13 s8 0
R8 s8 1 22e3
VS9 10 s9 0
R9 s9 8 56e-1
VS10 3 s10 0
V10 e10 s10 DC 0 AC 27e0 0
RI10 e10 2 10e-1
VS11 8 s11 0
L11 s11 2 33e-4
VS12 4 s12 0
R12 s12 2 15e0
VS13 13 s13 0
L13 s13 6 18e-4
VS14 9 s14 0
R14 s14 0 82e3
VS15 6 s15 0
L15 s15 9 18e-4
VS16 9 s16 0
V16 e16 s16 DC 0 AC 18e0 -120
RI16 e16 7 68e-1
VS17 16 s17 0
V17 e17 s17 DC 0 AC 56e-1 120
RI17 e17 m17 47e-3
LI17 m17 1 47e-7
VS18 16 s18 0
V18 e18 s18 DC 0 AC 12e1 0
RI18 e18 m18 68e-2
LI18 m18 0 18e-7
VS19 16 s19 0
V19 e19 s19 DC 0 AC 47e-1 180
RI19 e19 m19 10e-3
LI19 m19 6 12e-6
VS20 4 s20 0
L20 s20 14 82e-5
VS21 7 s21 0
L21 s21 12 68e-3
VS22 9 s22 0
L22 s22 11 47e-3
VS23 9 s23 0
V23 e23 s23 DC 0 AC 27e0 -120
RI23 e23 14 15e-3
.control
set numdgt=17
ac lin 1 60 60
print v(1) v(2) v(3) v(4) v(5) v(6) v(7) v(8) v(9) v(10)
print v(11) v(12) v(13) v(14) v(15) v(16)
print i(vs0) i(vs1) i(vs2) i(vs3) i(vs4) i(vs5) i(vs6) i(vs7) i(vs8) i(vs9)
print i(vs10) i(vs11) i(vs12) i(vs13) i(vs14) i(vs15) i(vs16) i(vs17) i(vs18) i(vs19)
print i(vs20) i(vs21) i(vs22) i(vs23)
.endc
.end
