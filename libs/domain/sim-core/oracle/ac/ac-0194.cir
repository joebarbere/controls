controls oracle ac-0194
* Generated (plan F2.7, ADR 0012): do not edit; regenerate with `pnpm sim oracle regen`. ac seed 20261031 index 194 nodes 17 elements 32
.options sparse gmin=1e-12 noopac
RG1 1 0 1000000000000
RG2 2 0 1000000000000
RG3 3 0 1000000000000
RG4 4 0 1000000000000
RG5 5 0 1000000000000
RG6 6 0 1000000000000
RG7 7 0 1000000000000
RG8 8 0 1000000000000
RG9 9 0 1000000000000
RG10 10 0 1000000000000
RG11 11 0 1000000000000
RG12 12 0 1000000000000
RG13 13 0 1000000000000
RG14 14 0 1000000000000
RG15 15 0 1000000000000
RG16 16 0 1000000000000
VS0 0 s0 0
R0 s0 13 18e3
VS1 7 s1 0
L1 s1 15 33e-4
VS2 10 s2 0
C2 s2 14 27e-6
VS3 9 s3 0
R3 s3 8 56e-1
VS4 12 s4 0
C4 s4 7 47e-5
VS5 13 s5 0
C5 s5 5 33e-6
VS6 1 s6 0
C6 s6 9 15e-6
VS7 0 s7 0
V7 e7 s7 DC 0 AC 18e0 -120
RI7 e7 n7 68e-1
H7 n7 h7 VS12 39e-2
ED7 h7 7 d7 0 68e-7
F7 0 d7 VS12 1
LD7 d7 0 1
VS8 3 s8 0
C8 s8 2 27e-5
VS9 8 s9 0
R9 s9 3 22e3
VS10 10 s10 0
C10 s10 5 10e-7
VS11 16 s11 0
L11 s11 6 47e-5
VS12 5 s12 0
V12 e12 s12 DC 0 AC 33e1 -120
RI12 e12 n12 33e-1
H12 n12 h12 VS7 39e-2
ED12 h12 1 d12 0 68e-7
F12 0 d12 VS7 1
LD12 d12 0 1
VS13 13 s13 0
V13 e13 s13 DC 0 AC 47e-1 180
RI13 e13 m13 10e-3
LI13 m13 14 82e-5
VS14 13 s14 0
R14 s14 12 33e1
VS15 13 s15 0
L15 s15 7 47e-3
VS16 8 s16 0
R16 s16 14 47e0
VS17 8 s17 0
R17 s17 14 39e0
VS18 6 s18 0
L18 s18 11 68e-2
VS19 10 s19 0
V19 e19 s19 DC 0 AC 10e1 -120
RI19 e19 m19 12e-2
LI19 m19 7 15e-6
VS20 4 s20 0
V20 e20 s20 DC 0 AC 18e1 0
RI20 e20 m20 15e-1
LI20 m20 9 22e-6
VS21 0 s21 0
R21 s21 2 18e0
VS22 4 s22 0
L22 s22 15 10e-3
VS23 5 s23 0
R23 s23 0 47e1
VS24 4 s24 0
C24 s24 13 10e-4
VS25 10 s25 0
L25 s25 7 82e-5
VS26 12 s26 0
R26 s26 8 18e1
VS27 13 s27 0
V27 e27 s27 DC 0 AC 39e0 -120
RI27 e27 m27 27e-3
LI27 m27 14 22e-5
VS28 2 s28 0
R28 s28 16 33e-1
VS29 2 s29 0
R29 s29 13 27e3
VS30 7 s30 0
L30 s30 9 39e-5
VS31 11 s31 0
R31 s31 7 22e2
.control
set numdgt=17
ac lin 1 60 60
print v(1) v(2) v(3) v(4) v(5) v(6) v(7) v(8) v(9) v(10)
print v(11) v(12) v(13) v(14) v(15) v(16)
print i(vs0) i(vs1) i(vs2) i(vs3) i(vs4) i(vs5) i(vs6) i(vs7) i(vs8) i(vs9)
print i(vs10) i(vs11) i(vs12) i(vs13) i(vs14) i(vs15) i(vs16) i(vs17) i(vs18) i(vs19)
print i(vs20) i(vs21) i(vs22) i(vs23) i(vs24) i(vs25) i(vs26) i(vs27) i(vs28) i(vs29)
print i(vs30) i(vs31)
.endc
.end
