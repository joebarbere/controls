controls oracle ac-0389
* Generated (plan F2.7, ADR 0012): do not edit; regenerate with `pnpm sim oracle regen`. ac seed 20261031 index 389 nodes 29 elements 44
.options sparse gmin=1e-12 noopac
RG1 1 0 1000000000000
RG2 2 0 1000000000000
RG3 3 0 1000000000000
RG4 4 0 1000000000000
RG5 5 0 1000000000000
RG6 6 0 1000000000000
RG7 7 0 1000000000000
RG8 8 0 1000000000000
RG9 9 0 1000000000000
RG10 10 0 1000000000000
RG11 11 0 1000000000000
RG12 12 0 1000000000000
RG13 13 0 1000000000000
RG14 14 0 1000000000000
RG15 15 0 1000000000000
RG16 16 0 1000000000000
RG17 17 0 1000000000000
RG18 18 0 1000000000000
RG19 19 0 1000000000000
RG20 20 0 1000000000000
RG21 21 0 1000000000000
RG22 22 0 1000000000000
RG23 23 0 1000000000000
RG24 24 0 1000000000000
RG25 25 0 1000000000000
RG26 26 0 1000000000000
RG27 27 0 1000000000000
RG28 28 0 1000000000000
VS0 12 s0 0
R0 s0 5 82e0
VS1 0 s1 0
V1 e1 s1 DC 0 AC 47e-1 -120
RI1 e1 3 82e-3
VS2 11 s2 0
C2 s2 17 27e-6
VS3 13 s3 0
L3 s3 16 27e-2
VS4 19 s4 0
R4 s4 17 18e-2
VS5 19 s5 0
R5 s5 27 10e-1
VS6 23 s6 0
L6 s6 24 33e-2
VS7 25 s7 0
L7 s7 8 18e-5
VS8 26 s8 0
L8 s8 22 82e-4
VS9 21 s9 0
R9 s9 0 27e0
VS10 4 s10 0
V10 e10 s10 DC 0 AC 39e0 0
RI10 e10 24 39e-3
VS11 2 s11 0
R11 s11 25 39e3
VS12 25 s12 0
C12 s12 23 27e-6
VS13 2 s13 0
V13 e13 s13 DC 0 AC 82e0 120
RI13 e13 m13 47e-3
LI13 m13 1 82e-6
VS14 21 s14 0
C14 s14 28 15e-4
VS15 7 s15 0
L15 s15 28 68e-5
VS16 16 s16 0
V16 e16 s16 DC 0 AC 22e0 -120
RI16 e16 5 10e-1
VS17 8 s17 0
L17 s17 2 56e-3
VS18 25 s18 0
V18 e18 s18 DC 0 AC 12e-1 0
RI18 e18 m18 18e-1
LI18 m18 12 27e-6
VS19 18 s19 0
R19 s19 26 82e3
VS20 14 s20 0
R20 s20 5 47e1
VS21 15 s21 0
V21 e21 s21 DC 0 AC 10e0 -120
RI21 e21 24 12e-2
VS22 9 s22 0
R22 s22 26 39e3
VS23 18 s23 0
C23 s23 15 10e-4
VS24 23 s24 0
L24 s24 1 15e-4
VS25 6 s25 0
R25 s25 25 15e-2
VS26 25 s26 0
R26 s26 9 12e3
VS27 21 s27 0
L27 s27 26 10e-5
VS28 11 s28 0
L28 s28 21 18e-3
VS29 20 s29 0
C29 s29 5 10e-4
VS30 23 s30 0
L30 s30 28 68e-5
VS31 3 s31 0
L31 s31 25 68e-5
VS32 27 s32 0
C32 s32 26 39e-7
VS33 6 s33 0
L33 s33 9 68e-5
VS34 20 s34 0
C34 s34 24 22e-5
VS35 3 s35 0
R35 s35 10 82e0
VS36 27 s36 0
C36 s36 24 15e-6
VS37 23 s37 0
L37 s37 18 10e-3
VS38 16 s38 0
L38 s38 14 47e-4
VS39 7 s39 0
C39 s39 15 39e-6
VS40 10 s40 0
R40 s40 27 33e0
VS41 26 s41 0
V41 e41 s41 DC 0 AC 15e0 180
RI41 e41 22 39e-2
VS42 22 s42 0
C42 s42 13 33e-4
VS43 2 s43 0
C43 s43 4 22e-6
.control
set numdgt=17
ac lin 1 60 60
print v(1) v(2) v(3) v(4) v(5) v(6) v(7) v(8) v(9) v(10)
print v(11) v(12) v(13) v(14) v(15) v(16) v(17) v(18) v(19) v(20)
print v(21) v(22) v(23) v(24) v(25) v(26) v(27) v(28)
print i(vs0) i(vs1) i(vs2) i(vs3) i(vs4) i(vs5) i(vs6) i(vs7) i(vs8) i(vs9)
print i(vs10) i(vs11) i(vs12) i(vs13) i(vs14) i(vs15) i(vs16) i(vs17) i(vs18) i(vs19)
print i(vs20) i(vs21) i(vs22) i(vs23) i(vs24) i(vs25) i(vs26) i(vs27) i(vs28) i(vs29)
print i(vs30) i(vs31) i(vs32) i(vs33) i(vs34) i(vs35) i(vs36) i(vs37) i(vs38) i(vs39)
print i(vs40) i(vs41) i(vs42) i(vs43)
.endc
.end
