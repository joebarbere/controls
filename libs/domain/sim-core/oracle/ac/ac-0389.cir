controls oracle ac-0389
* Generated (plan F2.7, ADR 0012): do not edit; regenerate with `pnpm sim oracle regen`. ac seed 20261031 index 389 nodes 29 elements 59
.options sparse gmin=1e-12 noopac
RG1 1 0 1000000000000
RG2 2 0 1000000000000
RG3 3 0 1000000000000
RG4 4 0 1000000000000
RG5 5 0 1000000000000
RG6 6 0 1000000000000
RG7 7 0 1000000000000
RG8 8 0 1000000000000
RG9 9 0 1000000000000
RG10 10 0 1000000000000
RG11 11 0 1000000000000
RG12 12 0 1000000000000
RG13 13 0 1000000000000
RG14 14 0 1000000000000
RG15 15 0 1000000000000
RG16 16 0 1000000000000
RG17 17 0 1000000000000
RG18 18 0 1000000000000
RG19 19 0 1000000000000
RG20 20 0 1000000000000
RG21 21 0 1000000000000
RG22 22 0 1000000000000
RG23 23 0 1000000000000
RG24 24 0 1000000000000
RG25 25 0 1000000000000
RG26 26 0 1000000000000
RG27 27 0 1000000000000
RG28 28 0 1000000000000
VS0 18 s0 0
C0 s0 28 27e-6
VS1 1 s1 0
R1 s1 3 15e1
VS2 4 s2 0
R2 s2 20 39e2
VS3 0 s3 0
V3 e3 s3 DC 0 AC 15e-1 180
RI3 e3 m3 56e-3
LI3 m3 17 33e-6
VS4 9 s4 0
V4 e4 s4 DC 0 AC 39e1 -120
RI4 e4 m4 18e-1
LI4 m4 6 82e-5
VS5 11 s5 0
R5 s5 12 47e1
VS6 8 s6 0
L6 s6 10 33e-2
VS7 24 s7 0
L7 s7 25 33e-4
VS8 16 s8 0
L8 s8 23 27e-3
VS9 13 s9 0
C9 s9 19 10e-5
VS10 4 s10 0
C10 s10 26 47e-4
VS11 0 s11 0
R11 s11 5 39e2
VS12 16 s12 0
R12 s12 1 47e-1
VS13 7 s13 0
V13 e13 s13 DC 0 AC 10e0 -120
RI13 e13 10 27e-1
VS14 3 s14 0
C14 s14 14 82e-4
VS15 18 s15 0
C15 s15 2 10e-6
VS16 12 s16 0
V16 e16 s16 DC 0 AC 27e-1 180
RI16 e16 m16 68e-1
LI16 m16 19 10e-5
VS17 25 s17 0
L17 s17 27 33e-3
VS18 12 s18 0
L18 s18 16 18e-5
VS19 16 s19 0
C19 s19 24 68e-7
VS20 10 s20 0
L20 s20 15 82e-3
VS21 19 s21 0
R21 s21 15 82e-2
VS22 22 s22 0
C22 s22 1 15e-6
VS23 28 s23 0
C23 s23 25 47e-4
VS24 5 s24 0
C24 s24 4 22e-4
VS25 24 s25 0
C25 s25 13 12e-4
VS26 16 s26 0
R26 s26 26 39e3
VS27 15 s27 0
V27 e27 s27 DC 0 AC 10e0 -120
RI27 e27 24 12e-2
VS28 12 s28 0
R28 s28 21 47e3
VS29 21 s29 0
L29 s29 26 10e-5
VS30 23 s30 0
L30 s30 18 10e-3
VS31 19 s31 0
C31 s31 14 22e-5
VS32 1 s32 0
C32 s32 10 10e-4
VS33 2 s33 0
V33 e33 s33 DC 0 AC 18e0 180
RI33 e33 m33 27e-2
LI33 m33 8 12e-5
VS34 26 s34 0
C34 s34 18 10e-7
VS35 15 s35 0
C35 s35 6 47e-6
VS36 8 s36 0
V36 e36 s36 DC 0 AC 47e1 -120
RI36 e36 m36 22e-1
LI36 m36 7 22e-5
VS37 27 s37 0
R37 s37 4 22e-2
VS38 7 s38 0
C38 s38 8 56e-7
VS39 3 s39 0
L39 s39 21 22e-4
VS40 21 s40 0
L40 s40 22 15e-5
VS41 18 s41 0
R41 s41 26 82e3
VS42 1 s42 0
R42 s42 7 33e0
VS43 11 s43 0
C43 s43 6 68e-7
VS44 5 s44 0
C44 s44 23 27e-5
VS45 21 s45 0
V45 e45 s45 DC 0 AC 56e1 180
RI45 e45 m45 33e-1
LI45 m45 6 82e-5
VS46 22 s46 0
V46 e46 s46 DC 0 AC 47e1 180
RI46 e46 17 10e-2
VS47 28 s47 0
C47 s47 12 12e-4
VS48 17 s48 0
R48 s48 26 47e3
VS49 23 s49 0
L49 s49 24 33e-2
VS50 2 s50 0
V50 e50 s50 DC 0 AC 12e0 180
RI50 e50 m50 82e-1
LI50 m50 7 15e-7
VS51 25 s51 0
V51 e51 s51 DC 0 AC 10e0 0
RI51 e51 7 82e-3
VS52 14 s52 0
L52 s52 3 47e-2
VS53 2 s53 0
R53 s53 7 56e0
VS54 21 s54 0
C54 s54 10 15e-4
VS55 20 s55 0
R55 s55 12 47e3
VS56 17 s56 0
R56 s56 12 33e1
VS57 27 s57 0
C57 s57 18 22e-6
VS58 9 s58 0
C58 s58 10 39e-7
.control
set numdgt=17
ac lin 1 60 60
print v(1) v(2) v(3) v(4) v(5) v(6) v(7) v(8) v(9) v(10)
print v(11) v(12) v(13) v(14) v(15) v(16) v(17) v(18) v(19) v(20)
print v(21) v(22) v(23) v(24) v(25) v(26) v(27) v(28)
print i(vs0) i(vs1) i(vs2) i(vs3) i(vs4) i(vs5) i(vs6) i(vs7) i(vs8) i(vs9)
print i(vs10) i(vs11) i(vs12) i(vs13) i(vs14) i(vs15) i(vs16) i(vs17) i(vs18) i(vs19)
print i(vs20) i(vs21) i(vs22) i(vs23) i(vs24) i(vs25) i(vs26) i(vs27) i(vs28) i(vs29)
print i(vs30) i(vs31) i(vs32) i(vs33) i(vs34) i(vs35) i(vs36) i(vs37) i(vs38) i(vs39)
print i(vs40) i(vs41) i(vs42) i(vs43) i(vs44) i(vs45) i(vs46) i(vs47) i(vs48) i(vs49)
print i(vs50) i(vs51) i(vs52) i(vs53) i(vs54) i(vs55) i(vs56) i(vs57) i(vs58)
.endc
.end
