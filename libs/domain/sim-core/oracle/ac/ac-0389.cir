controls oracle ac-0389
* Generated (plan F2.7, ADR 0012): do not edit; regenerate with `pnpm sim oracle regen`. ac seed 20261031 index 389 nodes 29 elements 39
.options sparse gmin=1e-12 noopac
RG1 1 0 1000000000000
RG2 2 0 1000000000000
RG3 3 0 1000000000000
RG4 4 0 1000000000000
RG5 5 0 1000000000000
RG6 6 0 1000000000000
RG7 7 0 1000000000000
RG8 8 0 1000000000000
RG9 9 0 1000000000000
RG10 10 0 1000000000000
RG11 11 0 1000000000000
RG12 12 0 1000000000000
RG13 13 0 1000000000000
RG14 14 0 1000000000000
RG15 15 0 1000000000000
RG16 16 0 1000000000000
RG17 17 0 1000000000000
RG18 18 0 1000000000000
RG19 19 0 1000000000000
RG20 20 0 1000000000000
RG21 21 0 1000000000000
RG22 22 0 1000000000000
RG23 23 0 1000000000000
RG24 24 0 1000000000000
RG25 25 0 1000000000000
RG26 26 0 1000000000000
RG27 27 0 1000000000000
RG28 28 0 1000000000000
VS0 25 s0 0
R0 s0 9 12e3
VS1 21 s1 0
C1 s1 28 15e-4
VS2 26 s2 0
L2 s2 22 82e-4
VS3 0 s3 0
V3 e3 s3 DC 0 AC 47e-1 -120
RI3 e3 3 82e-3
VS4 4 s4 0
V4 e4 s4 DC 0 AC 39e0 0
RI4 e4 24 39e-3
VS5 6 s5 0
R5 s5 25 15e-2
VS6 20 s6 0
C6 s6 24 22e-5
VS7 7 s7 0
C7 s7 15 39e-6
VS8 2 s8 0
R8 s8 25 39e3
VS9 25 s9 0
V9 e9 s9 DC 0 AC 12e-1 0
RI9 e9 12 18e-1
VS10 23 s10 0
L10 s10 18 10e-3
VS11 3 s11 0
R11 s11 10 82e0
VS12 16 s12 0
L12 s12 14 47e-4
VS13 2 s13 0
V13 e13 s13 DC 0 AC 82e0 120
RI13 e13 1 47e-3
VS14 23 s14 0
L14 s14 24 33e-2
VS15 14 s15 0
R15 s15 5 47e1
VS16 27 s16 0
C16 s16 24 15e-6
VS17 21 s17 0
R17 s17 0 27e0
VS18 11 s18 0
L18 s18 21 18e-3
VS19 26 s19 0
V19 e19 s19 DC 0 AC 15e0 180
RI19 e19 22 39e-2
VS20 3 s20 0
L20 s20 25 68e-5
VS21 9 s21 0
R21 s21 26 39e3
VS22 11 s22 0
C22 s22 17 27e-6
VS23 18 s23 0
C23 s23 15 10e-4
VS24 23 s24 0
L24 s24 1 15e-4
VS25 18 s25 0
R25 s25 26 82e3
VS26 12 s26 0
R26 s26 5 82e0
VS27 10 s27 0
R27 s27 27 33e0
VS28 27 s28 0
C28 s28 26 39e-7
VS29 6 s29 0
L29 s29 9 68e-5
VS30 15 s30 0
V30 e30 s30 DC 0 AC 10e0 -120
RI30 e30 24 12e-2
VS31 25 s31 0
L31 s31 8 18e-5
VS32 23 s32 0
L32 s32 28 68e-5
VS33 19 s33 0
R33 s33 17 18e-2
VS34 16 s34 0
V34 e34 s34 DC 0 AC 22e0 -120
RI34 e34 5 10e-1
VS35 13 s35 0
L35 s35 16 27e-2
VS36 19 s36 0
R36 s36 27 10e-1
VS37 21 s37 0
L37 s37 26 10e-5
VS38 25 s38 0
C38 s38 23 27e-6
.control
set numdgt=17
ac lin 1 60 60
print v(1) v(2) v(3) v(4) v(5) v(6) v(7) v(8) v(9) v(10)
print v(11) v(12) v(13) v(14) v(15) v(16) v(17) v(18) v(19) v(20)
print v(21) v(22) v(23) v(24) v(25) v(26) v(27) v(28)
print i(vs0) i(vs1) i(vs2) i(vs3) i(vs4) i(vs5) i(vs6) i(vs7) i(vs8) i(vs9)
print i(vs10) i(vs11) i(vs12) i(vs13) i(vs14) i(vs15) i(vs16) i(vs17) i(vs18) i(vs19)
print i(vs20) i(vs21) i(vs22) i(vs23) i(vs24) i(vs25) i(vs26) i(vs27) i(vs28) i(vs29)
print i(vs30) i(vs31) i(vs32) i(vs33) i(vs34) i(vs35) i(vs36) i(vs37) i(vs38)
.endc
.end
