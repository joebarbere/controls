controls oracle ac-0132
* Generated (plan F2.7, ADR 0012): do not edit; regenerate with `pnpm sim oracle regen`. ac seed 20261031 index 132 nodes 26 elements 31
.options sparse gmin=1e-12 noopac
RG1 1 0 1000000000000
RG2 2 0 1000000000000
RG3 3 0 1000000000000
RG4 4 0 1000000000000
RG5 5 0 1000000000000
RG6 6 0 1000000000000
RG7 7 0 1000000000000
RG8 8 0 1000000000000
RG9 9 0 1000000000000
RG10 10 0 1000000000000
RG11 11 0 1000000000000
RG12 12 0 1000000000000
RG13 13 0 1000000000000
RG14 14 0 1000000000000
RG15 15 0 1000000000000
RG16 16 0 1000000000000
RG17 17 0 1000000000000
RG18 18 0 1000000000000
RG19 19 0 1000000000000
RG20 20 0 1000000000000
RG21 21 0 1000000000000
RG22 22 0 1000000000000
RG23 23 0 1000000000000
RG24 24 0 1000000000000
RG25 25 0 1000000000000
VS0 9 s0 0
L0 s0 17 18e-3
VS1 20 s1 0
L1 s1 5 15e-5
VS2 10 s2 0
L2 s2 16 39e-5
VS3 8 s3 0
C3 s3 0 82e-5
VS4 17 s4 0
R4 s4 15 82e2
VS5 21 s5 0
R5 s5 10 33e1
VS6 22 s6 0
L6 s6 15 82e-3
VS7 0 s7 0
R7 s7 5 15e3
VS8 12 s8 0
L8 s8 0 15e-2
VS9 21 s9 0
L9 s9 25 12e-2
VS10 0 s10 0
R10 s10 19 47e0
VS11 7 s11 0
R11 s11 21 39e-2
VS12 3 s12 0
C12 s12 2 56e-7
VS13 9 s13 0
R13 s13 24 68e1
VS14 11 s14 0
R14 s14 19 47e-1
VS15 16 s15 0
R15 s15 13 15e1
VS16 16 s16 0
R16 s16 4 33e-1
VS17 0 s17 0
V17 e17 s17 DC 0 AC 15e0 120
RI17 e17 8 56e-3
VS18 23 s18 0
R18 s18 22 15e2
VS19 18 s19 0
L19 s19 21 27e-2
VS20 3 s20 0
L20 s20 9 15e-5
VS21 9 s21 0
L21 s21 1 12e-5
VS22 6 s22 0
V22 e22 s22 DC 0 AC 22e0 -120
RI22 e22 14 12e-3
VS23 17 s23 0
C23 s23 16 12e-5
VS24 14 s24 0
C24 s24 17 39e-7
VS25 0 s25 0
R25 s25 16 33e2
VS26 17 s26 0
C26 s26 16 22e-5
VS27 23 s27 0
R27 s27 2 10e0
VS28 2 s28 0
C28 s28 24 39e-7
VS29 7 s29 0
C29 s29 18 22e-6
VS30 20 s30 0
L30 s30 22 15e-2
.control
set numdgt=17
ac lin 1 60 60
print v(1) v(2) v(3) v(4) v(5) v(6) v(7) v(8) v(9) v(10)
print v(11) v(12) v(13) v(14) v(15) v(16) v(17) v(18) v(19) v(20)
print v(21) v(22) v(23) v(24) v(25)
print i(vs0) i(vs1) i(vs2) i(vs3) i(vs4) i(vs5) i(vs6) i(vs7) i(vs8) i(vs9)
print i(vs10) i(vs11) i(vs12) i(vs13) i(vs14) i(vs15) i(vs16) i(vs17) i(vs18) i(vs19)
print i(vs20) i(vs21) i(vs22) i(vs23) i(vs24) i(vs25) i(vs26) i(vs27) i(vs28) i(vs29)
print i(vs30)
.endc
.end
