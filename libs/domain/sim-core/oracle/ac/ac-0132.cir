controls oracle ac-0132
* Generated (plan F2.7, ADR 0012): do not edit; regenerate with `pnpm sim oracle regen`. ac seed 20261031 index 132 nodes 26 elements 36
.options sparse gmin=1e-12 noopac
RG1 1 0 1000000000000
RG2 2 0 1000000000000
RG3 3 0 1000000000000
RG4 4 0 1000000000000
RG5 5 0 1000000000000
RG6 6 0 1000000000000
RG7 7 0 1000000000000
RG8 8 0 1000000000000
RG9 9 0 1000000000000
RG10 10 0 1000000000000
RG11 11 0 1000000000000
RG12 12 0 1000000000000
RG13 13 0 1000000000000
RG14 14 0 1000000000000
RG15 15 0 1000000000000
RG16 16 0 1000000000000
RG17 17 0 1000000000000
RG18 18 0 1000000000000
RG19 19 0 1000000000000
RG20 20 0 1000000000000
RG21 21 0 1000000000000
RG22 22 0 1000000000000
RG23 23 0 1000000000000
RG24 24 0 1000000000000
RG25 25 0 1000000000000
VS0 12 s0 0
L0 s0 10 15e-2
VS1 24 s1 0
C1 s1 0 39e-5
VS2 21 s2 0
R2 s2 15 33e1
VS3 15 s3 0
L3 s3 17 27e-3
VS4 7 s4 0
R4 s4 21 39e-2
VS5 8 s5 0
L5 s5 6 18e-4
VS6 9 s6 0
L6 s6 17 18e-3
VS7 8 s7 0
L7 s7 23 22e-2
VS8 3 s8 0
R8 s8 11 12e-2
VS9 14 s9 0
L9 s9 5 15e-5
VS10 6 s10 0
C10 s10 7 18e-7
VS11 12 s11 0
R11 s11 13 82e2
VS12 11 s12 0
R12 s12 24 15e1
VS13 10 s13 0
R13 s13 19 47e0
VS14 3 s14 0
L14 s14 9 15e-5
VS15 25 s15 0
R15 s15 19 39e1
VS16 0 s16 0
V16 e16 s16 DC 0 AC 22e0 -120
RI16 e16 m16 12e-3
LI16 m16 2 15e-5
VS17 25 s17 0
L17 s17 18 82e-2
VS18 7 s18 0
L18 s18 22 56e-2
VS19 9 s19 0
L19 s19 1 12e-5
VS20 15 s20 0
L20 s20 16 39e-5
VS21 10 s21 0
R21 s21 16 33e2
VS22 16 s22 0
R22 s22 4 33e-1
VS23 4 s23 0
V23 e23 s23 DC 0 AC 33e1 120
RI23 e23 11 33e-3
VS24 13 s24 0
L24 s24 24 27e-4
VS25 10 s25 0
V25 e25 s25 DC 0 AC 15e0 120
RI25 e25 8 56e-3
VS26 8 s26 0
V26 e26 s26 DC 0 AC 82e-1 -120
RI26 e26 20 33e-2
VS27 18 s27 0
V27 e27 s27 DC 0 AC 22e0 -120
RI27 e27 22 12e-2
VS28 10 s28 0
R28 s28 5 15e3
VS29 7 s29 0
C29 s29 23 47e-4
VS30 18 s30 0
C30 s30 1 82e-5
VS31 6 s31 0
R31 s31 14 10e-1
VS32 21 s32 0
R32 s32 20 68e1
VS33 17 s33 0
C33 s33 16 12e-5
VS34 3 s34 0
C34 s34 2 56e-7
VS35 11 s35 0
R35 s35 16 56e-1
.control
set numdgt=17
ac lin 1 60 60
print v(1) v(2) v(3) v(4) v(5) v(6) v(7) v(8) v(9) v(10)
print v(11) v(12) v(13) v(14) v(15) v(16) v(17) v(18) v(19) v(20)
print v(21) v(22) v(23) v(24) v(25)
print i(vs0) i(vs1) i(vs2) i(vs3) i(vs4) i(vs5) i(vs6) i(vs7) i(vs8) i(vs9)
print i(vs10) i(vs11) i(vs12) i(vs13) i(vs14) i(vs15) i(vs16) i(vs17) i(vs18) i(vs19)
print i(vs20) i(vs21) i(vs22) i(vs23) i(vs24) i(vs25) i(vs26) i(vs27) i(vs28) i(vs29)
print i(vs30) i(vs31) i(vs32) i(vs33) i(vs34) i(vs35)
.endc
.end
