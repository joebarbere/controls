controls oracle ac-0132
* Generated (plan F2.7, ADR 0012): do not edit; regenerate with `pnpm sim oracle regen`. ac seed 20261031 index 132 nodes 26 elements 40
.options sparse gmin=1e-12 noopac
RG1 1 0 1000000000000
RG2 2 0 1000000000000
RG3 3 0 1000000000000
RG4 4 0 1000000000000
RG5 5 0 1000000000000
RG6 6 0 1000000000000
RG7 7 0 1000000000000
RG8 8 0 1000000000000
RG9 9 0 1000000000000
RG10 10 0 1000000000000
RG11 11 0 1000000000000
RG12 12 0 1000000000000
RG13 13 0 1000000000000
RG14 14 0 1000000000000
RG15 15 0 1000000000000
RG16 16 0 1000000000000
RG17 17 0 1000000000000
RG18 18 0 1000000000000
RG19 19 0 1000000000000
RG20 20 0 1000000000000
RG21 21 0 1000000000000
RG22 22 0 1000000000000
RG23 23 0 1000000000000
RG24 24 0 1000000000000
RG25 25 0 1000000000000
VS0 23 s0 0
R0 s0 4 10e-1
VS1 18 s1 0
L1 s1 21 27e-2
VS2 0 s2 0
V2 e2 s2 DC 0 AC 15e0 120
RI2 e2 8 56e-3
VS3 7 s3 0
C3 s3 18 22e-6
VS4 14 s4 0
C4 s4 17 39e-7
VS5 20 s5 0
L5 s5 22 15e-2
VS6 17 s6 0
C6 s6 16 12e-5
VS7 0 s7 0
R7 s7 19 47e0
VS8 20 s8 0
L8 s8 5 15e-5
VS9 7 s9 0
R9 s9 21 39e-2
VS10 3 s10 0
C10 s10 2 56e-7
VS11 12 s11 0
L11 s11 0 15e-2
VS12 1 s12 0
L12 s12 20 82e-2
VS13 17 s13 0
C13 s13 16 22e-5
VS14 10 s14 0
L14 s14 16 39e-5
VS15 13 s15 0
V15 e15 s15 DC 0 AC 33e1 120
RI15 e15 0 33e-3
VS16 8 s16 0
L16 s16 6 56e-2
VS17 23 s17 0
R17 s17 22 15e2
VS18 23 s18 0
R18 s18 2 10e0
VS19 2 s19 0
C19 s19 24 39e-7
VS20 21 s20 0
R20 s20 10 33e1
VS21 8 s21 0
R21 s21 14 56e-1
VS22 9 s22 0
L22 s22 1 12e-5
VS23 18 s23 0
V23 e23 s23 DC 0 AC 18e1 0
RI23 e23 25 56e-2
VS24 11 s24 0
R24 s24 19 47e-1
VS25 3 s25 0
L25 s25 9 15e-5
VS26 1 s26 0
L26 s26 10 27e-4
VS27 21 s27 0
L27 s27 25 12e-2
VS28 0 s28 0
R28 s28 16 33e2
VS29 16 s29 0
R29 s29 4 33e-1
VS30 17 s30 0
R30 s30 15 82e2
VS31 9 s31 0
R31 s31 24 68e1
VS32 9 s32 0
L32 s32 17 18e-3
VS33 5 s33 0
C33 s33 12 39e-5
VS34 4 s34 0
V34 e34 s34 DC 0 AC 27e-1 180
RI34 e34 18 15e-2
VS35 9 s35 0
R35 s35 11 12e2
VS36 16 s36 0
R36 s36 13 15e1
VS37 22 s37 0
L37 s37 15 82e-3
VS38 0 s38 0
R38 s38 5 15e3
VS39 6 s39 0
V39 e39 s39 DC 0 AC 22e0 -120
RI39 e39 14 12e-3
.control
set numdgt=17
ac lin 1 60 60
print v(1) v(2) v(3) v(4) v(5) v(6) v(7) v(8) v(9) v(10)
print v(11) v(12) v(13) v(14) v(15) v(16) v(17) v(18) v(19) v(20)
print v(21) v(22) v(23) v(24) v(25)
print i(vs0) i(vs1) i(vs2) i(vs3) i(vs4) i(vs5) i(vs6) i(vs7) i(vs8) i(vs9)
print i(vs10) i(vs11) i(vs12) i(vs13) i(vs14) i(vs15) i(vs16) i(vs17) i(vs18) i(vs19)
print i(vs20) i(vs21) i(vs22) i(vs23) i(vs24) i(vs25) i(vs26) i(vs27) i(vs28) i(vs29)
print i(vs30) i(vs31) i(vs32) i(vs33) i(vs34) i(vs35) i(vs36) i(vs37) i(vs38) i(vs39)
.endc
.end
