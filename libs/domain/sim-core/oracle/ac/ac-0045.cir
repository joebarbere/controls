controls oracle ac-0045
* Generated (plan F2.7, ADR 0012): do not edit; regenerate with `pnpm sim oracle regen`. ac seed 20261031 index 45 nodes 15 elements 27
.options sparse gmin=1e-12 noopac
RG1 1 0 1000000000000
RG2 2 0 1000000000000
RG3 3 0 1000000000000
RG4 4 0 1000000000000
RG5 5 0 1000000000000
RG6 6 0 1000000000000
RG7 7 0 1000000000000
RG8 8 0 1000000000000
RG9 9 0 1000000000000
RG10 10 0 1000000000000
RG11 11 0 1000000000000
RG12 12 0 1000000000000
RG13 13 0 1000000000000
RG14 14 0 1000000000000
VS0 10 s0 0
C0 s0 0 15e-4
VS1 4 s1 0
L1 s1 13 10e-4
VS2 9 s2 0
C2 s2 6 18e-7
VS3 0 s3 0
V3 e3 s3 DC 0 AC 22e1 0
RI3 e3 13 18e-1
VS4 9 s4 0
C4 s4 11 68e-5
VS5 11 s5 0
L5 s5 6 47e-4
VS6 8 s6 0
R6 s6 13 47e2
VS7 9 s7 0
V7 e7 s7 DC 0 AC 39e1 0
RI7 e7 m7 39e-2
LI7 m7 12 68e-7
VS8 1 s8 0
V8 e8 s8 DC 0 AC 12e0 -120
RI8 e8 9 82e-3
VS9 2 s9 0
C9 s9 12 10e-4
VS10 2 s10 0
R10 s10 10 10e3
VS11 8 s11 0
R11 s11 10 12e3
VS12 8 s12 0
L12 s12 3 33e-5
VS13 0 s13 0
R13 s13 4 39e3
VS14 7 s14 0
V14 e14 s14 DC 0 AC 10e-1 -120
RI14 e14 13 12e-2
VS15 6 s15 0
L15 s15 9 68e-5
VS16 9 s16 0
C16 s16 13 68e-6
VS17 11 s17 0
R17 s17 14 56e0
VS18 2 s18 0
C18 s18 14 15e-5
VS19 9 s19 0
L19 s19 13 18e-5
VS20 2 s20 0
R20 s20 12 27e-1
VS21 4 s21 0
V21 e21 s21 DC 0 AC 22e0 0
RI21 e21 m21 82e-1
LI21 m21 8 39e-6
VS22 7 s22 0
C22 s22 12 68e-5
VS23 1 s23 0
R23 s23 4 68e3
VS24 5 s24 0
R24 s24 10 22e-1
VS25 1 s25 0
C25 s25 3 15e-5
VS26 0 s26 0
V26 e26 s26 DC 0 AC 56e-1 180
RI26 e26 5 15e-2
.control
set numdgt=17
ac lin 1 60 60
print v(1) v(2) v(3) v(4) v(5) v(6) v(7) v(8) v(9) v(10)
print v(11) v(12) v(13) v(14)
print i(vs0) i(vs1) i(vs2) i(vs3) i(vs4) i(vs5) i(vs6) i(vs7) i(vs8) i(vs9)
print i(vs10) i(vs11) i(vs12) i(vs13) i(vs14) i(vs15) i(vs16) i(vs17) i(vs18) i(vs19)
print i(vs20) i(vs21) i(vs22) i(vs23) i(vs24) i(vs25) i(vs26)
.endc
.end
