controls oracle ac-0045
* Generated (plan F2.7, ADR 0012): do not edit; regenerate with `pnpm sim oracle regen`. ac seed 20261031 index 45 nodes 15 elements 19
.options sparse gmin=1e-12 noopac
RG1 1 0 1000000000000
RG2 2 0 1000000000000
RG3 3 0 1000000000000
RG4 4 0 1000000000000
RG5 5 0 1000000000000
RG6 6 0 1000000000000
RG7 7 0 1000000000000
RG8 8 0 1000000000000
RG9 9 0 1000000000000
RG10 10 0 1000000000000
RG11 11 0 1000000000000
RG12 12 0 1000000000000
RG13 13 0 1000000000000
RG14 14 0 1000000000000
VS0 14 s0 0
R0 s0 4 56e0
VS1 0 s1 0
R1 s1 14 68e3
VS2 8 s2 0
R2 s2 10 12e3
VS3 7 s3 0
R3 s3 10 22e-1
VS4 0 s4 0
V4 e4 s4 DC 0 AC 22e1 0
RI4 e4 m4 18e-1
LI4 m4 1 39e-5
VS5 3 s5 0
L5 s5 12 68e-5
VS6 2 s6 0
R6 s6 10 10e3
VS7 8 s7 0
R7 s7 7 33e2
VS8 9 s8 0
V8 e8 s8 DC 0 AC 39e1 0
RI8 e8 m8 39e-2
LI8 m8 12 15e-5
VS9 9 s9 0
L9 s9 11 10e-4
VS10 13 s10 0
R10 s10 11 47e3
VS11 4 s11 0
R11 s11 5 22e-2
VS12 7 s12 0
C12 s12 6 15e-6
VS13 3 s13 0
R13 s13 7 39e-2
VS14 0 s14 0
V14 e14 s14 DC 0 AC 15e0 120
RI14 e14 12 27e-1
VS15 6 s15 0
R15 s15 8 39e0
VS16 2 s16 0
R16 s16 12 27e-1
VS17 13 s17 0
R17 s17 1 22e-1
VS18 5 s18 0
V18 e18 s18 DC 0 AC 15e0 0
RI18 e18 m18 15e-3
LI18 m18 2 47e-7
.control
set numdgt=17
ac lin 1 60 60
print v(1) v(2) v(3) v(4) v(5) v(6) v(7) v(8) v(9) v(10)
print v(11) v(12) v(13) v(14)
print i(vs0) i(vs1) i(vs2) i(vs3) i(vs4) i(vs5) i(vs6) i(vs7) i(vs8) i(vs9)
print i(vs10) i(vs11) i(vs12) i(vs13) i(vs14) i(vs15) i(vs16) i(vs17) i(vs18)
.endc
.end
