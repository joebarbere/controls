controls oracle ac-0363
* Generated (plan F2.7, ADR 0012): do not edit; regenerate with `pnpm sim oracle regen`. ac seed 20261031 index 363 nodes 23 elements 37
.options sparse gmin=1e-12 noopac
RG1 1 0 1000000000000
RG2 2 0 1000000000000
RG3 3 0 1000000000000
RG4 4 0 1000000000000
RG5 5 0 1000000000000
RG6 6 0 1000000000000
RG7 7 0 1000000000000
RG8 8 0 1000000000000
RG9 9 0 1000000000000
RG10 10 0 1000000000000
RG11 11 0 1000000000000
RG12 12 0 1000000000000
RG13 13 0 1000000000000
RG14 14 0 1000000000000
RG15 15 0 1000000000000
RG16 16 0 1000000000000
RG17 17 0 1000000000000
RG18 18 0 1000000000000
RG19 19 0 1000000000000
RG20 20 0 1000000000000
RG21 21 0 1000000000000
RG22 22 0 1000000000000
VS0 9 s0 0
L0 s0 7 47e-2
VS1 0 s1 0
V1 e1 s1 DC 0 AC 68e-1 120
RI1 e1 m1 10e-1
LI1 m1 9 68e-7
VS2 17 s2 0
V2 e2 s2 DC 0 AC 15e-1 -120
RI2 e2 6 27e-3
VS3 16 s3 0
V3 e3 s3 DC 0 AC 18e1 0
RI3 e3 21 39e-3
VS4 8 s4 0
R4 s4 0 82e-2
VS5 1 s5 0
R5 s5 19 22e3
VS6 3 s6 0
V6 e6 s6 DC 0 AC 15e1 180
RI6 e6 m6 47e-2
LI6 m6 19 10e-5
VS7 10 s7 0
L7 s7 2 10e-5
VS8 6 s8 0
R8 s8 16 22e3
VS9 9 s9 0
V9 e9 s9 DC 0 AC 10e1 180
RI9 e9 m9 56e-2
LI9 m9 6 56e-5
VS10 22 s10 0
V10 e10 s10 DC 0 AC 47e-1 180
RI10 e10 m10 33e-1
LI10 m10 18 47e-6
VS11 4 s11 0
R11 s11 7 15e0
VS12 21 s12 0
C12 s12 12 27e-4
VS13 14 s13 0
R13 s13 15 12e3
VS14 12 s14 0
R14 s14 5 56e-1
VS15 15 s15 0
V15 e15 s15 DC 0 AC 18e0 -120
RI15 e15 m15 39e-3
LI15 m15 12 33e-5
VS16 1 s16 0
R16 s16 2 68e0
VS17 21 s17 0
R17 s17 20 22e0
VS18 20 s18 0
C18 s18 2 18e-4
VS19 11 s19 0
L19 s19 19 18e-4
VS20 19 s20 0
R20 s20 12 22e-2
VS21 2 s21 0
R21 s21 4 56e-2
VS22 11 s22 0
V22 e22 s22 DC 0 AC 27e1 180
RI22 e22 21 18e-1
VS23 18 s23 0
R23 s23 12 12e3
VS24 9 s24 0
V24 e24 s24 DC 0 AC 22e0 120
RI24 e24 12 47e-3
VS25 15 s25 0
L25 s25 22 39e-3
VS26 6 s26 0
V26 e26 s26 DC 0 AC 82e-1 120
RI26 e26 m26 68e-2
LI26 m26 1 15e-7
VS27 12 s27 0
C27 s27 2 82e-4
VS28 14 s28 0
R28 s28 9 33e0
VS29 3 s29 0
L29 s29 16 68e-3
VS30 8 s30 0
R30 s30 20 27e-1
VS31 13 s31 0
C31 s31 2 15e-6
VS32 3 s32 0
L32 s32 5 47e-3
VS33 14 s33 0
L33 s33 17 33e-3
VS34 13 s34 0
C34 s34 4 56e-7
VS35 13 s35 0
R35 s35 6 22e-1
VS36 12 s36 0
L36 s36 10 22e-3
.control
set numdgt=17
ac lin 1 60 60
print v(1) v(2) v(3) v(4) v(5) v(6) v(7) v(8) v(9) v(10)
print v(11) v(12) v(13) v(14) v(15) v(16) v(17) v(18) v(19) v(20)
print v(21) v(22)
print i(vs0) i(vs1) i(vs2) i(vs3) i(vs4) i(vs5) i(vs6) i(vs7) i(vs8) i(vs9)
print i(vs10) i(vs11) i(vs12) i(vs13) i(vs14) i(vs15) i(vs16) i(vs17) i(vs18) i(vs19)
print i(vs20) i(vs21) i(vs22) i(vs23) i(vs24) i(vs25) i(vs26) i(vs27) i(vs28) i(vs29)
print i(vs30) i(vs31) i(vs32) i(vs33) i(vs34) i(vs35) i(vs36)
.endc
.end
