controls oracle ac-0283
* Generated (plan F2.7, ADR 0012): do not edit; regenerate with `pnpm sim oracle regen`. ac seed 20261031 index 283 nodes 7 elements 7
.options sparse gmin=1e-12 noopac
RG1 1 0 1000000000000
RG2 2 0 1000000000000
RG3 3 0 1000000000000
RG4 4 0 1000000000000
RG5 5 0 1000000000000
RG6 6 0 1000000000000
VS0 0 s0 0
V0 e0 s0 DC 0 AC 56e1 180
RI0 e0 1 47e-2
VS1 4 s1 0
V1 e1 s1 DC 0 AC 47e-1 120
RI1 e1 0 22e-1
VS2 0 s2 0
C2 s2 1 82e-5
VS3 3 s3 0
L3 s3 4 56e-4
VS4 5 s4 0
V4 e4 s4 DC 0 AC 12e1 0
RI4 e4 2 39e-3
VS5 6 s5 0
L5 s5 3 56e-2
VS6 0 s6 0
C6 s6 5 39e-4
.control
set numdgt=17
ac lin 1 60 60
print v(1) v(2) v(3) v(4) v(5) v(6)
print i(vs0) i(vs1) i(vs2) i(vs3) i(vs4) i(vs5) i(vs6)
.endc
.end
