controls oracle ac-0283
* Generated (plan F2.7, ADR 0012): do not edit; regenerate with `pnpm sim oracle regen`. ac seed 20261031 index 283 nodes 7 elements 11
.options sparse gmin=1e-12 noopac
RG1 1 0 1000000000000
RG2 2 0 1000000000000
RG3 3 0 1000000000000
RG4 4 0 1000000000000
RG5 5 0 1000000000000
RG6 6 0 1000000000000
VS0 0 s0 0
V0 e0 s0 DC 0 AC 82e-1 -120
RI0 e0 m0 39e-2
LI0 m0 3 12e-7
VS1 3 s1 0
L1 s1 0 27e-4
VS2 5 s2 0
V2 e2 s2 DC 0 AC 22e1 120
RI2 e2 m2 18e-1
LI2 m2 4 27e-6
VS3 3 s3 0
L3 s3 1 22e-2
VS4 6 s4 0
C4 s4 2 68e-5
VS5 1 s5 0
C5 s5 4 56e-5
VS6 5 s6 0
V6 e6 s6 DC 0 AC 12e1 0
RI6 e6 m6 39e-3
LI6 m6 2 33e-6
VS7 6 s7 0
V7 e7 s7 DC 0 AC 39e1 180
RI7 e7 m7 47e-1
LI7 m7 3 39e-7
VS8 0 s8 0
L8 s8 2 15e-2
VS9 1 s9 0
L9 s9 0 56e-3
VS10 1 s10 0
R10 s10 3 12e-2
.control
set numdgt=17
ac lin 1 60 60
print v(1) v(2) v(3) v(4) v(5) v(6)
print i(vs0) i(vs1) i(vs2) i(vs3) i(vs4) i(vs5) i(vs6) i(vs7) i(vs8) i(vs9)
print i(vs10)
.endc
.end
