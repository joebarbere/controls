controls oracle ac-0283
* Generated (plan F2.7, ADR 0012): do not edit; regenerate with `pnpm sim oracle regen`. ac seed 20261031 index 283 nodes 7 elements 9
.options sparse gmin=1e-12 noopac
RG1 1 0 1000000000000
RG2 2 0 1000000000000
RG3 3 0 1000000000000
RG4 4 0 1000000000000
RG5 5 0 1000000000000
RG6 6 0 1000000000000
VS0 0 s0 0
V0 e0 s0 DC 0 AC 39e0 180
RI0 e0 n0 12e-3
H0 n0 h0 VS3 -18e-4
ED0 h0 6 d0 0 39e-6
F0 0 d0 VS3 1
LD0 d0 0 1
VS1 0 s1 0
L1 s1 3 56e-2
VS2 1 s2 0
L2 s2 2 56e-3
VS3 6 s3 0
V3 e3 s3 DC 0 AC 12e1 0
RI3 e3 n3 39e-3
H3 n3 h3 VS0 -18e-4
ED3 h3 2 d3 0 39e-6
F3 0 d3 VS0 1
LD3 d3 0 1
VS4 5 s4 0
C4 s4 1 82e-5
VS5 5 s5 0
V5 e5 s5 DC 0 AC 56e1 180
RI5 e5 m5 47e-2
LI5 m5 1 12e-6
VS6 5 s6 0
C6 s6 6 39e-4
VS7 4 s7 0
V7 e7 s7 DC 0 AC 47e-1 120
RI7 e7 m7 22e-1
LI7 m7 5 39e-6
VS8 3 s8 0
L8 s8 4 56e-4
.control
set numdgt=17
ac lin 1 60 60
print v(1) v(2) v(3) v(4) v(5) v(6)
print i(vs0) i(vs1) i(vs2) i(vs3) i(vs4) i(vs5) i(vs6) i(vs7) i(vs8)
.endc
.end
