controls oracle ac-0325
* Generated (plan F2.7, ADR 0012): do not edit; regenerate with `pnpm sim oracle regen`. ac seed 20261031 index 325 nodes 13 elements 21
.options sparse gmin=1e-12 noopac
RG1 1 0 1000000000000
RG2 2 0 1000000000000
RG3 3 0 1000000000000
RG4 4 0 1000000000000
RG5 5 0 1000000000000
RG6 6 0 1000000000000
RG7 7 0 1000000000000
RG8 8 0 1000000000000
RG9 9 0 1000000000000
RG10 10 0 1000000000000
RG11 11 0 1000000000000
RG12 12 0 1000000000000
VS0 9 s0 0
R0 s0 1 12e-1
VS1 5 s1 0
R1 s1 4 47e-1
VS2 1 s2 0
R2 s2 5 10e-2
VS3 12 s3 0
C3 s3 0 10e-7
VS4 6 s4 0
C4 s4 9 10e-4
VS5 4 s5 0
R5 s5 2 39e1
VS6 6 s6 0
L6 s6 3 39e-4
VS7 8 s7 0
L7 s7 10 68e-5
VS8 11 s8 0
R8 s8 7 47e-1
VS9 10 s9 0
R9 s9 12 39e0
VS10 3 s10 0
C10 s10 5 27e-7
VS11 0 s11 0
V11 e11 s11 DC 0 AC 33e1 120
RI11 e11 m11 27e-1
LI11 m11 5 22e-6
VS12 0 s12 0
L12 s12 2 22e-4
VS13 5 s13 0
V13 e13 s13 DC 0 AC 82e-1 0
RI13 e13 m13 12e-3
LI13 m13 7 12e-6
VS14 3 s14 0
L14 s14 2 56e-5
VS15 10 s15 0
L15 s15 7 47e-4
VS16 7 s16 0
R16 s16 6 56e1
VS17 5 s17 0
C17 s17 11 15e-5
VS18 4 s18 0
R18 s18 3 10e3
VS19 3 s19 0
R19 s19 9 12e3
VS20 8 s20 0
R20 s20 5 15e-1
.control
set numdgt=17
ac lin 1 60 60
print v(1) v(2) v(3) v(4) v(5) v(6) v(7) v(8) v(9) v(10)
print v(11) v(12)
print i(vs0) i(vs1) i(vs2) i(vs3) i(vs4) i(vs5) i(vs6) i(vs7) i(vs8) i(vs9)
print i(vs10) i(vs11) i(vs12) i(vs13) i(vs14) i(vs15) i(vs16) i(vs17) i(vs18) i(vs19)
print i(vs20)
.endc
.end
