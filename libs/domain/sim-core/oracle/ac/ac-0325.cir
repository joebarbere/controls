controls oracle ac-0325
* Generated (plan F2.7, ADR 0012): do not edit; regenerate with `pnpm sim oracle regen`. ac seed 20261031 index 325 nodes 13 elements 21
.options sparse gmin=1e-12 noopac
RG1 1 0 1000000000000
RG2 2 0 1000000000000
RG3 3 0 1000000000000
RG4 4 0 1000000000000
RG5 5 0 1000000000000
RG6 6 0 1000000000000
RG7 7 0 1000000000000
RG8 8 0 1000000000000
RG9 9 0 1000000000000
RG10 10 0 1000000000000
RG11 11 0 1000000000000
RG12 12 0 1000000000000
VS0 0 s0 0
R0 s0 9 12e-1
VS1 5 s1 0
R1 s1 4 47e-1
VS2 9 s2 0
R2 s2 5 10e-2
VS3 12 s3 0
C3 s3 1 10e-7
VS4 0 s4 0
V4 e4 s4 DC 0 AC 12e1 120
RI4 e4 n4 10e-2
H4 n4 h4 VS6 -12e-3
ED4 h4 5 d4 0 -22e-5
F4 0 d4 VS6 1
LD4 d4 0 1
VS5 4 s5 0
R5 s5 2 39e1
VS6 10 s6 0
V6 e6 s6 DC 0 AC 47e0 180
RI6 e6 n6 68e-1
H6 n6 h6 VS4 -12e-3
ED6 h6 3 d6 0 -22e-5
F6 0 d6 VS4 1
LD6 d6 0 1
VS7 11 s7 0
L7 s7 6 68e-5
VS8 8 s8 0
R8 s8 7 47e-1
VS9 10 s9 0
R9 s9 12 39e0
VS10 3 s10 0
C10 s10 5 27e-7
VS11 1 s11 0
L11 s11 5 33e-4
VS12 2 s12 0
R12 s12 10 27e0
VS13 5 s13 0
V13 e13 s13 DC 0 AC 82e-1 0
RI13 e13 m13 12e-3
LI13 m13 7 82e-6
VS14 3 s14 0
L14 s14 2 56e-5
VS15 10 s15 0
V15 e15 s15 DC 0 AC 33e1 180
RI15 e15 m15 39e-2
LI15 m15 7 82e-6
VS16 1 s16 0
R16 s16 6 56e0
VS17 5 s17 0
C17 s17 11 15e-5
VS18 4 s18 0
R18 s18 3 10e3
VS19 3 s19 0
R19 s19 0 12e3
VS20 8 s20 0
L20 s20 9 22e-4
.control
set numdgt=17
ac lin 1 60 60
print v(1) v(2) v(3) v(4) v(5) v(6) v(7) v(8) v(9) v(10)
print v(11) v(12)
print i(vs0) i(vs1) i(vs2) i(vs3) i(vs4) i(vs5) i(vs6) i(vs7) i(vs8) i(vs9)
print i(vs10) i(vs11) i(vs12) i(vs13) i(vs14) i(vs15) i(vs16) i(vs17) i(vs18) i(vs19)
print i(vs20)
.endc
.end
