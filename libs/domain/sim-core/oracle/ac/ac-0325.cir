controls oracle ac-0325
* Generated (plan F2.7, ADR 0012): do not edit; regenerate with `pnpm sim oracle regen`. ac seed 20261031 index 325 nodes 13 elements 18
.options sparse gmin=1e-12 noopac
RG1 1 0 1000000000000
RG2 2 0 1000000000000
RG3 3 0 1000000000000
RG4 4 0 1000000000000
RG5 5 0 1000000000000
RG6 6 0 1000000000000
RG7 7 0 1000000000000
RG8 8 0 1000000000000
RG9 9 0 1000000000000
RG10 10 0 1000000000000
RG11 11 0 1000000000000
RG12 12 0 1000000000000
VS0 4 s0 0
R0 s0 3 10e3
VS1 8 s1 0
L1 s1 5 22e-4
VS2 0 s2 0
V2 e2 s2 DC 0 AC 82e-1 0
RI2 e2 7 12e-3
VS3 5 s3 0
R3 s3 0 10e-2
VS4 1 s4 0
L4 s4 0 33e-4
VS5 4 s5 0
R5 s5 2 39e1
VS6 3 s6 0
C6 s6 0 27e-7
VS7 10 s7 0
V7 e7 s7 DC 0 AC 47e0 180
RI7 e7 3 68e-1
VS8 1 s8 0
R8 s8 6 56e0
VS9 0 s9 0
C9 s9 11 15e-5
VS10 0 s10 0
R10 s10 4 47e-1
VS11 9 s11 0
V11 e11 s11 DC 0 AC 12e1 120
RI11 e11 0 10e-2
VS12 3 s12 0
R12 s12 9 12e3
VS13 2 s13 0
R13 s13 10 27e0
VS14 10 s14 0
V14 e14 s14 DC 0 AC 33e1 180
RI14 e14 7 39e-2
VS15 9 s15 0
R15 s15 5 12e-1
VS16 12 s16 0
C16 s16 1 10e-7
VS17 3 s17 0
L17 s17 2 56e-5
.control
set numdgt=17
ac lin 1 60 60
print v(1) v(2) v(3) v(4) v(5) v(6) v(7) v(8) v(9) v(10)
print v(11) v(12)
print i(vs0) i(vs1) i(vs2) i(vs3) i(vs4) i(vs5) i(vs6) i(vs7) i(vs8) i(vs9)
print i(vs10) i(vs11) i(vs12) i(vs13) i(vs14) i(vs15) i(vs16) i(vs17)
.endc
.end
