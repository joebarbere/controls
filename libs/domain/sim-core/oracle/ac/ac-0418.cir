controls oracle ac-0418
* Generated (plan F2.7, ADR 0012): do not edit; regenerate with `pnpm sim oracle regen`. ac seed 20261031 index 418 nodes 28 elements 30
.options sparse gmin=1e-12 noopac
RG1 1 0 1000000000000
RG2 2 0 1000000000000
RG3 3 0 1000000000000
RG4 4 0 1000000000000
RG5 5 0 1000000000000
RG6 6 0 1000000000000
RG7 7 0 1000000000000
RG8 8 0 1000000000000
RG9 9 0 1000000000000
RG10 10 0 1000000000000
RG11 11 0 1000000000000
RG12 12 0 1000000000000
RG13 13 0 1000000000000
RG14 14 0 1000000000000
RG15 15 0 1000000000000
RG16 16 0 1000000000000
RG17 17 0 1000000000000
RG18 18 0 1000000000000
RG19 19 0 1000000000000
RG20 20 0 1000000000000
RG21 21 0 1000000000000
RG22 22 0 1000000000000
RG23 23 0 1000000000000
RG24 24 0 1000000000000
RG25 25 0 1000000000000
RG26 26 0 1000000000000
RG27 27 0 1000000000000
VS0 23 s0 0
R0 s0 24 68e2
VS1 0 s1 0
V1 e1 s1 DC 0 AC 15e1 -120
RI1 e1 11 33e-3
VS2 27 s2 0
V2 e2 s2 DC 0 AC 22e1 120
RI2 e2 3 33e-3
VS3 6 s3 0
R3 s3 7 47e2
VS4 12 s4 0
C4 s4 25 47e-6
VS5 10 s5 0
V5 e5 s5 DC 0 AC 15e1 120
RI5 e5 24 68e-2
VS6 5 s6 0
C6 s6 3 47e-6
VS7 2 s7 0
R7 s7 18 56e-2
VS8 11 s8 0
L8 s8 16 18e-2
VS9 3 s9 0
R9 s9 1 15e0
VS10 9 s10 0
R10 s10 24 22e1
VS11 18 s11 0
V11 e11 s11 DC 0 AC 22e-1 180
RI11 e11 16 12e-1
VS12 21 s12 0
C12 s12 15 39e-5
VS13 1 s13 0
L13 s13 3 12e-4
VS14 10 s14 0
V14 e14 s14 DC 0 AC 15e1 0
RI14 e14 11 10e-1
VS15 20 s15 0
R15 s15 26 47e2
VS16 2 s16 0
V16 e16 s16 DC 0 AC 22e0 180
RI16 e16 26 56e-3
VS17 9 s17 0
L17 s17 1 22e-4
VS18 6 s18 0
V18 e18 s18 DC 0 AC 33e1 0
RI18 e18 19 15e-3
VS19 26 s19 0
L19 s19 9 15e-5
VS20 24 s20 0
R20 s20 14 18e1
VS21 22 s21 0
L21 s21 21 27e-3
VS22 0 s22 0
C22 s22 17 10e-5
VS23 19 s23 0
C23 s23 25 18e-7
VS24 13 s24 0
L24 s24 19 18e-5
VS25 20 s25 0
C25 s25 10 47e-4
VS26 8 s26 0
V26 e26 s26 DC 0 AC 27e0 -120
RI26 e26 3 47e-3
VS27 6 s27 0
R27 s27 20 12e3
VS28 4 s28 0
C28 s28 19 39e-7
VS29 6 s29 0
C29 s29 15 68e-7
.control
set numdgt=17
ac lin 1 60 60
print v(1) v(2) v(3) v(4) v(5) v(6) v(7) v(8) v(9) v(10)
print v(11) v(12) v(13) v(14) v(15) v(16) v(17) v(18) v(19) v(20)
print v(21) v(22) v(23) v(24) v(25) v(26) v(27)
print i(vs0) i(vs1) i(vs2) i(vs3) i(vs4) i(vs5) i(vs6) i(vs7) i(vs8) i(vs9)
print i(vs10) i(vs11) i(vs12) i(vs13) i(vs14) i(vs15) i(vs16) i(vs17) i(vs18) i(vs19)
print i(vs20) i(vs21) i(vs22) i(vs23) i(vs24) i(vs25) i(vs26) i(vs27) i(vs28) i(vs29)
.endc
.end
