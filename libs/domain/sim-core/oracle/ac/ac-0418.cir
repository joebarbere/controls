controls oracle ac-0418
* Generated (plan F2.7, ADR 0012): do not edit; regenerate with `pnpm sim oracle regen`. ac seed 20261031 index 418 nodes 28 elements 53
.options sparse gmin=1e-12 noopac
RG1 1 0 1000000000000
RG2 2 0 1000000000000
RG3 3 0 1000000000000
RG4 4 0 1000000000000
RG5 5 0 1000000000000
RG6 6 0 1000000000000
RG7 7 0 1000000000000
RG8 8 0 1000000000000
RG9 9 0 1000000000000
RG10 10 0 1000000000000
RG11 11 0 1000000000000
RG12 12 0 1000000000000
RG13 13 0 1000000000000
RG14 14 0 1000000000000
RG15 15 0 1000000000000
RG16 16 0 1000000000000
RG17 17 0 1000000000000
RG18 18 0 1000000000000
RG19 19 0 1000000000000
RG20 20 0 1000000000000
RG21 21 0 1000000000000
RG22 22 0 1000000000000
RG23 23 0 1000000000000
RG24 24 0 1000000000000
RG25 25 0 1000000000000
RG26 26 0 1000000000000
RG27 27 0 1000000000000
VS0 12 s0 0
R0 s0 22 10e2
VS1 2 s1 0
L1 s1 24 15e-2
VS2 0 s2 0
V2 e2 s2 DC 0 AC 68e0 -120
RI2 e2 15 27e-1
VS3 26 s3 0
C3 s3 21 56e-7
VS4 15 s4 0
V4 e4 s4 DC 0 AC 68e0 120
RI4 e4 21 10e-1
VS5 25 s5 0
C5 s5 13 22e-7
VS6 5 s6 0
V6 e6 s6 DC 0 AC 39e-1 120
RI6 e6 2 12e-1
VS7 10 s7 0
R7 s7 11 82e0
VS8 20 s8 0
R8 s8 24 22e1
VS9 18 s9 0
R9 s9 27 18e0
VS10 7 s10 0
C10 s10 17 12e-4
VS11 26 s11 0
C11 s11 2 18e-4
VS12 19 s12 0
R12 s12 3 68e0
VS13 18 s13 0
R13 s13 25 12e0
VS14 7 s14 0
L14 s14 9 33e-4
VS15 25 s15 0
R15 s15 7 10e2
VS16 4 s16 0
C16 s16 20 27e-5
VS17 8 s17 0
L17 s17 22 27e-3
VS18 4 s18 0
R18 s18 10 27e-1
VS19 26 s19 0
L19 s19 6 56e-4
VS20 10 s20 0
L20 s20 4 18e-3
VS21 17 s21 0
L21 s21 12 18e-2
VS22 19 s22 0
L22 s22 9 27e-3
VS23 0 s23 0
V23 e23 s23 DC 0 AC 39e1 180
RI23 e23 m23 82e-2
LI23 m23 12 56e-5
VS24 19 s24 0
R24 s24 13 39e0
VS25 19 s25 0
L25 s25 20 82e-3
VS26 2 s26 0
V26 e26 s26 DC 0 AC 22e1 180
RI26 e26 18 10e-2
VS27 24 s27 0
R27 s27 1 82e1
VS28 16 s28 0
L28 s28 2 27e-5
VS29 24 s29 0
L29 s29 0 18e-2
VS30 4 s30 0
L30 s30 25 12e-4
VS31 11 s31 0
C31 s31 27 15e-5
VS32 14 s32 0
L32 s32 21 82e-4
VS33 6 s33 0
C33 s33 0 82e-5
VS34 12 s34 0
R34 s34 19 12e1
VS35 3 s35 0
R35 s35 8 27e1
VS36 9 s36 0
R36 s36 4 82e0
VS37 9 s37 0
R37 s37 15 18e2
VS38 23 s38 0
C38 s38 2 68e-7
VS39 11 s39 0
R39 s39 26 33e-1
VS40 20 s40 0
R40 s40 15 47e1
VS41 14 s41 0
V41 e41 s41 DC 0 AC 10e-1 180
RI41 e41 19 18e-2
VS42 11 s42 0
C42 s42 5 39e-6
VS43 23 s43 0
R43 s43 17 18e2
VS44 5 s44 0
C44 s44 6 15e-4
VS45 7 s45 0
R45 s45 27 15e-1
VS46 22 s46 0
R46 s46 8 22e2
VS47 0 s47 0
V47 e47 s47 DC 0 AC 15e-1 -120
RI47 e47 1 10e-3
VS48 7 s48 0
L48 s48 23 22e-2
VS49 10 s49 0
V49 e49 s49 DC 0 AC 15e1 120
RI49 e49 24 68e-2
VS50 6 s50 0
V50 e50 s50 DC 0 AC 15e-1 180
RI50 e50 23 47e-2
VS51 16 s51 0
V51 e51 s51 DC 0 AC 33e-1 120
RI51 e51 6 10e-1
VS52 4 s52 0
L52 s52 22 12e-5
.control
set numdgt=17
ac lin 1 60 60
print v(1) v(2) v(3) v(4) v(5) v(6) v(7) v(8) v(9) v(10)
print v(11) v(12) v(13) v(14) v(15) v(16) v(17) v(18) v(19) v(20)
print v(21) v(22) v(23) v(24) v(25) v(26) v(27)
print i(vs0) i(vs1) i(vs2) i(vs3) i(vs4) i(vs5) i(vs6) i(vs7) i(vs8) i(vs9)
print i(vs10) i(vs11) i(vs12) i(vs13) i(vs14) i(vs15) i(vs16) i(vs17) i(vs18) i(vs19)
print i(vs20) i(vs21) i(vs22) i(vs23) i(vs24) i(vs25) i(vs26) i(vs27) i(vs28) i(vs29)
print i(vs30) i(vs31) i(vs32) i(vs33) i(vs34) i(vs35) i(vs36) i(vs37) i(vs38) i(vs39)
print i(vs40) i(vs41) i(vs42) i(vs43) i(vs44) i(vs45) i(vs46) i(vs47) i(vs48) i(vs49)
print i(vs50) i(vs51) i(vs52)
.endc
.end
