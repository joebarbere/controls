controls oracle ac-0418
* Generated (plan F2.7, ADR 0012): do not edit; regenerate with `pnpm sim oracle regen`. ac seed 20261031 index 418 nodes 28 elements 39
.options sparse gmin=1e-12 noopac
RG1 1 0 1000000000000
RG2 2 0 1000000000000
RG3 3 0 1000000000000
RG4 4 0 1000000000000
RG5 5 0 1000000000000
RG6 6 0 1000000000000
RG7 7 0 1000000000000
RG8 8 0 1000000000000
RG9 9 0 1000000000000
RG10 10 0 1000000000000
RG11 11 0 1000000000000
RG12 12 0 1000000000000
RG13 13 0 1000000000000
RG14 14 0 1000000000000
RG15 15 0 1000000000000
RG16 16 0 1000000000000
RG17 17 0 1000000000000
RG18 18 0 1000000000000
RG19 19 0 1000000000000
RG20 20 0 1000000000000
RG21 21 0 1000000000000
RG22 22 0 1000000000000
RG23 23 0 1000000000000
RG24 24 0 1000000000000
RG25 25 0 1000000000000
RG26 26 0 1000000000000
RG27 27 0 1000000000000
VS0 24 s0 0
R0 s0 14 18e1
VS1 22 s1 0
C1 s1 3 12e-6
VS2 20 s2 0
C2 s2 10 47e-4
VS3 0 s3 0
V3 e3 s3 DC 0 AC 27e0 -120
RI3 e3 3 47e-3
VS4 5 s4 0
C4 s4 3 47e-6
VS5 27 s5 0
V5 e5 s5 DC 0 AC 22e1 120
RI5 e5 3 33e-3
VS6 23 s6 0
R6 s6 24 68e2
VS7 4 s7 0
C7 s7 19 39e-7
VS8 10 s8 0
C8 s8 27 10e-6
VS9 26 s9 0
L9 s9 8 15e-5
VS10 7 s10 0
R10 s10 18 47e-2
VS11 12 s11 0
C11 s11 25 47e-6
VS12 20 s12 0
R12 s12 14 68e1
VS13 9 s13 0
V13 e13 s13 DC 0 AC 15e1 -120
RI13 e13 11 33e-3
VS14 6 s14 0
R14 s14 20 12e3
VS15 6 s15 0
C15 s15 15 68e-7
VS16 4 s16 0
R16 s16 11 10e3
VS17 9 s17 0
C17 s17 17 10e-5
VS18 6 s18 0
V18 e18 s18 DC 0 AC 33e1 0
RI18 e18 19 15e-3
VS19 20 s19 0
R19 s19 26 47e2
VS20 12 s20 0
V20 e20 s20 DC 0 AC 27e1 180
RI20 e20 13 47e-2
VS21 22 s21 0
L21 s21 21 27e-3
VS22 19 s22 0
C22 s22 25 18e-7
VS23 13 s23 0
L23 s23 19 18e-5
VS24 21 s24 0
C24 s24 15 39e-5
VS25 0 s25 0
C25 s25 17 56e-4
VS26 9 s26 0
R26 s26 23 82e0
VS27 2 s27 0
V27 e27 s27 DC 0 AC 22e0 180
RI27 e27 26 56e-3
VS28 2 s28 0
R28 s28 18 56e-2
VS29 3 s29 0
R29 s29 1 15e0
VS30 18 s30 0
V30 e30 s30 DC 0 AC 22e-1 180
RI30 e30 16 12e-1
VS31 11 s31 0
L31 s31 16 18e-2
VS32 10 s32 0
V32 e32 s32 DC 0 AC 15e1 120
RI32 e32 24 68e-2
VS33 1 s33 0
L33 s33 3 12e-4
VS34 8 s34 0
R34 s34 24 22e1
VS35 5 s35 0
C35 s35 12 15e-6
VS36 8 s36 0
L36 s36 1 22e-4
VS37 10 s37 0
V37 e37 s37 DC 0 AC 15e1 0
RI37 e37 11 10e-1
VS38 6 s38 0
R38 s38 7 47e2
.control
set numdgt=17
ac lin 1 60 60
print v(1) v(2) v(3) v(4) v(5) v(6) v(7) v(8) v(9) v(10)
print v(11) v(12) v(13) v(14) v(15) v(16) v(17) v(18) v(19) v(20)
print v(21) v(22) v(23) v(24) v(25) v(26) v(27)
print i(vs0) i(vs1) i(vs2) i(vs3) i(vs4) i(vs5) i(vs6) i(vs7) i(vs8) i(vs9)
print i(vs10) i(vs11) i(vs12) i(vs13) i(vs14) i(vs15) i(vs16) i(vs17) i(vs18) i(vs19)
print i(vs20) i(vs21) i(vs22) i(vs23) i(vs24) i(vs25) i(vs26) i(vs27) i(vs28) i(vs29)
print i(vs30) i(vs31) i(vs32) i(vs33) i(vs34) i(vs35) i(vs36) i(vs37) i(vs38)
.endc
.end
