controls oracle ac-0165
* Generated (plan F2.7, ADR 0012): do not edit; regenerate with `pnpm sim oracle regen`. ac seed 20261031 index 165 nodes 9 elements 13
.options sparse gmin=1e-12 noopac
RG1 1 0 1000000000000
RG2 2 0 1000000000000
RG3 3 0 1000000000000
RG4 4 0 1000000000000
RG5 5 0 1000000000000
RG6 6 0 1000000000000
RG7 7 0 1000000000000
RG8 8 0 1000000000000
VS0 4 s0 0
C0 s0 6 10e-7
VS1 0 s1 0
V1 e1 s1 DC 0 AC 33e-1 180
RI1 e1 7 33e-3
VS2 8 s2 0
V2 e2 s2 DC 0 AC 39e-1 180
RI2 e2 5 68e-3
VS3 3 s3 0
L3 s3 1 33e-4
VS4 1 s4 0
V4 e4 s4 DC 0 AC 27e0 -120
RI4 e4 5 18e-3
VS5 0 s5 0
L5 s5 6 22e-2
VS6 1 s6 0
V6 e6 s6 DC 0 AC 15e0 0
RI6 e6 3 47e-3
VS7 0 s7 0
R7 s7 4 33e1
VS8 4 s8 0
V8 e8 s8 DC 0 AC 18e-1 -120
RI8 e8 7 47e-2
VS9 5 s9 0
R9 s9 7 27e2
VS10 2 s10 0
C10 s10 6 27e-4
VS11 1 s11 0
L11 s11 2 68e-2
VS12 7 s12 0
C12 s12 3 33e-5
.control
set numdgt=17
ac lin 1 60 60
print v(1) v(2) v(3) v(4) v(5) v(6) v(7) v(8)
print i(vs0) i(vs1) i(vs2) i(vs3) i(vs4) i(vs5) i(vs6) i(vs7) i(vs8) i(vs9)
print i(vs10) i(vs11) i(vs12)
.endc
.end
