controls oracle ac-0140
* Generated (plan F2.7, ADR 0012): do not edit; regenerate with `pnpm sim oracle regen`. ac seed 20261031 index 140 nodes 28 elements 56
.options sparse gmin=1e-12 noopac
RG1 1 0 1000000000000
RG2 2 0 1000000000000
RG3 3 0 1000000000000
RG4 4 0 1000000000000
RG5 5 0 1000000000000
RG6 6 0 1000000000000
RG7 7 0 1000000000000
RG8 8 0 1000000000000
RG9 9 0 1000000000000
RG10 10 0 1000000000000
RG11 11 0 1000000000000
RG12 12 0 1000000000000
RG13 13 0 1000000000000
RG14 14 0 1000000000000
RG15 15 0 1000000000000
RG16 16 0 1000000000000
RG17 17 0 1000000000000
RG18 18 0 1000000000000
RG19 19 0 1000000000000
RG20 20 0 1000000000000
RG21 21 0 1000000000000
RG22 22 0 1000000000000
RG23 23 0 1000000000000
RG24 24 0 1000000000000
RG25 25 0 1000000000000
RG26 26 0 1000000000000
RG27 27 0 1000000000000
VS0 10 s0 0
C0 s0 16 56e-4
VS1 0 s1 0
V1 e1 s1 DC 0 AC 15e-1 180
RI1 e1 n1 68e-3
H1 n1 h1 VS3 22e-4
ED1 h1 13 d1 0 -82e-6
F1 0 d1 VS3 1
LD1 d1 0 1
VS2 23 s2 0
L2 s2 19 12e-2
VS3 11 s3 0
V3 e3 s3 DC 0 AC 22e1 -120
RI3 e3 m3 33e-2
LI3 m3 n3 10e-5
H3 n3 h3 VS1 22e-4
ED3 h3 24 d3 0 -82e-6
F3 0 d3 VS1 1
LD3 d3 0 1
VS4 18 s4 0
L4 s4 17 27e-5
VS5 11 s5 0
R5 s5 25 56e1
VS6 15 s6 0
L6 s6 11 39e-3
VS7 7 s7 0
V7 e7 s7 DC 0 AC 10e0 -120
RI7 e7 m7 22e-1
LI7 m7 26 39e-5
VS8 25 s8 0
R8 s8 27 18e-2
VS9 9 s9 0
R9 s9 27 27e-1
VS10 24 s10 0
C10 s10 15 18e-5
VS11 3 s11 0
C11 s11 19 33e-5
VS12 20 s12 0
L12 s12 7 47e-2
VS13 9 s13 0
L13 s13 7 12e-2
VS14 4 s14 0
L14 s14 19 22e-2
VS15 21 s15 0
R15 s15 25 15e1
VS16 20 s16 0
R16 s16 14 47e-2
VS17 13 s17 0
L17 s17 4 18e-5
VS18 20 s18 0
V18 e18 s18 DC 0 AC 22e0 180
RI18 e18 m18 15e-3
LI18 m18 4 82e-6
VS19 26 s19 0
C19 s19 9 27e-7
VS20 7 s20 0
C20 s20 24 15e-6
VS21 3 s21 0
V21 e21 s21 DC 0 AC 39e0 120
RI21 e21 m21 68e-1
LI21 m21 25 39e-5
VS22 9 s22 0
R22 s22 4 10e3
VS23 3 s23 0
C23 s23 18 18e-6
VS24 19 s24 0
R24 s24 25 47e2
VS25 21 s25 0
L25 s25 2 33e-4
VS26 15 s26 0
R26 s26 24 68e-2
VS27 26 s27 0
V27 e27 s27 DC 0 AC 56e-1 120
RI27 e27 m27 39e-1
LI27 m27 27 47e-7
VS28 6 s28 0
L28 s28 0 27e-5
VS29 8 s29 0
R29 s29 23 56e2
VS30 13 s30 0
V30 e30 s30 DC 0 AC 39e-1 0
RI30 e30 m30 12e-2
LI30 m30 20 18e-5
VS31 22 s31 0
R31 s31 19 10e-1
VS32 12 s32 0
L32 s32 19 15e-4
VS33 7 s33 0
C33 s33 17 33e-7
VS34 18 s34 0
R34 s34 10 12e1
VS35 18 s35 0
R35 s35 11 82e3
VS36 13 s36 0
R36 s36 27 47e2
VS37 17 s37 0
L37 s37 10 56e-4
VS38 3 s38 0
V38 e38 s38 DC 0 AC 22e1 120
RI38 e38 5 39e-3
VS39 26 s39 0
C39 s39 10 39e-5
VS40 3 s40 0
R40 s40 5 56e-2
VS41 8 s41 0
C41 s41 0 12e-4
VS42 12 s42 0
C42 s42 3 82e-7
VS43 16 s43 0
R43 s43 27 10e-1
VS44 12 s44 0
L44 s44 2 22e-3
VS45 2 s45 0
R45 s45 1 12e-1
VS46 20 s46 0
L46 s46 23 12e-4
VS47 5 s47 0
C47 s47 2 56e-4
VS48 15 s48 0
R48 s48 22 47e1
VS49 20 s49 0
V49 e49 s49 DC 0 AC 12e-1 -120
RI49 e49 m49 18e-2
LI49 m49 1 47e-5
VS50 14 s50 0
L50 s50 7 18e-2
VS51 0 s51 0
L51 s51 27 56e-2
VS52 16 s52 0
L52 s52 26 56e-5
VS53 6 s53 0
R53 s53 23 12e2
VS54 26 s54 0
R54 s54 9 27e0
VS55 15 s55 0
R55 s55 26 12e-2
.control
set numdgt=17
ac lin 1 60 60
print v(1) v(2) v(3) v(4) v(5) v(6) v(7) v(8) v(9) v(10)
print v(11) v(12) v(13) v(14) v(15) v(16) v(17) v(18) v(19) v(20)
print v(21) v(22) v(23) v(24) v(25) v(26) v(27)
print i(vs0) i(vs1) i(vs2) i(vs3) i(vs4) i(vs5) i(vs6) i(vs7) i(vs8) i(vs9)
print i(vs10) i(vs11) i(vs12) i(vs13) i(vs14) i(vs15) i(vs16) i(vs17) i(vs18) i(vs19)
print i(vs20) i(vs21) i(vs22) i(vs23) i(vs24) i(vs25) i(vs26) i(vs27) i(vs28) i(vs29)
print i(vs30) i(vs31) i(vs32) i(vs33) i(vs34) i(vs35) i(vs36) i(vs37) i(vs38) i(vs39)
print i(vs40) i(vs41) i(vs42) i(vs43) i(vs44) i(vs45) i(vs46) i(vs47) i(vs48) i(vs49)
print i(vs50) i(vs51) i(vs52) i(vs53) i(vs54) i(vs55)
.endc
.end
