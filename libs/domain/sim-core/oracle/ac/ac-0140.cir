controls oracle ac-0140
* Generated (plan F2.7, ADR 0012): do not edit; regenerate with `pnpm sim oracle regen`. ac seed 20261031 index 140 nodes 28 elements 53
.options sparse gmin=1e-12 noopac
RG1 1 0 1000000000000
RG2 2 0 1000000000000
RG3 3 0 1000000000000
RG4 4 0 1000000000000
RG5 5 0 1000000000000
RG6 6 0 1000000000000
RG7 7 0 1000000000000
RG8 8 0 1000000000000
RG9 9 0 1000000000000
RG10 10 0 1000000000000
RG11 11 0 1000000000000
RG12 12 0 1000000000000
RG13 13 0 1000000000000
RG14 14 0 1000000000000
RG15 15 0 1000000000000
RG16 16 0 1000000000000
RG17 17 0 1000000000000
RG18 18 0 1000000000000
RG19 19 0 1000000000000
RG20 20 0 1000000000000
RG21 21 0 1000000000000
RG22 22 0 1000000000000
RG23 23 0 1000000000000
RG24 24 0 1000000000000
RG25 25 0 1000000000000
RG26 26 0 1000000000000
RG27 27 0 1000000000000
VS0 7 s0 0
C0 s0 24 15e-6
VS1 0 s1 0
V1 e1 s1 DC 0 AC 39e-1 0
RI1 e1 20 12e-2
VS2 18 s2 0
R2 s2 10 12e1
VS3 12 s3 0
V3 e3 s3 DC 0 AC 15e-1 180
RI3 e3 0 68e-3
VS4 9 s4 0
R4 s4 27 27e-1
VS5 25 s5 0
R5 s5 27 18e-2
VS6 15 s6 0
L6 s6 11 39e-3
VS7 7 s7 0
V7 e7 s7 DC 0 AC 10e0 -120
RI7 e7 26 22e-1
VS8 10 s8 0
C8 s8 16 56e-4
VS9 7 s9 0
C9 s9 17 33e-7
VS10 0 s10 0
L10 s10 4 18e-5
VS11 3 s11 0
V11 e11 s11 DC 0 AC 22e1 120
RI11 e11 5 39e-3
VS12 21 s12 0
L12 s12 2 33e-4
VS13 8 s13 0
R13 s13 23 56e2
VS14 18 s14 0
R14 s14 11 82e3
VS15 16 s15 0
R15 s15 27 10e-1
VS16 15 s16 0
R16 s16 24 68e-2
VS17 20 s17 0
L17 s17 23 12e-4
VS18 26 s18 0
V18 e18 s18 DC 0 AC 56e-1 120
RI18 e18 27 39e-1
VS19 14 s19 0
L19 s19 7 18e-2
VS20 9 s20 0
L20 s20 7 12e-2
VS21 23 s21 0
L21 s21 19 12e-2
VS22 13 s22 0
L22 s22 2 22e-3
VS23 6 s23 0
R23 s23 23 12e2
VS24 2 s24 0
R24 s24 1 12e-1
VS25 8 s25 0
C25 s25 12 12e-4
VS26 17 s26 0
L26 s26 10 56e-4
VS27 11 s27 0
R27 s27 25 56e1
VS28 15 s28 0
R28 s28 22 47e1
VS29 9 s29 0
R29 s29 4 10e3
VS30 26 s30 0
C30 s30 9 27e-7
VS31 12 s31 0
L31 s31 27 56e-2
VS32 15 s32 0
R32 s32 26 12e-2
VS33 20 s33 0
V33 e33 s33 DC 0 AC 22e0 180
RI33 e33 4 15e-3
VS34 26 s34 0
R34 s34 9 27e0
VS35 13 s35 0
L35 s35 19 15e-4
VS36 4 s36 0
L36 s36 19 22e-2
VS37 22 s37 0
R37 s37 19 10e-1
VS38 20 s38 0
L38 s38 7 47e-2
VS39 0 s39 0
R39 s39 27 47e2
VS40 3 s40 0
R40 s40 5 56e-2
VS41 21 s41 0
R41 s41 25 15e1
VS42 6 s42 0
L42 s42 12 27e-5
VS43 11 s43 0
V43 e43 s43 DC 0 AC 22e1 -120
RI43 e43 24 33e-2
VS44 24 s44 0
C44 s44 15 18e-5
VS45 26 s45 0
C45 s45 10 39e-5
VS46 3 s46 0
C46 s46 19 33e-5
VS47 16 s47 0
L47 s47 26 56e-5
VS48 19 s48 0
R48 s48 25 47e2
VS49 18 s49 0
L49 s49 17 27e-5
VS50 3 s50 0
V50 e50 s50 DC 0 AC 39e0 120
RI50 e50 25 68e-1
VS51 3 s51 0
C51 s51 18 18e-6
VS52 13 s52 0
C52 s52 3 82e-7
.control
set numdgt=17
ac lin 1 60 60
print v(1) v(2) v(3) v(4) v(5) v(6) v(7) v(8) v(9) v(10)
print v(11) v(12) v(13) v(14) v(15) v(16) v(17) v(18) v(19) v(20)
print v(21) v(22) v(23) v(24) v(25) v(26) v(27)
print i(vs0) i(vs1) i(vs2) i(vs3) i(vs4) i(vs5) i(vs6) i(vs7) i(vs8) i(vs9)
print i(vs10) i(vs11) i(vs12) i(vs13) i(vs14) i(vs15) i(vs16) i(vs17) i(vs18) i(vs19)
print i(vs20) i(vs21) i(vs22) i(vs23) i(vs24) i(vs25) i(vs26) i(vs27) i(vs28) i(vs29)
print i(vs30) i(vs31) i(vs32) i(vs33) i(vs34) i(vs35) i(vs36) i(vs37) i(vs38) i(vs39)
print i(vs40) i(vs41) i(vs42) i(vs43) i(vs44) i(vs45) i(vs46) i(vs47) i(vs48) i(vs49)
print i(vs50) i(vs51) i(vs52)
.endc
.end
