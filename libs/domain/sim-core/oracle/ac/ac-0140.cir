controls oracle ac-0140
* Generated (plan F2.7, ADR 0012): do not edit; regenerate with `pnpm sim oracle regen`. ac seed 20261031 index 140 nodes 28 elements 39
.options sparse gmin=1e-12 noopac
RG1 1 0 1000000000000
RG2 2 0 1000000000000
RG3 3 0 1000000000000
RG4 4 0 1000000000000
RG5 5 0 1000000000000
RG6 6 0 1000000000000
RG7 7 0 1000000000000
RG8 8 0 1000000000000
RG9 9 0 1000000000000
RG10 10 0 1000000000000
RG11 11 0 1000000000000
RG12 12 0 1000000000000
RG13 13 0 1000000000000
RG14 14 0 1000000000000
RG15 15 0 1000000000000
RG16 16 0 1000000000000
RG17 17 0 1000000000000
RG18 18 0 1000000000000
RG19 19 0 1000000000000
RG20 20 0 1000000000000
RG21 21 0 1000000000000
RG22 22 0 1000000000000
RG23 23 0 1000000000000
RG24 24 0 1000000000000
RG25 25 0 1000000000000
RG26 26 0 1000000000000
RG27 27 0 1000000000000
VS0 22 s0 0
R0 s0 19 10e-1
VS1 11 s1 0
L1 s1 14 56e-5
VS2 7 s2 0
L2 s2 19 39e-4
VS3 9 s3 0
R3 s3 14 68e-1
VS4 15 s4 0
L4 s4 9 82e-3
VS5 23 s5 0
L5 s5 19 12e-2
VS6 0 s6 0
V6 e6 s6 DC 0 AC 12e1 0
RI6 e6 20 56e-1
VS7 12 s7 0
R7 s7 18 18e2
VS8 19 s8 0
R8 s8 25 47e2
VS9 10 s9 0
C9 s9 17 10e-6
VS10 0 s10 0
L10 s10 2 22e-3
VS11 25 s11 0
R11 s11 5 82e-1
VS12 12 s12 0
R12 s12 23 82e-1
VS13 18 s13 0
L13 s13 19 10e-4
VS14 2 s14 0
R14 s14 1 12e-1
VS15 1 s15 0
R15 s15 15 18e1
VS16 12 s16 0
V16 e16 s16 DC 0 AC 39e0 120
RI16 e16 24 18e-2
VS17 27 s17 0
R17 s17 8 47e0
VS18 22 s18 0
C18 s18 13 15e-4
VS19 0 s19 0
R19 s19 16 47e-2
VS20 15 s20 0
R20 s20 26 12e-2
VS21 15 s21 0
L21 s21 14 12e-2
VS22 6 s22 0
C22 s22 4 82e-7
VS23 27 s23 0
L23 s23 10 68e-4
VS24 16 s24 0
R24 s24 12 27e1
VS25 6 s25 0
R25 s25 23 12e2
VS26 21 s26 0
C26 s26 11 82e-5
VS27 26 s27 0
C27 s27 25 68e-4
VS28 20 s28 0
R28 s28 21 68e2
VS29 4 s29 0
L29 s29 10 15e-5
VS30 19 s30 0
C30 s30 11 56e-5
VS31 15 s31 0
R31 s31 22 47e1
VS32 8 s32 0
R32 s32 23 56e2
VS33 13 s33 0
L33 s33 17 12e-2
VS34 5 s34 0
V34 e34 s34 DC 0 AC 10e0 0
RI34 e34 m34 56e-2
LI34 m34 7 18e-7
VS35 3 s35 0
V35 e35 s35 DC 0 AC 39e0 120
RI35 e35 25 68e-1
VS36 0 s36 0
V36 e36 s36 DC 0 AC 18e0 -120
RI36 e36 m36 33e-1
LI36 m36 21 68e-5
VS37 0 s37 0
L37 s37 19 15e-4
VS38 24 s38 0
L38 s38 3 33e-4
.control
set numdgt=17
ac lin 1 60 60
print v(1) v(2) v(3) v(4) v(5) v(6) v(7) v(8) v(9) v(10)
print v(11) v(12) v(13) v(14) v(15) v(16) v(17) v(18) v(19) v(20)
print v(21) v(22) v(23) v(24) v(25) v(26) v(27)
print i(vs0) i(vs1) i(vs2) i(vs3) i(vs4) i(vs5) i(vs6) i(vs7) i(vs8) i(vs9)
print i(vs10) i(vs11) i(vs12) i(vs13) i(vs14) i(vs15) i(vs16) i(vs17) i(vs18) i(vs19)
print i(vs20) i(vs21) i(vs22) i(vs23) i(vs24) i(vs25) i(vs26) i(vs27) i(vs28) i(vs29)
print i(vs30) i(vs31) i(vs32) i(vs33) i(vs34) i(vs35) i(vs36) i(vs37) i(vs38)
.endc
.end
