controls oracle ac-0098
* Generated (plan F2.7, ADR 0012): do not edit; regenerate with `pnpm sim oracle regen`. ac seed 20261031 index 98 nodes 23 elements 36
.options sparse gmin=1e-12 noopac
RG1 1 0 1000000000000
RG2 2 0 1000000000000
RG3 3 0 1000000000000
RG4 4 0 1000000000000
RG5 5 0 1000000000000
RG6 6 0 1000000000000
RG7 7 0 1000000000000
RG8 8 0 1000000000000
RG9 9 0 1000000000000
RG10 10 0 1000000000000
RG11 11 0 1000000000000
RG12 12 0 1000000000000
RG13 13 0 1000000000000
RG14 14 0 1000000000000
RG15 15 0 1000000000000
RG16 16 0 1000000000000
RG17 17 0 1000000000000
RG18 18 0 1000000000000
RG19 19 0 1000000000000
RG20 20 0 1000000000000
RG21 21 0 1000000000000
RG22 22 0 1000000000000
VS0 4 s0 0
C0 s0 16 39e-5
VS1 13 s1 0
R1 s1 12 68e2
VS2 22 s2 0
C2 s2 2 22e-4
VS3 15 s3 0
L3 s3 21 56e-4
VS4 0 s4 0
R4 s4 14 22e2
VS5 15 s5 0
R5 s5 17 39e0
VS6 4 s6 0
R6 s6 14 12e3
VS7 0 s7 0
V7 e7 s7 DC 0 AC 22e-1 120
RI7 e7 19 18e-1
VS8 4 s8 0
L8 s8 18 10e-2
VS9 5 s9 0
R9 s9 1 39e0
VS10 14 s10 0
R10 s10 2 10e2
VS11 7 s11 0
R11 s11 6 15e2
VS12 7 s12 0
V12 e12 s12 DC 0 AC 15e-1 180
RI12 e12 m12 33e-1
LI12 m12 2 15e-6
VS13 9 s13 0
V13 e13 s13 DC 0 AC 10e1 180
RI13 e13 22 47e-1
VS14 7 s14 0
C14 s14 0 82e-6
VS15 11 s15 0
L15 s15 8 27e-4
VS16 7 s16 0
L16 s16 17 18e-4
VS17 3 s17 0
V17 e17 s17 DC 0 AC 27e1 120
RI17 e17 21 10e-1
VS18 22 s18 0
L18 s18 10 12e-4
VS19 10 s19 0
C19 s19 20 47e-4
VS20 9 s20 0
C20 s20 4 39e-4
VS21 2 s21 0
C21 s21 5 22e-6
VS22 11 s22 0
C22 s22 19 22e-5
VS23 2 s23 0
R23 s23 11 82e2
VS24 17 s24 0
L24 s24 0 47e-4
VS25 12 s25 0
V25 e25 s25 DC 0 AC 12e0 0
RI25 e25 14 22e-3
VS26 12 s26 0
R26 s26 5 15e-1
VS27 20 s27 0
V27 e27 s27 DC 0 AC 15e-1 -120
RI27 e27 18 12e-1
VS28 21 s28 0
V28 e28 s28 DC 0 AC 12e0 -120
RI28 e28 m28 39e-2
LI28 m28 2 12e-5
VS29 2 s29 0
C29 s29 12 39e-7
VS30 6 s30 0
R30 s30 8 56e-2
VS31 8 s31 0
L31 s31 16 27e-5
VS32 8 s32 0
V32 e32 s32 DC 0 AC 22e1 120
RI32 e32 13 18e-1
VS33 1 s33 0
R33 s33 0 39e1
VS34 3 s34 0
R34 s34 4 56e0
VS35 11 s35 0
C35 s35 13 27e-5
.control
set numdgt=17
ac lin 1 60 60
print v(1) v(2) v(3) v(4) v(5) v(6) v(7) v(8) v(9) v(10)
print v(11) v(12) v(13) v(14) v(15) v(16) v(17) v(18) v(19) v(20)
print v(21) v(22)
print i(vs0) i(vs1) i(vs2) i(vs3) i(vs4) i(vs5) i(vs6) i(vs7) i(vs8) i(vs9)
print i(vs10) i(vs11) i(vs12) i(vs13) i(vs14) i(vs15) i(vs16) i(vs17) i(vs18) i(vs19)
print i(vs20) i(vs21) i(vs22) i(vs23) i(vs24) i(vs25) i(vs26) i(vs27) i(vs28) i(vs29)
print i(vs30) i(vs31) i(vs32) i(vs33) i(vs34) i(vs35)
.endc
.end
