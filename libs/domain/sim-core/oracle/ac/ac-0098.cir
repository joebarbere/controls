controls oracle ac-0098
* Generated (plan F2.7, ADR 0012): do not edit; regenerate with `pnpm sim oracle regen`. ac seed 20261031 index 98 nodes 23 elements 45
.options sparse gmin=1e-12 noopac
RG1 1 0 1000000000000
RG2 2 0 1000000000000
RG3 3 0 1000000000000
RG4 4 0 1000000000000
RG5 5 0 1000000000000
RG6 6 0 1000000000000
RG7 7 0 1000000000000
RG8 8 0 1000000000000
RG9 9 0 1000000000000
RG10 10 0 1000000000000
RG11 11 0 1000000000000
RG12 12 0 1000000000000
RG13 13 0 1000000000000
RG14 14 0 1000000000000
RG15 15 0 1000000000000
RG16 16 0 1000000000000
RG17 17 0 1000000000000
RG18 18 0 1000000000000
RG19 19 0 1000000000000
RG20 20 0 1000000000000
RG21 21 0 1000000000000
RG22 22 0 1000000000000
VS0 3 s0 0
C0 s0 12 15e-5
VS1 13 s1 0
R1 s1 8 10e1
VS2 16 s2 0
L2 s2 10 68e-4
VS3 13 s3 0
R3 s3 20 68e0
VS4 0 s4 0
V4 e4 s4 DC 0 AC 15e1 180
RI4 e4 m4 47e-2
LI4 m4 2 10e-5
VS5 8 s5 0
V5 e5 s5 DC 0 AC 12e-1 -120
RI5 e5 m5 12e-3
LI5 m5 22 56e-6
VS6 22 s6 0
R6 s6 5 15e2
VS7 15 s7 0
R7 s7 5 39e1
VS8 9 s8 0
R8 s8 20 82e-2
VS9 19 s9 0
C9 s9 4 15e-7
VS10 1 s10 0
C10 s10 17 27e-5
VS11 21 s11 0
C11 s11 0 68e-7
VS12 21 s12 0
V12 e12 s12 DC 0 AC 56e-1 180
RI12 e12 m12 18e-2
LI12 m12 3 56e-7
VS13 9 s13 0
R13 s13 7 12e-2
VS14 22 s14 0
L14 s14 11 33e-4
VS15 22 s15 0
V15 e15 s15 DC 0 AC 22e-1 0
RI15 e15 m15 15e-2
LI15 m15 3 68e-5
VS16 22 s16 0
C16 s16 10 22e-4
VS17 17 s17 0
L17 s17 6 82e-4
VS18 9 s18 0
V18 e18 s18 DC 0 AC 10e1 180
RI18 e18 22 47e-1
VS19 14 s19 0
C19 s19 18 47e-7
VS20 12 s20 0
L20 s20 17 22e-5
VS21 7 s21 0
V21 e21 s21 DC 0 AC 68e1 0
RI21 e21 m21 18e-2
LI21 m21 18 12e-7
VS22 9 s22 0
R22 s22 11 39e0
VS23 9 s23 0
L23 s23 15 68e-2
VS24 4 s24 0
L24 s24 10 10e-4
VS25 14 s25 0
L25 s25 16 82e-3
VS26 18 s26 0
R26 s26 16 39e-2
VS27 9 s27 0
C27 s27 18 82e-7
VS28 14 s28 0
V28 e28 s28 DC 0 AC 56e0 180
RI28 e28 m28 10e-1
LI28 m28 12 82e-6
VS29 13 s29 0
R29 s29 21 56e-2
VS30 20 s30 0
L30 s30 7 27e-4
VS31 9 s31 0
V31 e31 s31 DC 0 AC 47e0 -120
RI31 e31 17 47e-1
VS32 20 s32 0
L32 s32 7 82e-3
VS33 19 s33 0
C33 s33 11 33e-5
VS34 1 s34 0
R34 s34 13 15e2
VS35 21 s35 0
C35 s35 7 22e-6
VS36 17 s36 0
C36 s36 21 18e-4
VS37 4 s37 0
C37 s37 16 27e-7
VS38 6 s38 0
R38 s38 16 10e0
VS39 8 s39 0
L39 s39 17 68e-2
VS40 6 s40 0
R40 s40 0 33e-2
VS41 12 s41 0
R41 s41 2 12e2
VS42 19 s42 0
C42 s42 16 18e-7
VS43 7 s43 0
C43 s43 14 22e-5
VS44 22 s44 0
V44 e44 s44 DC 0 AC 39e1 -120
RI44 e44 7 56e-3
.control
set numdgt=17
ac lin 1 60 60
print v(1) v(2) v(3) v(4) v(5) v(6) v(7) v(8) v(9) v(10)
print v(11) v(12) v(13) v(14) v(15) v(16) v(17) v(18) v(19) v(20)
print v(21) v(22)
print i(vs0) i(vs1) i(vs2) i(vs3) i(vs4) i(vs5) i(vs6) i(vs7) i(vs8) i(vs9)
print i(vs10) i(vs11) i(vs12) i(vs13) i(vs14) i(vs15) i(vs16) i(vs17) i(vs18) i(vs19)
print i(vs20) i(vs21) i(vs22) i(vs23) i(vs24) i(vs25) i(vs26) i(vs27) i(vs28) i(vs29)
print i(vs30) i(vs31) i(vs32) i(vs33) i(vs34) i(vs35) i(vs36) i(vs37) i(vs38) i(vs39)
print i(vs40) i(vs41) i(vs42) i(vs43) i(vs44)
.endc
.end
