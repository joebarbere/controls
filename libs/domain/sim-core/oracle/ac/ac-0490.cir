controls oracle ac-0490
* Generated (plan F2.7, ADR 0012): do not edit; regenerate with `pnpm sim oracle regen`. ac seed 20261031 index 490 nodes 11 elements 21
.options sparse gmin=1e-12 noopac
RG1 1 0 1000000000000
RG2 2 0 1000000000000
RG3 3 0 1000000000000
RG4 4 0 1000000000000
RG5 5 0 1000000000000
RG6 6 0 1000000000000
RG7 7 0 1000000000000
RG8 8 0 1000000000000
RG9 9 0 1000000000000
RG10 10 0 1000000000000
VS0 4 s0 0
R0 s0 7 10e1
VS1 0 s1 0
V1 e1 s1 DC 0 AC 27e1 -120
RI1 e1 m1 15e-2
LI1 m1 n1 18e-7
H1 n1 h1 VS9 -39e-3
ED1 h1 1 d1 0 -10e-7
F1 0 d1 VS9 1
LD1 d1 0 1
VS2 10 s2 0
R2 s2 4 56e1
VS3 0 s3 0
C3 s3 3 12e-7
VS4 5 s4 0
R4 s4 6 27e0
VS5 0 s5 0
L5 s5 8 33e-4
VS6 10 s6 0
L6 s6 3 47e-4
VS7 0 s7 0
C7 s7 9 22e-6
VS8 9 s8 0
C8 s8 1 68e-5
VS9 0 s9 0
V9 e9 s9 DC 0 AC 39e0 -120
RI9 e9 m9 22e-2
LI9 m9 n9 22e-6
H9 n9 h9 VS1 -39e-3
ED9 h9 3 d9 0 -10e-7
F9 0 d9 VS1 1
LD9 d9 0 1
VS10 1 s10 0
R10 s10 2 27e3
VS11 0 s11 0
R11 s11 6 18e-1
VS12 8 s12 0
V12 e12 s12 DC 0 AC 15e1 120
RI12 e12 m12 22e-3
LI12 m12 4 15e-6
VS13 5 s13 0
V13 e13 s13 DC 0 AC 82e1 0
RI13 e13 6 82e-2
VS14 8 s14 0
R14 s14 0 33e0
VS15 8 s15 0
R15 s15 5 15e0
VS16 5 s16 0
V16 e16 s16 DC 0 AC 22e0 -120
RI16 e16 9 56e-3
VS17 1 s17 0
L17 s17 2 82e-3
VS18 2 s18 0
R18 s18 5 27e2
VS19 3 s19 0
C19 s19 7 68e-4
VS20 5 s20 0
R20 s20 10 68e1
.control
set numdgt=17
ac lin 1 60 60
print v(1) v(2) v(3) v(4) v(5) v(6) v(7) v(8) v(9) v(10)
print i(vs0) i(vs1) i(vs2) i(vs3) i(vs4) i(vs5) i(vs6) i(vs7) i(vs8) i(vs9)
print i(vs10) i(vs11) i(vs12) i(vs13) i(vs14) i(vs15) i(vs16) i(vs17) i(vs18) i(vs19)
print i(vs20)
.endc
.end
