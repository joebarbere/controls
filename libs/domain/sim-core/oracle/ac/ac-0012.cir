controls oracle ac-0012
* Generated (plan F2.7, ADR 0012): do not edit; regenerate with `pnpm sim oracle regen`. ac seed 20261031 index 12 nodes 13 elements 24
.options sparse gmin=1e-12 noopac
RG1 1 0 1000000000000
RG2 2 0 1000000000000
RG3 3 0 1000000000000
RG4 4 0 1000000000000
RG5 5 0 1000000000000
RG6 6 0 1000000000000
RG7 7 0 1000000000000
RG8 8 0 1000000000000
RG9 9 0 1000000000000
RG10 10 0 1000000000000
RG11 11 0 1000000000000
RG12 12 0 1000000000000
VS0 11 s0 0
L0 s0 10 15e-4
VS1 0 s1 0
V1 e1 s1 DC 0 AC 68e0 0
RI1 e1 2 18e-1
VS2 3 s2 0
L2 s2 6 33e-4
VS3 7 s3 0
L3 s3 11 22e-3
VS4 2 s4 0
R4 s4 4 39e1
VS5 4 s5 0
L5 s5 10 56e-2
VS6 12 s6 0
C6 s6 9 12e-6
VS7 9 s7 0
C7 s7 2 12e-5
VS8 9 s8 0
L8 s8 0 18e-2
VS9 0 s9 0
L9 s9 7 18e-2
VS10 2 s10 0
L10 s10 1 10e-5
VS11 3 s11 0
V11 e11 s11 DC 0 AC 15e1 120
RI11 e11 4 33e-2
VS12 3 s12 0
C12 s12 1 39e-6
VS13 3 s13 0
C13 s13 6 82e-7
VS14 10 s14 0
C14 s14 5 68e-5
VS15 1 s15 0
R15 s15 0 27e-2
VS16 2 s16 0
V16 e16 s16 DC 0 AC 10e-1 -120
RI16 e16 11 27e-3
VS17 11 s17 0
V17 e17 s17 DC 0 AC 27e-1 -120
RI17 e17 7 15e-1
VS18 9 s18 0
R18 s18 2 18e2
VS19 3 s19 0
R19 s19 11 82e-1
VS20 7 s20 0
L20 s20 0 68e-5
VS21 6 s21 0
C21 s21 1 12e-7
VS22 11 s22 0
V22 e22 s22 DC 0 AC 47e-1 0
RI22 e22 12 27e-3
VS23 8 s23 0
V23 e23 s23 DC 0 AC 15e0 180
RI23 e23 9 10e-1
.control
set numdgt=17
ac lin 1 60 60
print v(1) v(2) v(3) v(4) v(5) v(6) v(7) v(8) v(9) v(10)
print v(11) v(12)
print i(vs0) i(vs1) i(vs2) i(vs3) i(vs4) i(vs5) i(vs6) i(vs7) i(vs8) i(vs9)
print i(vs10) i(vs11) i(vs12) i(vs13) i(vs14) i(vs15) i(vs16) i(vs17) i(vs18) i(vs19)
print i(vs20) i(vs21) i(vs22) i(vs23)
.endc
.end
