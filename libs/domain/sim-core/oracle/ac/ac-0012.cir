controls oracle ac-0012
* Generated (plan F2.7, ADR 0012): do not edit; regenerate with `pnpm sim oracle regen`. ac seed 20261031 index 12 nodes 13 elements 21
.options sparse gmin=1e-12 noopac
RG1 1 0 1000000000000
RG2 2 0 1000000000000
RG3 3 0 1000000000000
RG4 4 0 1000000000000
RG5 5 0 1000000000000
RG6 6 0 1000000000000
RG7 7 0 1000000000000
RG8 8 0 1000000000000
RG9 9 0 1000000000000
RG10 10 0 1000000000000
RG11 11 0 1000000000000
RG12 12 0 1000000000000
VS0 0 s0 0
V0 e0 s0 DC 0 AC 15e0 180
RI0 e0 m0 22e-3
LI0 m0 4 39e-5
VS1 3 s1 0
R1 s1 8 82e-1
VS2 5 s2 0
R2 s2 1 10e2
VS3 4 s3 0
L3 s3 11 15e-3
VS4 2 s4 0
L4 s4 8 33e-5
VS5 6 s5 0
C5 s5 0 47e-6
VS6 7 s6 0
V6 e6 s6 DC 0 AC 15e1 -120
RI6 e6 4 82e-1
VS7 9 s7 0
L7 s7 6 15e-2
VS8 6 s8 0
C8 s8 3 12e-6
VS9 12 s9 0
L9 s9 9 33e-3
VS10 6 s10 0
C10 s10 2 68e-4
VS11 4 s11 0
V11 e11 s11 DC 0 AC 18e0 180
RI11 e11 m11 10e-2
LI11 m11 2 68e-5
VS12 7 s12 0
L12 s12 8 22e-3
VS13 2 s13 0
V13 e13 s13 DC 0 AC 27e0 180
RI13 e13 1 27e-1
VS14 12 s14 0
V14 e14 s14 DC 0 AC 56e0 0
RI14 e14 m14 68e-1
LI14 m14 8 56e-6
VS15 6 s15 0
R15 s15 10 56e1
VS16 8 s16 0
C16 s16 10 56e-4
VS17 10 s17 0
R17 s17 2 22e1
VS18 1 s18 0
R18 s18 9 68e1
VS19 5 s19 0
C19 s19 11 82e-5
VS20 3 s20 0
V20 e20 s20 DC 0 AC 15e1 120
RI20 e20 4 33e-2
.control
set numdgt=17
ac lin 1 60 60
print v(1) v(2) v(3) v(4) v(5) v(6) v(7) v(8) v(9) v(10)
print v(11) v(12)
print i(vs0) i(vs1) i(vs2) i(vs3) i(vs4) i(vs5) i(vs6) i(vs7) i(vs8) i(vs9)
print i(vs10) i(vs11) i(vs12) i(vs13) i(vs14) i(vs15) i(vs16) i(vs17) i(vs18) i(vs19)
print i(vs20)
.endc
.end
