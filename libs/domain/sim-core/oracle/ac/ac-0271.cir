controls oracle ac-0271
* Generated (plan F2.7, ADR 0012): do not edit; regenerate with `pnpm sim oracle regen`. ac seed 20261031 index 271 nodes 17 elements 35
.options sparse gmin=1e-12 noopac
RG1 1 0 1000000000000
RG2 2 0 1000000000000
RG3 3 0 1000000000000
RG4 4 0 1000000000000
RG5 5 0 1000000000000
RG6 6 0 1000000000000
RG7 7 0 1000000000000
RG8 8 0 1000000000000
RG9 9 0 1000000000000
RG10 10 0 1000000000000
RG11 11 0 1000000000000
RG12 12 0 1000000000000
RG13 13 0 1000000000000
RG14 14 0 1000000000000
RG15 15 0 1000000000000
RG16 16 0 1000000000000
VS0 0 s0 0
V0 e0 s0 DC 0 AC 47e1 -120
RI0 e0 n0 15e-3
H0 n0 h0 VS4 18e-4
ED0 h0 6 d0 0 -82e-5
F0 0 d0 VS4 1
LD0 d0 0 1
VS1 1 s1 0
R1 s1 2 15e-2
VS2 15 s2 0
R2 s2 16 10e2
VS3 6 s3 0
C3 s3 16 47e-6
VS4 14 s4 0
V4 e4 s4 DC 0 AC 22e-1 0
RI4 e4 n4 47e-1
H4 n4 h4 VS0 18e-4
ED4 h4 0 d4 0 -82e-5
F4 0 d4 VS0 1
LD4 d4 0 1
VS5 1 s5 0
L5 s5 16 27e-5
VS6 13 s6 0
L6 s6 0 12e-4
VS7 3 s7 0
V7 e7 s7 DC 0 AC 33e-1 120
RI7 e7 m7 12e-3
LI7 m7 0 68e-7
VS8 16 s8 0
R8 s8 9 18e-2
VS9 9 s9 0
R9 s9 4 47e-1
VS10 8 s10 0
L10 s10 16 18e-4
VS11 12 s11 0
L11 s11 10 56e-2
VS12 3 s12 0
L12 s12 14 22e-2
VS13 3 s13 0
R13 s13 9 15e0
VS14 8 s14 0
L14 s14 0 33e-5
VS15 11 s15 0
V15 e15 s15 DC 0 AC 82e1 0
RI15 e15 12 39e-2
VS16 15 s16 0
L16 s16 1 56e-5
VS17 7 s17 0
C17 s17 6 18e-7
VS18 16 s18 0
R18 s18 13 39e-2
VS19 8 s19 0
C19 s19 14 47e-6
VS20 1 s20 0
R20 s20 0 27e1
VS21 6 s21 0
R21 s21 5 22e0
VS22 6 s22 0
L22 s22 3 33e-5
VS23 16 s23 0
R23 s23 2 39e-1
VS24 7 s24 0
R24 s24 11 56e0
VS25 4 s25 0
L25 s25 0 33e-2
VS26 9 s26 0
R26 s26 10 33e-1
VS27 2 s27 0
R27 s27 9 82e1
VS28 13 s28 0
L28 s28 0 10e-3
VS29 8 s29 0
R29 s29 10 27e1
VS30 14 s30 0
R30 s30 7 68e0
VS31 5 s31 0
L31 s31 0 68e-3
VS32 10 s32 0
C32 s32 14 68e-6
VS33 5 s33 0
R33 s33 10 18e-2
VS34 16 s34 0
R34 s34 5 39e-1
.control
set numdgt=17
ac lin 1 60 60
print v(1) v(2) v(3) v(4) v(5) v(6) v(7) v(8) v(9) v(10)
print v(11) v(12) v(13) v(14) v(15) v(16)
print i(vs0) i(vs1) i(vs2) i(vs3) i(vs4) i(vs5) i(vs6) i(vs7) i(vs8) i(vs9)
print i(vs10) i(vs11) i(vs12) i(vs13) i(vs14) i(vs15) i(vs16) i(vs17) i(vs18) i(vs19)
print i(vs20) i(vs21) i(vs22) i(vs23) i(vs24) i(vs25) i(vs26) i(vs27) i(vs28) i(vs29)
print i(vs30) i(vs31) i(vs32) i(vs33) i(vs34)
.endc
.end
