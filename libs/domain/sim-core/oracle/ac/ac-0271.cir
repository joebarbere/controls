controls oracle ac-0271
* Generated (plan F2.7, ADR 0012): do not edit; regenerate with `pnpm sim oracle regen`. ac seed 20261031 index 271 nodes 17 elements 28
.options sparse gmin=1e-12 noopac
RG1 1 0 1000000000000
RG2 2 0 1000000000000
RG3 3 0 1000000000000
RG4 4 0 1000000000000
RG5 5 0 1000000000000
RG6 6 0 1000000000000
RG7 7 0 1000000000000
RG8 8 0 1000000000000
RG9 9 0 1000000000000
RG10 10 0 1000000000000
RG11 11 0 1000000000000
RG12 12 0 1000000000000
RG13 13 0 1000000000000
RG14 14 0 1000000000000
RG15 15 0 1000000000000
RG16 16 0 1000000000000
VS0 16 s0 0
R0 s0 15 56e1
VS1 8 s1 0
C1 s1 14 47e-6
VS2 7 s2 0
C2 s2 6 18e-7
VS3 12 s3 0
R3 s3 10 33e3
VS4 2 s4 0
L4 s4 4 12e-2
VS5 12 s5 0
L5 s5 10 56e-2
VS6 9 s6 0
L6 s6 5 33e-5
VS7 1 s7 0
L7 s7 16 27e-5
VS8 11 s8 0
R8 s8 10 18e-2
VS9 0 s9 0
V9 e9 s9 DC 0 AC 82e1 0
RI9 e9 12 39e-2
VS10 9 s10 0
C10 s10 3 22e-7
VS11 16 s11 0
R11 s11 9 18e-2
VS12 16 s12 0
R12 s12 11 39e-1
VS13 2 s13 0
R13 s13 1 56e1
VS14 10 s14 0
C14 s14 7 22e-5
VS15 2 s15 0
R15 s15 6 39e0
VS16 1 s16 0
R16 s16 9 39e-2
VS17 2 s17 0
V17 e17 s17 DC 0 AC 68e0 0
RI17 e17 7 18e-2
VS18 15 s18 0
R18 s18 16 10e2
VS19 15 s19 0
L19 s19 3 12e-3
VS20 13 s20 0
R20 s20 9 82e-2
VS21 11 s21 0
V21 e21 s21 DC 0 AC 33e1 180
RI21 e21 m21 56e-1
LI21 m21 13 39e-5
VS22 5 s22 0
C22 s22 11 33e-5
VS23 6 s23 0
R23 s23 11 22e0
VS24 14 s24 0
R24 s24 4 22e-2
VS25 8 s25 0
L25 s25 16 18e-4
VS26 7 s26 0
L26 s26 1 47e-4
VS27 0 s27 0
C27 s27 2 47e-7
.control
set numdgt=17
ac lin 1 60 60
print v(1) v(2) v(3) v(4) v(5) v(6) v(7) v(8) v(9) v(10)
print v(11) v(12) v(13) v(14) v(15) v(16)
print i(vs0) i(vs1) i(vs2) i(vs3) i(vs4) i(vs5) i(vs6) i(vs7) i(vs8) i(vs9)
print i(vs10) i(vs11) i(vs12) i(vs13) i(vs14) i(vs15) i(vs16) i(vs17) i(vs18) i(vs19)
print i(vs20) i(vs21) i(vs22) i(vs23) i(vs24) i(vs25) i(vs26) i(vs27)
.endc
.end
