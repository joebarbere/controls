controls oracle ac-0271
* Generated (plan F2.7, ADR 0012): do not edit; regenerate with `pnpm sim oracle regen`. ac seed 20261031 index 271 nodes 17 elements 33
.options sparse gmin=1e-12 noopac
RG1 1 0 1000000000000
RG2 2 0 1000000000000
RG3 3 0 1000000000000
RG4 4 0 1000000000000
RG5 5 0 1000000000000
RG6 6 0 1000000000000
RG7 7 0 1000000000000
RG8 8 0 1000000000000
RG9 9 0 1000000000000
RG10 10 0 1000000000000
RG11 11 0 1000000000000
RG12 12 0 1000000000000
RG13 13 0 1000000000000
RG14 14 0 1000000000000
RG15 15 0 1000000000000
RG16 16 0 1000000000000
VS0 16 s0 0
R0 s0 9 18e-2
VS1 1 s1 0
L1 s1 16 27e-5
VS2 0 s2 0
V2 e2 s2 DC 0 AC 33e-1 120
RI2 e2 5 12e-3
VS3 9 s3 0
R3 s3 10 33e-1
VS4 11 s4 0
V4 e4 s4 DC 0 AC 82e1 0
RI4 e4 12 39e-2
VS5 5 s5 0
V5 e5 s5 DC 0 AC 47e1 -120
RI5 e5 6 15e-3
VS6 12 s6 0
L6 s6 10 56e-2
VS7 6 s7 0
R7 s7 3 22e0
VS8 8 s8 0
C8 s8 14 47e-6
VS9 9 s9 0
R9 s9 4 47e-1
VS10 14 s10 0
R10 s10 7 68e0
VS11 14 s11 0
V11 e11 s11 DC 0 AC 22e-1 0
RI11 e11 5 47e-1
VS12 0 s12 0
L12 s12 14 22e-2
VS13 6 s13 0
C13 s13 16 47e-6
VS14 7 s14 0
C14 s14 6 18e-7
VS15 13 s15 0
L15 s15 5 12e-4
VS16 8 s16 0
R16 s16 10 27e1
VS17 3 s17 0
L17 s17 5 68e-3
VS18 15 s18 0
R18 s18 16 10e2
VS19 10 s19 0
C19 s19 14 68e-6
VS20 8 s20 0
L20 s20 5 33e-5
VS21 0 s21 0
R21 s21 9 15e0
VS22 16 s22 0
R22 s22 2 39e-1
VS23 16 s23 0
R23 s23 13 39e-2
VS24 1 s24 0
R24 s24 5 27e1
VS25 2 s25 0
R25 s25 9 82e1
VS26 16 s26 0
R26 s26 3 39e-1
VS27 1 s27 0
R27 s27 2 15e-2
VS28 3 s28 0
R28 s28 10 18e-2
VS29 4 s29 0
L29 s29 5 33e-2
VS30 8 s30 0
L30 s30 16 18e-4
VS31 13 s31 0
L31 s31 5 10e-3
VS32 6 s32 0
L32 s32 0 33e-5
.control
set numdgt=17
ac lin 1 60 60
print v(1) v(2) v(3) v(4) v(5) v(6) v(7) v(8) v(9) v(10)
print v(11) v(12) v(13) v(14) v(15) v(16)
print i(vs0) i(vs1) i(vs2) i(vs3) i(vs4) i(vs5) i(vs6) i(vs7) i(vs8) i(vs9)
print i(vs10) i(vs11) i(vs12) i(vs13) i(vs14) i(vs15) i(vs16) i(vs17) i(vs18) i(vs19)
print i(vs20) i(vs21) i(vs22) i(vs23) i(vs24) i(vs25) i(vs26) i(vs27) i(vs28) i(vs29)
print i(vs30) i(vs31) i(vs32)
.endc
.end
