controls oracle ac-0105
* Generated (plan F2.7, ADR 0012): do not edit; regenerate with `pnpm sim oracle regen`. ac seed 20261031 index 105 nodes 25 elements 51
.options sparse gmin=1e-12 noopac
RG1 1 0 1000000000000
RG2 2 0 1000000000000
RG3 3 0 1000000000000
RG4 4 0 1000000000000
RG5 5 0 1000000000000
RG6 6 0 1000000000000
RG7 7 0 1000000000000
RG8 8 0 1000000000000
RG9 9 0 1000000000000
RG10 10 0 1000000000000
RG11 11 0 1000000000000
RG12 12 0 1000000000000
RG13 13 0 1000000000000
RG14 14 0 1000000000000
RG15 15 0 1000000000000
RG16 16 0 1000000000000
RG17 17 0 1000000000000
RG18 18 0 1000000000000
RG19 19 0 1000000000000
RG20 20 0 1000000000000
RG21 21 0 1000000000000
RG22 22 0 1000000000000
RG23 23 0 1000000000000
RG24 24 0 1000000000000
VS0 21 s0 0
C0 s0 14 22e-7
VS1 8 s1 0
R1 s1 10 56e-2
VS2 13 s2 0
R2 s2 20 27e-1
VS3 7 s3 0
C3 s3 1 10e-6
VS4 13 s4 0
C4 s4 20 47e-4
VS5 22 s5 0
L5 s5 11 12e-5
VS6 0 s6 0
C6 s6 1 22e-7
VS7 0 s7 0
R7 s7 20 33e-2
VS8 15 s8 0
L8 s8 9 56e-4
VS9 0 s9 0
V9 e9 s9 DC 0 AC 12e1 0
RI9 e9 2 33e-2
VS10 23 s10 0
R10 s10 0 10e0
VS11 4 s11 0
C11 s11 5 18e-7
VS12 24 s12 0
L12 s12 3 47e-5
VS13 18 s13 0
R13 s13 7 33e0
VS14 15 s14 0
R14 s14 13 39e1
VS15 8 s15 0
C15 s15 13 18e-6
VS16 20 s16 0
R16 s16 7 47e0
VS17 14 s17 0
V17 e17 s17 DC 0 AC 56e-1 180
RI17 e17 m17 27e-3
LI17 m17 9 47e-5
VS18 10 s18 0
L18 s18 22 39e-4
VS19 18 s19 0
R19 s19 1 47e-1
VS20 22 s20 0
L20 s20 10 39e-3
VS21 13 s21 0
V21 e21 s21 DC 0 AC 47e-1 180
RI21 e21 8 12e-2
VS22 22 s22 0
V22 e22 s22 DC 0 AC 15e1 0
RI22 e22 m22 33e-2
LI22 m22 7 68e-6
VS23 14 s23 0
L23 s23 22 27e-5
VS24 23 s24 0
V24 e24 s24 DC 0 AC 15e-1 -120
RI24 e24 12 22e-3
VS25 6 s25 0
L25 s25 0 10e-3
VS26 16 s26 0
R26 s26 0 15e-1
VS27 3 s27 0
L27 s27 6 15e-4
VS28 4 s28 0
V28 e28 s28 DC 0 AC 39e1 0
RI28 e28 14 18e-1
VS29 19 s29 0
L29 s29 8 18e-3
VS30 20 s30 0
L30 s30 18 39e-4
VS31 1 s31 0
R31 s31 7 33e1
VS32 12 s32 0
L32 s32 6 47e-5
VS33 24 s33 0
R33 s33 7 27e3
VS34 11 s34 0
R34 s34 19 33e3
VS35 20 s35 0
L35 s35 17 33e-2
VS36 12 s36 0
R36 s36 20 18e-2
VS37 7 s37 0
R37 s37 19 15e1
VS38 8 s38 0
R38 s38 10 82e-1
VS39 20 s39 0
R39 s39 9 47e1
VS40 23 s40 0
L40 s40 15 27e-2
VS41 5 s41 0
L41 s41 0 22e-3
VS42 2 s42 0
R42 s42 5 12e1
VS43 0 s43 0
C43 s43 21 22e-4
VS44 5 s44 0
R44 s44 1 47e-2
VS45 9 s45 0
V45 e45 s45 DC 0 AC 18e-1 -120
RI45 e45 m45 27e-1
LI45 m45 13 33e-7
VS46 17 s46 0
R46 s46 23 22e-2
VS47 12 s47 0
V47 e47 s47 DC 0 AC 56e-1 180
RI47 e47 m47 18e-1
LI47 m47 5 47e-5
VS48 16 s48 0
R48 s48 13 56e1
VS49 21 s49 0
C49 s49 7 33e-6
VS50 5 s50 0
C50 s50 18 22e-7
.control
set numdgt=17
ac lin 1 60 60
print v(1) v(2) v(3) v(4) v(5) v(6) v(7) v(8) v(9) v(10)
print v(11) v(12) v(13) v(14) v(15) v(16) v(17) v(18) v(19) v(20)
print v(21) v(22) v(23) v(24)
print i(vs0) i(vs1) i(vs2) i(vs3) i(vs4) i(vs5) i(vs6) i(vs7) i(vs8) i(vs9)
print i(vs10) i(vs11) i(vs12) i(vs13) i(vs14) i(vs15) i(vs16) i(vs17) i(vs18) i(vs19)
print i(vs20) i(vs21) i(vs22) i(vs23) i(vs24) i(vs25) i(vs26) i(vs27) i(vs28) i(vs29)
print i(vs30) i(vs31) i(vs32) i(vs33) i(vs34) i(vs35) i(vs36) i(vs37) i(vs38) i(vs39)
print i(vs40) i(vs41) i(vs42) i(vs43) i(vs44) i(vs45) i(vs46) i(vs47) i(vs48) i(vs49)
print i(vs50)
.endc
.end
