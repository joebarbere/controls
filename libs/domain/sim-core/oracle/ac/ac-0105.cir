controls oracle ac-0105
* Generated (plan F2.7, ADR 0012): do not edit; regenerate with `pnpm sim oracle regen`. ac seed 20261031 index 105 nodes 25 elements 39
.options sparse gmin=1e-12 noopac
RG1 1 0 1000000000000
RG2 2 0 1000000000000
RG3 3 0 1000000000000
RG4 4 0 1000000000000
RG5 5 0 1000000000000
RG6 6 0 1000000000000
RG7 7 0 1000000000000
RG8 8 0 1000000000000
RG9 9 0 1000000000000
RG10 10 0 1000000000000
RG11 11 0 1000000000000
RG12 12 0 1000000000000
RG13 13 0 1000000000000
RG14 14 0 1000000000000
RG15 15 0 1000000000000
RG16 16 0 1000000000000
RG17 17 0 1000000000000
RG18 18 0 1000000000000
RG19 19 0 1000000000000
RG20 20 0 1000000000000
RG21 21 0 1000000000000
RG22 22 0 1000000000000
RG23 23 0 1000000000000
RG24 24 0 1000000000000
VS0 24 s0 0
R0 s0 7 27e3
VS1 10 s1 0
R1 s1 1 27e-1
VS2 22 s2 0
R2 s2 18 68e-1
VS3 11 s3 0
L3 s3 4 10e-4
VS4 17 s4 0
L4 s4 0 33e-3
VS5 0 s5 0
V5 e5 s5 DC 0 AC 39e1 -120
RI5 e5 23 56e-3
VS6 14 s6 0
L6 s6 22 27e-5
VS7 8 s7 0
C7 s7 3 12e-6
VS8 23 s8 0
R8 s8 4 27e3
VS9 19 s9 0
L9 s9 8 18e-3
VS10 16 s10 0
R10 s10 11 82e-1
VS11 2 s11 0
V11 e11 s11 DC 0 AC 22e-1 120
RI11 e11 m11 33e-1
LI11 m11 8 10e-5
VS12 1 s12 0
C12 s12 24 22e-4
VS13 13 s13 0
C13 s13 20 47e-4
VS14 22 s14 0
V14 e14 s14 DC 0 AC 15e1 0
RI14 e14 7 33e-2
VS15 5 s15 0
C15 s15 18 22e-7
VS16 3 s16 0
R16 s16 17 10e-2
VS17 12 s17 0
C17 s17 7 33e-6
VS18 1 s18 0
R18 s18 7 33e1
VS19 18 s19 0
R19 s19 7 39e1
VS20 4 s20 0
V20 e20 s20 DC 0 AC 39e1 0
RI20 e20 14 18e-1
VS21 20 s21 0
L21 s21 21 68e-3
VS22 13 s22 0
L22 s22 12 56e-3
VS23 9 s23 0
R23 s23 15 68e2
VS24 2 s24 0
V24 e24 s24 DC 0 AC 18e-1 -120
RI24 e24 m24 27e-1
LI24 m24 22 10e-5
VS25 10 s25 0
C25 s25 11 18e-7
VS26 13 s26 0
C26 s26 19 39e-6
VS27 5 s27 0
R27 s27 1 47e-2
VS28 21 s28 0
C28 s28 12 22e-4
VS29 15 s29 0
V29 e29 s29 DC 0 AC 22e-1 180
RI29 e29 m29 39e-3
LI29 m29 7 39e-6
VS30 13 s30 0
V30 e30 s30 DC 0 AC 15e-1 120
RI30 e30 8 12e-1
VS31 20 s31 0
R31 s31 1 27e2
VS32 8 s32 0
R32 s32 18 56e1
VS33 6 s33 0
L33 s33 21 10e-3
VS34 14 s34 0
L34 s34 15 82e-5
VS35 16 s35 0
R35 s35 8 39e3
VS36 0 s36 0
L36 s36 13 47e-3
VS37 9 s37 0
C37 s37 0 39e-5
VS38 0 s38 0
C38 s38 6 22e-6
.control
set numdgt=17
ac lin 1 60 60
print v(1) v(2) v(3) v(4) v(5) v(6) v(7) v(8) v(9) v(10)
print v(11) v(12) v(13) v(14) v(15) v(16) v(17) v(18) v(19) v(20)
print v(21) v(22) v(23) v(24)
print i(vs0) i(vs1) i(vs2) i(vs3) i(vs4) i(vs5) i(vs6) i(vs7) i(vs8) i(vs9)
print i(vs10) i(vs11) i(vs12) i(vs13) i(vs14) i(vs15) i(vs16) i(vs17) i(vs18) i(vs19)
print i(vs20) i(vs21) i(vs22) i(vs23) i(vs24) i(vs25) i(vs26) i(vs27) i(vs28) i(vs29)
print i(vs30) i(vs31) i(vs32) i(vs33) i(vs34) i(vs35) i(vs36) i(vs37) i(vs38)
.endc
.end
