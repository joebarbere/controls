controls oracle ac-0105
* Generated (plan F2.7, ADR 0012): do not edit; regenerate with `pnpm sim oracle regen`. ac seed 20261031 index 105 nodes 25 elements 36
.options sparse gmin=1e-12 noopac
RG1 1 0 1000000000000
RG2 2 0 1000000000000
RG3 3 0 1000000000000
RG4 4 0 1000000000000
RG5 5 0 1000000000000
RG6 6 0 1000000000000
RG7 7 0 1000000000000
RG8 8 0 1000000000000
RG9 9 0 1000000000000
RG10 10 0 1000000000000
RG11 11 0 1000000000000
RG12 12 0 1000000000000
RG13 13 0 1000000000000
RG14 14 0 1000000000000
RG15 15 0 1000000000000
RG16 16 0 1000000000000
RG17 17 0 1000000000000
RG18 18 0 1000000000000
RG19 19 0 1000000000000
RG20 20 0 1000000000000
RG21 21 0 1000000000000
RG22 22 0 1000000000000
RG23 23 0 1000000000000
RG24 24 0 1000000000000
VS0 18 s0 0
R0 s0 7 39e1
VS1 13 s1 0
C1 s1 7 33e-6
VS2 17 s2 0
L2 s2 12 33e-3
VS3 0 s3 0
V3 e3 s3 DC 0 AC 15e-1 120
RI3 e3 8 12e-1
VS4 1 s4 0
C4 s4 24 22e-4
VS5 23 s5 0
R5 s5 4 27e3
VS6 9 s6 0
R6 s6 15 68e2
VS7 19 s7 0
L7 s7 8 18e-3
VS8 0 s8 0
C8 s8 19 39e-6
VS9 5 s9 0
R9 s9 1 47e-2
VS10 12 s10 0
C10 s10 6 22e-6
VS11 0 s11 0
L11 s11 13 56e-3
VS12 21 s12 0
C12 s12 13 22e-4
VS13 3 s13 0
R13 s13 17 10e-2
VS14 12 s14 0
L14 s14 0 47e-3
VS15 20 s15 0
R15 s15 1 27e2
VS16 14 s16 0
L16 s16 15 82e-5
VS17 4 s17 0
V17 e17 s17 DC 0 AC 39e1 0
RI17 e17 14 18e-1
VS18 8 s18 0
R18 s18 18 56e1
VS19 0 s19 0
C19 s19 20 47e-4
VS20 14 s20 0
L20 s20 22 27e-5
VS21 12 s21 0
V21 e21 s21 DC 0 AC 39e1 -120
RI21 e21 23 56e-3
VS22 11 s22 0
L22 s22 4 10e-4
VS23 9 s23 0
C23 s23 12 39e-5
VS24 8 s24 0
C24 s24 3 12e-6
VS25 5 s25 0
C25 s25 18 22e-7
VS26 22 s26 0
V26 e26 s26 DC 0 AC 15e1 0
RI26 e26 7 33e-2
VS27 15 s27 0
V27 e27 s27 DC 0 AC 22e-1 180
RI27 e27 7 39e-3
VS28 1 s28 0
R28 s28 7 33e1
VS29 24 s29 0
R29 s29 7 27e3
VS30 16 s30 0
R30 s30 8 39e3
VS31 2 s31 0
V31 e31 s31 DC 0 AC 22e-1 120
RI31 e31 8 33e-1
VS32 6 s32 0
L32 s32 21 10e-3
VS33 20 s33 0
L33 s33 21 68e-3
VS34 10 s34 0
R34 s34 1 27e-1
VS35 22 s35 0
R35 s35 18 68e-1
.control
set numdgt=17
ac lin 1 60 60
print v(1) v(2) v(3) v(4) v(5) v(6) v(7) v(8) v(9) v(10)
print v(11) v(12) v(13) v(14) v(15) v(16) v(17) v(18) v(19) v(20)
print v(21) v(22) v(23) v(24)
print i(vs0) i(vs1) i(vs2) i(vs3) i(vs4) i(vs5) i(vs6) i(vs7) i(vs8) i(vs9)
print i(vs10) i(vs11) i(vs12) i(vs13) i(vs14) i(vs15) i(vs16) i(vs17) i(vs18) i(vs19)
print i(vs20) i(vs21) i(vs22) i(vs23) i(vs24) i(vs25) i(vs26) i(vs27) i(vs28) i(vs29)
print i(vs30) i(vs31) i(vs32) i(vs33) i(vs34) i(vs35)
.endc
.end
