controls oracle ac-0075
* Generated (plan F2.7, ADR 0012): do not edit; regenerate with `pnpm sim oracle regen`. ac seed 20261031 index 75 nodes 16 elements 25
.options sparse gmin=1e-12 noopac
RG1 1 0 1000000000000
RG2 2 0 1000000000000
RG3 3 0 1000000000000
RG4 4 0 1000000000000
RG5 5 0 1000000000000
RG6 6 0 1000000000000
RG7 7 0 1000000000000
RG8 8 0 1000000000000
RG9 9 0 1000000000000
RG10 10 0 1000000000000
RG11 11 0 1000000000000
RG12 12 0 1000000000000
RG13 13 0 1000000000000
RG14 14 0 1000000000000
RG15 15 0 1000000000000
VS0 0 s0 0
L0 s0 9 47e-3
VS1 11 s1 0
R1 s1 9 68e3
VS2 0 s2 0
V2 e2 s2 DC 0 AC 18e1 180
RI2 e2 m2 33e-1
LI2 m2 n2 33e-7
H2 n2 h2 VS14 12e-4
ED2 h2 11 d2 0 27e-6
F2 0 d2 VS14 1
LD2 d2 0 1
VS3 12 s3 0
R3 s3 0 47e-2
VS4 15 s4 0
L4 s4 13 47e-3
VS5 8 s5 0
C5 s5 12 15e-7
VS6 12 s6 0
R6 s6 5 39e2
VS7 2 s7 0
R7 s7 6 56e1
VS8 3 s8 0
C8 s8 7 22e-4
VS9 6 s9 0
C9 s9 8 22e-5
VS10 14 s10 0
R10 s10 15 39e-1
VS11 4 s11 0
R11 s11 5 22e3
VS12 12 s12 0
C12 s12 5 18e-7
VS13 3 s13 0
C13 s13 10 47e-5
VS14 2 s14 0
V14 e14 s14 DC 0 AC 39e-1 -120
RI14 e14 m14 82e-3
LI14 m14 n14 82e-7
H14 n14 h14 VS2 12e-4
ED14 h14 11 d14 0 27e-6
F14 0 d14 VS2 1
LD14 d14 0 1
VS15 9 s15 0
R15 s15 14 12e2
VS16 7 s16 0
V16 e16 s16 DC 0 AC 56e0 -120
RI16 e16 m16 27e-1
LI16 m16 12 22e-5
VS17 13 s17 0
V17 e17 s17 DC 0 AC 27e-1 0
RI17 e17 m17 39e-3
LI17 m17 0 27e-7
VS18 7 s18 0
L18 s18 9 10e-2
VS19 6 s19 0
C19 s19 1 82e-5
VS20 10 s20 0
L20 s20 13 15e-2
VS21 4 s21 0
L21 s21 2 47e-5
VS22 0 s22 0
L22 s22 9 47e-3
VS23 9 s23 0
R23 s23 1 68e2
VS24 13 s24 0
L24 s24 4 27e-2
.control
set numdgt=17
ac lin 1 60 60
print v(1) v(2) v(3) v(4) v(5) v(6) v(7) v(8) v(9) v(10)
print v(11) v(12) v(13) v(14) v(15)
print i(vs0) i(vs1) i(vs2) i(vs3) i(vs4) i(vs5) i(vs6) i(vs7) i(vs8) i(vs9)
print i(vs10) i(vs11) i(vs12) i(vs13) i(vs14) i(vs15) i(vs16) i(vs17) i(vs18) i(vs19)
print i(vs20) i(vs21) i(vs22) i(vs23) i(vs24)
.endc
.end
