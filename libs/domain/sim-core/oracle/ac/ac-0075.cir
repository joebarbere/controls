controls oracle ac-0075
* Generated (plan F2.7, ADR 0012): do not edit; regenerate with `pnpm sim oracle regen`. ac seed 20261031 index 75 nodes 16 elements 20
.options sparse gmin=1e-12 noopac
RG1 1 0 1000000000000
RG2 2 0 1000000000000
RG3 3 0 1000000000000
RG4 4 0 1000000000000
RG5 5 0 1000000000000
RG6 6 0 1000000000000
RG7 7 0 1000000000000
RG8 8 0 1000000000000
RG9 9 0 1000000000000
RG10 10 0 1000000000000
RG11 11 0 1000000000000
RG12 12 0 1000000000000
RG13 13 0 1000000000000
RG14 14 0 1000000000000
RG15 15 0 1000000000000
VS0 10 s0 0
L0 s0 13 15e-2
VS1 0 s1 0
L1 s1 9 47e-3
VS2 4 s2 0
L2 s2 2 47e-5
VS3 12 s3 0
R3 s3 0 47e-2
VS4 0 s4 0
V4 e4 s4 DC 0 AC 18e1 180
RI4 e4 11 33e-1
VS5 8 s5 0
C5 s5 12 15e-7
VS6 7 s6 0
L6 s6 9 10e-2
VS7 12 s7 0
C7 s7 5 18e-7
VS8 3 s8 0
C8 s8 7 22e-4
VS9 2 s9 0
V9 e9 s9 DC 0 AC 39e-1 -120
RI9 e9 11 82e-3
VS10 13 s10 0
V10 e10 s10 DC 0 AC 27e-1 0
RI10 e10 0 39e-3
VS11 11 s11 0
R11 s11 9 68e3
VS12 12 s12 0
R12 s12 5 39e2
VS13 0 s13 0
L13 s13 9 47e-3
VS14 2 s14 0
R14 s14 6 56e1
VS15 15 s15 0
L15 s15 13 47e-3
VS16 9 s16 0
R16 s16 14 12e2
VS17 7 s17 0
V17 e17 s17 DC 0 AC 56e0 -120
RI17 e17 12 27e-1
VS18 9 s18 0
R18 s18 1 68e2
VS19 13 s19 0
L19 s19 4 27e-2
.control
set numdgt=17
ac lin 1 60 60
print v(1) v(2) v(3) v(4) v(5) v(6) v(7) v(8) v(9) v(10)
print v(11) v(12) v(13) v(14) v(15)
print i(vs0) i(vs1) i(vs2) i(vs3) i(vs4) i(vs5) i(vs6) i(vs7) i(vs8) i(vs9)
print i(vs10) i(vs11) i(vs12) i(vs13) i(vs14) i(vs15) i(vs16) i(vs17) i(vs18) i(vs19)
.endc
.end
