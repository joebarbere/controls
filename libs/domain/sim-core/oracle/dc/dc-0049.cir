controls oracle dc-0049
* Generated (plan F2.7, ADR 0012): do not edit; regenerate with `pnpm sim oracle regen`. dc seed 20261030 index 49 nodes 8 elements 13
.options sparse gmin=1e-12 noopac
RG1 1 0 1000000000000
RG2 2 0 1000000000000
RG3 3 0 1000000000000
RG4 4 0 1000000000000
RG5 5 0 1000000000000
RG6 6 0 1000000000000
RG7 7 0 1000000000000
VS0 5 s0 0
I0 s0 1 DC 39e-4
VS1 0 s1 0
V1 e1 s1 DC 47e-1
RI1 e1 5 12e-3
VS2 3 s2 0
V2 e2 s2 DC 22e-1
RI2 e2 1 39e-1
VS3 4 s3 0
R3 s3 5 12e1
VS4 2 s4 0
V4 e4 s4 DC 47e-1
RI4 e4 6 12e-1
VS5 7 s5 0
V5 e5 s5 DC 10e-1
RI5 e5 4 82e-3
VS6 2 s6 0
V6 e6 s6 DC 12e0
RI6 e6 4 15e-1
VS7 1 s7 0
R7 s7 4 56e0
VS8 4 s8 0
R8 s8 5 82e-2
VS9 7 s9 0
R9 s9 6 18e-1
VS10 3 s10 0
R10 s10 4 39e2
VS11 6 s11 0
R11 s11 0 39e1
VS12 3 s12 0
R12 s12 0 47e-2
.control
set numdgt=17
op
print v(1) v(2) v(3) v(4) v(5) v(6) v(7)
print i(vs0) i(vs1) i(vs2) i(vs3) i(vs4) i(vs5) i(vs6) i(vs7) i(vs8) i(vs9)
print i(vs10) i(vs11) i(vs12)
.endc
.end
