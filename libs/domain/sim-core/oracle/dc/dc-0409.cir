controls oracle dc-0409
* Generated (plan F2.7, ADR 0012): do not edit; regenerate with `pnpm sim oracle regen`. dc seed 20261030 index 409 nodes 21 elements 40
.options sparse gmin=1e-12 noopac
RG1 1 0 1000000000000
RG2 2 0 1000000000000
RG3 3 0 1000000000000
RG4 4 0 1000000000000
RG5 5 0 1000000000000
RG6 6 0 1000000000000
RG7 7 0 1000000000000
RG8 8 0 1000000000000
RG9 9 0 1000000000000
RG10 10 0 1000000000000
RG11 11 0 1000000000000
RG12 12 0 1000000000000
RG13 13 0 1000000000000
RG14 14 0 1000000000000
RG15 15 0 1000000000000
RG16 16 0 1000000000000
RG17 17 0 1000000000000
RG18 18 0 1000000000000
RG19 19 0 1000000000000
RG20 20 0 1000000000000
VS0 2 s0 0
R0 s0 1 68e1
VS1 0 s1 0
V1 e1 s1 DC 10e1
RI1 e1 1 18e-3
VS2 13 s2 0
R2 s2 16 39e-2
VS3 1 s3 0
R3 s3 20 39e-1
VS4 15 s4 0
R4 s4 17 56e-2
VS5 17 s5 0
R5 s5 11 56e-2
VS6 4 s6 0
V6 e6 s6 DC 18e1
RI6 e6 6 39e-2
VS7 9 s7 0
V7 e7 s7 DC 56e-1
RI7 e7 5 33e-1
VS8 15 s8 0
R8 s8 5 22e-1
VS9 16 s9 0
R9 s9 19 82e2
VS10 18 s10 0
V10 e10 s10 DC 15e-1
RI10 e10 11 12e-1
VS11 14 s11 0
V11 e11 s11 DC 47e-1
RI11 e11 6 27e-2
VS12 19 s12 0
R12 s12 5 56e-1
VS13 3 s13 0
R13 s13 4 15e1
VS14 11 s14 0
R14 s14 18 22e3
VS15 10 s15 0
R15 s15 19 33e-1
VS16 19 s16 0
R16 s16 13 10e-2
VS17 4 s17 0
R17 s17 17 22e-2
VS18 15 s18 0
V18 e18 s18 DC 33e0
RI18 e18 0 22e-1
VS19 3 s19 0
R19 s19 12 15e2
VS20 18 s20 0
R20 s20 7 12e3
VS21 18 s21 0
I21 s21 3 DC 12e-2
VS22 17 s22 0
R22 s22 6 68e0
VS23 3 s23 0
R23 s23 12 22e2
VS24 18 s24 0
R24 s24 5 10e-2
VS25 7 s25 0
V25 e25 s25 DC 18e1
RI25 e25 14 22e-3
VS26 17 s26 0
V26 e26 s26 DC 68e1
RI26 e26 13 12e-1
VS27 5 s27 0
R27 s27 9 68e-1
VS28 17 s28 0
I28 s28 14 DC 15e-1
VS29 17 s29 0
I29 s29 2 DC 82e-3
VS30 20 s30 0
V30 e30 s30 DC 10e-1
RI30 e30 7 56e-3
VS31 3 s31 0
I31 s31 14 DC 33e-3
VS32 15 s32 0
R32 s32 3 10e-2
VS33 2 s33 0
V33 e33 s33 DC 56e1
RI33 e33 8 68e-3
VS34 18 s34 0
R34 s34 0 18e3
VS35 14 s35 0
R35 s35 8 68e-1
VS36 12 s36 0
R36 s36 9 47e2
VS37 20 s37 0
R37 s37 13 22e-1
VS38 5 s38 0
R38 s38 13 15e3
VS39 16 s39 0
R39 s39 10 15e-1
.control
set numdgt=17
op
print v(1) v(2) v(3) v(4) v(5) v(6) v(7) v(8) v(9) v(10)
print v(11) v(12) v(13) v(14) v(15) v(16) v(17) v(18) v(19) v(20)
print i(vs0) i(vs1) i(vs2) i(vs3) i(vs4) i(vs5) i(vs6) i(vs7) i(vs8) i(vs9)
print i(vs10) i(vs11) i(vs12) i(vs13) i(vs14) i(vs15) i(vs16) i(vs17) i(vs18) i(vs19)
print i(vs20) i(vs21) i(vs22) i(vs23) i(vs24) i(vs25) i(vs26) i(vs27) i(vs28) i(vs29)
print i(vs30) i(vs31) i(vs32) i(vs33) i(vs34) i(vs35) i(vs36) i(vs37) i(vs38) i(vs39)
.endc
.end
