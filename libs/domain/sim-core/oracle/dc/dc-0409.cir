controls oracle dc-0409
* Generated (plan F2.7, ADR 0012): do not edit; regenerate with `pnpm sim oracle regen`. dc seed 20261030 index 409 nodes 21 elements 35
.options sparse gmin=1e-12 noopac
RG1 1 0 1000000000000
RG2 2 0 1000000000000
RG3 3 0 1000000000000
RG4 4 0 1000000000000
RG5 5 0 1000000000000
RG6 6 0 1000000000000
RG7 7 0 1000000000000
RG8 8 0 1000000000000
RG9 9 0 1000000000000
RG10 10 0 1000000000000
RG11 11 0 1000000000000
RG12 12 0 1000000000000
RG13 13 0 1000000000000
RG14 14 0 1000000000000
RG15 15 0 1000000000000
RG16 16 0 1000000000000
RG17 17 0 1000000000000
RG18 18 0 1000000000000
RG19 19 0 1000000000000
RG20 20 0 1000000000000
VS0 0 s0 0
V0 e0 s0 DC 10e1
RI0 e0 1 18e-3
VS1 17 s1 0
I1 s1 2 DC 82e-3
VS2 1 s2 0
R2 s2 20 39e-1
VS3 15 s3 0
R3 s3 3 10e-2
VS4 16 s4 0
R4 s4 19 82e2
VS5 17 s5 0
I5 s5 14 DC 15e-1
VS6 20 s6 0
V6 e6 s6 DC 10e-1
RI6 e6 7 56e-3
VS7 17 s7 0
V7 e7 s7 DC 68e1
RI7 e7 13 12e-1
VS8 18 s8 0
R8 s8 7 12e3
VS9 16 s9 0
R9 s9 10 15e-1
VS10 19 s10 0
R10 s10 13 10e-2
VS11 9 s11 0
V11 e11 s11 DC 56e-1
RI11 e11 5 33e-1
VS12 5 s12 0
R12 s12 13 15e3
VS13 4 s13 0
V13 e13 s13 DC 18e1
RI13 e13 6 39e-2
VS14 17 s14 0
R14 s14 6 68e0
VS15 13 s15 0
R15 s15 16 39e-2
VS16 3 s16 0
R16 s16 12 22e2
VS17 18 s17 0
R17 s17 0 18e3
VS18 4 s18 0
R18 s18 17 22e-2
VS19 3 s19 0
R19 s19 12 15e2
VS20 2 s20 0
R20 s20 1 68e1
VS21 5 s21 0
R21 s21 9 68e-1
VS22 7 s22 0
V22 e22 s22 DC 18e1
RI22 e22 14 22e-3
VS23 15 s23 0
V23 e23 s23 DC 33e0
RI23 e23 0 22e-1
VS24 3 s24 0
I24 s24 14 DC 33e-3
VS25 19 s25 0
R25 s25 5 56e-1
VS26 17 s26 0
R26 s26 11 56e-2
VS27 18 s27 0
V27 e27 s27 DC 15e-1
RI27 e27 11 12e-1
VS28 15 s28 0
R28 s28 17 56e-2
VS29 15 s29 0
R29 s29 5 22e-1
VS30 20 s30 0
R30 s30 13 22e-1
VS31 18 s31 0
I31 s31 3 DC 12e-2
VS32 11 s32 0
R32 s32 18 22e3
VS33 2 s33 0
V33 e33 s33 DC 56e1
RI33 e33 8 68e-3
VS34 18 s34 0
R34 s34 5 10e-2
.control
set numdgt=17
op
print v(1) v(2) v(3) v(4) v(5) v(6) v(7) v(8) v(9) v(10)
print v(11) v(12) v(13) v(14) v(15) v(16) v(17) v(18) v(19) v(20)
print i(vs0) i(vs1) i(vs2) i(vs3) i(vs4) i(vs5) i(vs6) i(vs7) i(vs8) i(vs9)
print i(vs10) i(vs11) i(vs12) i(vs13) i(vs14) i(vs15) i(vs16) i(vs17) i(vs18) i(vs19)
print i(vs20) i(vs21) i(vs22) i(vs23) i(vs24) i(vs25) i(vs26) i(vs27) i(vs28) i(vs29)
print i(vs30) i(vs31) i(vs32) i(vs33) i(vs34)
.endc
.end
