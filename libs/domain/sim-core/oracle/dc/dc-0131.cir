controls oracle dc-0131
* Generated (plan F2.7, ADR 0012): do not edit; regenerate with `pnpm sim oracle regen`. dc seed 20261030 index 131 nodes 14 elements 26
.options sparse gmin=1e-12 noopac
RG1 1 0 1000000000000
RG2 2 0 1000000000000
RG3 3 0 1000000000000
RG4 4 0 1000000000000
RG5 5 0 1000000000000
RG6 6 0 1000000000000
RG7 7 0 1000000000000
RG8 8 0 1000000000000
RG9 9 0 1000000000000
RG10 10 0 1000000000000
RG11 11 0 1000000000000
RG12 12 0 1000000000000
RG13 13 0 1000000000000
VS0 13 s0 0
R0 s0 12 47e2
VS1 7 s1 0
I1 s1 1 DC 18e-1
VS2 13 s2 0
R2 s2 1 12e3
VS3 0 s3 0
V3 e3 s3 DC 82e0
RI3 e3 10 12e-2
VS4 2 s4 0
R4 s4 5 68e1
VS5 6 s5 0
I5 s5 8 DC 18e-1
VS6 10 s6 0
R6 s6 7 56e3
VS7 4 s7 0
V7 e7 s7 DC 56e1
RI7 e7 13 33e-3
VS8 11 s8 0
V8 e8 s8 DC 39e-1
RI8 e8 8 47e-2
VS9 0 s9 0
R9 s9 4 10e2
VS10 13 s10 0
R10 s10 1 33e3
VS11 12 s11 0
I11 s11 7 DC 47e-4
VS12 11 s12 0
R12 s12 9 18e-1
VS13 2 s13 0
V13 e13 s13 DC 33e-1
RI13 e13 10 82e-3
VS14 10 s14 0
V14 e14 s14 DC 82e1
RI14 e14 9 68e-3
VS15 11 s15 0
V15 e15 s15 DC 27e-1
RI15 e15 2 15e-1
VS16 3 s16 0
R16 s16 7 12e-2
VS17 10 s17 0
I17 s17 11 DC 18e-2
VS18 0 s18 0
R18 s18 11 18e0
VS19 13 s19 0
R19 s19 10 82e-2
VS20 12 s20 0
R20 s20 3 39e0
VS21 11 s21 0
R21 s21 7 82e-1
VS22 11 s22 0
I22 s22 7 DC 12e-4
VS23 1 s23 0
R23 s23 12 22e-2
VS24 1 s24 0
R24 s24 6 27e3
VS25 12 s25 0
R25 s25 1 27e-2
.control
set numdgt=17
op
print v(1) v(2) v(3) v(4) v(5) v(6) v(7) v(8) v(9) v(10)
print v(11) v(12) v(13)
print i(vs0) i(vs1) i(vs2) i(vs3) i(vs4) i(vs5) i(vs6) i(vs7) i(vs8) i(vs9)
print i(vs10) i(vs11) i(vs12) i(vs13) i(vs14) i(vs15) i(vs16) i(vs17) i(vs18) i(vs19)
print i(vs20) i(vs21) i(vs22) i(vs23) i(vs24) i(vs25)
.endc
.end
