controls oracle dc-0131
* Generated (plan F2.7, ADR 0012): do not edit; regenerate with `pnpm sim oracle regen`. dc seed 20261030 index 131 nodes 14 elements 28
.options sparse gmin=1e-12 noopac
RG1 1 0 1000000000000
RG2 2 0 1000000000000
RG3 3 0 1000000000000
RG4 4 0 1000000000000
RG5 5 0 1000000000000
RG6 6 0 1000000000000
RG7 7 0 1000000000000
RG8 8 0 1000000000000
RG9 9 0 1000000000000
RG10 10 0 1000000000000
RG11 11 0 1000000000000
RG12 12 0 1000000000000
RG13 13 0 1000000000000
VS0 11 s0 0
R0 s0 7 82e-1
VS1 0 s1 0
V1 e1 s1 DC 82e1
RI1 e1 9 68e-3
VS2 6 s2 0
R2 s2 5 27e3
VS3 2 s3 0
R3 s3 5 68e1
VS4 13 s4 0
R4 s4 1 12e3
VS5 0 s5 0
I5 s5 11 DC 18e-2
VS6 13 s6 0
R6 s6 1 33e3
VS7 11 s7 0
V7 e7 s7 DC 39e-1
RI7 e7 8 47e-2
VS8 4 s8 0
V8 e8 s8 DC 56e1
RI8 e8 13 33e-3
VS9 11 s9 0
I9 s9 7 DC 12e-4
VS10 12 s10 0
I10 s10 7 DC 47e-4
VS11 12 s11 0
R11 s11 3 39e0
VS12 7 s12 0
I12 s12 1 DC 18e-1
VS13 1 s13 0
R13 s13 6 27e3
VS14 12 s14 0
R14 s14 1 27e-2
VS15 6 s15 0
I15 s15 8 DC 18e-1
VS16 11 s16 0
V16 e16 s16 DC 27e-1
RI16 e16 2 15e-1
VS17 11 s17 0
R17 s17 9 18e-1
VS18 13 s18 0
R18 s18 12 47e2
VS19 10 s19 0
V19 e19 s19 DC 82e0
RI19 e19 0 12e-2
VS20 0 s20 0
R20 s20 7 56e3
VS21 2 s21 0
V21 e21 s21 DC 33e-1
RI21 e21 0 82e-3
VS22 6 s22 0
R22 s22 8 10e3
VS23 10 s23 0
R23 s23 11 18e0
VS24 1 s24 0
R24 s24 12 22e-2
VS25 13 s25 0
R25 s25 0 82e-2
VS26 10 s26 0
R26 s26 4 10e2
VS27 3 s27 0
R27 s27 7 12e-2
.control
set numdgt=17
op
print v(1) v(2) v(3) v(4) v(5) v(6) v(7) v(8) v(9) v(10)
print v(11) v(12) v(13)
print i(vs0) i(vs1) i(vs2) i(vs3) i(vs4) i(vs5) i(vs6) i(vs7) i(vs8) i(vs9)
print i(vs10) i(vs11) i(vs12) i(vs13) i(vs14) i(vs15) i(vs16) i(vs17) i(vs18) i(vs19)
print i(vs20) i(vs21) i(vs22) i(vs23) i(vs24) i(vs25) i(vs26) i(vs27)
.endc
.end
