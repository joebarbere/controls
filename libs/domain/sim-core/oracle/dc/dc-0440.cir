controls oracle dc-0440
* Generated (plan F2.7, ADR 0012): do not edit; regenerate with `pnpm sim oracle regen`. dc seed 20261030 index 440 nodes 13 elements 22
.options sparse gmin=1e-12 noopac
RG1 1 0 1000000000000
RG2 2 0 1000000000000
RG3 3 0 1000000000000
RG4 4 0 1000000000000
RG5 5 0 1000000000000
RG6 6 0 1000000000000
RG7 7 0 1000000000000
RG8 8 0 1000000000000
RG9 9 0 1000000000000
RG10 10 0 1000000000000
RG11 11 0 1000000000000
RG12 12 0 1000000000000
VS0 0 s0 0
V0 e0 s0 DC 39e-1
RI0 e0 9 68e-3
VS1 1 s1 0
V1 e1 s1 DC 39e1
RI1 e1 8 10e-1
VS2 4 s2 0
R2 s2 12 18e-2
VS3 11 s3 0
R3 s3 6 10e-2
VS4 0 s4 0
R4 s4 1 82e-1
VS5 12 s5 0
V5 e5 s5 DC 18e-1
RI5 e5 2 39e-2
VS6 3 s6 0
R6 s6 9 33e2
VS7 3 s7 0
I7 s7 2 DC 10e-1
VS8 3 s8 0
R8 s8 11 33e-2
VS9 9 s9 0
R9 s9 2 56e-1
VS10 4 s10 0
R10 s10 8 68e-1
VS11 10 s11 0
R11 s11 8 10e-2
VS12 9 s12 0
R12 s12 11 12e3
VS13 11 s13 0
V13 e13 s13 DC 82e1
RI13 e13 12 18e-3
VS14 7 s14 0
R14 s14 5 82e0
VS15 6 s15 0
R15 s15 7 18e-1
VS16 6 s16 0
R16 s16 10 39e0
VS17 5 s17 0
R17 s17 7 68e-1
VS18 6 s18 0
R18 s18 3 47e1
VS19 5 s19 0
R19 s19 12 82e0
VS20 10 s20 0
I20 s20 6 DC 12e-3
VS21 5 s21 0
I21 s21 10 DC 18e-2
.control
set numdgt=17
op
print v(1) v(2) v(3) v(4) v(5) v(6) v(7) v(8) v(9) v(10)
print v(11) v(12)
print i(vs0) i(vs1) i(vs2) i(vs3) i(vs4) i(vs5) i(vs6) i(vs7) i(vs8) i(vs9)
print i(vs10) i(vs11) i(vs12) i(vs13) i(vs14) i(vs15) i(vs16) i(vs17) i(vs18) i(vs19)
print i(vs20) i(vs21)
.endc
.end
