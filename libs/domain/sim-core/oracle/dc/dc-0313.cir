controls oracle dc-0313
* Generated (plan F2.7, ADR 0012): do not edit; regenerate with `pnpm sim oracle regen`. dc seed 20261030 index 313 nodes 23 elements 43
.options sparse gmin=1e-12 noopac
RG1 1 0 1000000000000
RG2 2 0 1000000000000
RG3 3 0 1000000000000
RG4 4 0 1000000000000
RG5 5 0 1000000000000
RG6 6 0 1000000000000
RG7 7 0 1000000000000
RG8 8 0 1000000000000
RG9 9 0 1000000000000
RG10 10 0 1000000000000
RG11 11 0 1000000000000
RG12 12 0 1000000000000
RG13 13 0 1000000000000
RG14 14 0 1000000000000
RG15 15 0 1000000000000
RG16 16 0 1000000000000
RG17 17 0 1000000000000
RG18 18 0 1000000000000
RG19 19 0 1000000000000
RG20 20 0 1000000000000
RG21 21 0 1000000000000
RG22 22 0 1000000000000
VS0 1 s0 0
R0 s0 6 18e3
VS1 0 s1 0
V1 e1 s1 DC 33e1
RI1 e1 22 10e-2
VS2 3 s2 0
R2 s2 5 33e3
VS3 2 s3 0
V3 e3 s3 DC 12e1
RI3 e3 4 12e-2
VS4 18 s4 0
R4 s4 14 68e3
VS5 16 s5 0
R5 s5 7 39e1
VS6 18 s6 0
R6 s6 17 47e-2
VS7 2 s7 0
R7 s7 14 47e-2
VS8 13 s8 0
R8 s8 22 10e1
VS9 9 s9 0
R9 s9 10 47e-1
VS10 13 s10 0
R10 s10 1 10e-1
VS11 9 s11 0
I11 s11 21 DC 82e-3
VS12 21 s12 0
I12 s12 7 DC 18e-2
VS13 14 s13 0
R13 s13 2 33e-2
VS14 2 s14 0
I14 s14 0 DC 27e-3
VS15 18 s15 0
R15 s15 4 47e0
VS16 6 s16 0
I16 s16 14 DC 39e-1
VS17 3 s17 0
V17 e17 s17 DC 18e1
RI17 e17 16 47e-1
VS18 15 s18 0
R18 s18 12 33e3
VS19 8 s19 0
R19 s19 0 39e-1
VS20 3 s20 0
V20 e20 s20 DC 56e0
RI20 e20 22 18e-3
VS21 20 s21 0
V21 e21 s21 DC 68e1
RI21 e21 17 15e-2
VS22 13 s22 0
R22 s22 15 10e3
VS23 11 s23 0
R23 s23 16 22e0
VS24 8 s24 0
R24 s24 19 68e2
VS25 17 s25 0
R25 s25 22 10e-1
VS26 6 s26 0
R26 s26 14 10e3
VS27 17 s27 0
R27 s27 8 27e1
VS28 13 s28 0
R28 s28 12 68e0
VS29 0 s29 0
R29 s29 21 15e-1
VS30 0 s30 0
V30 e30 s30 DC 27e0
RI30 e30 16 82e-2
VS31 19 s31 0
R31 s31 3 22e3
VS32 20 s32 0
R32 s32 13 18e1
VS33 6 s33 0
R33 s33 21 18e-2
VS34 11 s34 0
R34 s34 18 68e0
VS35 9 s35 0
I35 s35 20 DC 22e-1
VS36 21 s36 0
R36 s36 12 47e1
VS37 21 s37 0
R37 s37 2 27e-1
VS38 18 s38 0
R38 s38 17 18e0
VS39 8 s39 0
R39 s39 4 82e3
VS40 10 s40 0
R40 s40 1 82e3
VS41 10 s41 0
R41 s41 20 82e-1
VS42 19 s42 0
V42 e42 s42 DC 12e1
RI42 e42 9 15e-3
.control
set numdgt=17
op
print v(1) v(2) v(3) v(4) v(5) v(6) v(7) v(8) v(9) v(10)
print v(11) v(12) v(13) v(14) v(15) v(16) v(17) v(18) v(19) v(20)
print v(21) v(22)
print i(vs0) i(vs1) i(vs2) i(vs3) i(vs4) i(vs5) i(vs6) i(vs7) i(vs8) i(vs9)
print i(vs10) i(vs11) i(vs12) i(vs13) i(vs14) i(vs15) i(vs16) i(vs17) i(vs18) i(vs19)
print i(vs20) i(vs21) i(vs22) i(vs23) i(vs24) i(vs25) i(vs26) i(vs27) i(vs28) i(vs29)
print i(vs30) i(vs31) i(vs32) i(vs33) i(vs34) i(vs35) i(vs36) i(vs37) i(vs38) i(vs39)
print i(vs40) i(vs41) i(vs42)
.endc
.end
