controls oracle dc-0313
* Generated (plan F2.7, ADR 0012): do not edit; regenerate with `pnpm sim oracle regen`. dc seed 20261030 index 313 nodes 23 elements 45
.options sparse gmin=1e-12 noopac
RG1 1 0 1000000000000
RG2 2 0 1000000000000
RG3 3 0 1000000000000
RG4 4 0 1000000000000
RG5 5 0 1000000000000
RG6 6 0 1000000000000
RG7 7 0 1000000000000
RG8 8 0 1000000000000
RG9 9 0 1000000000000
RG10 10 0 1000000000000
RG11 11 0 1000000000000
RG12 12 0 1000000000000
RG13 13 0 1000000000000
RG14 14 0 1000000000000
RG15 15 0 1000000000000
RG16 16 0 1000000000000
RG17 17 0 1000000000000
RG18 18 0 1000000000000
RG19 19 0 1000000000000
RG20 20 0 1000000000000
RG21 21 0 1000000000000
RG22 22 0 1000000000000
VS0 6 s0 0
I0 s0 14 DC 39e-1
VS1 2 s1 0
R1 s1 14 47e-2
VS2 13 s2 0
R2 s2 12 68e0
VS3 18 s3 0
R3 s3 17 47e-2
VS4 13 s4 0
R4 s4 15 10e3
VS5 9 s5 0
I5 s5 21 DC 82e-3
VS6 0 s6 0
V6 e6 s6 DC 12e1
RI6 e6 9 15e-3
VS7 6 s7 0
R7 s7 14 10e3
VS8 11 s8 0
R8 s8 18 68e0
VS9 16 s9 0
R9 s9 7 39e1
VS10 10 s10 0
R10 s10 20 82e-1
VS11 15 s11 0
R11 s11 12 33e3
VS12 14 s12 0
V12 e12 s12 DC 82e-1
RI12 e12 7 47e-1
VS13 17 s13 0
R13 s13 22 10e-1
VS14 18 s14 0
R14 s14 4 47e0
VS15 9 s15 0
I15 s15 20 DC 22e-1
VS16 13 s16 0
R16 s16 22 10e1
VS17 20 s17 0
R17 s17 13 18e1
VS18 2 s18 0
V18 e18 s18 DC 12e1
RI18 e18 4 12e-2
VS19 10 s19 0
R19 s19 1 82e3
VS20 20 s20 0
V20 e20 s20 DC 68e1
RI20 e20 17 15e-2
VS21 3 s21 0
V21 e21 s21 DC 27e0
RI21 e21 16 82e-2
VS22 1 s22 0
R22 s22 6 18e3
VS23 8 s23 0
R23 s23 4 82e3
VS24 21 s24 0
I24 s24 7 DC 18e-2
VS25 19 s25 0
V25 e25 s25 DC 56e0
RI25 e25 22 18e-3
VS26 18 s26 0
R26 s26 17 18e0
VS27 14 s27 0
R27 s27 2 33e-2
VS28 13 s28 0
R28 s28 1 10e-1
VS29 9 s29 0
R29 s29 10 47e-1
VS30 6 s30 0
R30 s30 21 18e-2
VS31 3 s31 0
R31 s31 21 15e-1
VS32 2 s32 0
I32 s32 3 DC 27e-3
VS33 18 s33 0
R33 s33 14 68e3
VS34 19 s34 0
R34 s34 5 33e3
VS35 0 s35 0
R35 s35 19 22e3
VS36 3 s36 0
V36 e36 s36 DC 33e1
RI36 e36 22 10e-2
VS37 8 s37 0
R37 s37 0 68e2
VS38 8 s38 0
R38 s38 3 39e-1
VS39 21 s39 0
R39 s39 2 27e-1
VS40 17 s40 0
R40 s40 8 27e1
VS41 19 s41 0
V41 e41 s41 DC 18e1
RI41 e41 16 47e-1
VS42 11 s42 0
R42 s42 16 22e0
VS43 21 s43 0
R43 s43 12 47e1
VS44 11 s44 0
R44 s44 5 68e1
.control
set numdgt=17
op
print v(1) v(2) v(3) v(4) v(5) v(6) v(7) v(8) v(9) v(10)
print v(11) v(12) v(13) v(14) v(15) v(16) v(17) v(18) v(19) v(20)
print v(21) v(22)
print i(vs0) i(vs1) i(vs2) i(vs3) i(vs4) i(vs5) i(vs6) i(vs7) i(vs8) i(vs9)
print i(vs10) i(vs11) i(vs12) i(vs13) i(vs14) i(vs15) i(vs16) i(vs17) i(vs18) i(vs19)
print i(vs20) i(vs21) i(vs22) i(vs23) i(vs24) i(vs25) i(vs26) i(vs27) i(vs28) i(vs29)
print i(vs30) i(vs31) i(vs32) i(vs33) i(vs34) i(vs35) i(vs36) i(vs37) i(vs38) i(vs39)
print i(vs40) i(vs41) i(vs42) i(vs43) i(vs44)
.endc
.end
