controls oracle dc-0201
* Generated (plan F2.7, ADR 0012): do not edit; regenerate with `pnpm sim oracle regen`. dc seed 20261030 index 201 nodes 8 elements 14
.options sparse gmin=1e-12 noopac
RG1 1 0 1000000000000
RG2 2 0 1000000000000
RG3 3 0 1000000000000
RG4 4 0 1000000000000
RG5 5 0 1000000000000
RG6 6 0 1000000000000
RG7 7 0 1000000000000
VS0 5 s0 0
I0 s0 7 DC 27e-3
VS1 1 s1 0
I1 s1 0 DC 18e-2
VS2 0 s2 0
V2 e2 s2 DC 12e-1
RI2 e2 3 15e-3
VS3 7 s3 0
R3 s3 6 22e-2
VS4 3 s4 0
V4 e4 s4 DC 27e1
RI4 e4 2 68e-2
VS5 3 s5 0
R5 s5 4 56e2
VS6 5 s6 0
V6 e6 s6 DC 39e1
RI6 e6 1 68e-3
VS7 4 s7 0
V7 e7 s7 DC 56e-1
RI7 e7 7 22e-1
VS8 7 s8 0
V8 e8 s8 DC 68e-1
RI8 e8 5 12e-1
VS9 1 s9 0
R9 s9 0 12e0
VS10 6 s10 0
R10 s10 1 56e0
VS11 1 s11 0
R11 s11 4 10e2
VS12 2 s12 0
R12 s12 1 10e3
VS13 5 s13 0
R13 s13 6 27e3
.control
set numdgt=17
op
print v(1) v(2) v(3) v(4) v(5) v(6) v(7)
print i(vs0) i(vs1) i(vs2) i(vs3) i(vs4) i(vs5) i(vs6) i(vs7) i(vs8) i(vs9)
print i(vs10) i(vs11) i(vs12) i(vs13)
.endc
.end
