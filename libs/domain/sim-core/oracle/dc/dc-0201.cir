controls oracle dc-0201
* Generated (plan F2.7, ADR 0012): do not edit; regenerate with `pnpm sim oracle regen`. dc seed 20261030 index 201 nodes 8 elements 13
.options sparse gmin=1e-12 noopac
RG1 1 0 1000000000000
RG2 2 0 1000000000000
RG3 3 0 1000000000000
RG4 4 0 1000000000000
RG5 5 0 1000000000000
RG6 6 0 1000000000000
RG7 7 0 1000000000000
VS0 0 s0 0
V0 e0 s0 DC 39e1
RI0 e0 5 68e-3
VS1 7 s1 0
V1 e1 s1 DC 68e-1
RI1 e1 0 12e-1
VS2 7 s2 0
R2 s2 6 22e-2
VS3 0 s3 0
R3 s3 6 27e3
VS4 5 s4 0
R4 s4 1 12e0
VS5 0 s5 0
I5 s5 7 DC 27e-3
VS6 1 s6 0
V6 e6 s6 DC 12e-1
RI6 e6 3 15e-3
VS7 3 s7 0
R7 s7 4 56e2
VS8 2 s8 0
R8 s8 5 10e3
VS9 6 s9 0
R9 s9 5 56e0
VS10 5 s10 0
R10 s10 4 10e2
VS11 5 s11 0
I11 s11 1 DC 18e-2
VS12 4 s12 0
V12 e12 s12 DC 56e-1
RI12 e12 7 22e-1
.control
set numdgt=17
op
print v(1) v(2) v(3) v(4) v(5) v(6) v(7)
print i(vs0) i(vs1) i(vs2) i(vs3) i(vs4) i(vs5) i(vs6) i(vs7) i(vs8) i(vs9)
print i(vs10) i(vs11) i(vs12)
.endc
.end
