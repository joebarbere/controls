controls oracle dc-0042
* Generated (plan F2.7, ADR 0012): do not edit; regenerate with `pnpm sim oracle regen`. dc seed 20261030 index 42 nodes 12 elements 17
.options sparse gmin=1e-12 noopac
RG1 1 0 1000000000000
RG2 2 0 1000000000000
RG3 3 0 1000000000000
RG4 4 0 1000000000000
RG5 5 0 1000000000000
RG6 6 0 1000000000000
RG7 7 0 1000000000000
RG8 8 0 1000000000000
RG9 9 0 1000000000000
RG10 10 0 1000000000000
RG11 11 0 1000000000000
VS0 10 s0 0
R0 s0 5 56e0
VS1 4 s1 0
R1 s1 9 82e3
VS2 3 s2 0
R2 s2 2 47e-1
VS3 3 s3 0
R3 s3 7 39e-1
VS4 5 s4 0
R4 s4 1 82e2
VS5 1 s5 0
R5 s5 2 47e1
VS6 7 s6 0
R6 s6 1 56e0
VS7 0 s7 0
V7 e7 s7 DC 15e-1
RI7 e7 8 18e-3
VS8 4 s8 0
I8 s8 6 DC 82e-1
VS9 8 s9 0
V9 e9 s9 DC 15e1
RI9 e9 9 15e-3
VS10 10 s10 0
R10 s10 4 12e-1
VS11 11 s11 0
R11 s11 5 68e1
VS12 7 s12 0
V12 e12 s12 DC 47e1
RI12 e12 0 33e-1
VS13 0 s13 0
V13 e13 s13 DC 15e0
RI13 e13 11 47e-2
VS14 4 s14 0
R14 s14 6 39e3
VS15 4 s15 0
R15 s15 0 56e2
VS16 6 s16 0
R16 s16 7 56e3
.control
set numdgt=17
op
print v(1) v(2) v(3) v(4) v(5) v(6) v(7) v(8) v(9) v(10)
print v(11)
print i(vs0) i(vs1) i(vs2) i(vs3) i(vs4) i(vs5) i(vs6) i(vs7) i(vs8) i(vs9)
print i(vs10) i(vs11) i(vs12) i(vs13) i(vs14) i(vs15) i(vs16)
.endc
.end
