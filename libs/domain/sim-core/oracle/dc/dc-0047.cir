controls oracle dc-0047
* Generated (plan F2.7, ADR 0012): do not edit; regenerate with `pnpm sim oracle regen`. dc seed 20261030 index 47 nodes 12 elements 16
.options sparse gmin=1e-12 noopac
RG1 1 0 1000000000000
RG2 2 0 1000000000000
RG3 3 0 1000000000000
RG4 4 0 1000000000000
RG5 5 0 1000000000000
RG6 6 0 1000000000000
RG7 7 0 1000000000000
RG8 8 0 1000000000000
RG9 9 0 1000000000000
RG10 10 0 1000000000000
RG11 11 0 1000000000000
VS0 4 s0 0
R0 s0 10 18e-2
VS1 6 s1 0
R1 s1 3 12e0
VS2 2 s2 0
R2 s2 7 82e2
VS3 0 s3 0
V3 e3 s3 DC 39e1
RI3 e3 9 33e-2
VS4 11 s4 0
R4 s4 7 18e0
VS5 4 s5 0
R5 s5 8 39e-2
VS6 2 s6 0
I6 s6 10 DC 47e-1
VS7 6 s7 0
R7 s7 10 47e-1
VS8 0 s8 0
R8 s8 10 39e1
VS9 0 s9 0
R9 s9 9 10e0
VS10 7 s10 0
R10 s10 5 47e2
VS11 0 s11 0
I11 s11 5 DC 15e-1
VS12 11 s12 0
R12 s12 6 33e0
VS13 1 s13 0
V13 e13 s13 DC 15e0
RI13 e13 10 15e-2
VS14 10 s14 0
R14 s14 4 47e0
VS15 1 s15 0
V15 e15 s15 DC 68e-1
RI15 e15 11 68e-3
.control
set numdgt=17
op
print v(1) v(2) v(3) v(4) v(5) v(6) v(7) v(8) v(9) v(10)
print v(11)
print i(vs0) i(vs1) i(vs2) i(vs3) i(vs4) i(vs5) i(vs6) i(vs7) i(vs8) i(vs9)
print i(vs10) i(vs11) i(vs12) i(vs13) i(vs14) i(vs15)
.endc
.end
