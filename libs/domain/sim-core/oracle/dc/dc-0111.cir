controls oracle dc-0111
* Generated (plan F2.7, ADR 0012): do not edit; regenerate with `pnpm sim oracle regen`. dc seed 20261030 index 111 nodes 8 elements 14
.options sparse gmin=1e-12 noopac
RG1 1 0 1000000000000
RG2 2 0 1000000000000
RG3 3 0 1000000000000
RG4 4 0 1000000000000
RG5 5 0 1000000000000
RG6 6 0 1000000000000
RG7 7 0 1000000000000
VS0 0 s0 0
I0 s0 2 DC 56e-3
VS1 2 s1 0
R1 s1 7 27e2
VS2 0 s2 0
V2 e2 s2 DC 56e1
RI2 e2 5 22e-2
VS3 3 s3 0
R3 s3 7 10e-1
VS4 4 s4 0
I4 s4 5 DC 56e-3
VS5 4 s5 0
R5 s5 2 82e2
VS6 0 s6 0
V6 e6 s6 DC 15e1
RI6 e6 2 33e-3
VS7 5 s7 0
I7 s7 4 DC 82e-4
VS8 1 s8 0
I8 s8 6 DC 18e-4
VS9 5 s9 0
R9 s9 2 18e-1
VS10 6 s10 0
R10 s10 3 82e2
VS11 1 s11 0
R11 s11 6 47e1
VS12 7 s12 0
I12 s12 4 DC 47e-4
VS13 5 s13 0
I13 s13 2 DC 12e-2
.control
set numdgt=17
op
print v(1) v(2) v(3) v(4) v(5) v(6) v(7)
print i(vs0) i(vs1) i(vs2) i(vs3) i(vs4) i(vs5) i(vs6) i(vs7) i(vs8) i(vs9)
print i(vs10) i(vs11) i(vs12) i(vs13)
.endc
.end
