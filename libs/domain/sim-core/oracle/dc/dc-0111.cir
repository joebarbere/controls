controls oracle dc-0111
* Generated (plan F2.7, ADR 0012): do not edit; regenerate with `pnpm sim oracle regen`. dc seed 20261030 index 111 nodes 8 elements 17
.options sparse gmin=1e-12 noopac
RG1 1 0 1000000000000
RG2 2 0 1000000000000
RG3 3 0 1000000000000
RG4 4 0 1000000000000
RG5 5 0 1000000000000
RG6 6 0 1000000000000
RG7 7 0 1000000000000
VS0 6 s0 0
R0 s0 3 82e2
VS1 4 s1 0
R1 s1 7 22e-1
VS2 1 s2 0
I2 s2 6 DC 18e-4
VS3 4 s3 0
I3 s3 5 DC 56e-3
VS4 0 s4 0
I4 s4 2 DC 56e-3
VS5 4 s5 0
R5 s5 2 82e2
VS6 4 s6 0
R6 s6 1 56e3
VS7 5 s7 0
I7 s7 2 DC 12e-2
VS8 0 s8 0
V8 e8 s8 DC 22e1
RI8 e8 6 56e-3
VS9 2 s9 0
R9 s9 7 27e2
VS10 3 s10 0
R10 s10 7 10e-1
VS11 0 s11 0
V11 e11 s11 DC 15e1
RI11 e11 2 33e-3
VS12 5 s12 0
R12 s12 2 18e-1
VS13 0 s13 0
V13 e13 s13 DC 56e1
RI13 e13 5 22e-2
VS14 5 s14 0
I14 s14 4 DC 82e-4
VS15 1 s15 0
R15 s15 6 47e1
VS16 7 s16 0
I16 s16 4 DC 47e-4
.control
set numdgt=17
op
print v(1) v(2) v(3) v(4) v(5) v(6) v(7)
print i(vs0) i(vs1) i(vs2) i(vs3) i(vs4) i(vs5) i(vs6) i(vs7) i(vs8) i(vs9)
print i(vs10) i(vs11) i(vs12) i(vs13) i(vs14) i(vs15) i(vs16)
.endc
.end
