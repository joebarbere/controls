controls oracle dc-0116
* Generated (plan F2.7, ADR 0012): do not edit; regenerate with `pnpm sim oracle regen`. dc seed 20261030 index 116 nodes 4 elements 5
.options sparse gmin=1e-12 noopac
RG1 1 0 1000000000000
RG2 2 0 1000000000000
RG3 3 0 1000000000000
VS0 1 s0 0
I0 s0 2 DC 10e-2
VS1 0 s1 0
R1 s1 3 10e0
VS2 0 s2 0
V2 e2 s2 DC 27e-1
RI2 e2 1 18e-3
VS3 2 s3 0
R3 s3 1 12e1
VS4 3 s4 0
V4 e4 s4 DC 82e0
RI4 e4 2 15e-3
.control
set numdgt=17
op
print v(1) v(2) v(3)
print i(vs0) i(vs1) i(vs2) i(vs3) i(vs4)
.endc
.end
