controls oracle dc-0286
* Generated (plan F2.7, ADR 0012): do not edit; regenerate with `pnpm sim oracle regen`. dc seed 20261030 index 286 nodes 23 elements 37
.options sparse gmin=1e-12 noopac
RG1 1 0 1000000000000
RG2 2 0 1000000000000
RG3 3 0 1000000000000
RG4 4 0 1000000000000
RG5 5 0 1000000000000
RG6 6 0 1000000000000
RG7 7 0 1000000000000
RG8 8 0 1000000000000
RG9 9 0 1000000000000
RG10 10 0 1000000000000
RG11 11 0 1000000000000
RG12 12 0 1000000000000
RG13 13 0 1000000000000
RG14 14 0 1000000000000
RG15 15 0 1000000000000
RG16 16 0 1000000000000
RG17 17 0 1000000000000
RG18 18 0 1000000000000
RG19 19 0 1000000000000
RG20 20 0 1000000000000
RG21 21 0 1000000000000
RG22 22 0 1000000000000
VS0 11 s0 0
R0 s0 10 39e0
VS1 21 s1 0
R1 s1 7 82e1
VS2 17 s2 0
R2 s2 7 33e2
VS3 2 s3 0
R3 s3 20 68e0
VS4 3 s4 0
R4 s4 16 68e-2
VS5 0 s5 0
V5 e5 s5 DC 18e1
RI5 e5 10 82e-2
VS6 9 s6 0
R6 s6 18 82e0
VS7 21 s7 0
I7 s7 5 DC 12e-3
VS8 9 s8 0
R8 s8 0 18e-2
VS9 8 s9 0
R9 s9 18 15e-2
VS10 2 s10 0
V10 e10 s10 DC 33e1
RI10 e10 18 12e-2
VS11 11 s11 0
R11 s11 12 18e2
VS12 13 s12 0
R12 s12 22 56e1
VS13 3 s13 0
V13 e13 s13 DC 82e0
RI13 e13 10 12e-1
VS14 19 s14 0
V14 e14 s14 DC 56e0
RI14 e14 10 47e-1
VS15 3 s15 0
R15 s15 1 18e-2
VS16 10 s16 0
R16 s16 5 18e1
VS17 21 s17 0
V17 e17 s17 DC 68e-1
RI17 e17 16 27e-1
VS18 20 s18 0
R18 s18 16 18e0
VS19 0 s19 0
V19 e19 s19 DC 10e-1
RI19 e19 13 15e-3
VS20 11 s20 0
V20 e20 s20 DC 18e0
RI20 e20 21 10e-2
VS21 11 s21 0
I21 s21 19 DC 82e-3
VS22 4 s22 0
R22 s22 6 10e1
VS23 21 s23 0
R23 s23 12 33e3
VS24 13 s24 0
R24 s24 17 68e1
VS25 8 s25 0
R25 s25 2 47e3
VS26 10 s26 0
R26 s26 3 82e2
VS27 2 s27 0
R27 s27 1 39e3
VS28 20 s28 0
V28 e28 s28 DC 82e-1
RI28 e28 21 27e-1
VS29 13 s29 0
R29 s29 3 10e1
VS30 13 s30 0
R30 s30 21 47e3
VS31 3 s31 0
R31 s31 18 22e3
VS32 2 s32 0
R32 s32 15 56e-1
VS33 1 s33 0
R33 s33 6 18e2
VS34 2 s34 0
R34 s34 22 15e2
VS35 14 s35 0
R35 s35 13 82e3
VS36 2 s36 0
R36 s36 1 18e0
.control
set numdgt=17
op
print v(1) v(2) v(3) v(4) v(5) v(6) v(7) v(8) v(9) v(10)
print v(11) v(12) v(13) v(14) v(15) v(16) v(17) v(18) v(19) v(20)
print v(21) v(22)
print i(vs0) i(vs1) i(vs2) i(vs3) i(vs4) i(vs5) i(vs6) i(vs7) i(vs8) i(vs9)
print i(vs10) i(vs11) i(vs12) i(vs13) i(vs14) i(vs15) i(vs16) i(vs17) i(vs18) i(vs19)
print i(vs20) i(vs21) i(vs22) i(vs23) i(vs24) i(vs25) i(vs26) i(vs27) i(vs28) i(vs29)
print i(vs30) i(vs31) i(vs32) i(vs33) i(vs34) i(vs35) i(vs36)
.endc
.end
