controls oracle dc-0286
* Generated (plan F2.7, ADR 0012): do not edit; regenerate with `pnpm sim oracle regen`. dc seed 20261030 index 286 nodes 23 elements 42
.options sparse gmin=1e-12 noopac
RG1 1 0 1000000000000
RG2 2 0 1000000000000
RG3 3 0 1000000000000
RG4 4 0 1000000000000
RG5 5 0 1000000000000
RG6 6 0 1000000000000
RG7 7 0 1000000000000
RG8 8 0 1000000000000
RG9 9 0 1000000000000
RG10 10 0 1000000000000
RG11 11 0 1000000000000
RG12 12 0 1000000000000
RG13 13 0 1000000000000
RG14 14 0 1000000000000
RG15 15 0 1000000000000
RG16 16 0 1000000000000
RG17 17 0 1000000000000
RG18 18 0 1000000000000
RG19 19 0 1000000000000
RG20 20 0 1000000000000
RG21 21 0 1000000000000
RG22 22 0 1000000000000
VS0 2 s0 0
R0 s0 20 39e3
VS1 0 s1 0
R1 s1 16 18e0
VS2 2 s2 0
R2 s2 20 18e0
VS3 0 s3 0
V3 e3 s3 DC 82e-1
RI3 e3 21 27e-1
VS4 10 s4 0
R4 s4 3 82e2
VS5 2 s5 0
R5 s5 15 56e-1
VS6 21 s6 0
R6 s6 12 33e3
VS7 13 s7 0
R7 s7 22 56e1
VS8 17 s8 0
R8 s8 7 33e2
VS9 9 s9 0
R9 s9 18 82e0
VS10 8 s10 0
R10 s10 2 47e3
VS11 21 s11 0
R11 s11 7 82e1
VS12 8 s12 0
R12 s12 18 15e-2
VS13 2 s13 0
R13 s13 19 22e3
VS14 21 s14 0
V14 e14 s14 DC 68e-1
RI14 e14 16 27e-1
VS15 19 s15 0
V15 e15 s15 DC 56e0
RI15 e15 10 47e-1
VS16 14 s16 0
R16 s16 13 82e3
VS17 3 s17 0
R17 s17 18 22e3
VS18 2 s18 0
R18 s18 22 15e2
VS19 20 s19 0
R19 s19 5 47e-2
VS20 11 s20 0
R20 s20 12 18e2
VS21 3 s21 0
R21 s21 16 68e-2
VS22 11 s22 0
R22 s22 10 39e0
VS23 14 s23 0
R23 s23 0 56e3
VS24 10 s24 0
R24 s24 5 18e1
VS25 11 s25 0
I25 s25 19 DC 82e-3
VS26 9 s26 0
R26 s26 1 18e-2
VS27 13 s27 0
R27 s27 17 68e1
VS28 20 s28 0
R28 s28 6 18e2
VS29 4 s29 0
R29 s29 6 10e1
VS30 13 s30 0
R30 s30 3 10e1
VS31 1 s31 0
V31 e31 s31 DC 10e-1
RI31 e31 13 15e-3
VS32 21 s32 0
I32 s32 5 DC 12e-3
VS33 2 s33 0
R33 s33 0 68e0
VS34 2 s34 0
R34 s34 4 18e0
VS35 21 s35 0
R35 s35 15 18e-2
VS36 3 s36 0
R36 s36 20 18e-2
VS37 1 s37 0
V37 e37 s37 DC 18e1
RI37 e37 10 82e-2
VS38 3 s38 0
V38 e38 s38 DC 82e0
RI38 e38 10 12e-1
VS39 13 s39 0
R39 s39 21 47e3
VS40 11 s40 0
V40 e40 s40 DC 18e0
RI40 e40 21 10e-2
VS41 2 s41 0
V41 e41 s41 DC 33e1
RI41 e41 18 12e-2
.control
set numdgt=17
op
print v(1) v(2) v(3) v(4) v(5) v(6) v(7) v(8) v(9) v(10)
print v(11) v(12) v(13) v(14) v(15) v(16) v(17) v(18) v(19) v(20)
print v(21) v(22)
print i(vs0) i(vs1) i(vs2) i(vs3) i(vs4) i(vs5) i(vs6) i(vs7) i(vs8) i(vs9)
print i(vs10) i(vs11) i(vs12) i(vs13) i(vs14) i(vs15) i(vs16) i(vs17) i(vs18) i(vs19)
print i(vs20) i(vs21) i(vs22) i(vs23) i(vs24) i(vs25) i(vs26) i(vs27) i(vs28) i(vs29)
print i(vs30) i(vs31) i(vs32) i(vs33) i(vs34) i(vs35) i(vs36) i(vs37) i(vs38) i(vs39)
print i(vs40) i(vs41)
.endc
.end
