controls oracle dc-0113
* Generated (plan F2.7, ADR 0012): do not edit; regenerate with `pnpm sim oracle regen`. dc seed 20261030 index 113 nodes 9 elements 12
.options sparse gmin=1e-12 noopac
RG1 1 0 1000000000000
RG2 2 0 1000000000000
RG3 3 0 1000000000000
RG4 4 0 1000000000000
RG5 5 0 1000000000000
RG6 6 0 1000000000000
RG7 7 0 1000000000000
RG8 8 0 1000000000000
VS0 1 s0 0
R0 s0 0 68e-1
VS1 0 s1 0
V1 e1 s1 DC 27e0
RI1 e1 2 56e-1
VS2 2 s2 0
I2 s2 4 DC 12e-3
VS3 1 s3 0
R3 s3 5 39e0
VS4 6 s4 0
V4 e4 s4 DC 82e1
RI4 e4 8 39e-1
VS5 0 s5 0
R5 s5 3 47e2
VS6 3 s6 0
R6 s6 8 39e-2
VS7 4 s7 0
R7 s7 5 27e2
VS8 3 s8 0
R8 s8 7 33e2
VS9 4 s9 0
R9 s9 6 56e2
VS10 2 s10 0
R10 s10 8 56e3
VS11 7 s11 0
V11 e11 s11 DC 18e1
RI11 e11 8 47e-1
.control
set numdgt=17
op
print v(1) v(2) v(3) v(4) v(5) v(6) v(7) v(8)
print i(vs0) i(vs1) i(vs2) i(vs3) i(vs4) i(vs5) i(vs6) i(vs7) i(vs8) i(vs9)
print i(vs10) i(vs11)
.endc
.end
