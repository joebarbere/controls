controls oracle dc-0113
* Generated (plan F2.7, ADR 0012): do not edit; regenerate with `pnpm sim oracle regen`. dc seed 20261030 index 113 nodes 9 elements 9
.options sparse gmin=1e-12 noopac
RG1 1 0 1000000000000
RG2 2 0 1000000000000
RG3 3 0 1000000000000
RG4 4 0 1000000000000
RG5 5 0 1000000000000
RG6 6 0 1000000000000
RG7 7 0 1000000000000
RG8 8 0 1000000000000
VS0 0 s0 0
R0 s0 3 47e2
VS1 0 s1 0
V1 e1 s1 DC 27e0
RI1 e1 2 56e-1
VS2 7 s2 0
V2 e2 s2 DC 18e1
RI2 e2 8 47e-1
VS3 1 s3 0
R3 s3 0 68e-1
VS4 1 s4 0
R4 s4 5 39e0
VS5 4 s5 0
R5 s5 5 27e2
VS6 6 s6 0
V6 e6 s6 DC 82e1
RI6 e6 8 39e-1
VS7 3 s7 0
R7 s7 8 39e-2
VS8 2 s8 0
I8 s8 4 DC 12e-3
.control
set numdgt=17
op
print v(1) v(2) v(3) v(4) v(5) v(6) v(7) v(8)
print i(vs0) i(vs1) i(vs2) i(vs3) i(vs4) i(vs5) i(vs6) i(vs7) i(vs8)
.endc
.end
