controls oracle dc-0103
* Generated (plan F2.7, ADR 0012): do not edit; regenerate with `pnpm sim oracle regen`. dc seed 20261030 index 103 nodes 5 elements 8
.options sparse gmin=1e-12 noopac
RG1 1 0 1000000000000
RG2 2 0 1000000000000
RG3 3 0 1000000000000
RG4 4 0 1000000000000
VS0 0 s0 0
V0 e0 s0 DC 18e-1
RI0 e0 1 82e-1
VS1 3 s1 0
R1 s1 0 39e0
VS2 1 s2 0
R2 s2 2 56e1
VS3 2 s3 0
R3 s3 3 18e3
VS4 2 s4 0
R4 s4 3 15e3
VS5 1 s5 0
V5 e5 s5 DC 22e1
RI5 e5 4 22e-3
VS6 4 s6 0
R6 s6 0 68e3
VS7 4 s7 0
I7 s7 2 DC 15e-4
.control
set numdgt=17
op
print v(1) v(2) v(3) v(4)
print i(vs0) i(vs1) i(vs2) i(vs3) i(vs4) i(vs5) i(vs6) i(vs7)
.endc
.end
