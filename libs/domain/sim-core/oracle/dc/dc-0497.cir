controls oracle dc-0497
* Generated (plan F2.7, ADR 0012): do not edit; regenerate with `pnpm sim oracle regen`. dc seed 20261030 index 497 nodes 8 elements 8
.options sparse gmin=1e-12 noopac
RG1 1 0 1000000000000
RG2 2 0 1000000000000
RG3 3 0 1000000000000
RG4 4 0 1000000000000
RG5 5 0 1000000000000
RG6 6 0 1000000000000
RG7 7 0 1000000000000
VS0 1 s0 0
R0 s0 6 27e1
VS1 5 s1 0
R1 s1 2 15e1
VS2 7 s2 0
R2 s2 4 47e1
VS3 4 s3 0
R3 s3 0 82e-2
VS4 5 s4 0
R4 s4 0 10e0
VS5 0 s5 0
V5 e5 s5 DC 33e1
RI5 e5 3 12e-1
VS6 0 s6 0
R6 s6 3 12e-2
VS7 6 s7 0
R7 s7 3 47e2
.control
set numdgt=17
op
print v(1) v(2) v(3) v(4) v(5) v(6) v(7)
print i(vs0) i(vs1) i(vs2) i(vs3) i(vs4) i(vs5) i(vs6) i(vs7)
.endc
.end
