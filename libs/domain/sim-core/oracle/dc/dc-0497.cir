controls oracle dc-0497
* Generated (plan F2.7, ADR 0012): do not edit; regenerate with `pnpm sim oracle regen`. dc seed 20261030 index 497 nodes 8 elements 9
.options sparse gmin=1e-12 noopac
RG1 1 0 1000000000000
RG2 2 0 1000000000000
RG3 3 0 1000000000000
RG4 4 0 1000000000000
RG5 5 0 1000000000000
RG6 6 0 1000000000000
RG7 7 0 1000000000000
VS0 5 s0 0
R0 s0 0 15e1
VS1 5 s1 0
R1 s1 1 33e2
VS2 5 s2 0
R2 s2 2 10e0
VS3 4 s3 0
R3 s3 2 82e-2
VS4 1 s4 0
R4 s4 6 27e1
VS5 6 s5 0
R5 s5 3 47e2
VS6 7 s6 0
R6 s6 4 47e1
VS7 0 s7 0
V7 e7 s7 DC 22e1
RI7 e7 7 22e-3
VS8 2 s8 0
V8 e8 s8 DC 33e1
RI8 e8 3 12e-1
.control
set numdgt=17
op
print v(1) v(2) v(3) v(4) v(5) v(6) v(7)
print i(vs0) i(vs1) i(vs2) i(vs3) i(vs4) i(vs5) i(vs6) i(vs7) i(vs8)
.endc
.end
