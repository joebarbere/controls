controls oracle dc-0024
* Generated (plan F2.7, ADR 0012): do not edit; regenerate with `pnpm sim oracle regen`. dc seed 20261030 index 24 nodes 26 elements 42
.options sparse gmin=1e-12 noopac
RG1 1 0 1000000000000
RG2 2 0 1000000000000
RG3 3 0 1000000000000
RG4 4 0 1000000000000
RG5 5 0 1000000000000
RG6 6 0 1000000000000
RG7 7 0 1000000000000
RG8 8 0 1000000000000
RG9 9 0 1000000000000
RG10 10 0 1000000000000
RG11 11 0 1000000000000
RG12 12 0 1000000000000
RG13 13 0 1000000000000
RG14 14 0 1000000000000
RG15 15 0 1000000000000
RG16 16 0 1000000000000
RG17 17 0 1000000000000
RG18 18 0 1000000000000
RG19 19 0 1000000000000
RG20 20 0 1000000000000
RG21 21 0 1000000000000
RG22 22 0 1000000000000
RG23 23 0 1000000000000
RG24 24 0 1000000000000
RG25 25 0 1000000000000
VS0 18 s0 0
R0 s0 15 82e-1
VS1 6 s1 0
R1 s1 7 68e3
VS2 0 s2 0
V2 e2 s2 DC 39e1
RI2 e2 4 56e-2
VS3 17 s3 0
V3 e3 s3 DC 27e1
RI3 e3 18 56e-2
VS4 3 s4 0
R4 s4 7 12e-2
VS5 12 s5 0
R5 s5 20 10e2
VS6 23 s6 0
R6 s6 15 12e1
VS7 1 s7 0
I7 s7 5 DC 12e-2
VS8 4 s8 0
R8 s8 16 10e-1
VS9 11 s9 0
R9 s9 14 82e-1
VS10 5 s10 0
R10 s10 19 10e-2
VS11 5 s11 0
R11 s11 22 27e0
VS12 13 s12 0
R12 s12 22 56e1
VS13 18 s13 0
R13 s13 8 22e-1
VS14 9 s14 0
R14 s14 2 39e3
VS15 15 s15 0
R15 s15 4 39e-1
VS16 12 s16 0
R16 s16 22 68e-2
VS17 16 s17 0
R17 s17 15 47e1
VS18 10 s18 0
R18 s18 17 18e0
VS19 18 s19 0
R19 s19 1 10e3
VS20 9 s20 0
R20 s20 14 68e3
VS21 2 s21 0
R21 s21 11 33e0
VS22 24 s22 0
R22 s22 22 10e2
VS23 3 s23 0
R23 s23 18 22e2
VS24 5 s24 0
R24 s24 20 39e-2
VS25 25 s25 0
R25 s25 0 33e2
VS26 13 s26 0
R26 s26 17 27e0
VS27 20 s27 0
R27 s27 25 68e2
VS28 8 s28 0
R28 s28 14 33e-1
VS29 9 s29 0
V29 e29 s29 DC 27e-1
RI29 e29 14 47e-3
VS30 13 s30 0
R30 s30 23 12e3
VS31 2 s31 0
R31 s31 18 56e3
VS32 21 s32 0
V32 e32 s32 DC 12e0
RI32 e32 13 12e-2
VS33 7 s33 0
R33 s33 2 27e-1
VS34 12 s34 0
R34 s34 20 18e3
VS35 18 s35 0
R35 s35 20 22e3
VS36 6 s36 0
R36 s36 10 15e3
VS37 10 s37 0
R37 s37 21 68e0
VS38 19 s38 0
R38 s38 0 12e1
VS39 24 s39 0
R39 s39 19 56e3
VS40 9 s40 0
R40 s40 1 47e2
VS41 19 s41 0
V41 e41 s41 DC 33e-1
RI41 e41 10 15e-3
.control
set numdgt=17
op
print v(1) v(2) v(3) v(4) v(5) v(6) v(7) v(8) v(9) v(10)
print v(11) v(12) v(13) v(14) v(15) v(16) v(17) v(18) v(19) v(20)
print v(21) v(22) v(23) v(24) v(25)
print i(vs0) i(vs1) i(vs2) i(vs3) i(vs4) i(vs5) i(vs6) i(vs7) i(vs8) i(vs9)
print i(vs10) i(vs11) i(vs12) i(vs13) i(vs14) i(vs15) i(vs16) i(vs17) i(vs18) i(vs19)
print i(vs20) i(vs21) i(vs22) i(vs23) i(vs24) i(vs25) i(vs26) i(vs27) i(vs28) i(vs29)
print i(vs30) i(vs31) i(vs32) i(vs33) i(vs34) i(vs35) i(vs36) i(vs37) i(vs38) i(vs39)
print i(vs40) i(vs41)
.endc
.end
