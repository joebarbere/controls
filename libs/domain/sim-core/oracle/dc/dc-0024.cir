controls oracle dc-0024
* Generated (plan F2.7, ADR 0012): do not edit; regenerate with `pnpm sim oracle regen`. dc seed 20261030 index 24 nodes 26 elements 31
.options sparse gmin=1e-12 noopac
RG1 1 0 1000000000000
RG2 2 0 1000000000000
RG3 3 0 1000000000000
RG4 4 0 1000000000000
RG5 5 0 1000000000000
RG6 6 0 1000000000000
RG7 7 0 1000000000000
RG8 8 0 1000000000000
RG9 9 0 1000000000000
RG10 10 0 1000000000000
RG11 11 0 1000000000000
RG12 12 0 1000000000000
RG13 13 0 1000000000000
RG14 14 0 1000000000000
RG15 15 0 1000000000000
RG16 16 0 1000000000000
RG17 17 0 1000000000000
RG18 18 0 1000000000000
RG19 19 0 1000000000000
RG20 20 0 1000000000000
RG21 21 0 1000000000000
RG22 22 0 1000000000000
RG23 23 0 1000000000000
RG24 24 0 1000000000000
RG25 25 0 1000000000000
VS0 5 s0 0
R0 s0 19 39e-2
VS1 0 s1 0
V1 e1 s1 DC 33e-1
RI1 e1 10 15e-3
VS2 19 s2 0
R2 s2 25 68e2
VS3 24 s3 0
R3 s3 0 56e3
VS4 9 s4 0
V4 e4 s4 DC 27e-1
RI4 e4 14 47e-3
VS5 3 s5 0
R5 s5 7 12e-2
VS6 10 s6 0
R6 s6 17 18e0
VS7 9 s7 0
R7 s7 14 68e3
VS8 23 s8 0
R8 s8 15 12e1
VS9 6 s9 0
R9 s9 7 68e3
VS10 18 s10 0
R10 s10 15 82e-1
VS11 8 s11 0
R11 s11 14 33e-1
VS12 2 s12 0
R12 s12 11 33e0
VS13 15 s13 0
R13 s13 4 39e-1
VS14 7 s14 0
R14 s14 2 27e-1
VS15 4 s15 0
R15 s15 16 10e-1
VS16 12 s16 0
R16 s16 19 18e3
VS17 17 s17 0
V17 e17 s17 DC 27e1
RI17 e17 18 56e-2
VS18 18 s18 0
R18 s18 19 22e3
VS19 18 s19 0
R19 s19 1 10e3
VS20 11 s20 0
R20 s20 14 82e-1
VS21 16 s21 0
R21 s21 15 47e1
VS22 21 s22 0
V22 e22 s22 DC 12e0
RI22 e22 13 12e-2
VS23 18 s23 0
R23 s23 8 22e-1
VS24 2 s24 0
R24 s24 18 56e3
VS25 13 s25 0
R25 s25 17 27e0
VS26 5 s26 0
R26 s26 0 10e-2
VS27 1 s27 0
I27 s27 5 DC 12e-2
VS28 0 s28 0
R28 s28 20 12e1
VS29 12 s29 0
R29 s29 19 10e2
VS30 5 s30 0
R30 s30 22 27e0
.control
set numdgt=17
op
print v(1) v(2) v(3) v(4) v(5) v(6) v(7) v(8) v(9) v(10)
print v(11) v(12) v(13) v(14) v(15) v(16) v(17) v(18) v(19) v(20)
print v(21) v(22) v(23) v(24) v(25)
print i(vs0) i(vs1) i(vs2) i(vs3) i(vs4) i(vs5) i(vs6) i(vs7) i(vs8) i(vs9)
print i(vs10) i(vs11) i(vs12) i(vs13) i(vs14) i(vs15) i(vs16) i(vs17) i(vs18) i(vs19)
print i(vs20) i(vs21) i(vs22) i(vs23) i(vs24) i(vs25) i(vs26) i(vs27) i(vs28) i(vs29)
print i(vs30)
.endc
.end
