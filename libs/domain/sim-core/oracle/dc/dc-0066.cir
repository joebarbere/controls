controls oracle dc-0066
* Generated (plan F2.7, ADR 0012): do not edit; regenerate with `pnpm sim oracle regen`. dc seed 20261030 index 66 nodes 7 elements 10
.options sparse gmin=1e-12 noopac
RG1 1 0 1000000000000
RG2 2 0 1000000000000
RG3 3 0 1000000000000
RG4 4 0 1000000000000
RG5 5 0 1000000000000
RG6 6 0 1000000000000
VS0 6 s0 0
R0 s0 0 18e-1
VS1 1 s1 0
R1 s1 4 15e-1
VS2 0 s2 0
R2 s2 5 18e0
VS3 1 s3 0
R3 s3 3 18e3
VS4 3 s4 0
R4 s4 0 56e2
VS5 0 s5 0
V5 e5 s5 DC 18e0
RI5 e5 1 15e-2
VS6 5 s6 0
R6 s6 2 22e0
VS7 4 s7 0
R7 s7 0 68e0
VS8 6 s8 0
R8 s8 4 12e2
VS9 5 s9 0
R9 s9 6 82e0
.control
set numdgt=17
op
print v(1) v(2) v(3) v(4) v(5) v(6)
print i(vs0) i(vs1) i(vs2) i(vs3) i(vs4) i(vs5) i(vs6) i(vs7) i(vs8) i(vs9)
.endc
.end
