controls oracle dc-0066
* Generated (plan F2.7, ADR 0012): do not edit; regenerate with `pnpm sim oracle regen`. dc seed 20261030 index 66 nodes 7 elements 11
.options sparse gmin=1e-12 noopac
RG1 1 0 1000000000000
RG2 2 0 1000000000000
RG3 3 0 1000000000000
RG4 4 0 1000000000000
RG5 5 0 1000000000000
RG6 6 0 1000000000000
VS0 1 s0 0
R0 s0 4 15e-1
VS1 5 s1 0
R1 s1 2 22e0
VS2 6 s2 0
R2 s2 4 12e2
VS3 1 s3 0
R3 s3 2 15e3
VS4 0 s4 0
R4 s4 5 18e0
VS5 3 s5 0
R5 s5 0 56e2
VS6 1 s6 0
R6 s6 3 18e3
VS7 4 s7 0
R7 s7 0 68e0
VS8 5 s8 0
R8 s8 6 82e0
VS9 6 s9 0
R9 s9 0 18e-1
VS10 0 s10 0
V10 e10 s10 DC 18e0
RI10 e10 1 15e-2
.control
set numdgt=17
op
print v(1) v(2) v(3) v(4) v(5) v(6)
print i(vs0) i(vs1) i(vs2) i(vs3) i(vs4) i(vs5) i(vs6) i(vs7) i(vs8) i(vs9)
print i(vs10)
.endc
.end
