controls oracle dc-0209
* Generated (plan F2.7, ADR 0012): do not edit; regenerate with `pnpm sim oracle regen`. dc seed 20261030 index 209 nodes 17 elements 28
.options sparse gmin=1e-12 noopac
RG1 1 0 1000000000000
RG2 2 0 1000000000000
RG3 3 0 1000000000000
RG4 4 0 1000000000000
RG5 5 0 1000000000000
RG6 6 0 1000000000000
RG7 7 0 1000000000000
RG8 8 0 1000000000000
RG9 9 0 1000000000000
RG10 10 0 1000000000000
RG11 11 0 1000000000000
RG12 12 0 1000000000000
RG13 13 0 1000000000000
RG14 14 0 1000000000000
RG15 15 0 1000000000000
RG16 16 0 1000000000000
VS0 0 s0 0
V0 e0 s0 DC 12e0
RI0 e0 4 18e-3
VS1 11 s1 0
R1 s1 1 56e2
VS2 1 s2 0
I2 s2 9 DC 27e-1
VS3 10 s3 0
I3 s3 8 DC 27e-2
VS4 8 s4 0
R4 s4 11 12e2
VS5 7 s5 0
R5 s5 14 47e3
VS6 1 s6 0
R6 s6 6 56e2
VS7 12 s7 0
R7 s7 3 82e-1
VS8 1 s8 0
I8 s8 8 DC 82e-2
VS9 0 s9 0
R9 s9 16 18e2
VS10 10 s10 0
R10 s10 8 10e3
VS11 3 s11 0
R11 s11 14 18e3
VS12 3 s12 0
R12 s12 7 68e-2
VS13 9 s13 0
R13 s13 5 68e0
VS14 8 s14 0
R14 s14 0 82e2
VS15 14 s15 0
I15 s15 4 DC 56e-4
VS16 4 s16 0
R16 s16 14 22e3
VS17 13 s17 0
R17 s17 11 18e-2
VS18 0 s18 0
V18 e18 s18 DC 56e1
RI18 e18 9 56e-1
VS19 9 s19 0
V19 e19 s19 DC 15e-1
RI19 e19 13 22e-3
VS20 10 s20 0
R20 s20 12 27e-1
VS21 4 s21 0
R21 s21 15 39e-2
VS22 5 s22 0
R22 s22 11 27e2
VS23 0 s23 0
R23 s23 2 33e3
VS24 5 s24 0
R24 s24 2 39e2
VS25 14 s25 0
V25 e25 s25 DC 18e0
RI25 e25 16 33e-3
VS26 8 s26 0
R26 s26 12 68e3
VS27 15 s27 0
R27 s27 6 56e-1
.control
set numdgt=17
op
print v(1) v(2) v(3) v(4) v(5) v(6) v(7) v(8) v(9) v(10)
print v(11) v(12) v(13) v(14) v(15) v(16)
print i(vs0) i(vs1) i(vs2) i(vs3) i(vs4) i(vs5) i(vs6) i(vs7) i(vs8) i(vs9)
print i(vs10) i(vs11) i(vs12) i(vs13) i(vs14) i(vs15) i(vs16) i(vs17) i(vs18) i(vs19)
print i(vs20) i(vs21) i(vs22) i(vs23) i(vs24) i(vs25) i(vs26) i(vs27)
.endc
.end
