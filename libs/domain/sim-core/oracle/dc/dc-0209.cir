controls oracle dc-0209
* Generated (plan F2.7, ADR 0012): do not edit; regenerate with `pnpm sim oracle regen`. dc seed 20261030 index 209 nodes 17 elements 24
.options sparse gmin=1e-12 noopac
RG1 1 0 1000000000000
RG2 2 0 1000000000000
RG3 3 0 1000000000000
RG4 4 0 1000000000000
RG5 5 0 1000000000000
RG6 6 0 1000000000000
RG7 7 0 1000000000000
RG8 8 0 1000000000000
RG9 9 0 1000000000000
RG10 10 0 1000000000000
RG11 11 0 1000000000000
RG12 12 0 1000000000000
RG13 13 0 1000000000000
RG14 14 0 1000000000000
RG15 15 0 1000000000000
RG16 16 0 1000000000000
VS0 0 s0 0
R0 s0 16 18e2
VS1 8 s1 0
R1 s1 11 12e2
VS2 13 s2 0
R2 s2 11 18e-2
VS3 0 s3 0
V3 e3 s3 DC 56e1
RI3 e3 9 56e-1
VS4 1 s4 0
I4 s4 8 DC 82e-2
VS5 5 s5 0
R5 s5 2 39e2
VS6 10 s6 0
I6 s6 8 DC 27e-2
VS7 11 s7 0
R7 s7 1 56e2
VS8 4 s8 0
R8 s8 14 22e3
VS9 8 s9 0
R9 s9 0 82e2
VS10 3 s10 0
R10 s10 7 68e-2
VS11 4 s11 0
R11 s11 15 39e-2
VS12 12 s12 0
R12 s12 3 82e-1
VS13 10 s13 0
R13 s13 8 10e3
VS14 3 s14 0
R14 s14 14 18e3
VS15 1 s15 0
I15 s15 9 DC 27e-1
VS16 0 s16 0
V16 e16 s16 DC 12e0
RI16 e16 4 18e-3
VS17 7 s17 0
R17 s17 14 47e3
VS18 14 s18 0
V18 e18 s18 DC 18e0
RI18 e18 16 33e-3
VS19 14 s19 0
I19 s19 4 DC 56e-4
VS20 8 s20 0
R20 s20 12 68e3
VS21 15 s21 0
R21 s21 6 56e-1
VS22 0 s22 0
R22 s22 2 33e3
VS23 1 s23 0
R23 s23 6 56e2
.control
set numdgt=17
op
print v(1) v(2) v(3) v(4) v(5) v(6) v(7) v(8) v(9) v(10)
print v(11) v(12) v(13) v(14) v(15) v(16)
print i(vs0) i(vs1) i(vs2) i(vs3) i(vs4) i(vs5) i(vs6) i(vs7) i(vs8) i(vs9)
print i(vs10) i(vs11) i(vs12) i(vs13) i(vs14) i(vs15) i(vs16) i(vs17) i(vs18) i(vs19)
print i(vs20) i(vs21) i(vs22) i(vs23)
.endc
.end
