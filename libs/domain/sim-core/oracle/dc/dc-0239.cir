controls oracle dc-0239
* Generated (plan F2.7, ADR 0012): do not edit; regenerate with `pnpm sim oracle regen`. dc seed 20261030 index 239 nodes 22 elements 22
.options sparse gmin=1e-12 noopac
RG1 1 0 1000000000000
RG2 2 0 1000000000000
RG3 3 0 1000000000000
RG4 4 0 1000000000000
RG5 5 0 1000000000000
RG6 6 0 1000000000000
RG7 7 0 1000000000000
RG8 8 0 1000000000000
RG9 9 0 1000000000000
RG10 10 0 1000000000000
RG11 11 0 1000000000000
RG12 12 0 1000000000000
RG13 13 0 1000000000000
RG14 14 0 1000000000000
RG15 15 0 1000000000000
RG16 16 0 1000000000000
RG17 17 0 1000000000000
RG18 18 0 1000000000000
RG19 19 0 1000000000000
RG20 20 0 1000000000000
RG21 21 0 1000000000000
VS0 0 s0 0
V0 e0 s0 DC 68e-1
RI0 e0 5 12e-2
VS1 7 s1 0
R1 s1 16 15e0
VS2 18 s2 0
V2 e2 s2 DC 33e1
RI2 e2 12 68e-3
VS3 14 s3 0
V3 e3 s3 DC 82e1
RI3 e3 16 68e-2
VS4 9 s4 0
R4 s4 19 12e3
VS5 9 s5 0
R5 s5 16 56e-1
VS6 1 s6 0
R6 s6 18 10e2
VS7 12 s7 0
R7 s7 0 27e2
VS8 3 s8 0
V8 e8 s8 DC 33e1
RI8 e8 8 82e-2
VS9 9 s9 0
R9 s9 10 82e2
VS10 14 s10 0
R10 s10 10 39e-2
VS11 6 s11 0
R11 s11 5 18e1
VS12 13 s12 0
R12 s12 8 82e2
VS13 2 s13 0
R13 s13 15 12e3
VS14 20 s14 0
R14 s14 0 39e0
VS15 12 s15 0
R15 s15 10 82e2
VS16 21 s16 0
R16 s16 5 22e3
VS17 21 s17 0
V17 e17 s17 DC 56e0
RI17 e17 11 15e-1
VS18 0 s18 0
V18 e18 s18 DC 18e0
RI18 e18 17 10e-3
VS19 4 s19 0
R19 s19 15 12e0
VS20 0 s20 0
R20 s20 15 18e2
VS21 21 s21 0
R21 s21 8 33e2
.control
set numdgt=17
op
print v(1) v(2) v(3) v(4) v(5) v(6) v(7) v(8) v(9) v(10)
print v(11) v(12) v(13) v(14) v(15) v(16) v(17) v(18) v(19) v(20)
print v(21)
print i(vs0) i(vs1) i(vs2) i(vs3) i(vs4) i(vs5) i(vs6) i(vs7) i(vs8) i(vs9)
print i(vs10) i(vs11) i(vs12) i(vs13) i(vs14) i(vs15) i(vs16) i(vs17) i(vs18) i(vs19)
print i(vs20) i(vs21)
.endc
.end
