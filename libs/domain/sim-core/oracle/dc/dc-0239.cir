controls oracle dc-0239
* Generated (plan F2.7, ADR 0012): do not edit; regenerate with `pnpm sim oracle regen`. dc seed 20261030 index 239 nodes 22 elements 30
.options sparse gmin=1e-12 noopac
RG1 1 0 1000000000000
RG2 2 0 1000000000000
RG3 3 0 1000000000000
RG4 4 0 1000000000000
RG5 5 0 1000000000000
RG6 6 0 1000000000000
RG7 7 0 1000000000000
RG8 8 0 1000000000000
RG9 9 0 1000000000000
RG10 10 0 1000000000000
RG11 11 0 1000000000000
RG12 12 0 1000000000000
RG13 13 0 1000000000000
RG14 14 0 1000000000000
RG15 15 0 1000000000000
RG16 16 0 1000000000000
RG17 17 0 1000000000000
RG18 18 0 1000000000000
RG19 19 0 1000000000000
RG20 20 0 1000000000000
RG21 21 0 1000000000000
VS0 19 s0 0
R0 s0 11 82e1
VS1 0 s1 0
R1 s1 10 39e-2
VS2 4 s2 0
R2 s2 15 12e0
VS3 2 s3 0
R3 s3 15 12e3
VS4 12 s4 0
R4 s4 14 27e2
VS5 9 s5 0
R5 s5 16 56e-1
VS6 21 s6 0
R6 s6 5 22e3
VS7 0 s7 0
V7 e7 s7 DC 82e1
RI7 e7 16 68e-2
VS8 9 s8 0
R8 s8 10 82e2
VS9 12 s9 0
V9 e9 s9 DC 22e1
RI9 e9 7 82e-3
VS10 7 s10 0
R10 s10 16 15e0
VS11 11 s11 0
V11 e11 s11 DC 15e-1
RI11 e11 4 18e-3
VS12 2 s12 0
R12 s12 20 18e2
VS13 3 s13 0
V13 e13 s13 DC 33e1
RI13 e13 8 82e-2
VS14 20 s14 0
R14 s14 6 22e1
VS15 21 s15 0
R15 s15 8 33e2
VS16 17 s16 0
R16 s16 13 15e1
VS17 18 s17 0
V17 e17 s17 DC 33e1
RI17 e17 12 68e-3
VS18 1 s18 0
R18 s18 18 10e2
VS19 14 s19 0
V19 e19 s19 DC 68e-1
RI19 e19 5 12e-2
VS20 12 s20 0
R20 s20 10 82e2
VS21 20 s21 0
R21 s21 14 39e0
VS22 3 s22 0
R22 s22 1 33e3
VS23 14 s23 0
V23 e23 s23 DC 18e0
RI23 e23 17 10e-3
VS24 6 s24 0
R24 s24 5 18e1
VS25 13 s25 0
R25 s25 8 82e2
VS26 19 s26 0
V26 e26 s26 DC 68e1
RI26 e26 18 27e-1
VS27 21 s27 0
V27 e27 s27 DC 56e0
RI27 e27 11 15e-1
VS28 9 s28 0
R28 s28 19 12e3
VS29 14 s29 0
R29 s29 15 18e2
.control
set numdgt=17
op
print v(1) v(2) v(3) v(4) v(5) v(6) v(7) v(8) v(9) v(10)
print v(11) v(12) v(13) v(14) v(15) v(16) v(17) v(18) v(19) v(20)
print v(21)
print i(vs0) i(vs1) i(vs2) i(vs3) i(vs4) i(vs5) i(vs6) i(vs7) i(vs8) i(vs9)
print i(vs10) i(vs11) i(vs12) i(vs13) i(vs14) i(vs15) i(vs16) i(vs17) i(vs18) i(vs19)
print i(vs20) i(vs21) i(vs22) i(vs23) i(vs24) i(vs25) i(vs26) i(vs27) i(vs28) i(vs29)
.endc
.end
