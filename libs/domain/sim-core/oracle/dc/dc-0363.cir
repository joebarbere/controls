controls oracle dc-0363
* Generated (plan F2.7, ADR 0012): do not edit; regenerate with `pnpm sim oracle regen`. dc seed 20261030 index 363 nodes 30 elements 49
.options sparse gmin=1e-12 noopac
RG1 1 0 1000000000000
RG2 2 0 1000000000000
RG3 3 0 1000000000000
RG4 4 0 1000000000000
RG5 5 0 1000000000000
RG6 6 0 1000000000000
RG7 7 0 1000000000000
RG8 8 0 1000000000000
RG9 9 0 1000000000000
RG10 10 0 1000000000000
RG11 11 0 1000000000000
RG12 12 0 1000000000000
RG13 13 0 1000000000000
RG14 14 0 1000000000000
RG15 15 0 1000000000000
RG16 16 0 1000000000000
RG17 17 0 1000000000000
RG18 18 0 1000000000000
RG19 19 0 1000000000000
RG20 20 0 1000000000000
RG21 21 0 1000000000000
RG22 22 0 1000000000000
RG23 23 0 1000000000000
RG24 24 0 1000000000000
RG25 25 0 1000000000000
RG26 26 0 1000000000000
RG27 27 0 1000000000000
RG28 28 0 1000000000000
RG29 29 0 1000000000000
VS0 14 s0 0
R0 s0 7 82e1
VS1 5 s1 0
I1 s1 3 DC 82e-2
VS2 14 s2 0
I2 s2 24 DC 39e-1
VS3 19 s3 0
R3 s3 25 18e0
VS4 29 s4 0
R4 s4 28 10e2
VS5 24 s5 0
R5 s5 23 27e-1
VS6 20 s6 0
R6 s6 0 22e-2
VS7 19 s7 0
R7 s7 3 12e3
VS8 0 s8 0
V8 e8 s8 DC 68e-1
RI8 e8 15 68e-3
VS9 25 s9 0
R9 s9 4 22e1
VS10 9 s10 0
R10 s10 11 56e-1
VS11 23 s11 0
R11 s11 14 22e3
VS12 25 s12 0
R12 s12 4 33e-1
VS13 5 s13 0
R13 s13 15 18e2
VS14 26 s14 0
I14 s14 29 DC 27e-1
VS15 13 s15 0
R15 s15 10 12e2
VS16 21 s16 0
R16 s16 27 68e0
VS17 10 s17 0
R17 s17 11 68e3
VS18 1 s18 0
R18 s18 28 22e2
VS19 29 s19 0
R19 s19 18 47e1
VS20 28 s20 0
V20 e20 s20 DC 18e1
RI20 e20 1 12e-2
VS21 26 s21 0
V21 e21 s21 DC 27e-1
RI21 e21 22 22e-3
VS22 1 s22 0
R22 s22 14 18e1
VS23 1 s23 0
R23 s23 13 27e1
VS24 19 s24 0
R24 s24 16 10e3
VS25 13 s25 0
R25 s25 25 68e3
VS26 9 s26 0
R26 s26 15 68e3
VS27 24 s27 0
V27 e27 s27 DC 82e0
RI27 e27 17 39e-3
VS28 26 s28 0
I28 s28 6 DC 47e-2
VS29 27 s29 0
R29 s29 3 10e-1
VS30 15 s30 0
R30 s30 29 12e2
VS31 18 s31 0
R31 s31 5 33e-1
VS32 6 s32 0
R32 s32 20 22e1
VS33 10 s33 0
R33 s33 16 12e3
VS34 0 s34 0
R34 s34 7 82e3
VS35 21 s35 0
R35 s35 27 68e2
VS36 18 s36 0
R36 s36 19 68e0
VS37 4 s37 0
R37 s37 12 33e-2
VS38 10 s38 0
R38 s38 7 68e1
VS39 0 s39 0
R39 s39 4 22e-2
VS40 24 s40 0
V40 e40 s40 DC 47e-1
RI40 e40 26 12e-3
VS41 22 s41 0
R41 s41 20 56e2
VS42 5 s42 0
R42 s42 27 33e0
VS43 26 s43 0
I43 s43 23 DC 10e-2
VS44 1 s44 0
R44 s44 12 33e-2
VS45 19 s45 0
V45 e45 s45 DC 12e-1
RI45 e45 22 47e-3
VS46 7 s46 0
V46 e46 s46 DC 10e0
RI46 e46 2 47e-1
VS47 10 s47 0
R47 s47 18 27e2
VS48 22 s48 0
R48 s48 8 18e-2
.control
set numdgt=17
op
print v(1) v(2) v(3) v(4) v(5) v(6) v(7) v(8) v(9) v(10)
print v(11) v(12) v(13) v(14) v(15) v(16) v(17) v(18) v(19) v(20)
print v(21) v(22) v(23) v(24) v(25) v(26) v(27) v(28) v(29)
print i(vs0) i(vs1) i(vs2) i(vs3) i(vs4) i(vs5) i(vs6) i(vs7) i(vs8) i(vs9)
print i(vs10) i(vs11) i(vs12) i(vs13) i(vs14) i(vs15) i(vs16) i(vs17) i(vs18) i(vs19)
print i(vs20) i(vs21) i(vs22) i(vs23) i(vs24) i(vs25) i(vs26) i(vs27) i(vs28) i(vs29)
print i(vs30) i(vs31) i(vs32) i(vs33) i(vs34) i(vs35) i(vs36) i(vs37) i(vs38) i(vs39)
print i(vs40) i(vs41) i(vs42) i(vs43) i(vs44) i(vs45) i(vs46) i(vs47) i(vs48)
.endc
.end
