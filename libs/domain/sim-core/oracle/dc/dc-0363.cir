controls oracle dc-0363
* Generated (plan F2.7, ADR 0012): do not edit; regenerate with `pnpm sim oracle regen`. dc seed 20261030 index 363 nodes 30 elements 54
.options sparse gmin=1e-12 noopac
RG1 1 0 1000000000000
RG2 2 0 1000000000000
RG3 3 0 1000000000000
RG4 4 0 1000000000000
RG5 5 0 1000000000000
RG6 6 0 1000000000000
RG7 7 0 1000000000000
RG8 8 0 1000000000000
RG9 9 0 1000000000000
RG10 10 0 1000000000000
RG11 11 0 1000000000000
RG12 12 0 1000000000000
RG13 13 0 1000000000000
RG14 14 0 1000000000000
RG15 15 0 1000000000000
RG16 16 0 1000000000000
RG17 17 0 1000000000000
RG18 18 0 1000000000000
RG19 19 0 1000000000000
RG20 20 0 1000000000000
RG21 21 0 1000000000000
RG22 22 0 1000000000000
RG23 23 0 1000000000000
RG24 24 0 1000000000000
RG25 25 0 1000000000000
RG26 26 0 1000000000000
RG27 27 0 1000000000000
RG28 28 0 1000000000000
RG29 29 0 1000000000000
VS0 17 s0 0
R0 s0 25 68e0
VS1 10 s1 0
R1 s1 11 68e3
VS2 4 s2 0
R2 s2 12 33e-2
VS3 20 s3 0
R3 s3 15 22e-2
VS4 26 s4 0
I4 s4 29 DC 27e-1
VS5 22 s5 0
R5 s5 8 18e-2
VS6 0 s6 0
V6 e6 s6 DC 18e1
RI6 e6 1 12e-2
VS7 26 s7 0
I7 s7 23 DC 10e-2
VS8 6 s8 0
V8 e8 s8 DC 10e-1
RI8 e8 12 12e-3
VS9 5 s9 0
I9 s9 3 DC 82e-2
VS10 10 s10 0
R10 s10 18 27e2
VS11 1 s11 0
R11 s11 12 33e-2
VS12 19 s12 0
R12 s12 25 18e0
VS13 9 s13 0
R13 s13 28 68e3
VS14 18 s14 0
R14 s14 19 68e0
VS15 1 s15 0
R15 s15 13 27e1
VS16 14 s16 0
R16 s16 7 82e1
VS17 27 s17 0
R17 s17 3 10e-1
VS18 15 s18 0
V18 e18 s18 DC 68e-1
RI18 e18 28 68e-3
VS19 26 s19 0
V19 e19 s19 DC 27e-1
RI19 e19 22 22e-3
VS20 19 s20 0
R20 s20 3 12e3
VS21 7 s21 0
V21 e21 s21 DC 10e0
RI21 e21 2 47e-1
VS22 21 s22 0
R22 s22 27 68e2
VS23 22 s23 0
R23 s23 20 56e2
VS24 5 s24 0
R24 s24 28 18e2
VS25 8 s25 0
R25 s25 16 33e0
VS26 24 s26 0
V26 e26 s26 DC 82e0
RI26 e26 17 39e-3
VS27 26 s27 0
I27 s27 6 DC 47e-2
VS28 9 s28 0
R28 s28 11 56e-1
VS29 24 s29 0
R29 s29 23 27e-1
VS30 2 s30 0
V30 e30 s30 DC 56e0
RI30 e30 1 56e-2
VS31 21 s31 0
R31 s31 27 68e0
VS32 6 s32 0
R32 s32 20 22e1
VS33 14 s33 0
V33 e33 s33 DC 12e1
RI33 e33 21 18e-3
VS34 10 s34 0
R34 s34 16 12e3
VS35 25 s35 0
R35 s35 4 22e1
VS36 29 s36 0
R36 s36 0 10e2
VS37 25 s37 0
R37 s37 4 33e-1
VS38 29 s38 0
R38 s38 18 47e1
VS39 10 s39 0
R39 s39 7 68e1
VS40 18 s40 0
R40 s40 5 33e-1
VS41 15 s41 0
R41 s41 4 22e-2
VS42 14 s42 0
I42 s42 24 DC 39e-1
VS43 24 s43 0
V43 e43 s43 DC 47e-1
RI43 e43 26 12e-3
VS44 13 s44 0
R44 s44 25 68e3
VS45 13 s45 0
R45 s45 10 12e2
VS46 28 s46 0
R46 s46 29 12e2
VS47 1 s47 0
R47 s47 14 18e1
VS48 19 s48 0
V48 e48 s48 DC 12e-1
RI48 e48 22 47e-3
VS49 5 s49 0
R49 s49 27 33e0
VS50 23 s50 0
R50 s50 14 22e3
VS51 15 s51 0
R51 s51 7 82e3
VS52 19 s52 0
R52 s52 16 10e3
VS53 1 s53 0
R53 s53 0 22e2
.control
set numdgt=17
op
print v(1) v(2) v(3) v(4) v(5) v(6) v(7) v(8) v(9) v(10)
print v(11) v(12) v(13) v(14) v(15) v(16) v(17) v(18) v(19) v(20)
print v(21) v(22) v(23) v(24) v(25) v(26) v(27) v(28) v(29)
print i(vs0) i(vs1) i(vs2) i(vs3) i(vs4) i(vs5) i(vs6) i(vs7) i(vs8) i(vs9)
print i(vs10) i(vs11) i(vs12) i(vs13) i(vs14) i(vs15) i(vs16) i(vs17) i(vs18) i(vs19)
print i(vs20) i(vs21) i(vs22) i(vs23) i(vs24) i(vs25) i(vs26) i(vs27) i(vs28) i(vs29)
print i(vs30) i(vs31) i(vs32) i(vs33) i(vs34) i(vs35) i(vs36) i(vs37) i(vs38) i(vs39)
print i(vs40) i(vs41) i(vs42) i(vs43) i(vs44) i(vs45) i(vs46) i(vs47) i(vs48) i(vs49)
print i(vs50) i(vs51) i(vs52) i(vs53)
.endc
.end
