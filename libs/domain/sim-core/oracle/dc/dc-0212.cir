controls oracle dc-0212
* Generated (plan F2.7, ADR 0012): do not edit; regenerate with `pnpm sim oracle regen`. dc seed 20261030 index 212 nodes 16 elements 25
.options sparse gmin=1e-12 noopac
RG1 1 0 1000000000000
RG2 2 0 1000000000000
RG3 3 0 1000000000000
RG4 4 0 1000000000000
RG5 5 0 1000000000000
RG6 6 0 1000000000000
RG7 7 0 1000000000000
RG8 8 0 1000000000000
RG9 9 0 1000000000000
RG10 10 0 1000000000000
RG11 11 0 1000000000000
RG12 12 0 1000000000000
RG13 13 0 1000000000000
RG14 14 0 1000000000000
RG15 15 0 1000000000000
VS0 3 s0 0
R0 s0 2 12e1
VS1 0 s1 0
V1 e1 s1 DC 15e1
RI1 e1 3 27e-3
VS2 8 s2 0
R2 s2 3 47e-1
VS3 6 s3 0
V3 e3 s3 DC 82e1
RI3 e3 5 12e-1
VS4 15 s4 0
R4 s4 9 10e0
VS5 6 s5 0
R5 s5 12 33e3
VS6 0 s6 0
R6 s6 8 47e0
VS7 4 s7 0
R7 s7 7 68e-2
VS8 8 s8 0
R8 s8 14 56e2
VS9 9 s9 0
V9 e9 s9 DC 18e-1
RI9 e9 14 68e-1
VS10 4 s10 0
R10 s10 8 12e1
VS11 9 s11 0
R11 s11 14 47e3
VS12 11 s12 0
I12 s12 8 DC 22e-4
VS13 7 s13 0
V13 e13 s13 DC 68e0
RI13 e13 0 10e-1
VS14 0 s14 0
R14 s14 9 47e1
VS15 8 s15 0
R15 s15 7 22e1
VS16 12 s16 0
V16 e16 s16 DC 33e-1
RI16 e16 13 33e-1
VS17 3 s17 0
R17 s17 12 68e1
VS18 5 s18 0
R18 s18 12 12e-2
VS19 10 s19 0
R19 s19 7 15e0
VS20 9 s20 0
R20 s20 1 10e-2
VS21 4 s21 0
I21 s21 9 DC 56e-2
VS22 2 s22 0
R22 s22 13 56e3
VS23 0 s23 0
I23 s23 10 DC 18e-1
VS24 11 s24 0
R24 s24 2 22e3
.control
set numdgt=17
op
print v(1) v(2) v(3) v(4) v(5) v(6) v(7) v(8) v(9) v(10)
print v(11) v(12) v(13) v(14) v(15)
print i(vs0) i(vs1) i(vs2) i(vs3) i(vs4) i(vs5) i(vs6) i(vs7) i(vs8) i(vs9)
print i(vs10) i(vs11) i(vs12) i(vs13) i(vs14) i(vs15) i(vs16) i(vs17) i(vs18) i(vs19)
print i(vs20) i(vs21) i(vs22) i(vs23) i(vs24)
.endc
.end
