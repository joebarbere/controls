controls oracle dc-0419
* Generated (plan F2.7, ADR 0012): do not edit; regenerate with `pnpm sim oracle regen`. dc seed 20261030 index 419 nodes 19 elements 33
.options sparse gmin=1e-12 noopac
RG1 1 0 1000000000000
RG2 2 0 1000000000000
RG3 3 0 1000000000000
RG4 4 0 1000000000000
RG5 5 0 1000000000000
RG6 6 0 1000000000000
RG7 7 0 1000000000000
RG8 8 0 1000000000000
RG9 9 0 1000000000000
RG10 10 0 1000000000000
RG11 11 0 1000000000000
RG12 12 0 1000000000000
RG13 13 0 1000000000000
RG14 14 0 1000000000000
RG15 15 0 1000000000000
RG16 16 0 1000000000000
RG17 17 0 1000000000000
RG18 18 0 1000000000000
VS0 0 s0 0
V0 e0 s0 DC 33e1
RI0 e0 17 10e-2
VS1 9 s1 0
R1 s1 13 12e-2
VS2 1 s2 0
V2 e2 s2 DC 10e1
RI2 e2 7 82e-1
VS3 9 s3 0
R3 s3 8 15e2
VS4 2 s4 0
R4 s4 18 68e2
VS5 3 s5 0
R5 s5 9 10e-1
VS6 7 s6 0
R6 s6 15 15e-2
VS7 16 s7 0
R7 s7 9 18e-2
VS8 5 s8 0
R8 s8 1 47e-1
VS9 8 s9 0
R9 s9 9 10e2
VS10 13 s10 0
R10 s10 18 82e1
VS11 2 s11 0
R11 s11 3 12e3
VS12 11 s12 0
R12 s12 15 82e2
VS13 6 s13 0
V13 e13 s13 DC 15e-1
RI13 e13 7 33e-1
VS14 9 s14 0
R14 s14 4 82e2
VS15 15 s15 0
I15 s15 7 DC 22e-1
VS16 6 s16 0
R16 s16 13 27e3
VS17 10 s17 0
V17 e17 s17 DC 47e0
RI17 e17 13 33e-1
VS18 15 s18 0
R18 s18 8 56e0
VS19 5 s19 0
R19 s19 4 12e3
VS20 2 s20 0
R20 s20 11 68e0
VS21 7 s21 0
R21 s21 17 33e3
VS22 7 s22 0
R22 s22 16 15e0
VS23 14 s23 0
V23 e23 s23 DC 22e-1
RI23 e23 6 18e-3
VS24 12 s24 0
R24 s24 14 10e0
VS25 12 s25 0
V25 e25 s25 DC 33e-1
RI25 e25 11 39e-2
VS26 16 s26 0
I26 s26 7 DC 18e-3
VS27 18 s27 0
I27 s27 9 DC 68e-1
VS28 2 s28 0
V28 e28 s28 DC 82e0
RI28 e28 0 10e-1
VS29 2 s29 0
V29 e29 s29 DC 68e-1
RI29 e29 5 39e-1
VS30 3 s30 0
R30 s30 6 22e3
VS31 16 s31 0
R31 s31 5 10e3
VS32 3 s32 0
R32 s32 10 10e3
.control
set numdgt=17
op
print v(1) v(2) v(3) v(4) v(5) v(6) v(7) v(8) v(9) v(10)
print v(11) v(12) v(13) v(14) v(15) v(16) v(17) v(18)
print i(vs0) i(vs1) i(vs2) i(vs3) i(vs4) i(vs5) i(vs6) i(vs7) i(vs8) i(vs9)
print i(vs10) i(vs11) i(vs12) i(vs13) i(vs14) i(vs15) i(vs16) i(vs17) i(vs18) i(vs19)
print i(vs20) i(vs21) i(vs22) i(vs23) i(vs24) i(vs25) i(vs26) i(vs27) i(vs28) i(vs29)
print i(vs30) i(vs31) i(vs32)
.endc
.end
