controls oracle dc-0419
* Generated (plan F2.7, ADR 0012): do not edit; regenerate with `pnpm sim oracle regen`. dc seed 20261030 index 419 nodes 19 elements 29
.options sparse gmin=1e-12 noopac
RG1 1 0 1000000000000
RG2 2 0 1000000000000
RG3 3 0 1000000000000
RG4 4 0 1000000000000
RG5 5 0 1000000000000
RG6 6 0 1000000000000
RG7 7 0 1000000000000
RG8 8 0 1000000000000
RG9 9 0 1000000000000
RG10 10 0 1000000000000
RG11 11 0 1000000000000
RG12 12 0 1000000000000
RG13 13 0 1000000000000
RG14 14 0 1000000000000
RG15 15 0 1000000000000
RG16 16 0 1000000000000
RG17 17 0 1000000000000
RG18 18 0 1000000000000
VS0 0 s0 0
V0 e0 s0 DC 22e-1
RI0 e0 6 18e-3
VS1 2 s1 0
R1 s1 3 12e3
VS2 2 s2 0
R2 s2 11 68e0
VS3 16 s3 0
R3 s3 9 18e-2
VS4 6 s4 0
V4 e4 s4 DC 15e-1
RI4 e4 7 33e-1
VS5 13 s5 0
R5 s5 18 82e1
VS6 7 s6 0
R6 s6 16 15e0
VS7 16 s7 0
R7 s7 14 10e3
VS8 9 s8 0
R8 s8 8 15e2
VS9 12 s9 0
V9 e9 s9 DC 33e-1
RI9 e9 11 39e-2
VS10 16 s10 0
I10 s10 7 DC 18e-3
VS11 11 s11 0
R11 s11 15 82e2
VS12 6 s12 0
R12 s12 13 27e3
VS13 15 s13 0
R13 s13 8 56e0
VS14 3 s14 0
R14 s14 10 10e3
VS15 14 s15 0
R15 s15 4 12e3
VS16 2 s16 0
R16 s16 18 68e2
VS17 9 s17 0
R17 s17 4 82e2
VS18 5 s18 0
V18 e18 s18 DC 33e1
RI18 e18 17 10e-2
VS19 8 s19 0
R19 s19 9 10e2
VS20 7 s20 0
R20 s20 17 33e3
VS21 1 s21 0
V21 e21 s21 DC 10e1
RI21 e21 7 82e-1
VS22 2 s22 0
V22 e22 s22 DC 68e-1
RI22 e22 14 39e-1
VS23 15 s23 0
I23 s23 7 DC 22e-1
VS24 3 s24 0
R24 s24 9 10e-1
VS25 9 s25 0
R25 s25 13 12e-2
VS26 3 s26 0
R26 s26 6 22e3
VS27 18 s27 0
I27 s27 9 DC 68e-1
VS28 7 s28 0
R28 s28 15 15e-2
.control
set numdgt=17
op
print v(1) v(2) v(3) v(4) v(5) v(6) v(7) v(8) v(9) v(10)
print v(11) v(12) v(13) v(14) v(15) v(16) v(17) v(18)
print i(vs0) i(vs1) i(vs2) i(vs3) i(vs4) i(vs5) i(vs6) i(vs7) i(vs8) i(vs9)
print i(vs10) i(vs11) i(vs12) i(vs13) i(vs14) i(vs15) i(vs16) i(vs17) i(vs18) i(vs19)
print i(vs20) i(vs21) i(vs22) i(vs23) i(vs24) i(vs25) i(vs26) i(vs27) i(vs28)
.endc
.end
