controls oracle dc-0229
* Generated (plan F2.7, ADR 0012): do not edit; regenerate with `pnpm sim oracle regen`. dc seed 20261030 index 229 nodes 14 elements 28
.options sparse gmin=1e-12 noopac
RG1 1 0 1000000000000
RG2 2 0 1000000000000
RG3 3 0 1000000000000
RG4 4 0 1000000000000
RG5 5 0 1000000000000
RG6 6 0 1000000000000
RG7 7 0 1000000000000
RG8 8 0 1000000000000
RG9 9 0 1000000000000
RG10 10 0 1000000000000
RG11 11 0 1000000000000
RG12 12 0 1000000000000
RG13 13 0 1000000000000
VS0 3 s0 0
R0 s0 9 68e-2
VS1 0 s1 0
V1 e1 s1 DC 82e1
RI1 e1 9 68e-3
VS2 1 s2 0
R2 s2 7 15e1
VS3 4 s3 0
R3 s3 11 15e3
VS4 0 s4 0
R4 s4 13 82e0
VS5 5 s5 0
R5 s5 1 39e3
VS6 12 s6 0
I6 s6 10 DC 56e-1
VS7 12 s7 0
R7 s7 6 10e1
VS8 2 s8 0
R8 s8 0 22e0
VS9 8 s9 0
R9 s9 2 18e1
VS10 9 s10 0
V10 e10 s10 DC 47e0
RI10 e10 3 10e-2
VS11 7 s11 0
R11 s11 11 22e3
VS12 1 s12 0
I12 s12 10 DC 15e-1
VS13 2 s13 0
R13 s13 5 82e1
VS14 3 s14 0
I14 s14 9 DC 12e-1
VS15 10 s15 0
R15 s15 9 15e-2
VS16 6 s16 0
R16 s16 9 33e1
VS17 8 s17 0
R17 s17 11 27e-1
VS18 4 s18 0
V18 e18 s18 DC 82e1
RI18 e18 6 27e-1
VS19 3 s19 0
R19 s19 7 39e1
VS20 0 s20 0
I20 s20 2 DC 47e-2
VS21 1 s21 0
V21 e21 s21 DC 22e0
RI21 e21 10 18e-1
VS22 13 s22 0
R22 s22 4 15e-1
VS23 9 s23 0
I23 s23 0 DC 22e-2
VS24 11 s24 0
R24 s24 0 82e0
VS25 12 s25 0
R25 s25 1 82e1
VS26 5 s26 0
V26 e26 s26 DC 10e-1
RI26 e26 8 10e-1
VS27 7 s27 0
R27 s27 11 15e-2
.control
set numdgt=17
op
print v(1) v(2) v(3) v(4) v(5) v(6) v(7) v(8) v(9) v(10)
print v(11) v(12) v(13)
print i(vs0) i(vs1) i(vs2) i(vs3) i(vs4) i(vs5) i(vs6) i(vs7) i(vs8) i(vs9)
print i(vs10) i(vs11) i(vs12) i(vs13) i(vs14) i(vs15) i(vs16) i(vs17) i(vs18) i(vs19)
print i(vs20) i(vs21) i(vs22) i(vs23) i(vs24) i(vs25) i(vs26) i(vs27)
.endc
.end
