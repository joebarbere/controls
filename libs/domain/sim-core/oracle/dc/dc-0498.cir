controls oracle dc-0498
* Generated (plan F2.7, ADR 0012): do not edit; regenerate with `pnpm sim oracle regen`. dc seed 20261030 index 498 nodes 20 elements 36
.options sparse gmin=1e-12 noopac
RG1 1 0 1000000000000
RG2 2 0 1000000000000
RG3 3 0 1000000000000
RG4 4 0 1000000000000
RG5 5 0 1000000000000
RG6 6 0 1000000000000
RG7 7 0 1000000000000
RG8 8 0 1000000000000
RG9 9 0 1000000000000
RG10 10 0 1000000000000
RG11 11 0 1000000000000
RG12 12 0 1000000000000
RG13 13 0 1000000000000
RG14 14 0 1000000000000
RG15 15 0 1000000000000
RG16 16 0 1000000000000
RG17 17 0 1000000000000
RG18 18 0 1000000000000
RG19 19 0 1000000000000
VS0 6 s0 0
R0 s0 16 68e0
VS1 12 s1 0
R1 s1 11 56e1
VS2 13 s2 0
I2 s2 17 DC 27e-2
VS3 0 s3 0
V3 e3 s3 DC 10e-1
RI3 e3 7 33e-2
VS4 17 s4 0
R4 s4 18 56e2
VS5 19 s5 0
R5 s5 15 82e-1
VS6 13 s6 0
R6 s6 0 12e-1
VS7 11 s7 0
R7 s7 9 56e1
VS8 18 s8 0
R8 s8 6 10e-1
VS9 13 s9 0
R9 s9 8 12e2
VS10 15 s10 0
I10 s10 9 DC 15e-3
VS11 19 s11 0
R11 s11 16 39e3
VS12 6 s12 0
R12 s12 4 47e-2
VS13 11 s13 0
I13 s13 12 DC 15e-2
VS14 10 s14 0
V14 e14 s14 DC 33e0
RI14 e14 17 56e-1
VS15 9 s15 0
V15 e15 s15 DC 68e1
RI15 e15 19 15e-3
VS16 2 s16 0
R16 s16 9 39e-1
VS17 0 s17 0
R17 s17 10 22e2
VS18 8 s18 0
I18 s18 13 DC 47e-3
VS19 14 s19 0
R19 s19 19 68e2
VS20 16 s20 0
I20 s20 14 DC 22e-3
VS21 4 s21 0
R21 s21 13 68e0
VS22 11 s22 0
I22 s22 6 DC 15e-3
VS23 18 s23 0
R23 s23 12 39e-2
VS24 4 s24 0
V24 e24 s24 DC 47e0
RI24 e24 15 12e-3
VS25 11 s25 0
R25 s25 10 68e-1
VS26 3 s26 0
R26 s26 9 56e-1
VS27 17 s27 0
V27 e27 s27 DC 47e-1
RI27 e27 0 82e-2
VS28 14 s28 0
R28 s28 8 68e1
VS29 18 s29 0
R29 s29 17 39e-1
VS30 8 s30 0
R30 s30 1 47e2
VS31 12 s31 0
R31 s31 15 15e2
VS32 5 s32 0
V32 e32 s32 DC 18e-1
RI32 e32 15 10e-1
VS33 7 s33 0
I33 s33 2 DC 68e-4
VS34 15 s34 0
R34 s34 2 39e-1
VS35 2 s35 0
R35 s35 3 27e0
.control
set numdgt=17
op
print v(1) v(2) v(3) v(4) v(5) v(6) v(7) v(8) v(9) v(10)
print v(11) v(12) v(13) v(14) v(15) v(16) v(17) v(18) v(19)
print i(vs0) i(vs1) i(vs2) i(vs3) i(vs4) i(vs5) i(vs6) i(vs7) i(vs8) i(vs9)
print i(vs10) i(vs11) i(vs12) i(vs13) i(vs14) i(vs15) i(vs16) i(vs17) i(vs18) i(vs19)
print i(vs20) i(vs21) i(vs22) i(vs23) i(vs24) i(vs25) i(vs26) i(vs27) i(vs28) i(vs29)
print i(vs30) i(vs31) i(vs32) i(vs33) i(vs34) i(vs35)
.endc
.end
