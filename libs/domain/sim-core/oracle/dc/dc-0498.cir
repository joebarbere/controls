controls oracle dc-0498
* Generated (plan F2.7, ADR 0012): do not edit; regenerate with `pnpm sim oracle regen`. dc seed 20261030 index 498 nodes 20 elements 39
.options sparse gmin=1e-12 noopac
RG1 1 0 1000000000000
RG2 2 0 1000000000000
RG3 3 0 1000000000000
RG4 4 0 1000000000000
RG5 5 0 1000000000000
RG6 6 0 1000000000000
RG7 7 0 1000000000000
RG8 8 0 1000000000000
RG9 9 0 1000000000000
RG10 10 0 1000000000000
RG11 11 0 1000000000000
RG12 12 0 1000000000000
RG13 13 0 1000000000000
RG14 14 0 1000000000000
RG15 15 0 1000000000000
RG16 16 0 1000000000000
RG17 17 0 1000000000000
RG18 18 0 1000000000000
RG19 19 0 1000000000000
VS0 0 s0 0
R0 s0 17 56e2
VS1 14 s1 0
R1 s1 8 68e1
VS2 12 s2 0
R2 s2 11 56e1
VS3 18 s3 0
R3 s3 10 22e2
VS4 13 s4 0
R4 s4 18 12e-1
VS5 7 s5 0
R5 s5 10 12e-2
VS6 15 s6 0
I6 s6 9 DC 15e-3
VS7 15 s7 0
R7 s7 2 39e-1
VS8 0 s8 0
V8 e8 s8 DC 47e-1
RI8 e8 18 82e-2
VS9 11 s9 0
I9 s9 6 DC 15e-3
VS10 19 s10 0
R10 s10 15 82e-1
VS11 11 s11 0
R11 s11 9 56e1
VS12 13 s12 0
I12 s12 0 DC 27e-2
VS13 13 s13 0
R13 s13 8 12e2
VS14 3 s14 0
R14 s14 9 56e-1
VS15 16 s15 0
I15 s15 14 DC 22e-3
VS16 17 s16 0
R16 s16 6 10e-1
VS17 11 s17 0
I17 s17 12 DC 15e-2
VS18 10 s18 0
V18 e18 s18 DC 33e0
RI18 e18 0 56e-1
VS19 12 s19 0
R19 s19 15 15e2
VS20 17 s20 0
R20 s20 0 39e-1
VS21 5 s21 0
V21 e21 s21 DC 18e-1
RI21 e21 15 10e-1
VS22 5 s22 0
R22 s22 9 47e1
VS23 17 s23 0
R23 s23 12 39e-2
VS24 11 s24 0
R24 s24 10 68e-1
VS25 13 s25 0
R25 s25 1 47e3
VS26 7 s26 0
I26 s26 2 DC 68e-4
VS27 18 s27 0
V27 e27 s27 DC 10e-1
RI27 e27 7 33e-2
VS28 6 s28 0
R28 s28 16 68e0
VS29 14 s29 0
R29 s29 19 68e2
VS30 19 s30 0
R30 s30 16 39e3
VS31 6 s31 0
R31 s31 4 47e-2
VS32 9 s32 0
V32 e32 s32 DC 68e1
RI32 e32 19 15e-3
VS33 8 s33 0
R33 s33 1 47e2
VS34 4 s34 0
R34 s34 13 68e0
VS35 4 s35 0
V35 e35 s35 DC 47e0
RI35 e35 15 12e-3
VS36 2 s36 0
R36 s36 3 27e0
VS37 2 s37 0
R37 s37 9 39e-1
VS38 8 s38 0
I38 s38 13 DC 47e-3
.control
set numdgt=17
op
print v(1) v(2) v(3) v(4) v(5) v(6) v(7) v(8) v(9) v(10)
print v(11) v(12) v(13) v(14) v(15) v(16) v(17) v(18) v(19)
print i(vs0) i(vs1) i(vs2) i(vs3) i(vs4) i(vs5) i(vs6) i(vs7) i(vs8) i(vs9)
print i(vs10) i(vs11) i(vs12) i(vs13) i(vs14) i(vs15) i(vs16) i(vs17) i(vs18) i(vs19)
print i(vs20) i(vs21) i(vs22) i(vs23) i(vs24) i(vs25) i(vs26) i(vs27) i(vs28) i(vs29)
print i(vs30) i(vs31) i(vs32) i(vs33) i(vs34) i(vs35) i(vs36) i(vs37) i(vs38)
.endc
.end
