controls oracle dc-0007
* Generated (plan F2.7, ADR 0012): do not edit; regenerate with `pnpm sim oracle regen`. dc seed 20261030 index 7 nodes 6 elements 10
.options sparse gmin=1e-12 noopac
RG1 1 0 1000000000000
RG2 2 0 1000000000000
RG3 3 0 1000000000000
RG4 4 0 1000000000000
RG5 5 0 1000000000000
VS0 0 s0 0
R0 s0 5 18e2
VS1 2 s1 0
R1 s1 5 33e3
VS2 5 s2 0
R2 s2 1 27e0
VS3 0 s3 0
R3 s3 3 15e1
VS4 2 s4 0
R4 s4 4 39e0
VS5 5 s5 0
R5 s5 1 15e2
VS6 5 s6 0
R6 s6 1 56e-1
VS7 1 s7 0
R7 s7 4 10e2
VS8 0 s8 0
V8 e8 s8 DC 27e-1
RI8 e8 3 68e-1
VS9 3 s9 0
V9 e9 s9 DC 33e-1
RI9 e9 4 27e-2
.control
set numdgt=17
op
print v(1) v(2) v(3) v(4) v(5)
print i(vs0) i(vs1) i(vs2) i(vs3) i(vs4) i(vs5) i(vs6) i(vs7) i(vs8) i(vs9)
.endc
.end
