controls oracle dc-0412
* Generated (plan F2.7, ADR 0012): do not edit; regenerate with `pnpm sim oracle regen`. dc seed 20261030 index 412 nodes 8 elements 13
.options sparse gmin=1e-12 noopac
RG1 1 0 1000000000000
RG2 2 0 1000000000000
RG3 3 0 1000000000000
RG4 4 0 1000000000000
RG5 5 0 1000000000000
RG6 6 0 1000000000000
RG7 7 0 1000000000000
VS0 0 s0 0
R0 s0 2 68e-2
VS1 0 s1 0
R1 s1 4 82e-1
VS2 0 s2 0
V2 e2 s2 DC 18e1
RI2 e2 7 22e-2
VS3 3 s3 0
V3 e3 s3 DC 12e1
RI3 e3 0 10e-1
VS4 0 s4 0
R4 s4 7 82e-1
VS5 0 s5 0
R5 s5 5 12e1
VS6 6 s6 0
R6 s6 2 33e-1
VS7 3 s7 0
R7 s7 0 47e-2
VS8 5 s8 0
I8 s8 2 DC 68e-2
VS9 1 s9 0
I9 s9 0 DC 56e-2
VS10 1 s10 0
R10 s10 0 27e-1
VS11 1 s11 0
R11 s11 5 33e2
VS12 3 s12 0
R12 s12 1 39e0
.control
set numdgt=17
op
print v(1) v(2) v(3) v(4) v(5) v(6) v(7)
print i(vs0) i(vs1) i(vs2) i(vs3) i(vs4) i(vs5) i(vs6) i(vs7) i(vs8) i(vs9)
print i(vs10) i(vs11) i(vs12)
.endc
.end
