controls oracle dc-0412
* Generated (plan F2.7, ADR 0012): do not edit; regenerate with `pnpm sim oracle regen`. dc seed 20261030 index 412 nodes 8 elements 16
.options sparse gmin=1e-12 noopac
RG1 1 0 1000000000000
RG2 2 0 1000000000000
RG3 3 0 1000000000000
RG4 4 0 1000000000000
RG5 5 0 1000000000000
RG6 6 0 1000000000000
RG7 7 0 1000000000000
VS0 3 s0 0
R0 s0 1 39e0
VS1 0 s1 0
V1 e1 s1 DC 27e0
RI1 e1 4 18e-2
VS2 0 s2 0
I2 s2 2 DC 68e-2
VS3 3 s3 0
V3 e3 s3 DC 12e1
RI3 e3 5 10e-1
VS4 5 s4 0
V4 e4 s4 DC 18e1
RI4 e4 7 22e-2
VS5 5 s5 0
R5 s5 2 68e-2
VS6 5 s6 0
R6 s6 7 82e-1
VS7 1 s7 0
V7 e7 s7 DC 27e-1
RI7 e7 7 39e-1
VS8 5 s8 0
R8 s8 4 82e-1
VS9 1 s9 0
R9 s9 5 27e-1
VS10 5 s10 0
R10 s10 0 12e1
VS11 3 s11 0
R11 s11 6 39e-1
VS12 1 s12 0
R12 s12 0 33e2
VS13 1 s13 0
I13 s13 5 DC 56e-2
VS14 6 s14 0
R14 s14 2 33e-1
VS15 3 s15 0
R15 s15 5 47e-2
.control
set numdgt=17
op
print v(1) v(2) v(3) v(4) v(5) v(6) v(7)
print i(vs0) i(vs1) i(vs2) i(vs3) i(vs4) i(vs5) i(vs6) i(vs7) i(vs8) i(vs9)
print i(vs10) i(vs11) i(vs12) i(vs13) i(vs14) i(vs15)
.endc
.end
