controls oracle dc-0365
* Generated (plan F2.7, ADR 0012): do not edit; regenerate with `pnpm sim oracle regen`. dc seed 20261030 index 365 nodes 3 elements 5
.options sparse gmin=1e-12 noopac
RG1 1 0 1000000000000
RG2 2 0 1000000000000
VS0 2 s0 0
R0 s0 1 39e3
VS1 0 s1 0
V1 e1 s1 DC 15e0
RI1 e1 2 22e-3
VS2 0 s2 0
R2 s2 2 82e-2
VS3 1 s3 0
R3 s3 2 33e1
VS4 1 s4 0
I4 s4 0 DC 56e-2
.control
set numdgt=17
op
print v(1) v(2)
print i(vs0) i(vs1) i(vs2) i(vs3) i(vs4)
.endc
.end
