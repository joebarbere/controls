controls oracle dc-0365
* Generated (plan F2.7, ADR 0012): do not edit; regenerate with `pnpm sim oracle regen`. dc seed 20261030 index 365 nodes 3 elements 6
.options sparse gmin=1e-12 noopac
RG1 1 0 1000000000000
RG2 2 0 1000000000000
VS0 1 s0 0
R0 s0 0 27e2
VS1 1 s1 0
I1 s1 0 DC 56e-2
VS2 2 s2 0
R2 s2 1 39e3
VS3 0 s3 0
V3 e3 s3 DC 15e0
RI3 e3 2 22e-3
VS4 0 s4 0
R4 s4 2 82e-2
VS5 1 s5 0
R5 s5 2 33e1
.control
set numdgt=17
op
print v(1) v(2)
print i(vs0) i(vs1) i(vs2) i(vs3) i(vs4) i(vs5)
.endc
.end
