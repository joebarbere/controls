controls oracle dc-0105
* Generated (plan F2.7, ADR 0012): do not edit; regenerate with `pnpm sim oracle regen`. dc seed 20261030 index 105 nodes 28 elements 34
.options sparse gmin=1e-12 noopac
RG1 1 0 1000000000000
RG2 2 0 1000000000000
RG3 3 0 1000000000000
RG4 4 0 1000000000000
RG5 5 0 1000000000000
RG6 6 0 1000000000000
RG7 7 0 1000000000000
RG8 8 0 1000000000000
RG9 9 0 1000000000000
RG10 10 0 1000000000000
RG11 11 0 1000000000000
RG12 12 0 1000000000000
RG13 13 0 1000000000000
RG14 14 0 1000000000000
RG15 15 0 1000000000000
RG16 16 0 1000000000000
RG17 17 0 1000000000000
RG18 18 0 1000000000000
RG19 19 0 1000000000000
RG20 20 0 1000000000000
RG21 21 0 1000000000000
RG22 22 0 1000000000000
RG23 23 0 1000000000000
RG24 24 0 1000000000000
RG25 25 0 1000000000000
RG26 26 0 1000000000000
RG27 27 0 1000000000000
VS0 11 s0 0
R0 s0 21 33e-2
VS1 2 s1 0
R1 s1 11 68e-2
VS2 0 s2 0
R2 s2 4 27e1
VS3 7 s3 0
R3 s3 23 47e1
VS4 0 s4 0
V4 e4 s4 DC 33e0
RI4 e4 8 82e-1
VS5 14 s5 0
R5 s5 22 27e-2
VS6 7 s6 0
R6 s6 17 56e-2
VS7 5 s7 0
R7 s7 8 10e0
VS8 0 s8 0
I8 s8 4 DC 39e-4
VS9 10 s9 0
R9 s9 12 39e0
VS10 8 s10 0
R10 s10 10 10e0
VS11 18 s11 0
V11 e11 s11 DC 18e0
RI11 e11 0 27e-3
VS12 12 s12 0
R12 s12 8 56e-2
VS13 13 s13 0
V13 e13 s13 DC 15e-1
RI13 e13 1 12e-1
VS14 8 s14 0
V14 e14 s14 DC 10e0
RI14 e14 17 15e-1
VS15 8 s15 0
R15 s15 3 47e0
VS16 2 s16 0
R16 s16 16 68e1
VS17 24 s17 0
R17 s17 10 18e-2
VS18 10 s18 0
R18 s18 11 10e-2
VS19 7 s19 0
R19 s19 27 39e2
VS20 20 s20 0
R20 s20 6 33e3
VS21 17 s21 0
R21 s21 14 39e0
VS22 25 s22 0
R22 s22 27 56e2
VS23 13 s23 0
R23 s23 25 22e0
VS24 3 s24 0
R24 s24 9 56e-1
VS25 26 s25 0
R25 s25 24 15e-1
VS26 9 s26 0
R26 s26 3 47e-2
VS27 15 s27 0
R27 s27 9 15e3
VS28 23 s28 0
R28 s28 22 56e3
VS29 21 s29 0
V29 e29 s29 DC 47e1
RI29 e29 17 22e-1
VS30 17 s30 0
V30 e30 s30 DC 47e-1
RI30 e30 10 22e-3
VS31 6 s31 0
R31 s31 0 33e3
VS32 19 s32 0
R32 s32 8 47e1
VS33 8 s33 0
R33 s33 13 56e0
.control
set numdgt=17
op
print v(1) v(2) v(3) v(4) v(5) v(6) v(7) v(8) v(9) v(10)
print v(11) v(12) v(13) v(14) v(15) v(16) v(17) v(18) v(19) v(20)
print v(21) v(22) v(23) v(24) v(25) v(26) v(27)
print i(vs0) i(vs1) i(vs2) i(vs3) i(vs4) i(vs5) i(vs6) i(vs7) i(vs8) i(vs9)
print i(vs10) i(vs11) i(vs12) i(vs13) i(vs14) i(vs15) i(vs16) i(vs17) i(vs18) i(vs19)
print i(vs20) i(vs21) i(vs22) i(vs23) i(vs24) i(vs25) i(vs26) i(vs27) i(vs28) i(vs29)
print i(vs30) i(vs31) i(vs32) i(vs33)
.endc
.end
