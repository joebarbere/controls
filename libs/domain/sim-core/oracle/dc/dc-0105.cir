controls oracle dc-0105
* Generated (plan F2.7, ADR 0012): do not edit; regenerate with `pnpm sim oracle regen`. dc seed 20261030 index 105 nodes 28 elements 41
.options sparse gmin=1e-12 noopac
RG1 1 0 1000000000000
RG2 2 0 1000000000000
RG3 3 0 1000000000000
RG4 4 0 1000000000000
RG5 5 0 1000000000000
RG6 6 0 1000000000000
RG7 7 0 1000000000000
RG8 8 0 1000000000000
RG9 9 0 1000000000000
RG10 10 0 1000000000000
RG11 11 0 1000000000000
RG12 12 0 1000000000000
RG13 13 0 1000000000000
RG14 14 0 1000000000000
RG15 15 0 1000000000000
RG16 16 0 1000000000000
RG17 17 0 1000000000000
RG18 18 0 1000000000000
RG19 19 0 1000000000000
RG20 20 0 1000000000000
RG21 21 0 1000000000000
RG22 22 0 1000000000000
RG23 23 0 1000000000000
RG24 24 0 1000000000000
RG25 25 0 1000000000000
RG26 26 0 1000000000000
RG27 27 0 1000000000000
VS0 11 s0 0
R0 s0 21 33e-2
VS1 0 s1 0
V1 e1 s1 DC 27e0
RI1 e1 15 56e-3
VS2 25 s2 0
R2 s2 27 56e2
VS3 5 s3 0
R3 s3 11 27e-1
VS4 14 s4 0
R4 s4 22 27e-2
VS5 13 s5 0
R5 s5 25 22e0
VS6 23 s6 0
R6 s6 13 56e0
VS7 15 s7 0
R7 s7 9 15e3
VS8 9 s8 0
R8 s8 3 47e-2
VS9 13 s9 0
V9 e9 s9 DC 15e-1
RI9 e9 1 12e-1
VS10 17 s10 0
V10 e10 s10 DC 47e-1
RI10 e10 10 22e-3
VS11 2 s11 0
R11 s11 16 68e1
VS12 8 s12 0
R12 s12 4 27e1
VS13 4 s13 0
R13 s13 11 10e0
VS14 7 s14 0
R14 s14 17 56e-2
VS15 12 s15 0
R15 s15 23 56e-2
VS16 23 s16 0
R16 s16 10 10e0
VS17 7 s17 0
R17 s17 27 39e2
VS18 10 s18 0
R18 s18 12 39e0
VS19 26 s19 0
R19 s19 24 15e-1
VS20 20 s20 0
V20 e20 s20 DC 56e-1
RI20 e20 17 82e-3
VS21 19 s21 0
R21 s21 23 47e1
VS22 21 s22 0
V22 e22 s22 DC 47e1
RI22 e22 17 22e-1
VS23 10 s23 0
R23 s23 11 10e-2
VS24 7 s24 0
R24 s24 0 47e1
VS25 1 s25 0
R25 s25 19 82e-2
VS26 23 s26 0
V26 e26 s26 DC 10e0
RI26 e26 17 15e-1
VS27 2 s27 0
R27 s27 11 68e-2
VS28 6 s28 0
R28 s28 8 33e3
VS29 17 s29 0
R29 s29 14 39e0
VS30 18 s30 0
V30 e30 s30 DC 18e0
RI30 e30 8 27e-3
VS31 3 s31 0
R31 s31 9 56e-1
VS32 23 s32 0
R32 s32 3 47e0
VS33 26 s33 0
R33 s33 18 68e-2
VS34 24 s34 0
R34 s34 10 18e-2
VS35 20 s35 0
R35 s35 6 33e3
VS36 5 s36 0
R36 s36 23 10e0
VS37 8 s37 0
V37 e37 s37 DC 33e0
RI37 e37 23 82e-1
VS38 0 s38 0
R38 s38 22 56e3
VS39 8 s39 0
I39 s39 4 DC 39e-4
VS40 16 s40 0
R40 s40 27 39e3
.control
set numdgt=17
op
print v(1) v(2) v(3) v(4) v(5) v(6) v(7) v(8) v(9) v(10)
print v(11) v(12) v(13) v(14) v(15) v(16) v(17) v(18) v(19) v(20)
print v(21) v(22) v(23) v(24) v(25) v(26) v(27)
print i(vs0) i(vs1) i(vs2) i(vs3) i(vs4) i(vs5) i(vs6) i(vs7) i(vs8) i(vs9)
print i(vs10) i(vs11) i(vs12) i(vs13) i(vs14) i(vs15) i(vs16) i(vs17) i(vs18) i(vs19)
print i(vs20) i(vs21) i(vs22) i(vs23) i(vs24) i(vs25) i(vs26) i(vs27) i(vs28) i(vs29)
print i(vs30) i(vs31) i(vs32) i(vs33) i(vs34) i(vs35) i(vs36) i(vs37) i(vs38) i(vs39)
print i(vs40)
.endc
.end
