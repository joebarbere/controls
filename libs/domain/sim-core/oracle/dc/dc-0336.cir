controls oracle dc-0336
* Generated (plan F2.7, ADR 0012): do not edit; regenerate with `pnpm sim oracle regen`. dc seed 20261030 index 336 nodes 9 elements 14
.options sparse gmin=1e-12 noopac
RG1 1 0 1000000000000
RG2 2 0 1000000000000
RG3 3 0 1000000000000
RG4 4 0 1000000000000
RG5 5 0 1000000000000
RG6 6 0 1000000000000
RG7 7 0 1000000000000
RG8 8 0 1000000000000
VS0 6 s0 0
R0 s0 2 15e-1
VS1 8 s1 0
R1 s1 1 12e-1
VS2 0 s2 0
V2 e2 s2 DC 10e1
RI2 e2 6 12e-1
VS3 2 s3 0
R3 s3 4 15e3
VS4 4 s4 0
I4 s4 0 DC 47e-4
VS5 3 s5 0
V5 e5 s5 DC 82e0
RI5 e5 0 15e-3
VS6 4 s6 0
R6 s6 0 39e-2
VS7 5 s7 0
R7 s7 7 18e-1
VS8 5 s8 0
V8 e8 s8 DC 18e1
RI8 e8 2 27e-1
VS9 1 s9 0
R9 s9 3 27e3
VS10 2 s10 0
R10 s10 8 15e3
VS11 7 s11 0
I11 s11 4 DC 12e-3
VS12 3 s12 0
R12 s12 6 27e1
VS13 8 s13 0
R13 s13 3 39e3
.control
set numdgt=17
op
print v(1) v(2) v(3) v(4) v(5) v(6) v(7) v(8)
print i(vs0) i(vs1) i(vs2) i(vs3) i(vs4) i(vs5) i(vs6) i(vs7) i(vs8) i(vs9)
print i(vs10) i(vs11) i(vs12) i(vs13)
.endc
.end
