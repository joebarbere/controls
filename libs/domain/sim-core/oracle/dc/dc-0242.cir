controls oracle dc-0242
* Generated (plan F2.7, ADR 0012): do not edit; regenerate with `pnpm sim oracle regen`. dc seed 20261030 index 242 nodes 10 elements 10
.options sparse gmin=1e-12 noopac
RG1 1 0 1000000000000
RG2 2 0 1000000000000
RG3 3 0 1000000000000
RG4 4 0 1000000000000
RG5 5 0 1000000000000
RG6 6 0 1000000000000
RG7 7 0 1000000000000
RG8 8 0 1000000000000
RG9 9 0 1000000000000
VS0 0 s0 0
V0 e0 s0 DC 10e1
RI0 e0 4 12e-1
VS1 3 s1 0
R1 s1 0 22e1
VS2 8 s2 0
R2 s2 6 22e-2
VS3 9 s3 0
R3 s3 4 82e0
VS4 6 s4 0
R4 s4 5 39e1
VS5 4 s5 0
V5 e5 s5 DC 82e1
RI5 e5 7 22e-1
VS6 3 s6 0
R6 s6 7 18e0
VS7 4 s7 0
R7 s7 6 56e1
VS8 7 s8 0
R8 s8 2 22e-2
VS9 1 s9 0
V9 e9 s9 DC 82e1
RI9 e9 8 12e-1
.control
set numdgt=17
op
print v(1) v(2) v(3) v(4) v(5) v(6) v(7) v(8) v(9)
print i(vs0) i(vs1) i(vs2) i(vs3) i(vs4) i(vs5) i(vs6) i(vs7) i(vs8) i(vs9)
.endc
.end
