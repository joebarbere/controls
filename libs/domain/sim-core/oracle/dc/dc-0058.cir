controls oracle dc-0058
* Generated (plan F2.7, ADR 0012): do not edit; regenerate with `pnpm sim oracle regen`. dc seed 20261030 index 58 nodes 25 elements 40
.options sparse gmin=1e-12 noopac
RG1 1 0 1000000000000
RG2 2 0 1000000000000
RG3 3 0 1000000000000
RG4 4 0 1000000000000
RG5 5 0 1000000000000
RG6 6 0 1000000000000
RG7 7 0 1000000000000
RG8 8 0 1000000000000
RG9 9 0 1000000000000
RG10 10 0 1000000000000
RG11 11 0 1000000000000
RG12 12 0 1000000000000
RG13 13 0 1000000000000
RG14 14 0 1000000000000
RG15 15 0 1000000000000
RG16 16 0 1000000000000
RG17 17 0 1000000000000
RG18 18 0 1000000000000
RG19 19 0 1000000000000
RG20 20 0 1000000000000
RG21 21 0 1000000000000
RG22 22 0 1000000000000
RG23 23 0 1000000000000
RG24 24 0 1000000000000
VS0 0 s0 0
R0 s0 22 15e2
VS1 8 s1 0
R1 s1 7 82e3
VS2 15 s2 0
R2 s2 13 82e3
VS3 19 s3 0
R3 s3 3 47e2
VS4 2 s4 0
R4 s4 10 56e0
VS5 14 s5 0
R5 s5 1 18e1
VS6 1 s6 0
R6 s6 12 12e0
VS7 0 s7 0
V7 e7 s7 DC 18e-1
RI7 e7 5 18e-2
VS8 12 s8 0
I8 s8 4 DC 82e-4
VS9 17 s9 0
R9 s9 15 56e1
VS10 14 s10 0
V10 e10 s10 DC 33e-1
RI10 e10 22 82e-1
VS11 10 s11 0
I11 s11 11 DC 18e-4
VS12 14 s12 0
R12 s12 21 56e2
VS13 8 s13 0
R13 s13 23 68e1
VS14 18 s14 0
V14 e14 s14 DC 18e-1
RI14 e14 1 39e-1
VS15 10 s15 0
R15 s15 20 82e2
VS16 1 s16 0
R16 s16 2 15e-2
VS17 14 s17 0
I17 s17 19 DC 47e-3
VS18 24 s18 0
R18 s18 6 22e3
VS19 3 s19 0
R19 s19 23 56e-1
VS20 6 s20 0
R20 s20 12 56e-1
VS21 11 s21 0
R21 s21 21 47e3
VS22 3 s22 0
V22 e22 s22 DC 56e0
RI22 e22 24 68e-1
VS23 7 s23 0
I23 s23 8 DC 10e-2
VS24 21 s24 0
R24 s24 5 27e-1
VS25 2 s25 0
R25 s25 0 47e3
VS26 13 s26 0
V26 e26 s26 DC 10e0
RI26 e26 11 10e-2
VS27 9 s27 0
R27 s27 0 12e2
VS28 12 s28 0
R28 s28 3 10e-1
VS29 21 s29 0
R29 s29 7 56e2
VS30 19 s30 0
R30 s30 14 47e1
VS31 16 s31 0
V31 e31 s31 DC 15e1
RI31 e31 0 56e-3
VS32 18 s32 0
R32 s32 17 27e3
VS33 13 s33 0
R33 s33 16 82e1
VS34 4 s34 0
R34 s34 12 18e2
VS35 17 s35 0
R35 s35 22 39e2
VS36 4 s36 0
V36 e36 s36 DC 27e0
RI36 e36 3 47e-3
VS37 9 s37 0
R37 s37 17 56e2
VS38 20 s38 0
R38 s38 21 68e-2
VS39 0 s39 0
R39 s39 10 56e1
.control
set numdgt=17
op
print v(1) v(2) v(3) v(4) v(5) v(6) v(7) v(8) v(9) v(10)
print v(11) v(12) v(13) v(14) v(15) v(16) v(17) v(18) v(19) v(20)
print v(21) v(22) v(23) v(24)
print i(vs0) i(vs1) i(vs2) i(vs3) i(vs4) i(vs5) i(vs6) i(vs7) i(vs8) i(vs9)
print i(vs10) i(vs11) i(vs12) i(vs13) i(vs14) i(vs15) i(vs16) i(vs17) i(vs18) i(vs19)
print i(vs20) i(vs21) i(vs22) i(vs23) i(vs24) i(vs25) i(vs26) i(vs27) i(vs28) i(vs29)
print i(vs30) i(vs31) i(vs32) i(vs33) i(vs34) i(vs35) i(vs36) i(vs37) i(vs38) i(vs39)
.endc
.end
