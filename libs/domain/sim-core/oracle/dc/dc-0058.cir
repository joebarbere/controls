controls oracle dc-0058
* Generated (plan F2.7, ADR 0012): do not edit; regenerate with `pnpm sim oracle regen`. dc seed 20261030 index 58 nodes 25 elements 33
.options sparse gmin=1e-12 noopac
RG1 1 0 1000000000000
RG2 2 0 1000000000000
RG3 3 0 1000000000000
RG4 4 0 1000000000000
RG5 5 0 1000000000000
RG6 6 0 1000000000000
RG7 7 0 1000000000000
RG8 8 0 1000000000000
RG9 9 0 1000000000000
RG10 10 0 1000000000000
RG11 11 0 1000000000000
RG12 12 0 1000000000000
RG13 13 0 1000000000000
RG14 14 0 1000000000000
RG15 15 0 1000000000000
RG16 16 0 1000000000000
RG17 17 0 1000000000000
RG18 18 0 1000000000000
RG19 19 0 1000000000000
RG20 20 0 1000000000000
RG21 21 0 1000000000000
RG22 22 0 1000000000000
RG23 23 0 1000000000000
RG24 24 0 1000000000000
VS0 24 s0 0
R0 s0 6 22e3
VS1 12 s1 0
I1 s1 4 DC 82e-4
VS2 10 s2 0
I2 s2 11 DC 18e-4
VS3 16 s3 0
R3 s3 22 39e2
VS4 14 s4 0
I4 s4 19 DC 47e-3
VS5 17 s5 0
R5 s5 10 56e1
VS6 14 s6 0
R6 s6 21 56e2
VS7 20 s7 0
R7 s7 21 68e-2
VS8 0 s8 0
V8 e8 s8 DC 15e1
RI8 e8 17 56e-3
VS9 17 s9 0
R9 s9 22 15e2
VS10 14 s10 0
V10 e10 s10 DC 33e-1
RI10 e10 22 82e-1
VS11 19 s11 0
R11 s11 14 47e1
VS12 13 s12 0
V12 e12 s12 DC 10e0
RI12 e12 11 10e-2
VS13 9 s13 0
R13 s13 16 56e2
VS14 2 s14 0
R14 s14 17 47e3
VS15 2 s15 0
R15 s15 10 56e0
VS16 16 s16 0
R16 s16 15 56e1
VS17 1 s17 0
R17 s17 12 12e0
VS18 15 s18 0
R18 s18 13 82e3
VS19 12 s19 0
R19 s19 3 10e-1
VS20 18 s20 0
R20 s20 16 27e3
VS21 8 s21 0
R21 s21 7 82e3
VS22 9 s22 0
R22 s22 17 12e2
VS23 17 s23 0
V23 e23 s23 DC 18e-1
RI23 e23 5 18e-2
VS24 6 s24 0
R24 s24 12 56e-1
VS25 4 s25 0
R25 s25 12 18e2
VS26 21 s26 0
R26 s26 7 56e2
VS27 14 s27 0
R27 s27 1 18e1
VS28 18 s28 0
V28 e28 s28 DC 18e-1
RI28 e28 1 39e-1
VS29 19 s29 0
R29 s29 3 47e2
VS30 3 s30 0
R30 s30 23 56e-1
VS31 7 s31 0
I31 s31 8 DC 10e-2
VS32 1 s32 0
R32 s32 2 15e-2
.control
set numdgt=17
op
print v(1) v(2) v(3) v(4) v(5) v(6) v(7) v(8) v(9) v(10)
print v(11) v(12) v(13) v(14) v(15) v(16) v(17) v(18) v(19) v(20)
print v(21) v(22) v(23) v(24)
print i(vs0) i(vs1) i(vs2) i(vs3) i(vs4) i(vs5) i(vs6) i(vs7) i(vs8) i(vs9)
print i(vs10) i(vs11) i(vs12) i(vs13) i(vs14) i(vs15) i(vs16) i(vs17) i(vs18) i(vs19)
print i(vs20) i(vs21) i(vs22) i(vs23) i(vs24) i(vs25) i(vs26) i(vs27) i(vs28) i(vs29)
print i(vs30) i(vs31) i(vs32)
.endc
.end
