controls oracle dc-0119
* Generated (plan F2.7, ADR 0012): do not edit; regenerate with `pnpm sim oracle regen`. dc seed 20261030 index 119 nodes 20 elements 31
.options sparse gmin=1e-12 noopac
RG1 1 0 1000000000000
RG2 2 0 1000000000000
RG3 3 0 1000000000000
RG4 4 0 1000000000000
RG5 5 0 1000000000000
RG6 6 0 1000000000000
RG7 7 0 1000000000000
RG8 8 0 1000000000000
RG9 9 0 1000000000000
RG10 10 0 1000000000000
RG11 11 0 1000000000000
RG12 12 0 1000000000000
RG13 13 0 1000000000000
RG14 14 0 1000000000000
RG15 15 0 1000000000000
RG16 16 0 1000000000000
RG17 17 0 1000000000000
RG18 18 0 1000000000000
RG19 19 0 1000000000000
VS0 18 s0 0
R0 s0 5 10e0
VS1 6 s1 0
R1 s1 18 39e0
VS2 14 s2 0
R2 s2 10 15e-2
VS3 5 s3 0
R3 s3 1 68e3
VS4 14 s4 0
R4 s4 1 33e0
VS5 2 s5 0
R5 s5 14 10e-2
VS6 7 s6 0
R6 s6 13 33e3
VS7 5 s7 0
R7 s7 18 56e3
VS8 9 s8 0
R8 s8 12 18e-2
VS9 19 s9 0
R9 s9 17 27e3
VS10 3 s10 0
R10 s10 0 27e-1
VS11 14 s11 0
R11 s11 11 68e-1
VS12 3 s12 0
R12 s12 13 39e0
VS13 2 s13 0
R13 s13 4 68e0
VS14 14 s14 0
R14 s14 13 12e-1
VS15 19 s15 0
R15 s15 11 47e-2
VS16 15 s16 0
R16 s16 4 12e1
VS17 5 s17 0
R17 s17 9 47e3
VS18 1 s18 0
R18 s18 7 33e2
VS19 16 s19 0
R19 s19 19 33e-1
VS20 10 s20 0
R20 s20 8 56e-2
VS21 8 s21 0
R21 s21 12 27e3
VS22 0 s22 0
V22 e22 s22 DC 22e1
RI22 e22 15 12e-1
VS23 5 s23 0
V23 e23 s23 DC 82e-1
RI23 e23 0 47e-2
VS24 12 s24 0
V24 e24 s24 DC 39e-1
RI24 e24 7 33e-2
VS25 19 s25 0
R25 s25 9 15e3
VS26 9 s26 0
V26 e26 s26 DC 39e1
RI26 e26 10 22e-2
VS27 17 s27 0
R27 s27 5 33e3
VS28 13 s28 0
R28 s28 6 18e-2
VS29 18 s29 0
R29 s29 16 10e2
VS30 19 s30 0
R30 s30 18 27e3
.control
set numdgt=17
op
print v(1) v(2) v(3) v(4) v(5) v(6) v(7) v(8) v(9) v(10)
print v(11) v(12) v(13) v(14) v(15) v(16) v(17) v(18) v(19)
print i(vs0) i(vs1) i(vs2) i(vs3) i(vs4) i(vs5) i(vs6) i(vs7) i(vs8) i(vs9)
print i(vs10) i(vs11) i(vs12) i(vs13) i(vs14) i(vs15) i(vs16) i(vs17) i(vs18) i(vs19)
print i(vs20) i(vs21) i(vs22) i(vs23) i(vs24) i(vs25) i(vs26) i(vs27) i(vs28) i(vs29)
print i(vs30)
.endc
.end
