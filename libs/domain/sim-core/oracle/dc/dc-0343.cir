controls oracle dc-0343
* Generated (plan F2.7, ADR 0012): do not edit; regenerate with `pnpm sim oracle regen`. dc seed 20261030 index 343 nodes 25 elements 47
.options sparse gmin=1e-12 noopac
RG1 1 0 1000000000000
RG2 2 0 1000000000000
RG3 3 0 1000000000000
RG4 4 0 1000000000000
RG5 5 0 1000000000000
RG6 6 0 1000000000000
RG7 7 0 1000000000000
RG8 8 0 1000000000000
RG9 9 0 1000000000000
RG10 10 0 1000000000000
RG11 11 0 1000000000000
RG12 12 0 1000000000000
RG13 13 0 1000000000000
RG14 14 0 1000000000000
RG15 15 0 1000000000000
RG16 16 0 1000000000000
RG17 17 0 1000000000000
RG18 18 0 1000000000000
RG19 19 0 1000000000000
RG20 20 0 1000000000000
RG21 21 0 1000000000000
RG22 22 0 1000000000000
RG23 23 0 1000000000000
RG24 24 0 1000000000000
VS0 19 s0 0
R0 s0 22 47e3
VS1 21 s1 0
R1 s1 6 27e-2
VS2 12 s2 0
R2 s2 13 12e3
VS3 9 s3 0
R3 s3 15 68e1
VS4 20 s4 0
R4 s4 13 68e3
VS5 20 s5 0
R5 s5 6 56e-1
VS6 22 s6 0
R6 s6 18 10e-2
VS7 18 s7 0
R7 s7 13 47e3
VS8 20 s8 0
R8 s8 2 27e2
VS9 18 s9 0
R9 s9 23 18e-2
VS10 23 s10 0
R10 s10 15 18e2
VS11 16 s11 0
I11 s11 24 DC 82e-3
VS12 0 s12 0
V12 e12 s12 DC 82e0
RI12 e12 9 47e-1
VS13 24 s13 0
R13 s13 18 68e1
VS14 6 s14 0
R14 s14 3 47e2
VS15 3 s15 0
R15 s15 9 68e3
VS16 1 s16 0
R16 s16 2 22e-2
VS17 2 s17 0
R17 s17 12 18e2
VS18 15 s18 0
R18 s18 3 33e0
VS19 1 s19 0
V19 e19 s19 DC 56e1
RI19 e19 21 15e-1
VS20 14 s20 0
R20 s20 13 18e3
VS21 9 s21 0
I21 s21 16 DC 27e-2
VS22 6 s22 0
V22 e22 s22 DC 47e0
RI22 e22 9 68e-3
VS23 19 s23 0
R23 s23 23 18e0
VS24 10 s24 0
R24 s24 2 27e-1
VS25 21 s25 0
R25 s25 4 82e-2
VS26 2 s26 0
R26 s26 5 27e-2
VS27 10 s27 0
R27 s27 17 47e2
VS28 8 s28 0
I28 s28 6 DC 47e-2
VS29 0 s29 0
V29 e29 s29 DC 68e0
RI29 e29 12 39e-1
VS30 18 s30 0
R30 s30 0 39e-2
VS31 17 s31 0
R31 s31 23 15e-2
VS32 6 s32 0
V32 e32 s32 DC 39e-1
RI32 e32 16 47e-2
VS33 8 s33 0
I33 s33 19 DC 10e-4
VS34 17 s34 0
R34 s34 5 47e-2
VS35 12 s35 0
V35 e35 s35 DC 68e1
RI35 e35 19 68e-1
VS36 7 s36 0
V36 e36 s36 DC 18e1
RI36 e36 9 27e-2
VS37 8 s37 0
V37 e37 s37 DC 18e0
RI37 e37 13 10e-1
VS38 8 s38 0
I38 s38 7 DC 39e-1
VS39 15 s39 0
R39 s39 11 22e0
VS40 1 s40 0
R40 s40 23 18e1
VS41 9 s41 0
V41 e41 s41 DC 82e-1
RI41 e41 11 68e-1
VS42 6 s42 0
R42 s42 19 82e3
VS43 24 s43 0
I43 s43 11 DC 56e-4
VS44 11 s44 0
I44 s44 18 DC 68e-3
VS45 18 s45 0
R45 s45 21 82e3
VS46 23 s46 0
R46 s46 12 33e1
.control
set numdgt=17
op
print v(1) v(2) v(3) v(4) v(5) v(6) v(7) v(8) v(9) v(10)
print v(11) v(12) v(13) v(14) v(15) v(16) v(17) v(18) v(19) v(20)
print v(21) v(22) v(23) v(24)
print i(vs0) i(vs1) i(vs2) i(vs3) i(vs4) i(vs5) i(vs6) i(vs7) i(vs8) i(vs9)
print i(vs10) i(vs11) i(vs12) i(vs13) i(vs14) i(vs15) i(vs16) i(vs17) i(vs18) i(vs19)
print i(vs20) i(vs21) i(vs22) i(vs23) i(vs24) i(vs25) i(vs26) i(vs27) i(vs28) i(vs29)
print i(vs30) i(vs31) i(vs32) i(vs33) i(vs34) i(vs35) i(vs36) i(vs37) i(vs38) i(vs39)
print i(vs40) i(vs41) i(vs42) i(vs43) i(vs44) i(vs45) i(vs46)
.endc
.end
