controls oracle dc-0343
* Generated (plan F2.7, ADR 0012): do not edit; regenerate with `pnpm sim oracle regen`. dc seed 20261030 index 343 nodes 25 elements 53
.options sparse gmin=1e-12 noopac
RG1 1 0 1000000000000
RG2 2 0 1000000000000
RG3 3 0 1000000000000
RG4 4 0 1000000000000
RG5 5 0 1000000000000
RG6 6 0 1000000000000
RG7 7 0 1000000000000
RG8 8 0 1000000000000
RG9 9 0 1000000000000
RG10 10 0 1000000000000
RG11 11 0 1000000000000
RG12 12 0 1000000000000
RG13 13 0 1000000000000
RG14 14 0 1000000000000
RG15 15 0 1000000000000
RG16 16 0 1000000000000
RG17 17 0 1000000000000
RG18 18 0 1000000000000
RG19 19 0 1000000000000
RG20 20 0 1000000000000
RG21 21 0 1000000000000
RG22 22 0 1000000000000
RG23 23 0 1000000000000
RG24 24 0 1000000000000
VS0 6 s0 0
R0 s0 18 39e-2
VS1 6 s1 0
R1 s1 13 47e3
VS2 1 s2 0
R2 s2 2 22e-2
VS3 10 s3 0
R3 s3 2 27e-1
VS4 20 s4 0
R4 s4 2 27e2
VS5 6 s5 0
R5 s5 23 18e-2
VS6 20 s6 0
R6 s6 0 56e-1
VS7 6 s7 0
R7 s7 21 82e3
VS8 4 s8 0
R8 s8 18 10e0
VS9 0 s9 0
V9 e9 s9 DC 47e0
RI9 e9 9 68e-3
VS10 12 s10 0
V10 e10 s10 DC 68e1
RI10 e10 19 68e-1
VS11 2 s11 0
R11 s11 5 27e-2
VS12 17 s12 0
R12 s12 23 15e-2
VS13 18 s13 0
V13 e13 s13 DC 68e0
RI13 e13 12 39e-1
VS14 15 s14 0
R14 s14 11 22e0
VS15 21 s15 0
R15 s15 4 82e-2
VS16 3 s16 0
R16 s16 9 68e3
VS17 7 s17 0
R17 s17 13 56e0
VS18 12 s18 0
R18 s18 13 12e3
VS19 11 s19 0
I19 s19 6 DC 68e-3
VS20 15 s20 0
R20 s20 3 33e0
VS21 9 s21 0
V21 e21 s21 DC 82e-1
RI21 e21 11 68e-1
VS22 10 s22 0
R22 s22 17 47e2
VS23 9 s23 0
R23 s23 15 68e1
VS24 20 s24 0
R24 s24 13 68e3
VS25 9 s25 0
I25 s25 16 DC 27e-2
VS26 8 s26 0
V26 e26 s26 DC 18e0
RI26 e26 13 10e-1
VS27 18 s27 0
V27 e27 s27 DC 82e0
RI27 e27 9 47e-1
VS28 19 s28 0
R28 s28 22 47e3
VS29 23 s29 0
R29 s29 15 18e2
VS30 1 s30 0
V30 e30 s30 DC 56e1
RI30 e30 21 15e-1
VS31 0 s31 0
R31 s31 3 47e2
VS32 16 s32 0
R32 s32 9 15e2
VS33 0 s33 0
V33 e33 s33 DC 39e-1
RI33 e33 16 47e-2
VS34 8 s34 0
I34 s34 19 DC 10e-4
VS35 8 s35 0
I35 s35 7 DC 39e-1
VS36 11 s36 0
R36 s36 24 47e2
VS37 14 s37 0
R37 s37 2 10e2
VS38 14 s38 0
R38 s38 13 18e3
VS39 17 s39 0
R39 s39 5 47e-2
VS40 19 s40 0
R40 s40 23 18e0
VS41 8 s41 0
I41 s41 0 DC 47e-2
VS42 0 s42 0
R42 s42 19 82e3
VS43 21 s43 0
R43 s43 0 27e-2
VS44 23 s44 0
R44 s44 12 33e1
VS45 16 s45 0
I45 s45 24 DC 82e-3
VS46 24 s46 0
R46 s46 6 68e1
VS47 7 s47 0
V47 e47 s47 DC 18e1
RI47 e47 9 27e-2
VS48 2 s48 0
R48 s48 12 18e2
VS49 24 s49 0
I49 s49 11 DC 56e-4
VS50 1 s50 0
R50 s50 23 18e1
VS51 9 s51 0
R51 s51 8 22e-2
VS52 22 s52 0
R52 s52 6 10e-2
.control
set numdgt=17
op
print v(1) v(2) v(3) v(4) v(5) v(6) v(7) v(8) v(9) v(10)
print v(11) v(12) v(13) v(14) v(15) v(16) v(17) v(18) v(19) v(20)
print v(21) v(22) v(23) v(24)
print i(vs0) i(vs1) i(vs2) i(vs3) i(vs4) i(vs5) i(vs6) i(vs7) i(vs8) i(vs9)
print i(vs10) i(vs11) i(vs12) i(vs13) i(vs14) i(vs15) i(vs16) i(vs17) i(vs18) i(vs19)
print i(vs20) i(vs21) i(vs22) i(vs23) i(vs24) i(vs25) i(vs26) i(vs27) i(vs28) i(vs29)
print i(vs30) i(vs31) i(vs32) i(vs33) i(vs34) i(vs35) i(vs36) i(vs37) i(vs38) i(vs39)
print i(vs40) i(vs41) i(vs42) i(vs43) i(vs44) i(vs45) i(vs46) i(vs47) i(vs48) i(vs49)
print i(vs50) i(vs51) i(vs52)
.endc
.end
