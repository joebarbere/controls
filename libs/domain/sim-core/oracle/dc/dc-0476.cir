controls oracle dc-0476
* Generated (plan F2.7, ADR 0012): do not edit; regenerate with `pnpm sim oracle regen`. dc seed 20261030 index 476 nodes 11 elements 12
.options sparse gmin=1e-12 noopac
RG1 1 0 1000000000000
RG2 2 0 1000000000000
RG3 3 0 1000000000000
RG4 4 0 1000000000000
RG5 5 0 1000000000000
RG6 6 0 1000000000000
RG7 7 0 1000000000000
RG8 8 0 1000000000000
RG9 9 0 1000000000000
RG10 10 0 1000000000000
VS0 7 s0 0
I0 s0 10 DC 68e-3
VS1 7 s1 0
R1 s1 10 56e0
VS2 6 s2 0
R2 s2 0 33e1
VS3 8 s3 0
R3 s3 10 82e-2
VS4 7 s4 0
R4 s4 5 27e3
VS5 9 s5 0
R5 s5 2 15e-2
VS6 0 s6 0
V6 e6 s6 DC 56e1
RI6 e6 10 27e-2
VS7 9 s7 0
V7 e7 s7 DC 56e-1
RI7 e7 6 47e-3
VS8 1 s8 0
R8 s8 2 39e3
VS9 7 s9 0
R9 s9 5 39e2
VS10 4 s10 0
R10 s10 6 33e-1
VS11 3 s11 0
R11 s11 2 27e3
.control
set numdgt=17
op
print v(1) v(2) v(3) v(4) v(5) v(6) v(7) v(8) v(9) v(10)
print i(vs0) i(vs1) i(vs2) i(vs3) i(vs4) i(vs5) i(vs6) i(vs7) i(vs8) i(vs9)
print i(vs10) i(vs11)
.endc
.end
