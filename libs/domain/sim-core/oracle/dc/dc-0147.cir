controls oracle dc-0147
* Generated (plan F2.7, ADR 0012): do not edit; regenerate with `pnpm sim oracle regen`. dc seed 20261030 index 147 nodes 3 elements 4
.options sparse gmin=1e-12 noopac
RG1 1 0 1000000000000
RG2 2 0 1000000000000
VS0 2 s0 0
R0 s0 0 18e0
VS1 1 s1 0
R1 s1 0 10e1
VS2 1 s2 0
R2 s2 2 12e3
VS3 0 s3 0
V3 e3 s3 DC 27e1
RI3 e3 2 82e-2
.control
set numdgt=17
op
print v(1) v(2)
print i(vs0) i(vs1) i(vs2) i(vs3)
.endc
.end
