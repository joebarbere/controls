controls oracle dc-0448
* Generated (plan F2.7, ADR 0012): do not edit; regenerate with `pnpm sim oracle regen`. dc seed 20261030 index 448 nodes 27 elements 40
.options sparse gmin=1e-12 noopac
RG1 1 0 1000000000000
RG2 2 0 1000000000000
RG3 3 0 1000000000000
RG4 4 0 1000000000000
RG5 5 0 1000000000000
RG6 6 0 1000000000000
RG7 7 0 1000000000000
RG8 8 0 1000000000000
RG9 9 0 1000000000000
RG10 10 0 1000000000000
RG11 11 0 1000000000000
RG12 12 0 1000000000000
RG13 13 0 1000000000000
RG14 14 0 1000000000000
RG15 15 0 1000000000000
RG16 16 0 1000000000000
RG17 17 0 1000000000000
RG18 18 0 1000000000000
RG19 19 0 1000000000000
RG20 20 0 1000000000000
RG21 21 0 1000000000000
RG22 22 0 1000000000000
RG23 23 0 1000000000000
RG24 24 0 1000000000000
RG25 25 0 1000000000000
RG26 26 0 1000000000000
VS0 15 s0 0
R0 s0 2 15e3
VS1 16 s1 0
R1 s1 9 15e0
VS2 1 s2 0
R2 s2 14 15e3
VS3 12 s3 0
R3 s3 21 82e-1
VS4 15 s4 0
R4 s4 11 39e1
VS5 13 s5 0
R5 s5 16 12e1
VS6 25 s6 0
R6 s6 26 68e2
VS7 22 s7 0
R7 s7 18 18e1
VS8 4 s8 0
R8 s8 0 33e-1
VS9 0 s9 0
V9 e9 s9 DC 18e0
RI9 e9 13 22e-2
VS10 22 s10 0
R10 s10 3 56e3
VS11 20 s11 0
R11 s11 1 56e3
VS12 15 s12 0
V12 e12 s12 DC 27e0
RI12 e12 10 56e-3
VS13 25 s13 0
R13 s13 10 12e1
VS14 6 s14 0
R14 s14 3 39e1
VS15 21 s15 0
V15 e15 s15 DC 47e0
RI15 e15 5 27e-1
VS16 19 s16 0
R16 s16 21 47e0
VS17 12 s17 0
R17 s17 10 27e3
VS18 18 s18 0
R18 s18 20 39e1
VS19 17 s19 0
V19 e19 s19 DC 82e-1
RI19 e19 12 22e-1
VS20 22 s20 0
R20 s20 6 33e1
VS21 23 s21 0
R21 s21 8 12e2
VS22 19 s22 0
V22 e22 s22 DC 47e0
RI22 e22 3 82e-2
VS23 24 s23 0
I23 s23 14 DC 82e-2
VS24 8 s24 0
R24 s24 24 47e0
VS25 16 s25 0
R25 s25 17 10e1
VS26 0 s26 0
V26 e26 s26 DC 10e1
RI26 e26 26 82e-1
VS27 7 s27 0
V27 e27 s27 DC 68e0
RI27 e27 1 39e-1
VS28 5 s28 0
V28 e28 s28 DC 82e1
RI28 e28 7 15e-3
VS29 23 s29 0
R29 s29 12 12e3
VS30 17 s30 0
V30 e30 s30 DC 27e1
RI30 e30 2 22e-3
VS31 6 s31 0
R31 s31 24 68e1
VS32 15 s32 0
V32 e32 s32 DC 33e-1
RI32 e32 9 82e-1
VS33 11 s33 0
R33 s33 24 68e-2
VS34 20 s34 0
R34 s34 12 68e-2
VS35 2 s35 0
R35 s35 10 68e-1
VS36 3 s36 0
R36 s36 17 39e-1
VS37 22 s37 0
V37 e37 s37 DC 39e0
RI37 e37 4 47e-3
VS38 23 s38 0
R38 s38 14 56e0
VS39 25 s39 0
I39 s39 20 DC 47e-1
.control
set numdgt=17
op
print v(1) v(2) v(3) v(4) v(5) v(6) v(7) v(8) v(9) v(10)
print v(11) v(12) v(13) v(14) v(15) v(16) v(17) v(18) v(19) v(20)
print v(21) v(22) v(23) v(24) v(25) v(26)
print i(vs0) i(vs1) i(vs2) i(vs3) i(vs4) i(vs5) i(vs6) i(vs7) i(vs8) i(vs9)
print i(vs10) i(vs11) i(vs12) i(vs13) i(vs14) i(vs15) i(vs16) i(vs17) i(vs18) i(vs19)
print i(vs20) i(vs21) i(vs22) i(vs23) i(vs24) i(vs25) i(vs26) i(vs27) i(vs28) i(vs29)
print i(vs30) i(vs31) i(vs32) i(vs33) i(vs34) i(vs35) i(vs36) i(vs37) i(vs38) i(vs39)
.endc
.end
