controls oracle dc-0448
* Generated (plan F2.7, ADR 0012): do not edit; regenerate with `pnpm sim oracle regen`. dc seed 20261030 index 448 nodes 27 elements 34
.options sparse gmin=1e-12 noopac
RG1 1 0 1000000000000
RG2 2 0 1000000000000
RG3 3 0 1000000000000
RG4 4 0 1000000000000
RG5 5 0 1000000000000
RG6 6 0 1000000000000
RG7 7 0 1000000000000
RG8 8 0 1000000000000
RG9 9 0 1000000000000
RG10 10 0 1000000000000
RG11 11 0 1000000000000
RG12 12 0 1000000000000
RG13 13 0 1000000000000
RG14 14 0 1000000000000
RG15 15 0 1000000000000
RG16 16 0 1000000000000
RG17 17 0 1000000000000
RG18 18 0 1000000000000
RG19 19 0 1000000000000
RG20 20 0 1000000000000
RG21 21 0 1000000000000
RG22 22 0 1000000000000
RG23 23 0 1000000000000
RG24 24 0 1000000000000
RG25 25 0 1000000000000
RG26 26 0 1000000000000
VS0 4 s0 0
R0 s0 12 33e-1
VS1 0 s1 0
R1 s1 11 39e1
VS2 22 s2 0
R2 s2 18 18e1
VS3 11 s3 0
R3 s3 24 68e-2
VS4 6 s4 0
R4 s4 3 39e1
VS5 15 s5 0
R5 s5 10 27e3
VS6 0 s6 0
V6 e6 s6 DC 27e0
RI6 e6 10 56e-3
VS7 20 s7 0
R7 s7 1 56e3
VS8 13 s8 0
R8 s8 16 12e1
VS9 20 s9 0
R9 s9 15 68e-2
VS10 15 s10 0
R10 s10 21 82e-1
VS11 24 s11 0
I11 s11 14 DC 82e-2
VS12 7 s12 0
V12 e12 s12 DC 68e0
RI12 e12 1 39e-1
VS13 25 s13 0
I13 s13 20 DC 47e-1
VS14 23 s14 0
R14 s14 14 56e0
VS15 1 s15 0
R15 s15 14 15e3
VS16 22 s16 0
V16 e16 s16 DC 39e0
RI16 e16 4 47e-3
VS17 12 s17 0
V17 e17 s17 DC 10e1
RI17 e17 26 82e-1
VS18 22 s18 0
R18 s18 6 33e1
VS19 21 s19 0
V19 e19 s19 DC 47e0
RI19 e19 5 27e-1
VS20 19 s20 0
V20 e20 s20 DC 47e0
RI20 e20 3 82e-2
VS21 16 s21 0
R21 s21 17 10e1
VS22 6 s22 0
R22 s22 24 68e1
VS23 0 s23 0
R23 s23 2 15e3
VS24 16 s24 0
R24 s24 9 15e0
VS25 22 s25 0
R25 s25 3 56e3
VS26 3 s26 0
R26 s26 17 39e-1
VS27 0 s27 0
V27 e27 s27 DC 33e-1
RI27 e27 9 82e-1
VS28 23 s28 0
R28 s28 15 12e3
VS29 23 s29 0
R29 s29 8 12e2
VS30 2 s30 0
R30 s30 10 68e-1
VS31 25 s31 0
R31 s31 26 68e2
VS32 17 s32 0
V32 e32 s32 DC 82e-1
RI32 e32 15 22e-1
VS33 17 s33 0
V33 e33 s33 DC 27e1
RI33 e33 2 22e-3
.control
set numdgt=17
op
print v(1) v(2) v(3) v(4) v(5) v(6) v(7) v(8) v(9) v(10)
print v(11) v(12) v(13) v(14) v(15) v(16) v(17) v(18) v(19) v(20)
print v(21) v(22) v(23) v(24) v(25) v(26)
print i(vs0) i(vs1) i(vs2) i(vs3) i(vs4) i(vs5) i(vs6) i(vs7) i(vs8) i(vs9)
print i(vs10) i(vs11) i(vs12) i(vs13) i(vs14) i(vs15) i(vs16) i(vs17) i(vs18) i(vs19)
print i(vs20) i(vs21) i(vs22) i(vs23) i(vs24) i(vs25) i(vs26) i(vs27) i(vs28) i(vs29)
print i(vs30) i(vs31) i(vs32) i(vs33)
.endc
.end
