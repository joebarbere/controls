controls oracle dc-0331
* Generated (plan F2.7, ADR 0012): do not edit; regenerate with `pnpm sim oracle regen`. dc seed 20261030 index 331 nodes 22 elements 29
.options sparse gmin=1e-12 noopac
RG1 1 0 1000000000000
RG2 2 0 1000000000000
RG3 3 0 1000000000000
RG4 4 0 1000000000000
RG5 5 0 1000000000000
RG6 6 0 1000000000000
RG7 7 0 1000000000000
RG8 8 0 1000000000000
RG9 9 0 1000000000000
RG10 10 0 1000000000000
RG11 11 0 1000000000000
RG12 12 0 1000000000000
RG13 13 0 1000000000000
RG14 14 0 1000000000000
RG15 15 0 1000000000000
RG16 16 0 1000000000000
RG17 17 0 1000000000000
RG18 18 0 1000000000000
RG19 19 0 1000000000000
RG20 20 0 1000000000000
RG21 21 0 1000000000000
VS0 17 s0 0
R0 s0 6 47e3
VS1 9 s1 0
I1 s1 15 DC 39e-1
VS2 19 s2 0
R2 s2 18 22e3
VS3 0 s3 0
V3 e3 s3 DC 39e0
RI3 e3 16 68e-2
VS4 15 s4 0
R4 s4 6 12e-2
VS5 14 s5 0
R5 s5 18 47e-2
VS6 4 s6 0
R6 s6 9 12e3
VS7 17 s7 0
R7 s7 14 12e-1
VS8 14 s8 0
R8 s8 1 33e1
VS9 9 s9 0
R9 s9 5 47e-2
VS10 21 s10 0
R10 s10 13 47e3
VS11 9 s11 0
V11 e11 s11 DC 47e1
RI11 e11 16 82e-3
VS12 7 s12 0
R12 s12 6 33e0
VS13 14 s13 0
R13 s13 15 39e2
VS14 11 s14 0
R14 s14 16 68e-1
VS15 1 s15 0
R15 s15 10 33e2
VS16 3 s16 0
R16 s16 13 33e0
VS17 0 s17 0
R17 s17 11 18e0
VS18 17 s18 0
R18 s18 10 10e2
VS19 7 s19 0
V19 e19 s19 DC 18e-1
RI19 e19 2 27e-2
VS20 8 s20 0
R20 s20 14 15e3
VS21 10 s21 0
R21 s21 0 10e1
VS22 20 s22 0
R22 s22 17 68e3
VS23 21 s23 0
R23 s23 18 27e0
VS24 17 s24 0
R24 s24 5 10e3
VS25 20 s25 0
R25 s25 13 12e3
VS26 13 s26 0
R26 s26 15 27e3
VS27 13 s27 0
R27 s27 12 22e3
VS28 21 s28 0
R28 s28 19 27e2
.control
set numdgt=17
op
print v(1) v(2) v(3) v(4) v(5) v(6) v(7) v(8) v(9) v(10)
print v(11) v(12) v(13) v(14) v(15) v(16) v(17) v(18) v(19) v(20)
print v(21)
print i(vs0) i(vs1) i(vs2) i(vs3) i(vs4) i(vs5) i(vs6) i(vs7) i(vs8) i(vs9)
print i(vs10) i(vs11) i(vs12) i(vs13) i(vs14) i(vs15) i(vs16) i(vs17) i(vs18) i(vs19)
print i(vs20) i(vs21) i(vs22) i(vs23) i(vs24) i(vs25) i(vs26) i(vs27) i(vs28)
.endc
.end
