controls oracle dc-0331
* Generated (plan F2.7, ADR 0012): do not edit; regenerate with `pnpm sim oracle regen`. dc seed 20261030 index 331 nodes 22 elements 34
.options sparse gmin=1e-12 noopac
RG1 1 0 1000000000000
RG2 2 0 1000000000000
RG3 3 0 1000000000000
RG4 4 0 1000000000000
RG5 5 0 1000000000000
RG6 6 0 1000000000000
RG7 7 0 1000000000000
RG8 8 0 1000000000000
RG9 9 0 1000000000000
RG10 10 0 1000000000000
RG11 11 0 1000000000000
RG12 12 0 1000000000000
RG13 13 0 1000000000000
RG14 14 0 1000000000000
RG15 15 0 1000000000000
RG16 16 0 1000000000000
RG17 17 0 1000000000000
RG18 18 0 1000000000000
RG19 19 0 1000000000000
RG20 20 0 1000000000000
RG21 21 0 1000000000000
VS0 0 s0 0
I0 s0 15 DC 39e-1
VS1 0 s1 0
V1 e1 s1 DC 47e1
RI1 e1 16 82e-3
VS2 15 s2 0
R2 s2 6 12e-2
VS3 21 s3 0
R3 s3 18 27e0
VS4 9 s4 0
R4 s4 14 12e-1
VS5 3 s5 0
R5 s5 13 33e0
VS6 0 s6 0
R6 s6 5 47e-2
VS7 8 s7 0
R7 s7 14 15e3
VS8 12 s8 0
R8 s8 6 56e3
VS9 21 s9 0
R9 s9 13 47e3
VS10 7 s10 0
V10 e10 s10 DC 18e-1
RI10 e10 2 27e-2
VS11 19 s11 0
R11 s11 18 22e3
VS12 20 s12 0
R12 s12 9 68e3
VS13 2 s13 0
V13 e13 s13 DC 33e-1
RI13 e13 3 82e-2
VS14 10 s14 0
R14 s14 17 10e1
VS15 9 s15 0
R15 s15 10 10e2
VS16 1 s16 0
R16 s16 10 33e2
VS17 9 s17 0
R17 s17 6 47e3
VS18 15 s18 0
V18 e18 s18 DC 82e1
RI18 e18 8 18e-3
VS19 14 s19 0
R19 s19 15 39e2
VS20 14 s20 0
R20 s20 1 33e1
VS21 17 s21 0
V21 e21 s21 DC 39e0
RI21 e21 16 68e-2
VS22 9 s22 0
R22 s22 5 10e3
VS23 13 s23 0
R23 s23 15 27e3
VS24 7 s24 0
R24 s24 6 33e0
VS25 4 s25 0
R25 s25 0 12e3
VS26 14 s26 0
R26 s26 18 47e-2
VS27 4 s27 0
R27 s27 20 68e-1
VS28 11 s28 0
R28 s28 16 68e-1
VS29 13 s29 0
R29 s29 12 22e3
VS30 21 s30 0
R30 s30 19 27e2
VS31 11 s31 0
R31 s31 2 27e2
VS32 17 s32 0
R32 s32 11 18e0
VS33 20 s33 0
R33 s33 13 12e3
.control
set numdgt=17
op
print v(1) v(2) v(3) v(4) v(5) v(6) v(7) v(8) v(9) v(10)
print v(11) v(12) v(13) v(14) v(15) v(16) v(17) v(18) v(19) v(20)
print v(21)
print i(vs0) i(vs1) i(vs2) i(vs3) i(vs4) i(vs5) i(vs6) i(vs7) i(vs8) i(vs9)
print i(vs10) i(vs11) i(vs12) i(vs13) i(vs14) i(vs15) i(vs16) i(vs17) i(vs18) i(vs19)
print i(vs20) i(vs21) i(vs22) i(vs23) i(vs24) i(vs25) i(vs26) i(vs27) i(vs28) i(vs29)
print i(vs30) i(vs31) i(vs32) i(vs33)
.endc
.end
