controls oracle dc-0086
* Generated (plan F2.7, ADR 0012): do not edit; regenerate with `pnpm sim oracle regen`. dc seed 20261030 index 86 nodes 20 elements 30
.options sparse gmin=1e-12 noopac
RG1 1 0 1000000000000
RG2 2 0 1000000000000
RG3 3 0 1000000000000
RG4 4 0 1000000000000
RG5 5 0 1000000000000
RG6 6 0 1000000000000
RG7 7 0 1000000000000
RG8 8 0 1000000000000
RG9 9 0 1000000000000
RG10 10 0 1000000000000
RG11 11 0 1000000000000
RG12 12 0 1000000000000
RG13 13 0 1000000000000
RG14 14 0 1000000000000
RG15 15 0 1000000000000
RG16 16 0 1000000000000
RG17 17 0 1000000000000
RG18 18 0 1000000000000
RG19 19 0 1000000000000
VS0 9 s0 0
R0 s0 13 18e0
VS1 13 s1 0
R1 s1 10 47e2
VS2 8 s2 0
R2 s2 7 56e-2
VS3 18 s3 0
R3 s3 13 18e2
VS4 11 s4 0
R4 s4 6 56e-2
VS5 6 s5 0
R5 s5 2 12e0
VS6 8 s6 0
R6 s6 14 15e1
VS7 0 s7 0
V7 e7 s7 DC 68e1
RI7 e7 2 27e-1
VS8 1 s8 0
R8 s8 17 47e1
VS9 18 s9 0
R9 s9 4 27e2
VS10 15 s10 0
R10 s10 3 47e0
VS11 7 s11 0
R11 s11 9 47e3
VS12 11 s12 0
R12 s12 19 56e-2
VS13 10 s13 0
R13 s13 4 56e2
VS14 17 s14 0
R14 s14 10 39e0
VS15 19 s15 0
R15 s15 9 22e0
VS16 5 s16 0
R16 s16 4 56e-1
VS17 3 s17 0
R17 s17 0 68e1
VS18 6 s18 0
R18 s18 14 12e-1
VS19 14 s19 0
R19 s19 12 82e-1
VS20 14 s20 0
R20 s20 4 68e-2
VS21 11 s21 0
R21 s21 0 27e2
VS22 15 s22 0
R22 s22 10 82e1
VS23 5 s23 0
R23 s23 12 10e-2
VS24 16 s24 0
V24 e24 s24 DC 10e0
RI24 e24 14 39e-2
VS25 0 s25 0
R25 s25 1 33e1
VS26 18 s26 0
I26 s26 2 DC 12e-2
VS27 3 s27 0
I27 s27 13 DC 15e-2
VS28 0 s28 0
R28 s28 16 39e0
VS29 0 s29 0
R29 s29 13 47e2
.control
set numdgt=17
op
print v(1) v(2) v(3) v(4) v(5) v(6) v(7) v(8) v(9) v(10)
print v(11) v(12) v(13) v(14) v(15) v(16) v(17) v(18) v(19)
print i(vs0) i(vs1) i(vs2) i(vs3) i(vs4) i(vs5) i(vs6) i(vs7) i(vs8) i(vs9)
print i(vs10) i(vs11) i(vs12) i(vs13) i(vs14) i(vs15) i(vs16) i(vs17) i(vs18) i(vs19)
print i(vs20) i(vs21) i(vs22) i(vs23) i(vs24) i(vs25) i(vs26) i(vs27) i(vs28) i(vs29)
.endc
.end
