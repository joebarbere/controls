controls oracle dc-0086
* Generated (plan F2.7, ADR 0012): do not edit; regenerate with `pnpm sim oracle regen`. dc seed 20261030 index 86 nodes 20 elements 24
.options sparse gmin=1e-12 noopac
RG1 1 0 1000000000000
RG2 2 0 1000000000000
RG3 3 0 1000000000000
RG4 4 0 1000000000000
RG5 5 0 1000000000000
RG6 6 0 1000000000000
RG7 7 0 1000000000000
RG8 8 0 1000000000000
RG9 9 0 1000000000000
RG10 10 0 1000000000000
RG11 11 0 1000000000000
RG12 12 0 1000000000000
RG13 13 0 1000000000000
RG14 14 0 1000000000000
RG15 15 0 1000000000000
RG16 16 0 1000000000000
RG17 17 0 1000000000000
RG18 18 0 1000000000000
RG19 19 0 1000000000000
VS0 9 s0 0
R0 s0 13 18e0
VS1 0 s1 0
V1 e1 s1 DC 68e1
RI1 e1 2 27e-1
VS2 6 s2 0
R2 s2 14 12e-1
VS3 15 s3 0
R3 s3 3 47e0
VS4 18 s4 0
I4 s4 2 DC 12e-2
VS5 16 s5 0
V5 e5 s5 DC 10e0
RI5 e5 14 39e-2
VS6 5 s6 0
R6 s6 4 56e-1
VS7 8 s7 0
R7 s7 14 15e1
VS8 11 s8 0
R8 s8 6 56e-2
VS9 14 s9 0
R9 s9 12 82e-1
VS10 18 s10 0
R10 s10 4 27e2
VS11 1 s11 0
R11 s11 17 47e1
VS12 19 s12 0
R12 s12 9 22e0
VS13 13 s13 0
R13 s13 10 47e2
VS14 3 s14 0
R14 s14 0 68e1
VS15 18 s15 0
R15 s15 13 18e2
VS16 3 s16 0
I16 s16 13 DC 15e-2
VS17 11 s17 0
R17 s17 0 27e2
VS18 7 s18 0
R18 s18 9 47e3
VS19 0 s19 0
R19 s19 1 33e1
VS20 0 s20 0
R20 s20 13 47e2
VS21 14 s21 0
R21 s21 4 68e-2
VS22 11 s22 0
R22 s22 19 56e-2
VS23 10 s23 0
R23 s23 4 56e2
.control
set numdgt=17
op
print v(1) v(2) v(3) v(4) v(5) v(6) v(7) v(8) v(9) v(10)
print v(11) v(12) v(13) v(14) v(15) v(16) v(17) v(18) v(19)
print i(vs0) i(vs1) i(vs2) i(vs3) i(vs4) i(vs5) i(vs6) i(vs7) i(vs8) i(vs9)
print i(vs10) i(vs11) i(vs12) i(vs13) i(vs14) i(vs15) i(vs16) i(vs17) i(vs18) i(vs19)
print i(vs20) i(vs21) i(vs22) i(vs23)
.endc
.end
