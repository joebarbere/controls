controls oracle dc-0431
* Generated (plan F2.7, ADR 0012): do not edit; regenerate with `pnpm sim oracle regen`. dc seed 20261030 index 431 nodes 2 elements 3
.options sparse gmin=1e-12 noopac
RG1 1 0 1000000000000
VS0 0 s0 0
R0 s0 1 12e1
VS1 1 s1 0
R1 s1 0 82e-2
VS2 0 s2 0
V2 e2 s2 DC 56e-1
RI2 e2 1 22e-1
.control
set numdgt=17
op
print v(1)
print i(vs0) i(vs1) i(vs2)
.endc
.end
