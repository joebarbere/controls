controls oracle dc-0257
* Generated (plan F2.7, ADR 0012): do not edit; regenerate with `pnpm sim oracle regen`. dc seed 20261030 index 257 nodes 10 elements 10
.options sparse gmin=1e-12 noopac
RG1 1 0 1000000000000
RG2 2 0 1000000000000
RG3 3 0 1000000000000
RG4 4 0 1000000000000
RG5 5 0 1000000000000
RG6 6 0 1000000000000
RG7 7 0 1000000000000
RG8 8 0 1000000000000
RG9 9 0 1000000000000
VS0 3 s0 0
R0 s0 4 27e-1
VS1 0 s1 0
V1 e1 s1 DC 82e-1
RI1 e1 4 27e-1
VS2 4 s2 0
R2 s2 0 12e3
VS3 2 s3 0
R3 s3 6 39e1
VS4 5 s4 0
R4 s4 7 33e-1
VS5 9 s5 0
R5 s5 4 10e1
VS6 9 s6 0
V6 e6 s6 DC 12e1
RI6 e6 8 33e-3
VS7 4 s7 0
V7 e7 s7 DC 39e-1
RI7 e7 1 18e-2
VS8 5 s8 0
V8 e8 s8 DC 10e-1
RI8 e8 4 68e-2
VS9 7 s9 0
R9 s9 2 18e1
.control
set numdgt=17
op
print v(1) v(2) v(3) v(4) v(5) v(6) v(7) v(8) v(9)
print i(vs0) i(vs1) i(vs2) i(vs3) i(vs4) i(vs5) i(vs6) i(vs7) i(vs8) i(vs9)
.endc
.end
