controls oracle dc-0257
* Generated (plan F2.7, ADR 0012): do not edit; regenerate with `pnpm sim oracle regen`. dc seed 20261030 index 257 nodes 10 elements 14
.options sparse gmin=1e-12 noopac
RG1 1 0 1000000000000
RG2 2 0 1000000000000
RG3 3 0 1000000000000
RG4 4 0 1000000000000
RG5 5 0 1000000000000
RG6 6 0 1000000000000
RG7 7 0 1000000000000
RG8 8 0 1000000000000
RG9 9 0 1000000000000
VS0 0 s0 0
V0 e0 s0 DC 39e-1
RI0 e0 1 18e-2
VS1 3 s1 0
R1 s1 0 27e-1
VS2 9 s2 0
V2 e2 s2 DC 12e1
RI2 e2 8 33e-3
VS3 9 s3 0
R3 s3 0 10e1
VS4 7 s4 0
R4 s4 2 18e1
VS5 2 s5 0
V5 e5 s5 DC 68e-1
RI5 e5 3 68e-1
VS6 4 s6 0
V6 e6 s6 DC 82e-1
RI6 e6 0 27e-1
VS7 6 s7 0
V7 e7 s7 DC 82e-1
RI7 e7 4 68e-1
VS8 8 s8 0
R8 s8 6 10e-1
VS9 0 s9 0
R9 s9 4 12e3
VS10 2 s10 0
R10 s10 6 39e1
VS11 5 s11 0
V11 e11 s11 DC 10e-1
RI11 e11 0 68e-2
VS12 1 s12 0
R12 s12 9 27e3
VS13 5 s13 0
R13 s13 7 33e-1
.control
set numdgt=17
op
print v(1) v(2) v(3) v(4) v(5) v(6) v(7) v(8) v(9)
print i(vs0) i(vs1) i(vs2) i(vs3) i(vs4) i(vs5) i(vs6) i(vs7) i(vs8) i(vs9)
print i(vs10) i(vs11) i(vs12) i(vs13)
.endc
.end
