controls oracle dc-0321
* Generated (plan F2.7, ADR 0012): do not edit; regenerate with `pnpm sim oracle regen`. dc seed 20261030 index 321 nodes 19 elements 26
.options sparse gmin=1e-12 noopac
RG1 1 0 1000000000000
RG2 2 0 1000000000000
RG3 3 0 1000000000000
RG4 4 0 1000000000000
RG5 5 0 1000000000000
RG6 6 0 1000000000000
RG7 7 0 1000000000000
RG8 8 0 1000000000000
RG9 9 0 1000000000000
RG10 10 0 1000000000000
RG11 11 0 1000000000000
RG12 12 0 1000000000000
RG13 13 0 1000000000000
RG14 14 0 1000000000000
RG15 15 0 1000000000000
RG16 16 0 1000000000000
RG17 17 0 1000000000000
RG18 18 0 1000000000000
VS0 17 s0 0
R0 s0 16 12e0
VS1 15 s1 0
I1 s1 14 DC 82e-3
VS2 10 s2 0
R2 s2 13 68e-1
VS3 3 s3 0
R3 s3 12 68e1
VS4 12 s4 0
R4 s4 11 27e-2
VS5 6 s5 0
R5 s5 12 47e-2
VS6 2 s6 0
R6 s6 14 47e-1
VS7 2 s7 0
R7 s7 15 18e3
VS8 2 s8 0
R8 s8 3 10e2
VS9 4 s9 0
R9 s9 2 82e2
VS10 3 s10 0
R10 s10 10 39e0
VS11 0 s11 0
V11 e11 s11 DC 22e0
RI11 e11 3 18e-2
VS12 15 s12 0
R12 s12 3 22e1
VS13 2 s13 0
R13 s13 6 39e3
VS14 10 s14 0
R14 s14 3 68e1
VS15 5 s15 0
R15 s15 12 27e1
VS16 3 s16 0
R16 s16 17 10e3
VS17 9 s17 0
R17 s17 4 27e1
VS18 0 s18 0
R18 s18 7 10e3
VS19 3 s19 0
R19 s19 18 27e-1
VS20 8 s20 0
R20 s20 9 82e-1
VS21 1 s21 0
R21 s21 2 56e-1
VS22 16 s22 0
R22 s22 10 39e2
VS23 9 s23 0
R23 s23 16 33e0
VS24 2 s24 0
I24 s24 15 DC 82e-2
VS25 18 s25 0
R25 s25 4 10e-2
.control
set numdgt=17
op
print v(1) v(2) v(3) v(4) v(5) v(6) v(7) v(8) v(9) v(10)
print v(11) v(12) v(13) v(14) v(15) v(16) v(17) v(18)
print i(vs0) i(vs1) i(vs2) i(vs3) i(vs4) i(vs5) i(vs6) i(vs7) i(vs8) i(vs9)
print i(vs10) i(vs11) i(vs12) i(vs13) i(vs14) i(vs15) i(vs16) i(vs17) i(vs18) i(vs19)
print i(vs20) i(vs21) i(vs22) i(vs23) i(vs24) i(vs25)
.endc
.end
