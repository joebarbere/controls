controls oracle dc-0082
* Generated (plan F2.7, ADR 0012): do not edit; regenerate with `pnpm sim oracle regen`. dc seed 20261030 index 82 nodes 18 elements 18
.options sparse gmin=1e-12 noopac
RG1 1 0 1000000000000
RG2 2 0 1000000000000
RG3 3 0 1000000000000
RG4 4 0 1000000000000
RG5 5 0 1000000000000
RG6 6 0 1000000000000
RG7 7 0 1000000000000
RG8 8 0 1000000000000
RG9 9 0 1000000000000
RG10 10 0 1000000000000
RG11 11 0 1000000000000
RG12 12 0 1000000000000
RG13 13 0 1000000000000
RG14 14 0 1000000000000
RG15 15 0 1000000000000
RG16 16 0 1000000000000
RG17 17 0 1000000000000
VS0 13 s0 0
R0 s0 12 39e3
VS1 11 s1 0
R1 s1 6 68e-2
VS2 16 s2 0
R2 s2 14 82e-2
VS3 4 s3 0
R3 s3 11 39e-1
VS4 2 s4 0
R4 s4 17 82e-1
VS5 8 s5 0
R5 s5 7 12e3
VS6 16 s6 0
R6 s6 11 27e3
VS7 9 s7 0
R7 s7 8 15e-1
VS8 1 s8 0
R8 s8 11 68e2
VS9 0 s9 0
V9 e9 s9 DC 10e1
RI9 e9 3 82e-1
VS10 15 s10 0
R10 s10 8 68e1
VS11 8 s11 0
R11 s11 11 33e0
VS12 7 s12 0
I12 s12 17 DC 47e-1
VS13 8 s13 0
R13 s13 10 33e2
VS14 15 s14 0
R14 s14 17 39e-2
VS15 5 s15 0
R15 s15 11 10e3
VS16 12 s16 0
V16 e16 s16 DC 82e-1
RI16 e16 8 27e-2
VS17 3 s17 0
R17 s17 8 68e1
.control
set numdgt=17
op
print v(1) v(2) v(3) v(4) v(5) v(6) v(7) v(8) v(9) v(10)
print v(11) v(12) v(13) v(14) v(15) v(16) v(17)
print i(vs0) i(vs1) i(vs2) i(vs3) i(vs4) i(vs5) i(vs6) i(vs7) i(vs8) i(vs9)
print i(vs10) i(vs11) i(vs12) i(vs13) i(vs14) i(vs15) i(vs16) i(vs17)
.endc
.end
