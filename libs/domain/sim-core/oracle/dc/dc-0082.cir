controls oracle dc-0082
* Generated (plan F2.7, ADR 0012): do not edit; regenerate with `pnpm sim oracle regen`. dc seed 20261030 index 82 nodes 18 elements 29
.options sparse gmin=1e-12 noopac
RG1 1 0 1000000000000
RG2 2 0 1000000000000
RG3 3 0 1000000000000
RG4 4 0 1000000000000
RG5 5 0 1000000000000
RG6 6 0 1000000000000
RG7 7 0 1000000000000
RG8 8 0 1000000000000
RG9 9 0 1000000000000
RG10 10 0 1000000000000
RG11 11 0 1000000000000
RG12 12 0 1000000000000
RG13 13 0 1000000000000
RG14 14 0 1000000000000
RG15 15 0 1000000000000
RG16 16 0 1000000000000
RG17 17 0 1000000000000
VS0 11 s0 0
R0 s0 4 33e0
VS1 0 s1 0
R1 s1 17 39e-2
VS2 3 s2 0
R2 s2 13 18e3
VS3 2 s3 0
R3 s3 17 82e-1
VS4 10 s4 0
R4 s4 16 56e2
VS5 13 s5 0
R5 s5 5 12e-2
VS6 15 s6 0
R6 s6 6 68e-2
VS7 0 s7 0
V7 e7 s7 DC 39e1
RI7 e7 2 22e-2
VS8 9 s8 0
R8 s8 8 15e-1
VS9 16 s9 0
R9 s9 14 82e-2
VS10 8 s10 0
R10 s10 10 33e2
VS11 11 s11 0
V11 e11 s11 DC 10e1
RI11 e11 3 82e-1
VS12 15 s12 0
V12 e12 s12 DC 27e-1
RI12 e12 14 12e-3
VS13 5 s13 0
R13 s13 15 10e3
VS14 4 s14 0
R14 s14 15 39e-1
VS15 3 s15 0
R15 s15 8 68e1
VS16 7 s16 0
I16 s16 17 DC 47e-1
VS17 15 s17 0
R17 s17 7 39e-2
VS18 12 s18 0
V18 e18 s18 DC 82e-1
RI18 e18 8 27e-2
VS19 1 s19 0
R19 s19 15 68e2
VS20 16 s20 0
R20 s20 15 27e3
VS21 15 s21 0
R21 s21 9 47e2
VS22 13 s22 0
R22 s22 12 39e3
VS23 7 s23 0
R23 s23 1 10e3
VS24 9 s24 0
R24 s24 17 47e-2
VS25 0 s25 0
R25 s25 8 68e1
VS26 9 s26 0
V26 e26 s26 DC 68e-1
RI26 e26 6 22e-2
VS27 8 s27 0
R27 s27 15 33e0
VS28 8 s28 0
R28 s28 7 12e3
.control
set numdgt=17
op
print v(1) v(2) v(3) v(4) v(5) v(6) v(7) v(8) v(9) v(10)
print v(11) v(12) v(13) v(14) v(15) v(16) v(17)
print i(vs0) i(vs1) i(vs2) i(vs3) i(vs4) i(vs5) i(vs6) i(vs7) i(vs8) i(vs9)
print i(vs10) i(vs11) i(vs12) i(vs13) i(vs14) i(vs15) i(vs16) i(vs17) i(vs18) i(vs19)
print i(vs20) i(vs21) i(vs22) i(vs23) i(vs24) i(vs25) i(vs26) i(vs27) i(vs28)
.endc
.end
