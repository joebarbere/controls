controls oracle dc-0161
* Generated (plan F2.7, ADR 0012): do not edit; regenerate with `pnpm sim oracle regen`. dc seed 20261030 index 161 nodes 5 elements 7
.options sparse gmin=1e-12 noopac
RG1 1 0 1000000000000
RG2 2 0 1000000000000
RG3 3 0 1000000000000
RG4 4 0 1000000000000
VS0 0 s0 0
I0 s0 2 DC 10e-4
VS1 3 s1 0
R1 s1 2 82e1
VS2 1 s2 0
R2 s2 3 47e-1
VS3 0 s3 0
V3 e3 s3 DC 15e1
RI3 e3 3 15e-1
VS4 1 s4 0
R4 s4 4 15e3
VS5 2 s5 0
R5 s5 4 18e1
VS6 0 s6 0
R6 s6 2 10e3
.control
set numdgt=17
op
print v(1) v(2) v(3) v(4)
print i(vs0) i(vs1) i(vs2) i(vs3) i(vs4) i(vs5) i(vs6)
.endc
.end
