controls oracle dc-0278
* Generated (plan F2.7, ADR 0012): do not edit; regenerate with `pnpm sim oracle regen`. dc seed 20261030 index 278 nodes 24 elements 28
.options sparse gmin=1e-12 noopac
RG1 1 0 1000000000000
RG2 2 0 1000000000000
RG3 3 0 1000000000000
RG4 4 0 1000000000000
RG5 5 0 1000000000000
RG6 6 0 1000000000000
RG7 7 0 1000000000000
RG8 8 0 1000000000000
RG9 9 0 1000000000000
RG10 10 0 1000000000000
RG11 11 0 1000000000000
RG12 12 0 1000000000000
RG13 13 0 1000000000000
RG14 14 0 1000000000000
RG15 15 0 1000000000000
RG16 16 0 1000000000000
RG17 17 0 1000000000000
RG18 18 0 1000000000000
RG19 19 0 1000000000000
RG20 20 0 1000000000000
RG21 21 0 1000000000000
RG22 22 0 1000000000000
RG23 23 0 1000000000000
VS0 4 s0 0
R0 s0 6 82e-1
VS1 23 s1 0
R1 s1 1 56e3
VS2 2 s2 0
R2 s2 12 18e3
VS3 1 s3 0
R3 s3 18 12e1
VS4 16 s4 0
R4 s4 18 56e-1
VS5 17 s5 0
R5 s5 0 47e3
VS6 14 s6 0
R6 s6 5 56e2
VS7 6 s7 0
R7 s7 14 39e2
VS8 5 s8 0
R8 s8 22 18e2
VS9 17 s9 0
R9 s9 13 39e-2
VS10 9 s10 0
R10 s10 20 82e2
VS11 3 s11 0
R11 s11 18 27e2
VS12 12 s12 0
R12 s12 19 68e-2
VS13 13 s13 0
R13 s13 21 56e3
VS14 6 s14 0
R14 s14 1 12e3
VS15 0 s15 0
V15 e15 s15 DC 33e-1
RI15 e15 2 12e-2
VS16 3 s16 0
R16 s16 11 82e-1
VS17 7 s17 0
R17 s17 16 15e2
VS18 3 s18 0
R18 s18 0 10e3
VS19 17 s19 0
R19 s19 9 68e3
VS20 16 s20 0
R20 s20 10 22e1
VS21 16 s21 0
R21 s21 14 82e2
VS22 14 s22 0
R22 s22 15 22e-1
VS23 18 s23 0
R23 s23 2 82e-2
VS24 7 s24 0
R24 s24 15 47e3
VS25 16 s25 0
V25 e25 s25 DC 68e1
RI25 e25 9 12e-2
VS26 19 s26 0
R26 s26 14 82e-1
VS27 13 s27 0
R27 s27 8 27e-2
.control
set numdgt=17
op
print v(1) v(2) v(3) v(4) v(5) v(6) v(7) v(8) v(9) v(10)
print v(11) v(12) v(13) v(14) v(15) v(16) v(17) v(18) v(19) v(20)
print v(21) v(22) v(23)
print i(vs0) i(vs1) i(vs2) i(vs3) i(vs4) i(vs5) i(vs6) i(vs7) i(vs8) i(vs9)
print i(vs10) i(vs11) i(vs12) i(vs13) i(vs14) i(vs15) i(vs16) i(vs17) i(vs18) i(vs19)
print i(vs20) i(vs21) i(vs22) i(vs23) i(vs24) i(vs25) i(vs26) i(vs27)
.endc
.end
