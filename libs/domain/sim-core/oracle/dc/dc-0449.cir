controls oracle dc-0449
* Generated (plan F2.7, ADR 0012): do not edit; regenerate with `pnpm sim oracle regen`. dc seed 20261030 index 449 nodes 20 elements 22
.options sparse gmin=1e-12 noopac
RG1 1 0 1000000000000
RG2 2 0 1000000000000
RG3 3 0 1000000000000
RG4 4 0 1000000000000
RG5 5 0 1000000000000
RG6 6 0 1000000000000
RG7 7 0 1000000000000
RG8 8 0 1000000000000
RG9 9 0 1000000000000
RG10 10 0 1000000000000
RG11 11 0 1000000000000
RG12 12 0 1000000000000
RG13 13 0 1000000000000
RG14 14 0 1000000000000
RG15 15 0 1000000000000
RG16 16 0 1000000000000
RG17 17 0 1000000000000
RG18 18 0 1000000000000
RG19 19 0 1000000000000
VS0 0 s0 0
V0 e0 s0 DC 15e-1
RI0 e0 13 18e-1
VS1 6 s1 0
R1 s1 4 33e2
VS2 12 s2 0
R2 s2 2 22e-1
VS3 7 s3 0
R3 s3 17 10e-2
VS4 18 s4 0
R4 s4 0 33e-1
VS5 5 s5 0
R5 s5 16 12e2
VS6 6 s6 0
V6 e6 s6 DC 56e1
RI6 e6 3 27e-1
VS7 9 s7 0
R7 s7 0 82e0
VS8 10 s8 0
R8 s8 7 39e3
VS9 5 s9 0
R9 s9 1 39e2
VS10 15 s10 0
R10 s10 6 39e1
VS11 2 s11 0
R11 s11 3 47e3
VS12 17 s12 0
I12 s12 11 DC 12e-2
VS13 8 s13 0
R13 s13 16 27e1
VS14 5 s14 0
V14 e14 s14 DC 47e0
RI14 e14 10 18e-2
VS15 6 s15 0
R15 s15 0 33e2
VS16 9 s16 0
R16 s16 19 82e1
VS17 14 s17 0
R17 s17 19 68e0
VS18 11 s18 0
R18 s18 7 12e0
VS19 8 s19 0
R19 s19 0 27e2
VS20 19 s20 0
R20 s20 18 68e-2
VS21 7 s21 0
V21 e21 s21 DC 15e-1
RI21 e21 9 12e-1
.control
set numdgt=17
op
print v(1) v(2) v(3) v(4) v(5) v(6) v(7) v(8) v(9) v(10)
print v(11) v(12) v(13) v(14) v(15) v(16) v(17) v(18) v(19)
print i(vs0) i(vs1) i(vs2) i(vs3) i(vs4) i(vs5) i(vs6) i(vs7) i(vs8) i(vs9)
print i(vs10) i(vs11) i(vs12) i(vs13) i(vs14) i(vs15) i(vs16) i(vs17) i(vs18) i(vs19)
print i(vs20) i(vs21)
.endc
.end
