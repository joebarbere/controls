controls oracle dc-0449
* Generated (plan F2.7, ADR 0012): do not edit; regenerate with `pnpm sim oracle regen`. dc seed 20261030 index 449 nodes 20 elements 30
.options sparse gmin=1e-12 noopac
RG1 1 0 1000000000000
RG2 2 0 1000000000000
RG3 3 0 1000000000000
RG4 4 0 1000000000000
RG5 5 0 1000000000000
RG6 6 0 1000000000000
RG7 7 0 1000000000000
RG8 8 0 1000000000000
RG9 9 0 1000000000000
RG10 10 0 1000000000000
RG11 11 0 1000000000000
RG12 12 0 1000000000000
RG13 13 0 1000000000000
RG14 14 0 1000000000000
RG15 15 0 1000000000000
RG16 16 0 1000000000000
RG17 17 0 1000000000000
RG18 18 0 1000000000000
RG19 19 0 1000000000000
VS0 17 s0 0
I0 s0 11 DC 12e-2
VS1 1 s1 0
R1 s1 15 12e3
VS2 18 s2 0
R2 s2 0 33e-1
VS3 8 s3 0
R3 s3 0 27e2
VS4 1 s4 0
R4 s4 13 68e3
VS5 0 s5 0
V5 e5 s5 DC 15e-1
RI5 e5 13 18e-1
VS6 9 s6 0
R6 s6 19 82e1
VS7 11 s7 0
R7 s7 7 12e0
VS8 8 s8 0
R8 s8 16 27e1
VS9 7 s9 0
R9 s9 17 10e-2
VS10 11 s10 0
R10 s10 9 82e-2
VS11 17 s11 0
R11 s11 3 39e-1
VS12 14 s12 0
R12 s12 17 33e3
VS13 6 s13 0
V13 e13 s13 DC 56e1
RI13 e13 3 27e-1
VS14 15 s14 0
R14 s14 6 39e1
VS15 6 s15 0
R15 s15 0 33e2
VS16 5 s16 0
V16 e16 s16 DC 47e0
RI16 e16 10 18e-2
VS17 19 s17 0
R17 s17 18 68e-2
VS18 13 s18 0
R18 s18 4 18e3
VS19 7 s19 0
V19 e19 s19 DC 15e-1
RI19 e19 9 12e-1
VS20 12 s20 0
R20 s20 18 22e2
VS21 14 s21 0
R21 s21 19 68e0
VS22 2 s22 0
R22 s22 3 47e3
VS23 6 s23 0
R23 s23 4 33e2
VS24 5 s24 0
R24 s24 16 12e2
VS25 12 s25 0
R25 s25 2 22e-1
VS26 9 s26 0
R26 s26 0 82e0
VS27 5 s27 0
R27 s27 1 39e2
VS28 10 s28 0
R28 s28 1 82e3
VS29 10 s29 0
R29 s29 7 39e3
.control
set numdgt=17
op
print v(1) v(2) v(3) v(4) v(5) v(6) v(7) v(8) v(9) v(10)
print v(11) v(12) v(13) v(14) v(15) v(16) v(17) v(18) v(19)
print i(vs0) i(vs1) i(vs2) i(vs3) i(vs4) i(vs5) i(vs6) i(vs7) i(vs8) i(vs9)
print i(vs10) i(vs11) i(vs12) i(vs13) i(vs14) i(vs15) i(vs16) i(vs17) i(vs18) i(vs19)
print i(vs20) i(vs21) i(vs22) i(vs23) i(vs24) i(vs25) i(vs26) i(vs27) i(vs28) i(vs29)
.endc
.end
