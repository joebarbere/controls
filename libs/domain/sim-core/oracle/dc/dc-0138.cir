controls oracle dc-0138
* Generated (plan F2.7, ADR 0012): do not edit; regenerate with `pnpm sim oracle regen`. dc seed 20261030 index 138 nodes 12 elements 19
.options sparse gmin=1e-12 noopac
RG1 1 0 1000000000000
RG2 2 0 1000000000000
RG3 3 0 1000000000000
RG4 4 0 1000000000000
RG5 5 0 1000000000000
RG6 6 0 1000000000000
RG7 7 0 1000000000000
RG8 8 0 1000000000000
RG9 9 0 1000000000000
RG10 10 0 1000000000000
RG11 11 0 1000000000000
VS0 8 s0 0
R0 s0 10 18e-1
VS1 2 s1 0
R1 s1 11 12e0
VS2 2 s2 0
R2 s2 6 39e1
VS3 8 s3 0
R3 s3 0 82e-1
VS4 5 s4 0
R4 s4 1 33e-1
VS5 9 s5 0
I5 s5 4 DC 56e-2
VS6 2 s6 0
R6 s6 3 39e3
VS7 0 s7 0
R7 s7 7 18e-2
VS8 0 s8 0
R8 s8 9 22e1
VS9 4 s9 0
R9 s9 7 27e0
VS10 8 s10 0
R10 s10 4 68e2
VS11 3 s11 0
R11 s11 8 39e-2
VS12 7 s12 0
R12 s12 1 27e3
VS13 9 s13 0
R13 s13 7 39e1
VS14 6 s14 0
R14 s14 0 22e-2
VS15 2 s15 0
R15 s15 1 12e-2
VS16 11 s16 0
R16 s16 10 22e2
VS17 11 s17 0
R17 s17 9 22e3
VS18 5 s18 0
R18 s18 4 47e-2
.control
set numdgt=17
op
print v(1) v(2) v(3) v(4) v(5) v(6) v(7) v(8) v(9) v(10)
print v(11)
print i(vs0) i(vs1) i(vs2) i(vs3) i(vs4) i(vs5) i(vs6) i(vs7) i(vs8) i(vs9)
print i(vs10) i(vs11) i(vs12) i(vs13) i(vs14) i(vs15) i(vs16) i(vs17) i(vs18)
.endc
.end
