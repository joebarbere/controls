controls oracle dc-0037
* Generated (plan F2.7, ADR 0012): do not edit; regenerate with `pnpm sim oracle regen`. dc seed 20261030 index 37 nodes 26 elements 38
.options sparse gmin=1e-12 noopac
RG1 1 0 1000000000000
RG2 2 0 1000000000000
RG3 3 0 1000000000000
RG4 4 0 1000000000000
RG5 5 0 1000000000000
RG6 6 0 1000000000000
RG7 7 0 1000000000000
RG8 8 0 1000000000000
RG9 9 0 1000000000000
RG10 10 0 1000000000000
RG11 11 0 1000000000000
RG12 12 0 1000000000000
RG13 13 0 1000000000000
RG14 14 0 1000000000000
RG15 15 0 1000000000000
RG16 16 0 1000000000000
RG17 17 0 1000000000000
RG18 18 0 1000000000000
RG19 19 0 1000000000000
RG20 20 0 1000000000000
RG21 21 0 1000000000000
RG22 22 0 1000000000000
RG23 23 0 1000000000000
RG24 24 0 1000000000000
RG25 25 0 1000000000000
VS0 7 s0 0
R0 s0 12 15e-2
VS1 13 s1 0
R1 s1 11 22e1
VS2 17 s2 0
R2 s2 0 39e3
VS3 25 s3 0
R3 s3 5 12e3
VS4 4 s4 0
R4 s4 15 47e2
VS5 17 s5 0
R5 s5 13 39e0
VS6 18 s6 0
R6 s6 20 27e1
VS7 17 s7 0
R7 s7 24 82e1
VS8 3 s8 0
R8 s8 5 27e-1
VS9 11 s9 0
R9 s9 14 68e2
VS10 11 s10 0
R10 s10 8 27e0
VS11 8 s11 0
I11 s11 4 DC 47e-4
VS12 7 s12 0
R12 s12 15 12e2
VS13 11 s13 0
R13 s13 23 47e-1
VS14 25 s14 0
R14 s14 2 68e3
VS15 0 s15 0
V15 e15 s15 DC 12e1
RI15 e15 4 47e-2
VS16 12 s16 0
R16 s16 23 18e3
VS17 20 s17 0
R17 s17 4 47e-1
VS18 0 s18 0
R18 s18 2 27e0
VS19 25 s19 0
R19 s19 9 15e-2
VS20 10 s20 0
R20 s20 7 39e-2
VS21 19 s21 0
R21 s21 9 56e1
VS22 1 s22 0
R22 s22 3 27e0
VS23 16 s23 0
R23 s23 4 27e3
VS24 5 s24 0
R24 s24 8 27e-1
VS25 22 s25 0
R25 s25 25 18e3
VS26 12 s26 0
R26 s26 18 22e2
VS27 9 s27 0
R27 s27 21 27e1
VS28 8 s28 0
R28 s28 9 33e3
VS29 21 s29 0
V29 e29 s29 DC 10e1
RI29 e29 23 27e-2
VS30 25 s30 0
R30 s30 0 56e3
VS31 25 s31 0
R31 s31 7 56e-2
VS32 10 s32 0
V32 e32 s32 DC 68e0
RI32 e32 3 39e-2
VS33 0 s33 0
I33 s33 6 DC 39e-2
VS34 19 s34 0
R34 s34 12 33e1
VS35 25 s35 0
R35 s35 9 15e2
VS36 4 s36 0
V36 e36 s36 DC 10e1
RI36 e36 6 39e-1
VS37 10 s37 0
R37 s37 3 27e2
.control
set numdgt=17
op
print v(1) v(2) v(3) v(4) v(5) v(6) v(7) v(8) v(9) v(10)
print v(11) v(12) v(13) v(14) v(15) v(16) v(17) v(18) v(19) v(20)
print v(21) v(22) v(23) v(24) v(25)
print i(vs0) i(vs1) i(vs2) i(vs3) i(vs4) i(vs5) i(vs6) i(vs7) i(vs8) i(vs9)
print i(vs10) i(vs11) i(vs12) i(vs13) i(vs14) i(vs15) i(vs16) i(vs17) i(vs18) i(vs19)
print i(vs20) i(vs21) i(vs22) i(vs23) i(vs24) i(vs25) i(vs26) i(vs27) i(vs28) i(vs29)
print i(vs30) i(vs31) i(vs32) i(vs33) i(vs34) i(vs35) i(vs36) i(vs37)
.endc
.end
