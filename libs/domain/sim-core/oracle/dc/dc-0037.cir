controls oracle dc-0037
* Generated (plan F2.7, ADR 0012): do not edit; regenerate with `pnpm sim oracle regen`. dc seed 20261030 index 37 nodes 26 elements 43
.options sparse gmin=1e-12 noopac
RG1 1 0 1000000000000
RG2 2 0 1000000000000
RG3 3 0 1000000000000
RG4 4 0 1000000000000
RG5 5 0 1000000000000
RG6 6 0 1000000000000
RG7 7 0 1000000000000
RG8 8 0 1000000000000
RG9 9 0 1000000000000
RG10 10 0 1000000000000
RG11 11 0 1000000000000
RG12 12 0 1000000000000
RG13 13 0 1000000000000
RG14 14 0 1000000000000
RG15 15 0 1000000000000
RG16 16 0 1000000000000
RG17 17 0 1000000000000
RG18 18 0 1000000000000
RG19 19 0 1000000000000
RG20 20 0 1000000000000
RG21 21 0 1000000000000
RG22 22 0 1000000000000
RG23 23 0 1000000000000
RG24 24 0 1000000000000
RG25 25 0 1000000000000
VS0 22 s0 0
R0 s0 6 12e-2
VS1 20 s1 0
R1 s1 0 47e-1
VS2 16 s2 0
R2 s2 0 27e3
VS3 0 s3 0
V3 e3 s3 DC 10e1
RI3 e3 6 39e-1
VS4 5 s4 0
R4 s4 8 27e-1
VS5 19 s5 0
R5 s5 12 33e1
VS6 3 s6 0
R6 s6 5 27e-1
VS7 2 s7 0
V7 e7 s7 DC 27e0
RI7 e7 24 33e-1
VS8 21 s8 0
V8 e8 s8 DC 10e1
RI8 e8 23 27e-2
VS9 17 s9 0
R9 s9 13 39e0
VS10 22 s10 0
R10 s10 25 18e3
VS11 12 s11 0
R11 s11 18 22e2
VS12 12 s12 0
R12 s12 23 18e3
VS13 18 s13 0
R13 s13 20 27e1
VS14 16 s14 0
R14 s14 19 39e-1
VS15 0 s15 0
R15 s15 15 47e2
VS16 10 s16 0
R16 s16 3 27e2
VS17 11 s17 0
R17 s17 23 47e-1
VS18 7 s18 0
R18 s18 15 12e2
VS19 10 s19 0
V19 e19 s19 DC 68e0
RI19 e19 3 39e-2
VS20 25 s20 0
R20 s20 4 56e3
VS21 8 s21 0
R21 s21 9 33e3
VS22 4 s22 0
R22 s22 2 27e0
VS23 11 s23 0
R23 s23 8 27e0
VS24 25 s24 0
R24 s24 5 12e3
VS25 4 s25 0
V25 e25 s25 DC 12e1
RI25 e25 0 47e-2
VS26 25 s26 0
R26 s26 9 15e2
VS27 11 s27 0
R27 s27 14 68e2
VS28 25 s28 0
R28 s28 7 56e-2
VS29 23 s29 0
R29 s29 14 68e2
VS30 1 s30 0
R30 s30 3 27e0
VS31 8 s31 0
I31 s31 0 DC 47e-4
VS32 19 s32 0
R32 s32 9 56e1
VS33 9 s33 0
R33 s33 21 27e1
VS34 17 s34 0
R34 s34 4 39e3
VS35 25 s35 0
R35 s35 9 15e-2
VS36 4 s36 0
I36 s36 6 DC 39e-2
VS37 13 s37 0
R37 s37 11 22e1
VS38 10 s38 0
R38 s38 7 39e-2
VS39 25 s39 0
R39 s39 2 68e3
VS40 1 s40 0
V40 e40 s40 DC 68e-1
RI40 e40 14 33e-2
VS41 7 s41 0
R41 s41 12 15e-2
VS42 17 s42 0
R42 s42 24 82e1
.control
set numdgt=17
op
print v(1) v(2) v(3) v(4) v(5) v(6) v(7) v(8) v(9) v(10)
print v(11) v(12) v(13) v(14) v(15) v(16) v(17) v(18) v(19) v(20)
print v(21) v(22) v(23) v(24) v(25)
print i(vs0) i(vs1) i(vs2) i(vs3) i(vs4) i(vs5) i(vs6) i(vs7) i(vs8) i(vs9)
print i(vs10) i(vs11) i(vs12) i(vs13) i(vs14) i(vs15) i(vs16) i(vs17) i(vs18) i(vs19)
print i(vs20) i(vs21) i(vs22) i(vs23) i(vs24) i(vs25) i(vs26) i(vs27) i(vs28) i(vs29)
print i(vs30) i(vs31) i(vs32) i(vs33) i(vs34) i(vs35) i(vs36) i(vs37) i(vs38) i(vs39)
print i(vs40) i(vs41) i(vs42)
.endc
.end
