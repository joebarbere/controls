controls oracle dc-0222
* Generated (plan F2.7, ADR 0012): do not edit; regenerate with `pnpm sim oracle regen`. dc seed 20261030 index 222 nodes 22 elements 32
.options sparse gmin=1e-12 noopac
RG1 1 0 1000000000000
RG2 2 0 1000000000000
RG3 3 0 1000000000000
RG4 4 0 1000000000000
RG5 5 0 1000000000000
RG6 6 0 1000000000000
RG7 7 0 1000000000000
RG8 8 0 1000000000000
RG9 9 0 1000000000000
RG10 10 0 1000000000000
RG11 11 0 1000000000000
RG12 12 0 1000000000000
RG13 13 0 1000000000000
RG14 14 0 1000000000000
RG15 15 0 1000000000000
RG16 16 0 1000000000000
RG17 17 0 1000000000000
RG18 18 0 1000000000000
RG19 19 0 1000000000000
RG20 20 0 1000000000000
RG21 21 0 1000000000000
VS0 8 s0 0
R0 s0 17 15e2
VS1 11 s1 0
R1 s1 12 47e2
VS2 1 s2 0
R2 s2 6 10e3
VS3 5 s3 0
R3 s3 0 82e1
VS4 2 s4 0
R4 s4 6 12e3
VS5 8 s5 0
R5 s5 18 18e-2
VS6 21 s6 0
R6 s6 6 39e-2
VS7 0 s7 0
R7 s7 3 33e-2
VS8 8 s8 0
R8 s8 3 10e1
VS9 4 s9 0
I9 s9 17 DC 27e-3
VS10 1 s10 0
R10 s10 10 68e0
VS11 4 s11 0
R11 s11 17 10e0
VS12 19 s12 0
R12 s12 9 27e2
VS13 19 s13 0
R13 s13 10 82e2
VS14 12 s14 0
R14 s14 10 33e2
VS15 14 s15 0
R15 s15 7 82e1
VS16 16 s16 0
R16 s16 0 15e0
VS17 0 s17 0
R17 s17 13 47e-1
VS18 0 s18 0
V18 e18 s18 DC 56e0
RI18 e18 9 39e-3
VS19 1 s19 0
R19 s19 17 10e0
VS20 21 s20 0
V20 e20 s20 DC 15e-1
RI20 e20 18 39e-2
VS21 0 s21 0
I21 s21 18 DC 56e-4
VS22 16 s22 0
R22 s22 15 39e2
VS23 5 s23 0
R23 s23 15 82e-2
VS24 14 s24 0
R24 s24 11 39e-1
VS25 20 s25 0
R25 s25 10 27e-2
VS26 19 s26 0
R26 s26 7 33e-2
VS27 13 s27 0
R27 s27 18 56e-2
VS28 11 s28 0
V28 e28 s28 DC 39e0
RI28 e28 20 82e-3
VS29 20 s29 0
V29 e29 s29 DC 27e1
RI29 e29 15 39e-1
VS30 4 s30 0
R30 s30 2 27e1
VS31 8 s31 0
V31 e31 s31 DC 39e1
RI31 e31 15 33e-1
.control
set numdgt=17
op
print v(1) v(2) v(3) v(4) v(5) v(6) v(7) v(8) v(9) v(10)
print v(11) v(12) v(13) v(14) v(15) v(16) v(17) v(18) v(19) v(20)
print v(21)
print i(vs0) i(vs1) i(vs2) i(vs3) i(vs4) i(vs5) i(vs6) i(vs7) i(vs8) i(vs9)
print i(vs10) i(vs11) i(vs12) i(vs13) i(vs14) i(vs15) i(vs16) i(vs17) i(vs18) i(vs19)
print i(vs20) i(vs21) i(vs22) i(vs23) i(vs24) i(vs25) i(vs26) i(vs27) i(vs28) i(vs29)
print i(vs30) i(vs31)
.endc
.end
