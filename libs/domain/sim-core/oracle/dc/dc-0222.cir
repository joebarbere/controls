controls oracle dc-0222
* Generated (plan F2.7, ADR 0012): do not edit; regenerate with `pnpm sim oracle regen`. dc seed 20261030 index 222 nodes 22 elements 24
.options sparse gmin=1e-12 noopac
RG1 1 0 1000000000000
RG2 2 0 1000000000000
RG3 3 0 1000000000000
RG4 4 0 1000000000000
RG5 5 0 1000000000000
RG6 6 0 1000000000000
RG7 7 0 1000000000000
RG8 8 0 1000000000000
RG9 9 0 1000000000000
RG10 10 0 1000000000000
RG11 11 0 1000000000000
RG12 12 0 1000000000000
RG13 13 0 1000000000000
RG14 14 0 1000000000000
RG15 15 0 1000000000000
RG16 16 0 1000000000000
RG17 17 0 1000000000000
RG18 18 0 1000000000000
RG19 19 0 1000000000000
RG20 20 0 1000000000000
RG21 21 0 1000000000000
VS0 0 s0 0
V0 e0 s0 DC 39e1
RI0 e0 15 33e-1
VS1 19 s1 0
R1 s1 10 82e2
VS2 8 s2 0
R2 s2 3 33e-2
VS3 1 s3 0
R3 s3 17 10e0
VS4 0 s4 0
R4 s4 18 18e-2
VS5 14 s5 0
R5 s5 7 82e1
VS6 4 s6 0
R6 s6 17 10e0
VS7 21 s7 0
V7 e7 s7 DC 15e-1
RI7 e7 18 39e-2
VS8 14 s8 0
R8 s8 11 39e-1
VS9 21 s9 0
R9 s9 6 39e-2
VS10 4 s10 0
R10 s10 2 27e1
VS11 16 s11 0
R11 s11 15 39e2
VS12 0 s12 0
R12 s12 17 15e2
VS13 8 s13 0
I13 s13 18 DC 56e-4
VS14 13 s14 0
R14 s14 18 56e-2
VS15 12 s15 0
R15 s15 10 33e2
VS16 5 s16 0
R16 s16 15 82e-2
VS17 1 s17 0
R17 s17 10 68e0
VS18 16 s18 0
R18 s18 8 15e0
VS19 0 s19 0
R19 s19 3 10e1
VS20 4 s20 0
I20 s20 17 DC 27e-3
VS21 11 s21 0
V21 e21 s21 DC 39e0
RI21 e21 20 82e-3
VS22 8 s22 0
V22 e22 s22 DC 56e0
RI22 e22 9 39e-3
VS23 11 s23 0
R23 s23 12 47e2
.control
set numdgt=17
op
print v(1) v(2) v(3) v(4) v(5) v(6) v(7) v(8) v(9) v(10)
print v(11) v(12) v(13) v(14) v(15) v(16) v(17) v(18) v(19) v(20)
print v(21)
print i(vs0) i(vs1) i(vs2) i(vs3) i(vs4) i(vs5) i(vs6) i(vs7) i(vs8) i(vs9)
print i(vs10) i(vs11) i(vs12) i(vs13) i(vs14) i(vs15) i(vs16) i(vs17) i(vs18) i(vs19)
print i(vs20) i(vs21) i(vs22) i(vs23)
.endc
.end
