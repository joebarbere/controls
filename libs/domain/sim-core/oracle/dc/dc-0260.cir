controls oracle dc-0260
* Generated (plan F2.7, ADR 0012): do not edit; regenerate with `pnpm sim oracle regen`. dc seed 20261030 index 260 nodes 14 elements 23
.options sparse gmin=1e-12 noopac
RG1 1 0 1000000000000
RG2 2 0 1000000000000
RG3 3 0 1000000000000
RG4 4 0 1000000000000
RG5 5 0 1000000000000
RG6 6 0 1000000000000
RG7 7 0 1000000000000
RG8 8 0 1000000000000
RG9 9 0 1000000000000
RG10 10 0 1000000000000
RG11 11 0 1000000000000
RG12 12 0 1000000000000
RG13 13 0 1000000000000
VS0 2 s0 0
R0 s0 10 12e1
VS1 0 s1 0
R1 s1 2 10e3
VS2 12 s2 0
R2 s2 0 18e0
VS3 9 s3 0
R3 s3 5 39e0
VS4 11 s4 0
R4 s4 0 27e3
VS5 3 s5 0
R5 s5 4 10e3
VS6 4 s6 0
R6 s6 8 47e1
VS7 0 s7 0
V7 e7 s7 DC 18e1
RI7 e7 5 27e-2
VS8 7 s8 0
R8 s8 9 39e3
VS9 7 s9 0
V9 e9 s9 DC 56e-1
RI9 e9 13 27e-1
VS10 6 s10 0
R10 s10 9 12e-1
VS11 2 s11 0
V11 e11 s11 DC 10e0
RI11 e11 11 18e-1
VS12 7 s12 0
R12 s12 10 39e2
VS13 5 s13 0
R13 s13 3 82e-2
VS14 13 s14 0
R14 s14 12 68e3
VS15 0 s15 0
R15 s15 12 18e0
VS16 6 s16 0
R16 s16 3 12e-1
VS17 8 s17 0
V17 e17 s17 DC 22e-1
RI17 e17 1 82e-3
VS18 9 s18 0
R18 s18 6 27e-1
VS19 1 s19 0
V19 e19 s19 DC 12e1
RI19 e19 9 82e-2
VS20 0 s20 0
R20 s20 6 12e2
VS21 12 s21 0
R21 s21 8 56e1
VS22 12 s22 0
R22 s22 10 56e-1
.control
set numdgt=17
op
print v(1) v(2) v(3) v(4) v(5) v(6) v(7) v(8) v(9) v(10)
print v(11) v(12) v(13)
print i(vs0) i(vs1) i(vs2) i(vs3) i(vs4) i(vs5) i(vs6) i(vs7) i(vs8) i(vs9)
print i(vs10) i(vs11) i(vs12) i(vs13) i(vs14) i(vs15) i(vs16) i(vs17) i(vs18) i(vs19)
print i(vs20) i(vs21) i(vs22)
.endc
.end
