controls oracle dc-0260
* Generated (plan F2.7, ADR 0012): do not edit; regenerate with `pnpm sim oracle regen`. dc seed 20261030 index 260 nodes 14 elements 18
.options sparse gmin=1e-12 noopac
RG1 1 0 1000000000000
RG2 2 0 1000000000000
RG3 3 0 1000000000000
RG4 4 0 1000000000000
RG5 5 0 1000000000000
RG6 6 0 1000000000000
RG7 7 0 1000000000000
RG8 8 0 1000000000000
RG9 9 0 1000000000000
RG10 10 0 1000000000000
RG11 11 0 1000000000000
RG12 12 0 1000000000000
RG13 13 0 1000000000000
VS0 11 s0 0
R0 s0 2 27e3
VS1 12 s1 0
R1 s1 2 18e0
VS2 2 s2 0
R2 s2 12 18e0
VS3 6 s3 0
R3 s3 9 12e-1
VS4 3 s4 0
R4 s4 4 10e3
VS5 9 s5 0
R5 s5 6 27e-1
VS6 0 s6 0
R6 s6 9 39e3
VS7 2 s7 0
R7 s7 6 12e2
VS8 0 s8 0
V8 e8 s8 DC 56e-1
RI8 e8 13 27e-1
VS9 8 s9 0
V9 e9 s9 DC 22e-1
RI9 e9 1 82e-3
VS10 12 s10 0
R10 s10 8 56e1
VS11 2 s11 0
V11 e11 s11 DC 18e1
RI11 e11 5 27e-2
VS12 5 s12 0
R12 s12 3 82e-2
VS13 2 s13 0
R13 s13 7 10e3
VS14 9 s14 0
R14 s14 5 39e0
VS15 6 s15 0
R15 s15 3 12e-1
VS16 1 s16 0
V16 e16 s16 DC 12e1
RI16 e16 9 82e-2
VS17 12 s17 0
R17 s17 10 56e-1
.control
set numdgt=17
op
print v(1) v(2) v(3) v(4) v(5) v(6) v(7) v(8) v(9) v(10)
print v(11) v(12) v(13)
print i(vs0) i(vs1) i(vs2) i(vs3) i(vs4) i(vs5) i(vs6) i(vs7) i(vs8) i(vs9)
print i(vs10) i(vs11) i(vs12) i(vs13) i(vs14) i(vs15) i(vs16) i(vs17)
.endc
.end
