controls oracle dc-0389
* Generated (plan F2.7, ADR 0012): do not edit; regenerate with `pnpm sim oracle regen`. dc seed 20261030 index 389 nodes 28 elements 56
.options sparse gmin=1e-12 noopac
RG1 1 0 1000000000000
RG2 2 0 1000000000000
RG3 3 0 1000000000000
RG4 4 0 1000000000000
RG5 5 0 1000000000000
RG6 6 0 1000000000000
RG7 7 0 1000000000000
RG8 8 0 1000000000000
RG9 9 0 1000000000000
RG10 10 0 1000000000000
RG11 11 0 1000000000000
RG12 12 0 1000000000000
RG13 13 0 1000000000000
RG14 14 0 1000000000000
RG15 15 0 1000000000000
RG16 16 0 1000000000000
RG17 17 0 1000000000000
RG18 18 0 1000000000000
RG19 19 0 1000000000000
RG20 20 0 1000000000000
RG21 21 0 1000000000000
RG22 22 0 1000000000000
RG23 23 0 1000000000000
RG24 24 0 1000000000000
RG25 25 0 1000000000000
RG26 26 0 1000000000000
RG27 27 0 1000000000000
VS0 8 s0 0
R0 s0 15 56e2
VS1 0 s1 0
V1 e1 s1 DC 56e-1
RI1 e1 10 39e-2
VS2 11 s2 0
R2 s2 25 68e3
VS3 6 s3 0
R3 s3 15 47e3
VS4 27 s4 0
V4 e4 s4 DC 33e0
RI4 e4 23 12e-3
VS5 14 s5 0
R5 s5 5 12e0
VS6 21 s6 0
R6 s6 18 56e1
VS7 25 s7 0
R7 s7 0 33e0
VS8 6 s8 0
R8 s8 14 10e0
VS9 4 s9 0
V9 e9 s9 DC 39e1
RI9 e9 7 22e-1
VS10 15 s10 0
I10 s10 16 DC 15e-1
VS11 1 s11 0
R11 s11 15 47e1
VS12 4 s12 0
R12 s12 6 56e-1
VS13 10 s13 0
R13 s13 6 22e-1
VS14 0 s14 0
R14 s14 23 12e-2
VS15 10 s15 0
V15 e15 s15 DC 27e1
RI15 e15 3 10e-1
VS16 18 s16 0
R16 s16 0 82e1
VS17 25 s17 0
R17 s17 11 27e1
VS18 8 s18 0
R18 s18 18 33e3
VS19 18 s19 0
V19 e19 s19 DC 82e1
RI19 e19 3 18e-3
VS20 20 s20 0
I20 s20 22 DC 15e-4
VS21 11 s21 0
R21 s21 18 27e-1
VS22 3 s22 0
R22 s22 17 27e-2
VS23 6 s23 0
R23 s23 1 18e0
VS24 20 s24 0
R24 s24 4 39e0
VS25 7 s25 0
R25 s25 6 10e2
VS26 22 s26 0
V26 e26 s26 DC 47e1
RI26 e26 2 56e-2
VS27 21 s27 0
R27 s27 3 56e-2
VS28 20 s28 0
I28 s28 19 DC 68e-1
VS29 18 s29 0
R29 s29 22 39e0
VS30 4 s30 0
I30 s30 26 DC 12e-1
VS31 19 s31 0
V31 e31 s31 DC 15e1
RI31 e31 12 10e-2
VS32 20 s32 0
V32 e32 s32 DC 15e0
RI32 e32 8 12e-2
VS33 0 s33 0
I33 s33 12 DC 27e-2
VS34 26 s34 0
R34 s34 2 82e3
VS35 23 s35 0
I35 s35 10 DC 27e-2
VS36 13 s36 0
R36 s36 24 27e0
VS37 16 s37 0
V37 e37 s37 DC 10e-1
RI37 e37 3 15e-2
VS38 17 s38 0
R38 s38 2 10e3
VS39 27 s39 0
R39 s39 9 82e-2
VS40 24 s40 0
R40 s40 11 56e0
VS41 26 s41 0
V41 e41 s41 DC 33e1
RI41 e41 17 18e-1
VS42 23 s42 0
R42 s42 19 39e2
VS43 13 s43 0
V43 e43 s43 DC 12e0
RI43 e43 14 27e-2
VS44 4 s44 0
R44 s44 27 10e3
VS45 9 s45 0
V45 e45 s45 DC 10e0
RI45 e45 16 10e-3
VS46 27 s46 0
R46 s46 2 47e-2
VS47 20 s47 0
I47 s47 15 DC 56e-4
VS48 22 s48 0
R48 s48 12 22e2
VS49 27 s49 0
R49 s49 11 18e2
VS50 16 s50 0
R50 s50 5 27e0
VS51 16 s51 0
R51 s51 23 18e1
VS52 27 s52 0
V52 e52 s52 DC 22e0
RI52 e52 5 22e-3
VS53 8 s53 0
R53 s53 2 18e-2
VS54 4 s54 0
V54 e54 s54 DC 56e-1
RI54 e54 12 33e-3
VS55 16 s55 0
R55 s55 0 12e2
.control
set numdgt=17
op
print v(1) v(2) v(3) v(4) v(5) v(6) v(7) v(8) v(9) v(10)
print v(11) v(12) v(13) v(14) v(15) v(16) v(17) v(18) v(19) v(20)
print v(21) v(22) v(23) v(24) v(25) v(26) v(27)
print i(vs0) i(vs1) i(vs2) i(vs3) i(vs4) i(vs5) i(vs6) i(vs7) i(vs8) i(vs9)
print i(vs10) i(vs11) i(vs12) i(vs13) i(vs14) i(vs15) i(vs16) i(vs17) i(vs18) i(vs19)
print i(vs20) i(vs21) i(vs22) i(vs23) i(vs24) i(vs25) i(vs26) i(vs27) i(vs28) i(vs29)
print i(vs30) i(vs31) i(vs32) i(vs33) i(vs34) i(vs35) i(vs36) i(vs37) i(vs38) i(vs39)
print i(vs40) i(vs41) i(vs42) i(vs43) i(vs44) i(vs45) i(vs46) i(vs47) i(vs48) i(vs49)
print i(vs50) i(vs51) i(vs52) i(vs53) i(vs54) i(vs55)
.endc
.end
