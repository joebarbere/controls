controls oracle dc-0389
* Generated (plan F2.7, ADR 0012): do not edit; regenerate with `pnpm sim oracle regen`. dc seed 20261030 index 389 nodes 28 elements 51
.options sparse gmin=1e-12 noopac
RG1 1 0 1000000000000
RG2 2 0 1000000000000
RG3 3 0 1000000000000
RG4 4 0 1000000000000
RG5 5 0 1000000000000
RG6 6 0 1000000000000
RG7 7 0 1000000000000
RG8 8 0 1000000000000
RG9 9 0 1000000000000
RG10 10 0 1000000000000
RG11 11 0 1000000000000
RG12 12 0 1000000000000
RG13 13 0 1000000000000
RG14 14 0 1000000000000
RG15 15 0 1000000000000
RG16 16 0 1000000000000
RG17 17 0 1000000000000
RG18 18 0 1000000000000
RG19 19 0 1000000000000
RG20 20 0 1000000000000
RG21 21 0 1000000000000
RG22 22 0 1000000000000
RG23 23 0 1000000000000
RG24 24 0 1000000000000
RG25 25 0 1000000000000
RG26 26 0 1000000000000
RG27 27 0 1000000000000
VS0 0 s0 0
V0 e0 s0 DC 10e0
RI0 e0 16 10e-3
VS1 20 s1 0
I1 s1 15 DC 56e-4
VS2 25 s2 0
R2 s2 11 27e1
VS3 13 s3 0
R3 s3 24 27e0
VS4 3 s4 0
R4 s4 17 27e-2
VS5 16 s5 0
R5 s5 23 18e1
VS6 11 s6 0
R6 s6 25 68e3
VS7 1 s7 0
R7 s7 15 47e1
VS8 10 s8 0
R8 s8 6 22e-1
VS9 4 s9 0
R9 s9 27 10e3
VS10 21 s10 0
R10 s10 3 56e-2
VS11 27 s11 0
R11 s11 0 82e-2
VS12 27 s12 0
R12 s12 2 47e-2
VS13 8 s13 0
R13 s13 9 33e3
VS14 26 s14 0
V14 e14 s14 DC 33e1
RI14 e14 17 18e-1
VS15 17 s15 0
R15 s15 2 10e3
VS16 15 s16 0
I16 s16 16 DC 15e-1
VS17 9 s17 0
R17 s17 22 39e0
VS18 24 s18 0
R18 s18 11 56e0
VS19 4 s19 0
V19 e19 s19 DC 39e1
RI19 e19 7 22e-1
VS20 16 s20 0
R20 s20 18 12e2
VS21 9 s21 0
R21 s21 18 82e1
VS22 4 s22 0
I22 s22 26 DC 12e-1
VS23 20 s23 0
I23 s23 22 DC 15e-4
VS24 6 s24 0
R24 s24 14 10e0
VS25 27 s25 0
R25 s25 11 18e2
VS26 4 s26 0
R26 s26 6 56e-1
VS27 6 s27 0
R27 s27 15 47e3
VS28 10 s28 0
V28 e28 s28 DC 27e1
RI28 e28 3 10e-1
VS29 20 s29 0
V29 e29 s29 DC 15e0
RI29 e29 8 12e-2
VS30 8 s30 0
R30 s30 2 18e-2
VS31 22 s31 0
R31 s31 12 22e2
VS32 9 s32 0
V32 e32 s32 DC 82e1
RI32 e32 3 18e-3
VS33 16 s33 0
V33 e33 s33 DC 10e-1
RI33 e33 3 15e-2
VS34 14 s34 0
R34 s34 5 12e0
VS35 27 s35 0
V35 e35 s35 DC 33e0
RI35 e35 23 12e-3
VS36 7 s36 0
R36 s36 6 10e2
VS37 18 s37 0
I37 s37 12 DC 27e-2
VS38 23 s38 0
R38 s38 19 39e2
VS39 27 s39 0
V39 e39 s39 DC 22e0
RI39 e39 5 22e-3
VS40 23 s40 0
I40 s40 10 DC 27e-2
VS41 20 s41 0
I41 s41 19 DC 68e-1
VS42 21 s42 0
R42 s42 9 56e1
VS43 22 s43 0
V43 e43 s43 DC 47e1
RI43 e43 2 56e-2
VS44 25 s44 0
R44 s44 18 33e0
VS45 20 s45 0
R45 s45 4 39e0
VS46 11 s46 0
R46 s46 9 27e-1
VS47 6 s47 0
R47 s47 1 18e0
VS48 16 s48 0
R48 s48 5 27e0
VS49 18 s49 0
R49 s49 23 12e-2
VS50 18 s50 0
V50 e50 s50 DC 56e-1
RI50 e50 10 39e-2
.control
set numdgt=17
op
print v(1) v(2) v(3) v(4) v(5) v(6) v(7) v(8) v(9) v(10)
print v(11) v(12) v(13) v(14) v(15) v(16) v(17) v(18) v(19) v(20)
print v(21) v(22) v(23) v(24) v(25) v(26) v(27)
print i(vs0) i(vs1) i(vs2) i(vs3) i(vs4) i(vs5) i(vs6) i(vs7) i(vs8) i(vs9)
print i(vs10) i(vs11) i(vs12) i(vs13) i(vs14) i(vs15) i(vs16) i(vs17) i(vs18) i(vs19)
print i(vs20) i(vs21) i(vs22) i(vs23) i(vs24) i(vs25) i(vs26) i(vs27) i(vs28) i(vs29)
print i(vs30) i(vs31) i(vs32) i(vs33) i(vs34) i(vs35) i(vs36) i(vs37) i(vs38) i(vs39)
print i(vs40) i(vs41) i(vs42) i(vs43) i(vs44) i(vs45) i(vs46) i(vs47) i(vs48) i(vs49)
print i(vs50)
.endc
.end
