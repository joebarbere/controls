controls oracle dc-0166
* Generated (plan F2.7, ADR 0012): do not edit; regenerate with `pnpm sim oracle regen`. dc seed 20261030 index 166 nodes 19 elements 26
.options sparse gmin=1e-12 noopac
RG1 1 0 1000000000000
RG2 2 0 1000000000000
RG3 3 0 1000000000000
RG4 4 0 1000000000000
RG5 5 0 1000000000000
RG6 6 0 1000000000000
RG7 7 0 1000000000000
RG8 8 0 1000000000000
RG9 9 0 1000000000000
RG10 10 0 1000000000000
RG11 11 0 1000000000000
RG12 12 0 1000000000000
RG13 13 0 1000000000000
RG14 14 0 1000000000000
RG15 15 0 1000000000000
RG16 16 0 1000000000000
RG17 17 0 1000000000000
RG18 18 0 1000000000000
VS0 0 s0 0
V0 e0 s0 DC 15e1
RI0 e0 5 47e-3
VS1 5 s1 0
R1 s1 6 33e-1
VS2 3 s2 0
R2 s2 1 22e0
VS3 9 s3 0
R3 s3 13 18e-2
VS4 16 s4 0
V4 e4 s4 DC 27e-1
RI4 e4 5 68e-1
VS5 16 s5 0
R5 s5 14 27e-1
VS6 7 s6 0
R6 s6 14 12e3
VS7 12 s7 0
R7 s7 11 33e1
VS8 7 s8 0
R8 s8 11 10e1
VS9 18 s9 0
R9 s9 15 56e3
VS10 5 s10 0
R10 s10 4 10e-1
VS11 5 s11 0
R11 s11 8 27e3
VS12 7 s12 0
R12 s12 8 47e2
VS13 2 s13 0
R13 s13 13 22e3
VS14 10 s14 0
V14 e14 s14 DC 22e0
RI14 e14 13 22e-2
VS15 3 s15 0
R15 s15 12 15e-2
VS16 2 s16 0
R16 s16 6 18e1
VS17 12 s17 0
R17 s17 18 12e1
VS18 14 s18 0
V18 e18 s18 DC 33e-1
RI18 e18 17 22e-2
VS19 1 s19 0
R19 s19 6 47e-1
VS20 9 s20 0
V20 e20 s20 DC 22e-1
RI20 e20 17 56e-1
VS21 0 s21 0
R21 s21 10 18e2
VS22 15 s22 0
R22 s22 5 47e-1
VS23 12 s23 0
R23 s23 0 56e-1
VS24 4 s24 0
R24 s24 3 82e1
VS25 14 s25 0
R25 s25 0 10e3
.control
set numdgt=17
op
print v(1) v(2) v(3) v(4) v(5) v(6) v(7) v(8) v(9) v(10)
print v(11) v(12) v(13) v(14) v(15) v(16) v(17) v(18)
print i(vs0) i(vs1) i(vs2) i(vs3) i(vs4) i(vs5) i(vs6) i(vs7) i(vs8) i(vs9)
print i(vs10) i(vs11) i(vs12) i(vs13) i(vs14) i(vs15) i(vs16) i(vs17) i(vs18) i(vs19)
print i(vs20) i(vs21) i(vs22) i(vs23) i(vs24) i(vs25)
.endc
.end
