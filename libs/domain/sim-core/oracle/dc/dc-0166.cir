controls oracle dc-0166
* Generated (plan F2.7, ADR 0012): do not edit; regenerate with `pnpm sim oracle regen`. dc seed 20261030 index 166 nodes 19 elements 19
.options sparse gmin=1e-12 noopac
RG1 1 0 1000000000000
RG2 2 0 1000000000000
RG3 3 0 1000000000000
RG4 4 0 1000000000000
RG5 5 0 1000000000000
RG6 6 0 1000000000000
RG7 7 0 1000000000000
RG8 8 0 1000000000000
RG9 9 0 1000000000000
RG10 10 0 1000000000000
RG11 11 0 1000000000000
RG12 12 0 1000000000000
RG13 13 0 1000000000000
RG14 14 0 1000000000000
RG15 15 0 1000000000000
RG16 16 0 1000000000000
RG17 17 0 1000000000000
RG18 18 0 1000000000000
VS0 10 s0 0
R0 s0 0 18e2
VS1 14 s1 0
R1 s1 10 10e3
VS2 0 s2 0
V2 e2 s2 DC 22e0
RI2 e2 13 22e-2
VS3 14 s3 0
V3 e3 s3 DC 33e-1
RI3 e3 17 22e-2
VS4 7 s4 0
R4 s4 11 10e1
VS5 15 s5 0
R5 s5 5 47e-1
VS6 5 s6 0
R6 s6 4 10e-1
VS7 2 s7 0
R7 s7 6 18e1
VS8 10 s8 0
V8 e8 s8 DC 15e1
RI8 e8 5 47e-3
VS9 5 s9 0
R9 s9 6 33e-1
VS10 3 s10 0
R10 s10 12 15e-2
VS11 16 s11 0
R11 s11 14 27e-1
VS12 5 s12 0
R12 s12 8 27e3
VS13 12 s13 0
R13 s13 10 56e-1
VS14 7 s14 0
R14 s14 8 47e2
VS15 9 s15 0
V15 e15 s15 DC 22e-1
RI15 e15 17 56e-1
VS16 7 s16 0
R16 s16 14 12e3
VS17 1 s17 0
R17 s17 6 47e-1
VS18 18 s18 0
R18 s18 15 56e3
.control
set numdgt=17
op
print v(1) v(2) v(3) v(4) v(5) v(6) v(7) v(8) v(9) v(10)
print v(11) v(12) v(13) v(14) v(15) v(16) v(17) v(18)
print i(vs0) i(vs1) i(vs2) i(vs3) i(vs4) i(vs5) i(vs6) i(vs7) i(vs8) i(vs9)
print i(vs10) i(vs11) i(vs12) i(vs13) i(vs14) i(vs15) i(vs16) i(vs17) i(vs18)
.endc
.end
