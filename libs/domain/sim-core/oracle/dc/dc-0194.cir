controls oracle dc-0194
* Generated (plan F2.7, ADR 0012): do not edit; regenerate with `pnpm sim oracle regen`. dc seed 20261030 index 194 nodes 26 elements 54
.options sparse gmin=1e-12 noopac
RG1 1 0 1000000000000
RG2 2 0 1000000000000
RG3 3 0 1000000000000
RG4 4 0 1000000000000
RG5 5 0 1000000000000
RG6 6 0 1000000000000
RG7 7 0 1000000000000
RG8 8 0 1000000000000
RG9 9 0 1000000000000
RG10 10 0 1000000000000
RG11 11 0 1000000000000
RG12 12 0 1000000000000
RG13 13 0 1000000000000
RG14 14 0 1000000000000
RG15 15 0 1000000000000
RG16 16 0 1000000000000
RG17 17 0 1000000000000
RG18 18 0 1000000000000
RG19 19 0 1000000000000
RG20 20 0 1000000000000
RG21 21 0 1000000000000
RG22 22 0 1000000000000
RG23 23 0 1000000000000
RG24 24 0 1000000000000
RG25 25 0 1000000000000
VS0 23 s0 0
R0 s0 7 15e3
VS1 0 s1 0
V1 e1 s1 DC 18e-1
RI1 e1 7 22e-2
VS2 13 s2 0
R2 s2 7 22e1
VS3 3 s3 0
V3 e3 s3 DC 82e-1
RI3 e3 11 56e-2
VS4 3 s4 0
R4 s4 9 33e-2
VS5 7 s5 0
V5 e5 s5 DC 18e1
RI5 e5 20 22e-1
VS6 3 s6 0
R6 s6 11 27e2
VS7 0 s7 0
R7 s7 15 39e3
VS8 4 s8 0
R8 s8 17 56e-1
VS9 10 s9 0
I9 s9 11 DC 22e-1
VS10 23 s10 0
R10 s10 6 68e-2
VS11 25 s11 0
R11 s11 13 68e3
VS12 24 s12 0
R12 s12 21 47e2
VS13 10 s13 0
R13 s13 24 33e-1
VS14 8 s14 0
I14 s14 24 DC 56e-4
VS15 8 s15 0
V15 e15 s15 DC 47e0
RI15 e15 1 56e-3
VS16 2 s16 0
V16 e16 s16 DC 10e1
RI16 e16 18 12e-3
VS17 5 s17 0
I17 s17 7 DC 15e-4
VS18 21 s18 0
R18 s18 11 18e-2
VS19 2 s19 0
I19 s19 22 DC 56e-1
VS20 22 s20 0
I20 s20 15 DC 82e-3
VS21 9 s21 0
R21 s21 6 82e-2
VS22 2 s22 0
R22 s22 15 47e2
VS23 18 s23 0
V23 e23 s23 DC 12e1
RI23 e23 2 56e-2
VS24 14 s24 0
R24 s24 18 39e0
VS25 16 s25 0
R25 s25 23 56e1
VS26 17 s26 0
I26 s26 18 DC 22e-1
VS27 8 s27 0
V27 e27 s27 DC 39e-1
RI27 e27 16 82e-3
VS28 21 s28 0
R28 s28 1 12e1
VS29 0 s29 0
R29 s29 25 15e0
VS30 24 s30 0
R30 s30 19 10e2
VS31 10 s31 0
V31 e31 s31 DC 18e0
RI31 e31 2 12e-1
VS32 13 s32 0
R32 s32 23 56e-1
VS33 5 s33 0
V33 e33 s33 DC 47e-1
RI33 e33 0 68e-2
VS34 24 s34 0
R34 s34 20 27e0
VS35 16 s35 0
R35 s35 19 33e-2
VS36 16 s36 0
R36 s36 17 56e2
VS37 3 s37 0
R37 s37 23 12e3
VS38 1 s38 0
R38 s38 22 27e0
VS39 7 s39 0
R39 s39 4 39e-2
VS40 13 s40 0
R40 s40 22 27e3
VS41 2 s41 0
V41 e41 s41 DC 15e0
RI41 e41 1 33e-3
VS42 1 s42 0
V42 e42 s42 DC 10e-1
RI42 e42 13 15e-2
VS43 12 s43 0
R43 s43 21 68e1
VS44 14 s44 0
V44 e44 s44 DC 68e0
RI44 e44 0 56e-1
VS45 2 s45 0
R45 s45 19 47e2
VS46 2 s46 0
R46 s46 24 10e-1
VS47 3 s47 0
R47 s47 19 33e2
VS48 21 s48 0
R48 s48 5 22e1
VS49 21 s49 0
R49 s49 24 10e0
VS50 25 s50 0
V50 e50 s50 DC 10e0
RI50 e50 17 18e-2
VS51 2 s51 0
R51 s51 12 56e3
VS52 9 s52 0
I52 s52 0 DC 56e-1
VS53 14 s53 0
R53 s53 6 22e-1
.control
set numdgt=17
op
print v(1) v(2) v(3) v(4) v(5) v(6) v(7) v(8) v(9) v(10)
print v(11) v(12) v(13) v(14) v(15) v(16) v(17) v(18) v(19) v(20)
print v(21) v(22) v(23) v(24) v(25)
print i(vs0) i(vs1) i(vs2) i(vs3) i(vs4) i(vs5) i(vs6) i(vs7) i(vs8) i(vs9)
print i(vs10) i(vs11) i(vs12) i(vs13) i(vs14) i(vs15) i(vs16) i(vs17) i(vs18) i(vs19)
print i(vs20) i(vs21) i(vs22) i(vs23) i(vs24) i(vs25) i(vs26) i(vs27) i(vs28) i(vs29)
print i(vs30) i(vs31) i(vs32) i(vs33) i(vs34) i(vs35) i(vs36) i(vs37) i(vs38) i(vs39)
print i(vs40) i(vs41) i(vs42) i(vs43) i(vs44) i(vs45) i(vs46) i(vs47) i(vs48) i(vs49)
print i(vs50) i(vs51) i(vs52) i(vs53)
.endc
.end
