controls oracle dc-0194
* Generated (plan F2.7, ADR 0012): do not edit; regenerate with `pnpm sim oracle regen`. dc seed 20261030 index 194 nodes 26 elements 49
.options sparse gmin=1e-12 noopac
RG1 1 0 1000000000000
RG2 2 0 1000000000000
RG3 3 0 1000000000000
RG4 4 0 1000000000000
RG5 5 0 1000000000000
RG6 6 0 1000000000000
RG7 7 0 1000000000000
RG8 8 0 1000000000000
RG9 9 0 1000000000000
RG10 10 0 1000000000000
RG11 11 0 1000000000000
RG12 12 0 1000000000000
RG13 13 0 1000000000000
RG14 14 0 1000000000000
RG15 15 0 1000000000000
RG16 16 0 1000000000000
RG17 17 0 1000000000000
RG18 18 0 1000000000000
RG19 19 0 1000000000000
RG20 20 0 1000000000000
RG21 21 0 1000000000000
RG22 22 0 1000000000000
RG23 23 0 1000000000000
RG24 24 0 1000000000000
RG25 25 0 1000000000000
VS0 5 s0 0
I0 s0 7 DC 15e-4
VS1 23 s1 0
R1 s1 6 68e-2
VS2 3 s2 0
R2 s2 9 33e-2
VS3 13 s3 0
R3 s3 23 56e-1
VS4 0 s4 0
V4 e4 s4 DC 18e0
RI4 e4 10 12e-1
VS5 10 s5 0
R5 s5 19 47e2
VS6 2 s6 0
V6 e6 s6 DC 18e-1
RI6 e6 7 22e-2
VS7 13 s7 0
R7 s7 7 22e1
VS8 16 s8 0
R8 s8 17 56e2
VS9 25 s9 0
R9 s9 13 68e3
VS10 21 s10 0
R10 s10 11 18e-2
VS11 17 s11 0
I11 s11 18 DC 22e-1
VS12 21 s12 0
R12 s12 1 12e1
VS13 3 s13 0
R13 s13 11 27e2
VS14 1 s14 0
R14 s14 22 27e0
VS15 4 s15 0
R15 s15 17 56e-1
VS16 21 s16 0
R16 s16 5 22e1
VS17 16 s17 0
R17 s17 19 33e-2
VS18 18 s18 0
V18 e18 s18 DC 12e1
RI18 e18 10 56e-2
VS19 10 s19 0
I19 s19 22 DC 56e-1
VS20 14 s20 0
R20 s20 6 22e-1
VS21 7 s21 0
R21 s21 4 39e-2
VS22 0 s22 0
R22 s22 24 33e-1
VS23 9 s23 0
I23 s23 2 DC 56e-1
VS24 24 s24 0
R24 s24 19 10e2
VS25 10 s25 0
V25 e25 s25 DC 15e0
RI25 e25 1 33e-3
VS26 23 s26 0
R26 s26 7 15e3
VS27 0 s27 0
I27 s27 11 DC 22e-1
VS28 10 s28 0
V28 e28 s28 DC 10e1
RI28 e28 18 12e-3
VS29 16 s29 0
R29 s29 23 56e1
VS30 5 s30 0
V30 e30 s30 DC 47e-1
RI30 e30 2 68e-2
VS31 7 s31 0
V31 e31 s31 DC 18e1
RI31 e31 20 22e-1
VS32 24 s32 0
R32 s32 21 47e2
VS33 10 s33 0
R33 s33 12 56e3
VS34 8 s34 0
V34 e34 s34 DC 47e0
RI34 e34 1 56e-3
VS35 2 s35 0
R35 s35 15 39e3
VS36 24 s36 0
R36 s36 20 27e0
VS37 22 s37 0
I37 s37 15 DC 82e-3
VS38 2 s38 0
R38 s38 25 15e0
VS39 10 s39 0
R39 s39 15 47e2
VS40 14 s40 0
V40 e40 s40 DC 68e0
RI40 e40 2 56e-1
VS41 3 s41 0
V41 e41 s41 DC 82e-1
RI41 e41 11 56e-2
VS42 25 s42 0
V42 e42 s42 DC 10e0
RI42 e42 17 18e-2
VS43 3 s43 0
R43 s43 19 33e2
VS44 8 s44 0
I44 s44 24 DC 56e-4
VS45 10 s45 0
R45 s45 24 10e-1
VS46 3 s46 0
R46 s46 23 12e3
VS47 1 s47 0
V47 e47 s47 DC 10e-1
RI47 e47 13 15e-2
VS48 21 s48 0
R48 s48 24 10e0
.control
set numdgt=17
op
print v(1) v(2) v(3) v(4) v(5) v(6) v(7) v(8) v(9) v(10)
print v(11) v(12) v(13) v(14) v(15) v(16) v(17) v(18) v(19) v(20)
print v(21) v(22) v(23) v(24) v(25)
print i(vs0) i(vs1) i(vs2) i(vs3) i(vs4) i(vs5) i(vs6) i(vs7) i(vs8) i(vs9)
print i(vs10) i(vs11) i(vs12) i(vs13) i(vs14) i(vs15) i(vs16) i(vs17) i(vs18) i(vs19)
print i(vs20) i(vs21) i(vs22) i(vs23) i(vs24) i(vs25) i(vs26) i(vs27) i(vs28) i(vs29)
print i(vs30) i(vs31) i(vs32) i(vs33) i(vs34) i(vs35) i(vs36) i(vs37) i(vs38) i(vs39)
print i(vs40) i(vs41) i(vs42) i(vs43) i(vs44) i(vs45) i(vs46) i(vs47) i(vs48)
.endc
.end
