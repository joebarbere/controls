controls oracle dc-0163
* Generated (plan F2.7, ADR 0012): do not edit; regenerate with `pnpm sim oracle regen`. dc seed 20261030 index 163 nodes 10 elements 15
.options sparse gmin=1e-12 noopac
RG1 1 0 1000000000000
RG2 2 0 1000000000000
RG3 3 0 1000000000000
RG4 4 0 1000000000000
RG5 5 0 1000000000000
RG6 6 0 1000000000000
RG7 7 0 1000000000000
RG8 8 0 1000000000000
RG9 9 0 1000000000000
VS0 4 s0 0
R0 s0 1 27e1
VS1 0 s1 0
V1 e1 s1 DC 33e0
RI1 e1 5 22e-2
VS2 4 s2 0
I2 s2 5 DC 22e-2
VS3 3 s3 0
I3 s3 0 DC 82e-2
VS4 7 s4 0
I4 s4 3 DC 47e-3
VS5 6 s5 0
R5 s5 3 47e-1
VS6 3 s6 0
R6 s6 2 22e-2
VS7 8 s7 0
R7 s7 4 82e0
VS8 0 s8 0
R8 s8 4 22e2
VS9 7 s9 0
V9 e9 s9 DC 27e1
RI9 e9 4 22e-1
VS10 1 s10 0
I10 s10 0 DC 56e-3
VS11 2 s11 0
V11 e11 s11 DC 10e1
RI11 e11 5 56e-1
VS12 0 s12 0
R12 s12 6 18e-2
VS13 4 s13 0
R13 s13 9 10e3
VS14 1 s14 0
V14 e14 s14 DC 39e-1
RI14 e14 7 22e-3
.control
set numdgt=17
op
print v(1) v(2) v(3) v(4) v(5) v(6) v(7) v(8) v(9)
print i(vs0) i(vs1) i(vs2) i(vs3) i(vs4) i(vs5) i(vs6) i(vs7) i(vs8) i(vs9)
print i(vs10) i(vs11) i(vs12) i(vs13) i(vs14)
.endc
.end
