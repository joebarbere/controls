controls oracle dc-0163
* Generated (plan F2.7, ADR 0012): do not edit; regenerate with `pnpm sim oracle regen`. dc seed 20261030 index 163 nodes 10 elements 18
.options sparse gmin=1e-12 noopac
RG1 1 0 1000000000000
RG2 2 0 1000000000000
RG3 3 0 1000000000000
RG4 4 0 1000000000000
RG5 5 0 1000000000000
RG6 6 0 1000000000000
RG7 7 0 1000000000000
RG8 8 0 1000000000000
RG9 9 0 1000000000000
VS0 3 s0 0
I0 s0 4 DC 82e-2
VS1 0 s1 0
V1 e1 s1 DC 27e1
RI1 e1 7 22e-1
VS2 1 s2 0
I2 s2 4 DC 56e-3
VS3 2 s3 0
R3 s3 0 39e1
VS4 7 s4 0
R4 s4 1 27e1
VS5 8 s5 0
R5 s5 7 82e0
VS6 4 s6 0
R6 s6 6 18e-2
VS7 7 s7 0
I7 s7 5 DC 22e-2
VS8 4 s8 0
V8 e8 s8 DC 33e0
RI8 e8 5 22e-2
VS9 1 s9 0
V9 e9 s9 DC 39e-1
RI9 e9 0 22e-3
VS10 4 s10 0
R10 s10 7 22e2
VS11 2 s11 0
V11 e11 s11 DC 10e1
RI11 e11 5 56e-1
VS12 7 s12 0
R12 s12 9 10e3
VS13 3 s13 0
R13 s13 2 22e-2
VS14 6 s14 0
R14 s14 3 47e-1
VS15 0 s15 0
I15 s15 3 DC 47e-3
VS16 8 s16 0
R16 s16 2 10e1
VS17 0 s17 0
R17 s17 9 10e2
.control
set numdgt=17
op
print v(1) v(2) v(3) v(4) v(5) v(6) v(7) v(8) v(9)
print i(vs0) i(vs1) i(vs2) i(vs3) i(vs4) i(vs5) i(vs6) i(vs7) i(vs8) i(vs9)
print i(vs10) i(vs11) i(vs12) i(vs13) i(vs14) i(vs15) i(vs16) i(vs17)
.endc
.end
