controls oracle dc-0123
* Generated (plan F2.7, ADR 0012): do not edit; regenerate with `pnpm sim oracle regen`. dc seed 20261030 index 123 nodes 16 elements 18
.options sparse gmin=1e-12 noopac
RG1 1 0 1000000000000
RG2 2 0 1000000000000
RG3 3 0 1000000000000
RG4 4 0 1000000000000
RG5 5 0 1000000000000
RG6 6 0 1000000000000
RG7 7 0 1000000000000
RG8 8 0 1000000000000
RG9 9 0 1000000000000
RG10 10 0 1000000000000
RG11 11 0 1000000000000
RG12 12 0 1000000000000
RG13 13 0 1000000000000
RG14 14 0 1000000000000
RG15 15 0 1000000000000
VS0 11 s0 0
I0 s0 1 DC 12e-4
VS1 0 s1 0
V1 e1 s1 DC 33e0
RI1 e1 11 12e-1
VS2 9 s2 0
V2 e2 s2 DC 33e-1
RI2 e2 0 39e-3
VS3 5 s3 0
R3 s3 15 18e0
VS4 4 s4 0
R4 s4 1 82e-2
VS5 0 s5 0
R5 s5 1 39e2
VS6 7 s6 0
R6 s6 3 47e0
VS7 8 s7 0
R7 s7 7 15e0
VS8 0 s8 0
R8 s8 15 82e2
VS9 9 s9 0
V9 e9 s9 DC 33e1
RI9 e9 5 18e-1
VS10 2 s10 0
R10 s10 0 15e1
VS11 0 s11 0
R11 s11 10 68e-1
VS12 13 s12 0
R12 s12 10 18e2
VS13 2 s13 0
R13 s13 3 33e-1
VS14 8 s14 0
R14 s14 5 82e0
VS15 12 s15 0
R15 s15 9 47e1
VS16 14 s16 0
V16 e16 s16 DC 56e1
RI16 e16 15 15e-3
VS17 6 s17 0
R17 s17 11 22e-2
.control
set numdgt=17
op
print v(1) v(2) v(3) v(4) v(5) v(6) v(7) v(8) v(9) v(10)
print v(11) v(12) v(13) v(14) v(15)
print i(vs0) i(vs1) i(vs2) i(vs3) i(vs4) i(vs5) i(vs6) i(vs7) i(vs8) i(vs9)
print i(vs10) i(vs11) i(vs12) i(vs13) i(vs14) i(vs15) i(vs16) i(vs17)
.endc
.end
