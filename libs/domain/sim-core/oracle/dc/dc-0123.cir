controls oracle dc-0123
* Generated (plan F2.7, ADR 0012): do not edit; regenerate with `pnpm sim oracle regen`. dc seed 20261030 index 123 nodes 16 elements 23
.options sparse gmin=1e-12 noopac
RG1 1 0 1000000000000
RG2 2 0 1000000000000
RG3 3 0 1000000000000
RG4 4 0 1000000000000
RG5 5 0 1000000000000
RG6 6 0 1000000000000
RG7 7 0 1000000000000
RG8 8 0 1000000000000
RG9 9 0 1000000000000
RG10 10 0 1000000000000
RG11 11 0 1000000000000
RG12 12 0 1000000000000
RG13 13 0 1000000000000
RG14 14 0 1000000000000
RG15 15 0 1000000000000
VS0 0 s0 0
V0 e0 s0 DC 33e1
RI0 e0 5 18e-1
VS1 8 s1 0
R1 s1 5 82e0
VS2 12 s2 0
R2 s2 8 68e2
VS3 5 s3 0
R3 s3 15 18e0
VS4 0 s4 0
V4 e4 s4 DC 33e-1
RI4 e4 11 39e-3
VS5 13 s5 0
R5 s5 10 18e2
VS6 13 s6 0
R6 s6 14 27e1
VS7 7 s7 0
R7 s7 3 47e0
VS8 13 s8 0
R8 s8 6 82e1
VS9 12 s9 0
R9 s9 0 47e1
VS10 11 s10 0
R10 s10 15 82e2
VS11 4 s11 0
R11 s11 1 82e-2
VS12 11 s12 0
V12 e12 s12 DC 33e0
RI12 e12 9 12e-1
VS13 2 s13 0
R13 s13 11 15e1
VS14 11 s14 0
R14 s14 10 68e-1
VS15 9 s15 0
I15 s15 1 DC 12e-4
VS16 6 s16 0
R16 s16 9 22e-2
VS17 14 s17 0
V17 e17 s17 DC 56e1
RI17 e17 15 15e-3
VS18 11 s18 0
R18 s18 1 39e2
VS19 4 s19 0
R19 s19 13 22e1
VS20 0 s20 0
V20 e20 s20 DC 47e1
RI20 e20 9 18e-2
VS21 2 s21 0
R21 s21 3 33e-1
VS22 8 s22 0
R22 s22 7 15e0
.control
set numdgt=17
op
print v(1) v(2) v(3) v(4) v(5) v(6) v(7) v(8) v(9) v(10)
print v(11) v(12) v(13) v(14) v(15)
print i(vs0) i(vs1) i(vs2) i(vs3) i(vs4) i(vs5) i(vs6) i(vs7) i(vs8) i(vs9)
print i(vs10) i(vs11) i(vs12) i(vs13) i(vs14) i(vs15) i(vs16) i(vs17) i(vs18) i(vs19)
print i(vs20) i(vs21) i(vs22)
.endc
.end
