controls oracle dc-0001
* Generated (plan F2.7, ADR 0012): do not edit; regenerate with `pnpm sim oracle regen`. dc seed 20261030 index 1 nodes 29 elements 60
.options sparse gmin=1e-12 noopac
RG1 1 0 1000000000000
RG2 2 0 1000000000000
RG3 3 0 1000000000000
RG4 4 0 1000000000000
RG5 5 0 1000000000000
RG6 6 0 1000000000000
RG7 7 0 1000000000000
RG8 8 0 1000000000000
RG9 9 0 1000000000000
RG10 10 0 1000000000000
RG11 11 0 1000000000000
RG12 12 0 1000000000000
RG13 13 0 1000000000000
RG14 14 0 1000000000000
RG15 15 0 1000000000000
RG16 16 0 1000000000000
RG17 17 0 1000000000000
RG18 18 0 1000000000000
RG19 19 0 1000000000000
RG20 20 0 1000000000000
RG21 21 0 1000000000000
RG22 22 0 1000000000000
RG23 23 0 1000000000000
RG24 24 0 1000000000000
RG25 25 0 1000000000000
RG26 26 0 1000000000000
RG27 27 0 1000000000000
RG28 28 0 1000000000000
VS0 23 s0 0
R0 s0 11 56e3
VS1 14 s1 0
R1 s1 22 39e2
VS2 16 s2 0
R2 s2 28 33e-1
VS3 26 s3 0
R3 s3 16 10e2
VS4 15 s4 0
I4 s4 12 DC 33e-2
VS5 17 s5 0
R5 s5 9 56e-1
VS6 12 s6 0
R6 s6 21 22e-2
VS7 12 s7 0
I7 s7 1 DC 47e-2
VS8 2 s8 0
R8 s8 6 39e0
VS9 9 s9 0
R9 s9 12 18e-1
VS10 11 s10 0
R10 s10 25 56e3
VS11 27 s11 0
R11 s11 5 47e0
VS12 12 s12 0
I12 s12 1 DC 15e-2
VS13 2 s13 0
R13 s13 9 12e1
VS14 25 s14 0
R14 s14 10 15e0
VS15 0 s15 0
V15 e15 s15 DC 10e-1
RI15 e15 6 39e-2
VS16 12 s16 0
R16 s16 28 33e1
VS17 12 s17 0
R17 s17 7 47e0
VS18 23 s18 0
R18 s18 1 12e3
VS19 1 s19 0
R19 s19 27 27e2
VS20 18 s20 0
R20 s20 25 82e1
VS21 6 s21 0
R21 s21 7 33e2
VS22 0 s22 0
R22 s22 15 22e0
VS23 5 s23 0
V23 e23 s23 DC 33e-1
RI23 e23 23 39e-3
VS24 8 s24 0
R24 s24 14 10e1
VS25 11 s25 0
I25 s25 1 DC 15e-4
VS26 10 s26 0
R26 s26 19 56e1
VS27 19 s27 0
R27 s27 20 10e2
VS28 23 s28 0
R28 s28 19 47e0
VS29 17 s29 0
R29 s29 11 18e-2
VS30 24 s30 0
R30 s30 14 27e2
VS31 14 s31 0
I31 s31 5 DC 18e-4
VS32 24 s32 0
R32 s32 12 47e2
VS33 11 s33 0
I33 s33 21 DC 15e-2
VS34 8 s34 0
R34 s34 1 15e1
VS35 28 s35 0
I35 s35 5 DC 10e-4
VS36 16 s36 0
I36 s36 26 DC 68e-3
VS37 20 s37 0
R37 s37 17 82e-1
VS38 23 s38 0
R38 s38 6 68e0
VS39 24 s39 0
R39 s39 17 39e0
VS40 3 s40 0
V40 e40 s40 DC 68e1
RI40 e40 27 39e-2
VS41 19 s41 0
R41 s41 11 56e1
VS42 3 s42 0
R42 s42 25 56e-2
VS43 19 s43 0
R43 s43 26 12e-1
VS44 1 s44 0
R44 s44 26 39e1
VS45 5 s45 0
R45 s45 13 27e1
VS46 18 s46 0
R46 s46 20 68e0
VS47 26 s47 0
V47 e47 s47 DC 33e0
RI47 e47 9 39e-1
VS48 15 s48 0
R48 s48 4 56e-2
VS49 8 s49 0
V49 e49 s49 DC 12e-1
RI49 e49 19 22e-1
VS50 11 s50 0
R50 s50 16 39e2
VS51 20 s51 0
R51 s51 4 33e3
VS52 20 s52 0
I52 s52 18 DC 82e-2
VS53 22 s53 0
R53 s53 9 47e2
VS54 6 s54 0
R54 s54 24 18e-1
VS55 1 s55 0
R55 s55 28 82e-1
VS56 21 s56 0
R56 s56 6 27e1
VS57 28 s57 0
V57 e57 s57 DC 47e0
RI57 e57 13 39e-3
VS58 19 s58 0
R58 s58 15 82e-2
VS59 6 s59 0
I59 s59 12 DC 10e-1
.control
set numdgt=17
op
print v(1) v(2) v(3) v(4) v(5) v(6) v(7) v(8) v(9) v(10)
print v(11) v(12) v(13) v(14) v(15) v(16) v(17) v(18) v(19) v(20)
print v(21) v(22) v(23) v(24) v(25) v(26) v(27) v(28)
print i(vs0) i(vs1) i(vs2) i(vs3) i(vs4) i(vs5) i(vs6) i(vs7) i(vs8) i(vs9)
print i(vs10) i(vs11) i(vs12) i(vs13) i(vs14) i(vs15) i(vs16) i(vs17) i(vs18) i(vs19)
print i(vs20) i(vs21) i(vs22) i(vs23) i(vs24) i(vs25) i(vs26) i(vs27) i(vs28) i(vs29)
print i(vs30) i(vs31) i(vs32) i(vs33) i(vs34) i(vs35) i(vs36) i(vs37) i(vs38) i(vs39)
print i(vs40) i(vs41) i(vs42) i(vs43) i(vs44) i(vs45) i(vs46) i(vs47) i(vs48) i(vs49)
print i(vs50) i(vs51) i(vs52) i(vs53) i(vs54) i(vs55) i(vs56) i(vs57) i(vs58) i(vs59)
.endc
.end
