controls oracle dc-0001
* Generated (plan F2.7, ADR 0012): do not edit; regenerate with `pnpm sim oracle regen`. dc seed 20261030 index 1 nodes 29 elements 56
.options sparse gmin=1e-12 noopac
RG1 1 0 1000000000000
RG2 2 0 1000000000000
RG3 3 0 1000000000000
RG4 4 0 1000000000000
RG5 5 0 1000000000000
RG6 6 0 1000000000000
RG7 7 0 1000000000000
RG8 8 0 1000000000000
RG9 9 0 1000000000000
RG10 10 0 1000000000000
RG11 11 0 1000000000000
RG12 12 0 1000000000000
RG13 13 0 1000000000000
RG14 14 0 1000000000000
RG15 15 0 1000000000000
RG16 16 0 1000000000000
RG17 17 0 1000000000000
RG18 18 0 1000000000000
RG19 19 0 1000000000000
RG20 20 0 1000000000000
RG21 21 0 1000000000000
RG22 22 0 1000000000000
RG23 23 0 1000000000000
RG24 24 0 1000000000000
RG25 25 0 1000000000000
RG26 26 0 1000000000000
RG27 27 0 1000000000000
RG28 28 0 1000000000000
VS0 23 s0 0
R0 s0 1 12e3
VS1 8 s1 0
R1 s1 14 10e1
VS2 10 s2 0
R2 s2 19 56e1
VS3 0 s3 0
V3 e3 s3 DC 33e0
RI3 e3 9 39e-1
VS4 20 s4 0
R4 s4 17 82e-1
VS5 0 s5 0
R5 s5 16 10e2
VS6 5 s6 0
V6 e6 s6 DC 33e-1
RI6 e6 23 39e-3
VS7 5 s7 0
R7 s7 13 27e1
VS8 9 s8 0
R8 s8 12 18e-1
VS9 19 s9 0
R9 s9 0 12e-1
VS10 14 s10 0
I10 s10 5 DC 18e-4
VS11 19 s11 0
R11 s11 15 82e-2
VS12 8 s12 0
V12 e12 s12 DC 12e-1
RI12 e12 19 22e-1
VS13 1 s13 0
R13 s13 28 82e-1
VS14 11 s14 0
R14 s14 25 56e3
VS15 12 s15 0
I15 s15 1 DC 15e-2
VS16 17 s16 0
R16 s16 11 18e-2
VS17 3 s17 0
V17 e17 s17 DC 68e1
RI17 e17 27 39e-2
VS18 6 s18 0
R18 s18 24 18e-1
VS19 12 s19 0
R19 s19 21 22e-2
VS20 20 s20 0
I20 s20 18 DC 82e-2
VS21 22 s21 0
R21 s21 9 47e2
VS22 12 s22 0
R22 s22 7 47e0
VS23 1 s23 0
R23 s23 0 39e1
VS24 17 s24 0
R24 s24 9 56e-1
VS25 8 s25 0
R25 s25 1 15e1
VS26 19 s26 0
R26 s26 11 56e1
VS27 24 s27 0
R27 s27 14 27e2
VS28 28 s28 0
V28 e28 s28 DC 47e0
RI28 e28 13 39e-3
VS29 18 s29 0
R29 s29 25 82e1
VS30 6 s30 0
R30 s30 7 33e2
VS31 16 s31 0
I31 s31 0 DC 68e-3
VS32 23 s32 0
R32 s32 19 47e0
VS33 1 s33 0
R33 s33 27 27e2
VS34 11 s34 0
I34 s34 1 DC 15e-4
VS35 23 s35 0
R35 s35 11 56e3
VS36 23 s36 0
R36 s36 6 68e0
VS37 25 s37 0
R37 s37 10 15e0
VS38 26 s38 0
R38 s38 15 22e0
VS39 11 s39 0
I39 s39 21 DC 15e-2
VS40 20 s40 0
R40 s40 4 33e3
VS41 15 s41 0
R41 s41 4 56e-2
VS42 19 s42 0
R42 s42 20 10e2
VS43 18 s43 0
R43 s43 20 68e0
VS44 15 s44 0
I44 s44 12 DC 33e-2
VS45 11 s45 0
R45 s45 16 39e2
VS46 12 s46 0
I46 s46 1 DC 47e-2
VS47 28 s47 0
I47 s47 5 DC 10e-4
VS48 6 s48 0
I48 s48 12 DC 10e-1
VS49 27 s49 0
R49 s49 5 47e0
VS50 24 s50 0
R50 s50 12 47e2
VS51 2 s51 0
R51 s51 9 12e1
VS52 12 s52 0
R52 s52 28 33e1
VS53 24 s53 0
R53 s53 17 39e0
VS54 16 s54 0
R54 s54 28 33e-1
VS55 2 s55 0
R55 s55 6 39e0
.control
set numdgt=17
op
print v(1) v(2) v(3) v(4) v(5) v(6) v(7) v(8) v(9) v(10)
print v(11) v(12) v(13) v(14) v(15) v(16) v(17) v(18) v(19) v(20)
print v(21) v(22) v(23) v(24) v(25) v(26) v(27) v(28)
print i(vs0) i(vs1) i(vs2) i(vs3) i(vs4) i(vs5) i(vs6) i(vs7) i(vs8) i(vs9)
print i(vs10) i(vs11) i(vs12) i(vs13) i(vs14) i(vs15) i(vs16) i(vs17) i(vs18) i(vs19)
print i(vs20) i(vs21) i(vs22) i(vs23) i(vs24) i(vs25) i(vs26) i(vs27) i(vs28) i(vs29)
print i(vs30) i(vs31) i(vs32) i(vs33) i(vs34) i(vs35) i(vs36) i(vs37) i(vs38) i(vs39)
print i(vs40) i(vs41) i(vs42) i(vs43) i(vs44) i(vs45) i(vs46) i(vs47) i(vs48) i(vs49)
print i(vs50) i(vs51) i(vs52) i(vs53) i(vs54) i(vs55)
.endc
.end
