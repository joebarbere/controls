controls oracle dc-0251
* Generated (plan F2.7, ADR 0012): do not edit; regenerate with `pnpm sim oracle regen`. dc seed 20261030 index 251 nodes 30 elements 51
.options sparse gmin=1e-12 noopac
RG1 1 0 1000000000000
RG2 2 0 1000000000000
RG3 3 0 1000000000000
RG4 4 0 1000000000000
RG5 5 0 1000000000000
RG6 6 0 1000000000000
RG7 7 0 1000000000000
RG8 8 0 1000000000000
RG9 9 0 1000000000000
RG10 10 0 1000000000000
RG11 11 0 1000000000000
RG12 12 0 1000000000000
RG13 13 0 1000000000000
RG14 14 0 1000000000000
RG15 15 0 1000000000000
RG16 16 0 1000000000000
RG17 17 0 1000000000000
RG18 18 0 1000000000000
RG19 19 0 1000000000000
RG20 20 0 1000000000000
RG21 21 0 1000000000000
RG22 22 0 1000000000000
RG23 23 0 1000000000000
RG24 24 0 1000000000000
RG25 25 0 1000000000000
RG26 26 0 1000000000000
RG27 27 0 1000000000000
RG28 28 0 1000000000000
RG29 29 0 1000000000000
VS0 27 s0 0
R0 s0 17 10e-2
VS1 8 s1 0
R1 s1 23 27e1
VS2 24 s2 0
R2 s2 25 12e-1
VS3 17 s3 0
R3 s3 4 22e-2
VS4 17 s4 0
R4 s4 1 12e0
VS5 2 s5 0
R5 s5 19 15e1
VS6 7 s6 0
R6 s6 16 47e3
VS7 5 s7 0
R7 s7 17 22e2
VS8 4 s8 0
R8 s8 3 47e1
VS9 18 s9 0
R9 s9 25 33e1
VS10 10 s10 0
R10 s10 13 12e-1
VS11 12 s11 0
R11 s11 22 10e-1
VS12 20 s12 0
R12 s12 5 12e3
VS13 5 s13 0
R13 s13 6 18e-2
VS14 27 s14 0
R14 s14 26 56e-1
VS15 3 s15 0
I15 s15 29 DC 33e-2
VS16 0 s16 0
V16 e16 s16 DC 12e0
RI16 e16 27 68e-2
VS17 5 s17 0
R17 s17 15 12e1
VS18 7 s18 0
I18 s18 10 DC 82e-4
VS19 7 s19 0
R19 s19 6 22e-1
VS20 28 s20 0
R20 s20 22 18e1
VS21 1 s21 0
V21 e21 s21 DC 56e0
RI21 e21 7 18e-2
VS22 16 s22 0
V22 e22 s22 DC 12e0
RI22 e22 11 47e-3
VS23 28 s23 0
V23 e23 s23 DC 82e0
RI23 e23 26 22e-2
VS24 15 s24 0
I24 s24 14 DC 39e-4
VS25 18 s25 0
I25 s25 29 DC 15e-2
VS26 24 s26 0
R26 s26 29 15e-2
VS27 14 s27 0
R27 s27 7 12e-1
VS28 20 s28 0
R28 s28 7 12e3
VS29 19 s29 0
R29 s29 8 12e0
VS30 5 s30 0
V30 e30 s30 DC 22e0
RI30 e30 10 68e-1
VS31 20 s31 0
R31 s31 11 10e0
VS32 27 s32 0
R32 s32 15 39e-2
VS33 20 s33 0
R33 s33 26 27e2
VS34 3 s34 0
V34 e34 s34 DC 56e1
RI34 e34 10 56e-3
VS35 21 s35 0
R35 s35 27 82e0
VS36 19 s36 0
R36 s36 12 22e3
VS37 20 s37 0
R37 s37 9 47e1
VS38 14 s38 0
V38 e38 s38 DC 12e1
RI38 e38 4 27e-2
VS39 13 s39 0
R39 s39 21 12e0
VS40 2 s40 0
R40 s40 22 68e-2
VS41 21 s41 0
R41 s41 29 15e0
VS42 5 s42 0
I42 s42 25 DC 82e-3
VS43 21 s43 0
R43 s43 25 22e-1
VS44 19 s44 0
R44 s44 7 27e-2
VS45 18 s45 0
V45 e45 s45 DC 68e0
RI45 e45 21 10e-2
VS46 0 s46 0
R46 s46 21 27e2
VS47 12 s47 0
R47 s47 19 27e-2
VS48 9 s48 0
R48 s48 12 15e1
VS49 23 s49 0
V49 e49 s49 DC 56e-1
RI49 e49 16 15e-3
VS50 29 s50 0
V50 e50 s50 DC 18e1
RI50 e50 5 47e-1
.control
set numdgt=17
op
print v(1) v(2) v(3) v(4) v(5) v(6) v(7) v(8) v(9) v(10)
print v(11) v(12) v(13) v(14) v(15) v(16) v(17) v(18) v(19) v(20)
print v(21) v(22) v(23) v(24) v(25) v(26) v(27) v(28) v(29)
print i(vs0) i(vs1) i(vs2) i(vs3) i(vs4) i(vs5) i(vs6) i(vs7) i(vs8) i(vs9)
print i(vs10) i(vs11) i(vs12) i(vs13) i(vs14) i(vs15) i(vs16) i(vs17) i(vs18) i(vs19)
print i(vs20) i(vs21) i(vs22) i(vs23) i(vs24) i(vs25) i(vs26) i(vs27) i(vs28) i(vs29)
print i(vs30) i(vs31) i(vs32) i(vs33) i(vs34) i(vs35) i(vs36) i(vs37) i(vs38) i(vs39)
print i(vs40) i(vs41) i(vs42) i(vs43) i(vs44) i(vs45) i(vs46) i(vs47) i(vs48) i(vs49)
print i(vs50)
.endc
.end
