controls oracle dc-0251
* Generated (plan F2.7, ADR 0012): do not edit; regenerate with `pnpm sim oracle regen`. dc seed 20261030 index 251 nodes 30 elements 45
.options sparse gmin=1e-12 noopac
RG1 1 0 1000000000000
RG2 2 0 1000000000000
RG3 3 0 1000000000000
RG4 4 0 1000000000000
RG5 5 0 1000000000000
RG6 6 0 1000000000000
RG7 7 0 1000000000000
RG8 8 0 1000000000000
RG9 9 0 1000000000000
RG10 10 0 1000000000000
RG11 11 0 1000000000000
RG12 12 0 1000000000000
RG13 13 0 1000000000000
RG14 14 0 1000000000000
RG15 15 0 1000000000000
RG16 16 0 1000000000000
RG17 17 0 1000000000000
RG18 18 0 1000000000000
RG19 19 0 1000000000000
RG20 20 0 1000000000000
RG21 21 0 1000000000000
RG22 22 0 1000000000000
RG23 23 0 1000000000000
RG24 24 0 1000000000000
RG25 25 0 1000000000000
RG26 26 0 1000000000000
RG27 27 0 1000000000000
RG28 28 0 1000000000000
RG29 29 0 1000000000000
VS0 24 s0 0
R0 s0 25 12e-1
VS1 19 s1 0
R1 s1 7 27e-2
VS2 3 s2 0
R2 s2 17 22e2
VS3 0 s3 0
V3 e3 s3 DC 56e1
RI3 e3 10 56e-3
VS4 7 s4 0
R4 s4 16 47e3
VS5 20 s5 0
R5 s5 9 47e1
VS6 21 s6 0
R6 s6 25 22e-1
VS7 12 s7 0
R7 s7 22 10e-1
VS8 27 s8 0
R8 s8 17 10e-2
VS9 8 s9 0
R9 s9 23 27e1
VS10 20 s10 0
R10 s10 7 12e3
VS11 20 s11 0
R11 s11 11 10e0
VS12 29 s12 0
V12 e12 s12 DC 18e1
RI12 e12 3 47e-1
VS13 18 s13 0
R13 s13 25 33e1
VS14 18 s14 0
I14 s14 29 DC 15e-2
VS15 1 s15 0
V15 e15 s15 DC 56e0
RI15 e15 7 18e-2
VS16 5 s16 0
R16 s16 21 27e2
VS17 28 s17 0
R17 s17 22 18e1
VS18 15 s18 0
I18 s18 14 DC 39e-4
VS19 19 s19 0
R19 s19 12 22e3
VS20 5 s20 0
V20 e20 s20 DC 12e0
RI20 e20 27 68e-2
VS21 12 s21 0
R21 s21 19 27e-2
VS22 23 s22 0
V22 e22 s22 DC 56e-1
RI22 e22 16 15e-3
VS23 13 s23 0
R23 s23 21 12e0
VS24 3 s24 0
V24 e24 s24 DC 22e0
RI24 e24 10 68e-1
VS25 27 s25 0
R25 s25 15 39e-2
VS26 24 s26 0
R26 s26 29 15e-2
VS27 7 s27 0
I27 s27 10 DC 82e-4
VS28 21 s28 0
R28 s28 29 15e0
VS29 20 s29 0
R29 s29 26 27e2
VS30 17 s30 0
R30 s30 4 22e-2
VS31 27 s31 0
R31 s31 26 56e-1
VS32 16 s32 0
V32 e32 s32 DC 12e0
RI32 e32 11 47e-3
VS33 19 s33 0
R33 s33 8 12e0
VS34 14 s34 0
R34 s34 7 12e-1
VS35 3 s35 0
R35 s35 6 18e-2
VS36 17 s36 0
R36 s36 1 12e0
VS37 0 s37 0
I37 s37 29 DC 33e-2
VS38 3 s38 0
I38 s38 25 DC 82e-3
VS39 2 s39 0
R39 s39 22 68e-2
VS40 2 s40 0
R40 s40 19 15e1
VS41 20 s41 0
R41 s41 3 12e3
VS42 28 s42 0
V42 e42 s42 DC 82e0
RI42 e42 26 22e-2
VS43 18 s43 0
V43 e43 s43 DC 68e0
RI43 e43 21 10e-2
VS44 21 s44 0
R44 s44 27 82e0
.control
set numdgt=17
op
print v(1) v(2) v(3) v(4) v(5) v(6) v(7) v(8) v(9) v(10)
print v(11) v(12) v(13) v(14) v(15) v(16) v(17) v(18) v(19) v(20)
print v(21) v(22) v(23) v(24) v(25) v(26) v(27) v(28) v(29)
print i(vs0) i(vs1) i(vs2) i(vs3) i(vs4) i(vs5) i(vs6) i(vs7) i(vs8) i(vs9)
print i(vs10) i(vs11) i(vs12) i(vs13) i(vs14) i(vs15) i(vs16) i(vs17) i(vs18) i(vs19)
print i(vs20) i(vs21) i(vs22) i(vs23) i(vs24) i(vs25) i(vs26) i(vs27) i(vs28) i(vs29)
print i(vs30) i(vs31) i(vs32) i(vs33) i(vs34) i(vs35) i(vs36) i(vs37) i(vs38) i(vs39)
print i(vs40) i(vs41) i(vs42) i(vs43) i(vs44)
.endc
.end
