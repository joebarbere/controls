controls oracle dc-0474
* Generated (plan F2.7, ADR 0012): do not edit; regenerate with `pnpm sim oracle regen`. dc seed 20261030 index 474 nodes 20 elements 43
.options sparse gmin=1e-12 noopac
RG1 1 0 1000000000000
RG2 2 0 1000000000000
RG3 3 0 1000000000000
RG4 4 0 1000000000000
RG5 5 0 1000000000000
RG6 6 0 1000000000000
RG7 7 0 1000000000000
RG8 8 0 1000000000000
RG9 9 0 1000000000000
RG10 10 0 1000000000000
RG11 11 0 1000000000000
RG12 12 0 1000000000000
RG13 13 0 1000000000000
RG14 14 0 1000000000000
RG15 15 0 1000000000000
RG16 16 0 1000000000000
RG17 17 0 1000000000000
RG18 18 0 1000000000000
RG19 19 0 1000000000000
VS0 17 s0 0
R0 s0 6 27e-2
VS1 0 s1 0
V1 e1 s1 DC 47e0
RI1 e1 14 68e-3
VS2 4 s2 0
R2 s2 10 39e-1
VS3 5 s3 0
R3 s3 15 82e-2
VS4 5 s4 0
R4 s4 10 47e3
VS5 16 s5 0
R5 s5 2 10e0
VS6 11 s6 0
R6 s6 14 56e-2
VS7 13 s7 0
R7 s7 17 82e1
VS8 10 s8 0
R8 s8 6 68e2
VS9 1 s9 0
I9 s9 13 DC 27e-3
VS10 9 s10 0
R10 s10 10 39e-1
VS11 8 s11 0
V11 e11 s11 DC 82e1
RI11 e11 18 12e-3
VS12 7 s12 0
R12 s12 8 10e-1
VS13 19 s13 0
R13 s13 4 33e2
VS14 7 s14 0
I14 s14 15 DC 10e-2
VS15 14 s15 0
R15 s15 8 15e-1
VS16 19 s16 0
R16 s16 9 22e-1
VS17 1 s17 0
R17 s17 8 12e1
VS18 13 s18 0
R18 s18 5 33e1
VS19 15 s19 0
R19 s19 18 22e-2
VS20 19 s20 0
I20 s20 10 DC 22e-3
VS21 18 s21 0
I21 s21 11 DC 27e-1
VS22 17 s22 0
V22 e22 s22 DC 12e0
RI22 e22 10 22e-1
VS23 4 s23 0
I23 s23 3 DC 15e-3
VS24 1 s24 0
R24 s24 16 33e3
VS25 9 s25 0
I25 s25 19 DC 18e-1
VS26 14 s26 0
R26 s26 2 33e2
VS27 11 s27 0
R27 s27 2 82e-1
VS28 15 s28 0
R28 s28 18 39e-1
VS29 12 s29 0
R29 s29 3 10e3
VS30 18 s30 0
R30 s30 14 33e3
VS31 11 s31 0
R31 s31 12 47e3
VS32 3 s32 0
R32 s32 2 68e-1
VS33 18 s33 0
R33 s33 9 15e1
VS34 0 s34 0
R34 s34 1 68e0
VS35 7 s35 0
R35 s35 5 18e0
VS36 9 s36 0
I36 s36 6 DC 82e-4
VS37 10 s37 0
R37 s37 2 15e2
VS38 3 s38 0
R38 s38 8 68e2
VS39 8 s39 0
V39 e39 s39 DC 15e0
RI39 e39 9 68e-3
VS40 16 s40 0
R40 s40 4 56e-1
VS41 13 s41 0
R41 s41 6 22e-2
VS42 15 s42 0
R42 s42 16 82e2
.control
set numdgt=17
op
print v(1) v(2) v(3) v(4) v(5) v(6) v(7) v(8) v(9) v(10)
print v(11) v(12) v(13) v(14) v(15) v(16) v(17) v(18) v(19)
print i(vs0) i(vs1) i(vs2) i(vs3) i(vs4) i(vs5) i(vs6) i(vs7) i(vs8) i(vs9)
print i(vs10) i(vs11) i(vs12) i(vs13) i(vs14) i(vs15) i(vs16) i(vs17) i(vs18) i(vs19)
print i(vs20) i(vs21) i(vs22) i(vs23) i(vs24) i(vs25) i(vs26) i(vs27) i(vs28) i(vs29)
print i(vs30) i(vs31) i(vs32) i(vs33) i(vs34) i(vs35) i(vs36) i(vs37) i(vs38) i(vs39)
print i(vs40) i(vs41) i(vs42)
.endc
.end
