controls oracle dc-0474
* Generated (plan F2.7, ADR 0012): do not edit; regenerate with `pnpm sim oracle regen`. dc seed 20261030 index 474 nodes 20 elements 37
.options sparse gmin=1e-12 noopac
RG1 1 0 1000000000000
RG2 2 0 1000000000000
RG3 3 0 1000000000000
RG4 4 0 1000000000000
RG5 5 0 1000000000000
RG6 6 0 1000000000000
RG7 7 0 1000000000000
RG8 8 0 1000000000000
RG9 9 0 1000000000000
RG10 10 0 1000000000000
RG11 11 0 1000000000000
RG12 12 0 1000000000000
RG13 13 0 1000000000000
RG14 14 0 1000000000000
RG15 15 0 1000000000000
RG16 16 0 1000000000000
RG17 17 0 1000000000000
RG18 18 0 1000000000000
RG19 19 0 1000000000000
VS0 7 s0 0
R0 s0 8 10e-1
VS1 3 s1 0
R1 s1 2 68e-1
VS2 11 s2 0
R2 s2 14 56e-2
VS3 5 s3 0
R3 s3 15 82e-2
VS4 4 s4 0
I4 s4 3 DC 15e-3
VS5 17 s5 0
R5 s5 6 27e-2
VS6 0 s6 0
V6 e6 s6 DC 47e0
RI6 e6 14 68e-3
VS7 1 s7 0
R7 s7 16 33e3
VS8 15 s8 0
R8 s8 18 22e-2
VS9 1 s9 0
I9 s9 13 DC 27e-3
VS10 18 s10 0
I10 s10 11 DC 27e-1
VS11 11 s11 0
R11 s11 2 82e-1
VS12 18 s12 0
R12 s12 14 33e3
VS13 9 s13 0
R13 s13 10 39e-1
VS14 14 s14 0
R14 s14 8 15e-1
VS15 13 s15 0
R15 s15 6 22e-2
VS16 8 s16 0
V16 e16 s16 DC 15e0
RI16 e16 9 68e-3
VS17 10 s17 0
R17 s17 2 15e2
VS18 19 s18 0
R18 s18 9 22e-1
VS19 7 s19 0
I19 s19 15 DC 10e-2
VS20 15 s20 0
R20 s20 18 39e-1
VS21 10 s21 0
R21 s21 6 68e2
VS22 13 s22 0
R22 s22 17 82e1
VS23 4 s23 0
R23 s23 10 39e-1
VS24 11 s24 0
R24 s24 12 47e3
VS25 17 s25 0
V25 e25 s25 DC 12e0
RI25 e25 10 22e-1
VS26 14 s26 0
R26 s26 2 33e2
VS27 19 s27 0
I27 s27 10 DC 22e-3
VS28 9 s28 0
I28 s28 6 DC 82e-4
VS29 9 s29 0
I29 s29 19 DC 18e-1
VS30 8 s30 0
V30 e30 s30 DC 82e1
RI30 e30 18 12e-3
VS31 12 s31 0
R31 s31 3 10e3
VS32 16 s32 0
R32 s32 4 56e-1
VS33 18 s33 0
R33 s33 9 15e1
VS34 15 s34 0
R34 s34 16 82e2
VS35 3 s35 0
R35 s35 8 68e2
VS36 16 s36 0
R36 s36 2 10e0
.control
set numdgt=17
op
print v(1) v(2) v(3) v(4) v(5) v(6) v(7) v(8) v(9) v(10)
print v(11) v(12) v(13) v(14) v(15) v(16) v(17) v(18) v(19)
print i(vs0) i(vs1) i(vs2) i(vs3) i(vs4) i(vs5) i(vs6) i(vs7) i(vs8) i(vs9)
print i(vs10) i(vs11) i(vs12) i(vs13) i(vs14) i(vs15) i(vs16) i(vs17) i(vs18) i(vs19)
print i(vs20) i(vs21) i(vs22) i(vs23) i(vs24) i(vs25) i(vs26) i(vs27) i(vs28) i(vs29)
print i(vs30) i(vs31) i(vs32) i(vs33) i(vs34) i(vs35) i(vs36)
.endc
.end
