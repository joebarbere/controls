controls oracle dc-0489
* Generated (plan F2.7, ADR 0012): do not edit; regenerate with `pnpm sim oracle regen`. dc seed 20261030 index 489 nodes 29 elements 33
.options sparse gmin=1e-12 noopac
RG1 1 0 1000000000000
RG2 2 0 1000000000000
RG3 3 0 1000000000000
RG4 4 0 1000000000000
RG5 5 0 1000000000000
RG6 6 0 1000000000000
RG7 7 0 1000000000000
RG8 8 0 1000000000000
RG9 9 0 1000000000000
RG10 10 0 1000000000000
RG11 11 0 1000000000000
RG12 12 0 1000000000000
RG13 13 0 1000000000000
RG14 14 0 1000000000000
RG15 15 0 1000000000000
RG16 16 0 1000000000000
RG17 17 0 1000000000000
RG18 18 0 1000000000000
RG19 19 0 1000000000000
RG20 20 0 1000000000000
RG21 21 0 1000000000000
RG22 22 0 1000000000000
RG23 23 0 1000000000000
RG24 24 0 1000000000000
RG25 25 0 1000000000000
RG26 26 0 1000000000000
RG27 27 0 1000000000000
RG28 28 0 1000000000000
VS0 16 s0 0
R0 s0 15 82e2
VS1 3 s1 0
R1 s1 19 15e0
VS2 3 s2 0
R2 s2 7 22e2
VS3 25 s3 0
R3 s3 13 68e0
VS4 18 s4 0
R4 s4 17 22e1
VS5 12 s5 0
R5 s5 5 33e-2
VS6 2 s6 0
R6 s6 28 22e-2
VS7 0 s7 0
V7 e7 s7 DC 82e0
RI7 e7 9 18e-2
VS8 21 s8 0
R8 s8 0 33e3
VS9 12 s9 0
R9 s9 24 39e-2
VS10 14 s10 0
R10 s10 23 33e1
VS11 3 s11 0
V11 e11 s11 DC 15e0
RI11 e11 4 56e-3
VS12 8 s12 0
R12 s12 21 18e0
VS13 6 s13 0
R13 s13 23 10e2
VS14 26 s14 0
R14 s14 12 82e3
VS15 8 s15 0
R15 s15 11 56e2
VS16 2 s16 0
R16 s16 11 22e2
VS17 27 s17 0
R17 s17 3 18e2
VS18 0 s18 0
R18 s18 1 56e3
VS19 7 s19 0
R19 s19 6 56e2
VS20 16 s20 0
R20 s20 22 10e-1
VS21 22 s21 0
R21 s21 8 33e-2
VS22 23 s22 0
R22 s22 17 10e2
VS23 8 s23 0
R23 s23 6 39e2
VS24 8 s24 0
V24 e24 s24 DC 56e0
RI24 e24 28 39e-2
VS25 24 s25 0
R25 s25 9 27e3
VS26 23 s26 0
R26 s26 27 33e1
VS27 20 s27 0
R27 s27 14 18e-2
VS28 16 s28 0
R28 s28 3 27e2
VS29 22 s29 0
R29 s29 24 56e1
VS30 10 s30 0
I30 s30 22 DC 33e-2
VS31 2 s31 0
R31 s31 10 56e3
VS32 13 s32 0
R32 s32 8 39e0
.control
set numdgt=17
op
print v(1) v(2) v(3) v(4) v(5) v(6) v(7) v(8) v(9) v(10)
print v(11) v(12) v(13) v(14) v(15) v(16) v(17) v(18) v(19) v(20)
print v(21) v(22) v(23) v(24) v(25) v(26) v(27) v(28)
print i(vs0) i(vs1) i(vs2) i(vs3) i(vs4) i(vs5) i(vs6) i(vs7) i(vs8) i(vs9)
print i(vs10) i(vs11) i(vs12) i(vs13) i(vs14) i(vs15) i(vs16) i(vs17) i(vs18) i(vs19)
print i(vs20) i(vs21) i(vs22) i(vs23) i(vs24) i(vs25) i(vs26) i(vs27) i(vs28) i(vs29)
print i(vs30) i(vs31) i(vs32)
.endc
.end
