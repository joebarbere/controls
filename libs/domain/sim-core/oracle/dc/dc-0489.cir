controls oracle dc-0489
* Generated (plan F2.7, ADR 0012): do not edit; regenerate with `pnpm sim oracle regen`. dc seed 20261030 index 489 nodes 29 elements 40
.options sparse gmin=1e-12 noopac
RG1 1 0 1000000000000
RG2 2 0 1000000000000
RG3 3 0 1000000000000
RG4 4 0 1000000000000
RG5 5 0 1000000000000
RG6 6 0 1000000000000
RG7 7 0 1000000000000
RG8 8 0 1000000000000
RG9 9 0 1000000000000
RG10 10 0 1000000000000
RG11 11 0 1000000000000
RG12 12 0 1000000000000
RG13 13 0 1000000000000
RG14 14 0 1000000000000
RG15 15 0 1000000000000
RG16 16 0 1000000000000
RG17 17 0 1000000000000
RG18 18 0 1000000000000
RG19 19 0 1000000000000
RG20 20 0 1000000000000
RG21 21 0 1000000000000
RG22 22 0 1000000000000
RG23 23 0 1000000000000
RG24 24 0 1000000000000
RG25 25 0 1000000000000
RG26 26 0 1000000000000
RG27 27 0 1000000000000
RG28 28 0 1000000000000
VS0 7 s0 0
R0 s0 6 56e2
VS1 2 s1 0
R1 s1 10 56e3
VS2 0 s2 0
R2 s2 1 56e3
VS3 8 s3 0
R3 s3 6 39e2
VS4 23 s4 0
R4 s4 27 33e1
VS5 3 s5 0
R5 s5 7 22e2
VS6 21 s6 0
R6 s6 0 33e3
VS7 10 s7 0
I7 s7 22 DC 33e-2
VS8 24 s8 0
R8 s8 9 27e3
VS9 18 s9 0
R9 s9 17 22e1
VS10 19 s10 0
R10 s10 8 18e1
VS11 13 s11 0
R11 s11 8 39e0
VS12 8 s12 0
R12 s12 21 18e0
VS13 18 s13 0
R13 s13 5 39e1
VS14 27 s14 0
R14 s14 3 18e2
VS15 23 s15 0
R15 s15 17 10e2
VS16 8 s16 0
R16 s16 11 56e2
VS17 1 s17 0
R17 s17 15 18e-1
VS18 0 s18 0
V18 e18 s18 DC 82e0
RI18 e18 9 18e-2
VS19 12 s19 0
R19 s19 20 12e0
VS20 3 s20 0
V20 e20 s20 DC 15e0
RI20 e20 4 56e-3
VS21 6 s21 0
R21 s21 23 10e2
VS22 16 s22 0
R22 s22 3 27e2
VS23 2 s23 0
R23 s23 28 22e-2
VS24 12 s24 0
R24 s24 5 33e-2
VS25 16 s25 0
R25 s25 22 10e-1
VS26 20 s26 0
R26 s26 14 18e-2
VS27 25 s27 0
R27 s27 22 39e0
VS28 16 s28 0
R28 s28 15 82e2
VS29 12 s29 0
R29 s29 24 39e-2
VS30 17 s30 0
R30 s30 26 82e2
VS31 26 s31 0
R31 s31 12 82e3
VS32 8 s32 0
V32 e32 s32 DC 56e0
RI32 e32 28 39e-2
VS33 22 s33 0
R33 s33 24 56e1
VS34 2 s34 0
R34 s34 11 22e2
VS35 14 s35 0
R35 s35 23 33e1
VS36 25 s36 0
R36 s36 13 68e0
VS37 22 s37 0
R37 s37 8 33e-2
VS38 4 s38 0
R38 s38 10 39e2
VS39 3 s39 0
R39 s39 19 15e0
.control
set numdgt=17
op
print v(1) v(2) v(3) v(4) v(5) v(6) v(7) v(8) v(9) v(10)
print v(11) v(12) v(13) v(14) v(15) v(16) v(17) v(18) v(19) v(20)
print v(21) v(22) v(23) v(24) v(25) v(26) v(27) v(28)
print i(vs0) i(vs1) i(vs2) i(vs3) i(vs4) i(vs5) i(vs6) i(vs7) i(vs8) i(vs9)
print i(vs10) i(vs11) i(vs12) i(vs13) i(vs14) i(vs15) i(vs16) i(vs17) i(vs18) i(vs19)
print i(vs20) i(vs21) i(vs22) i(vs23) i(vs24) i(vs25) i(vs26) i(vs27) i(vs28) i(vs29)
print i(vs30) i(vs31) i(vs32) i(vs33) i(vs34) i(vs35) i(vs36) i(vs37) i(vs38) i(vs39)
.endc
.end
