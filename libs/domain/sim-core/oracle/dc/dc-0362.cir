controls oracle dc-0362
* Generated (plan F2.7, ADR 0012): do not edit; regenerate with `pnpm sim oracle regen`. dc seed 20261030 index 362 nodes 6 elements 9
.options sparse gmin=1e-12 noopac
RG1 1 0 1000000000000
RG2 2 0 1000000000000
RG3 3 0 1000000000000
RG4 4 0 1000000000000
RG5 5 0 1000000000000
VS0 1 s0 0
R0 s0 5 47e-1
VS1 4 s1 0
R1 s1 2 68e3
VS2 0 s2 0
V2 e2 s2 DC 18e-1
RI2 e2 5 27e-2
VS3 3 s3 0
R3 s3 5 27e1
VS4 1 s4 0
R4 s4 4 22e0
VS5 1 s5 0
I5 s5 3 DC 68e-1
VS6 0 s6 0
R6 s6 3 56e1
VS7 3 s7 0
I7 s7 0 DC 33e-1
VS8 5 s8 0
R8 s8 1 47e-1
.control
set numdgt=17
op
print v(1) v(2) v(3) v(4) v(5)
print i(vs0) i(vs1) i(vs2) i(vs3) i(vs4) i(vs5) i(vs6) i(vs7) i(vs8)
.endc
.end
