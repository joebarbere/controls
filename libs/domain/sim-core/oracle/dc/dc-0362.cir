controls oracle dc-0362
* Generated (plan F2.7, ADR 0012): do not edit; regenerate with `pnpm sim oracle regen`. dc seed 20261030 index 362 nodes 6 elements 11
.options sparse gmin=1e-12 noopac
RG1 1 0 1000000000000
RG2 2 0 1000000000000
RG3 3 0 1000000000000
RG4 4 0 1000000000000
RG5 5 0 1000000000000
VS0 3 s0 0
R0 s0 5 27e1
VS1 1 s1 0
R1 s1 4 22e0
VS2 2 s2 0
R2 s2 0 22e2
VS3 1 s3 0
I3 s3 3 DC 68e-1
VS4 1 s4 0
R4 s4 5 47e-1
VS5 0 s5 0
V5 e5 s5 DC 18e-1
RI5 e5 5 27e-2
VS6 3 s6 0
I6 s6 0 DC 33e-1
VS7 0 s7 0
R7 s7 3 56e1
VS8 3 s8 0
V8 e8 s8 DC 56e0
RI8 e8 4 82e-1
VS9 5 s9 0
R9 s9 1 47e-1
VS10 4 s10 0
R10 s10 2 68e3
.control
set numdgt=17
op
print v(1) v(2) v(3) v(4) v(5)
print i(vs0) i(vs1) i(vs2) i(vs3) i(vs4) i(vs5) i(vs6) i(vs7) i(vs8) i(vs9)
print i(vs10)
.endc
.end
