controls oracle dc-0217
* Generated (plan F2.7, ADR 0012): do not edit; regenerate with `pnpm sim oracle regen`. dc seed 20261030 index 217 nodes 3 elements 4
.options sparse gmin=1e-12 noopac
RG1 1 0 1000000000000
RG2 2 0 1000000000000
VS0 1 s0 0
R0 s0 2 56e0
VS1 0 s1 0
V1 e1 s1 DC 82e0
RI1 e1 1 15e-1
VS2 0 s2 0
I2 s2 2 DC 12e-4
VS3 2 s3 0
R3 s3 0 39e2
.control
set numdgt=17
op
print v(1) v(2)
print i(vs0) i(vs1) i(vs2) i(vs3)
.endc
.end
