controls oracle dc-0248
* Generated (plan F2.7, ADR 0012): do not edit; regenerate with `pnpm sim oracle regen`. dc seed 20261030 index 248 nodes 5 elements 7
.options sparse gmin=1e-12 noopac
RG1 1 0 1000000000000
RG2 2 0 1000000000000
RG3 3 0 1000000000000
RG4 4 0 1000000000000
VS0 2 s0 0
R0 s0 3 68e2
VS1 4 s1 0
R1 s1 0 15e1
VS2 1 s2 0
R2 s2 3 47e-2
VS3 1 s3 0
R3 s3 4 82e-1
VS4 0 s4 0
R4 s4 2 68e1
VS5 0 s5 0
V5 e5 s5 DC 82e1
RI5 e5 3 12e-1
VS6 3 s6 0
R6 s6 0 56e0
.control
set numdgt=17
op
print v(1) v(2) v(3) v(4)
print i(vs0) i(vs1) i(vs2) i(vs3) i(vs4) i(vs5) i(vs6)
.endc
.end
