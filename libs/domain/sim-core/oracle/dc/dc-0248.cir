controls oracle dc-0248
* Generated (plan F2.7, ADR 0012): do not edit; regenerate with `pnpm sim oracle regen`. dc seed 20261030 index 248 nodes 5 elements 5
.options sparse gmin=1e-12 noopac
RG1 1 0 1000000000000
RG2 2 0 1000000000000
RG3 3 0 1000000000000
RG4 4 0 1000000000000
VS0 1 s0 0
R0 s0 4 82e-1
VS1 3 s1 0
R1 s1 0 56e0
VS2 0 s2 0
R2 s2 2 68e1
VS3 0 s3 0
V3 e3 s3 DC 82e1
RI3 e3 3 12e-1
VS4 4 s4 0
R4 s4 0 15e1
.control
set numdgt=17
op
print v(1) v(2) v(3) v(4)
print i(vs0) i(vs1) i(vs2) i(vs3) i(vs4)
.endc
.end
