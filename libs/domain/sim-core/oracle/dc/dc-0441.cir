controls oracle dc-0441
* Generated (plan F2.7, ADR 0012): do not edit; regenerate with `pnpm sim oracle regen`. dc seed 20261030 index 441 nodes 16 elements 29
.options sparse gmin=1e-12 noopac
RG1 1 0 1000000000000
RG2 2 0 1000000000000
RG3 3 0 1000000000000
RG4 4 0 1000000000000
RG5 5 0 1000000000000
RG6 6 0 1000000000000
RG7 7 0 1000000000000
RG8 8 0 1000000000000
RG9 9 0 1000000000000
RG10 10 0 1000000000000
RG11 11 0 1000000000000
RG12 12 0 1000000000000
RG13 13 0 1000000000000
RG14 14 0 1000000000000
RG15 15 0 1000000000000
VS0 5 s0 0
R0 s0 8 18e3
VS1 15 s1 0
R1 s1 5 15e3
VS2 11 s2 0
R2 s2 0 18e-2
VS3 12 s3 0
R3 s3 1 56e2
VS4 1 s4 0
I4 s4 5 DC 12e-1
VS5 2 s5 0
R5 s5 11 56e2
VS6 14 s6 0
R6 s6 5 22e-2
VS7 12 s7 0
R7 s7 4 18e1
VS8 6 s8 0
R8 s8 10 15e2
VS9 6 s9 0
R9 s9 15 56e3
VS10 0 s10 0
V10 e10 s10 DC 82e0
RI10 e10 11 22e-2
VS11 8 s11 0
R11 s11 0 27e0
VS12 9 s12 0
R12 s12 14 10e1
VS13 14 s13 0
R13 s13 3 33e-2
VS14 13 s14 0
R14 s14 4 10e-1
VS15 9 s15 0
R15 s15 7 12e2
VS16 9 s16 0
I16 s16 14 DC 10e-4
VS17 4 s17 0
R17 s17 11 47e0
VS18 11 s18 0
R18 s18 5 22e3
VS19 10 s19 0
R19 s19 4 18e0
VS20 14 s20 0
V20 e20 s20 DC 15e-1
RI20 e20 10 27e-1
VS21 6 s21 0
V21 e21 s21 DC 68e-1
RI21 e21 5 56e-3
VS22 3 s22 0
I22 s22 13 DC 18e-2
VS23 1 s23 0
V23 e23 s23 DC 39e1
RI23 e23 3 33e-1
VS24 2 s24 0
R24 s24 4 15e-1
VS25 1 s25 0
R25 s25 5 12e-1
VS26 13 s26 0
R26 s26 11 22e3
VS27 4 s27 0
R27 s27 7 12e3
VS28 7 s28 0
R28 s28 11 82e1
.control
set numdgt=17
op
print v(1) v(2) v(3) v(4) v(5) v(6) v(7) v(8) v(9) v(10)
print v(11) v(12) v(13) v(14) v(15)
print i(vs0) i(vs1) i(vs2) i(vs3) i(vs4) i(vs5) i(vs6) i(vs7) i(vs8) i(vs9)
print i(vs10) i(vs11) i(vs12) i(vs13) i(vs14) i(vs15) i(vs16) i(vs17) i(vs18) i(vs19)
print i(vs20) i(vs21) i(vs22) i(vs23) i(vs24) i(vs25) i(vs26) i(vs27) i(vs28)
.endc
.end
