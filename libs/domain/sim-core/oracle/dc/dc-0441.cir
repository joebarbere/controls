controls oracle dc-0441
* Generated (plan F2.7, ADR 0012): do not edit; regenerate with `pnpm sim oracle regen`. dc seed 20261030 index 441 nodes 16 elements 23
.options sparse gmin=1e-12 noopac
RG1 1 0 1000000000000
RG2 2 0 1000000000000
RG3 3 0 1000000000000
RG4 4 0 1000000000000
RG5 5 0 1000000000000
RG6 6 0 1000000000000
RG7 7 0 1000000000000
RG8 8 0 1000000000000
RG9 9 0 1000000000000
RG10 10 0 1000000000000
RG11 11 0 1000000000000
RG12 12 0 1000000000000
RG13 13 0 1000000000000
RG14 14 0 1000000000000
RG15 15 0 1000000000000
VS0 12 s0 0
R0 s0 4 18e1
VS1 0 s1 0
R1 s1 10 15e2
VS2 8 s2 0
R2 s2 11 27e0
VS3 9 s3 0
R3 s3 7 12e2
VS4 6 s4 0
R4 s4 5 22e3
VS5 1 s5 0
I5 s5 5 DC 12e-1
VS6 3 s6 0
I6 s6 13 DC 18e-2
VS7 0 s7 0
R7 s7 15 56e3
VS8 5 s8 0
R8 s8 8 18e3
VS9 9 s9 0
I9 s9 14 DC 10e-4
VS10 4 s10 0
R10 s10 6 47e0
VS11 14 s11 0
R11 s11 5 22e-2
VS12 13 s12 0
R12 s12 6 22e3
VS13 14 s13 0
R13 s13 3 33e-2
VS14 4 s14 0
R14 s14 7 12e3
VS15 15 s15 0
R15 s15 5 15e3
VS16 7 s16 0
R16 s16 6 82e1
VS17 0 s17 0
V17 e17 s17 DC 68e-1
RI17 e17 5 56e-3
VS18 6 s18 0
R18 s18 11 18e-2
VS19 11 s19 0
V19 e19 s19 DC 82e0
RI19 e19 6 22e-2
VS20 1 s20 0
V20 e20 s20 DC 39e1
RI20 e20 3 33e-1
VS21 14 s21 0
V21 e21 s21 DC 15e-1
RI21 e21 10 27e-1
VS22 2 s22 0
R22 s22 6 56e2
.control
set numdgt=17
op
print v(1) v(2) v(3) v(4) v(5) v(6) v(7) v(8) v(9) v(10)
print v(11) v(12) v(13) v(14) v(15)
print i(vs0) i(vs1) i(vs2) i(vs3) i(vs4) i(vs5) i(vs6) i(vs7) i(vs8) i(vs9)
print i(vs10) i(vs11) i(vs12) i(vs13) i(vs14) i(vs15) i(vs16) i(vs17) i(vs18) i(vs19)
print i(vs20) i(vs21) i(vs22)
.endc
.end
