controls oracle dc-0067
* Generated (plan F2.7, ADR 0012): do not edit; regenerate with `pnpm sim oracle regen`. dc seed 20261030 index 67 nodes 25 elements 39
.options sparse gmin=1e-12 noopac
RG1 1 0 1000000000000
RG2 2 0 1000000000000
RG3 3 0 1000000000000
RG4 4 0 1000000000000
RG5 5 0 1000000000000
RG6 6 0 1000000000000
RG7 7 0 1000000000000
RG8 8 0 1000000000000
RG9 9 0 1000000000000
RG10 10 0 1000000000000
RG11 11 0 1000000000000
RG12 12 0 1000000000000
RG13 13 0 1000000000000
RG14 14 0 1000000000000
RG15 15 0 1000000000000
RG16 16 0 1000000000000
RG17 17 0 1000000000000
RG18 18 0 1000000000000
RG19 19 0 1000000000000
RG20 20 0 1000000000000
RG21 21 0 1000000000000
RG22 22 0 1000000000000
RG23 23 0 1000000000000
RG24 24 0 1000000000000
VS0 21 s0 0
I0 s0 4 DC 39e-1
VS1 20 s1 0
R1 s1 11 15e3
VS2 10 s2 0
R2 s2 1 27e0
VS3 2 s3 0
R3 s3 22 33e0
VS4 0 s4 0
V4 e4 s4 DC 39e-1
RI4 e4 20 56e-2
VS5 1 s5 0
R5 s5 9 18e2
VS6 12 s6 0
I6 s6 23 DC 39e-4
VS7 23 s7 0
I7 s7 13 DC 22e-2
VS8 22 s8 0
R8 s8 13 47e-2
VS9 7 s9 0
R9 s9 3 47e3
VS10 20 s10 0
R10 s10 17 27e-1
VS11 8 s11 0
R11 s11 17 68e0
VS12 22 s12 0
R12 s12 4 47e-2
VS13 2 s13 0
R13 s13 5 56e2
VS14 12 s14 0
V14 e14 s14 DC 82e-1
RI14 e14 10 39e-1
VS15 8 s15 0
V15 e15 s15 DC 27e0
RI15 e15 14 68e-1
VS16 9 s16 0
V16 e16 s16 DC 27e0
RI16 e16 24 10e-2
VS17 19 s17 0
R17 s17 0 47e3
VS18 2 s18 0
R18 s18 3 27e1
VS19 2 s19 0
R19 s19 24 47e0
VS20 20 s20 0
R20 s20 24 12e1
VS21 1 s21 0
I21 s21 3 DC 82e-4
VS22 12 s22 0
R22 s22 14 47e0
VS23 20 s23 0
I23 s23 22 DC 12e-3
VS24 7 s24 0
R24 s24 5 56e3
VS25 18 s25 0
R25 s25 7 82e2
VS26 16 s26 0
R26 s26 10 33e0
VS27 11 s27 0
I27 s27 23 DC 68e-1
VS28 13 s28 0
R28 s28 6 82e2
VS29 24 s29 0
R29 s29 8 18e3
VS30 22 s30 0
R30 s30 13 82e2
VS31 14 s31 0
R31 s31 6 47e2
VS32 1 s32 0
R32 s32 23 22e3
VS33 21 s33 0
V33 e33 s33 DC 15e-1
RI33 e33 7 56e-2
VS34 24 s34 0
R34 s34 6 22e2
VS35 19 s35 0
R35 s35 9 68e-1
VS36 2 s36 0
V36 e36 s36 DC 18e0
RI36 e36 15 22e-2
VS37 14 s37 0
R37 s37 18 33e-2
VS38 12 s38 0
R38 s38 15 47e-1
.control
set numdgt=17
op
print v(1) v(2) v(3) v(4) v(5) v(6) v(7) v(8) v(9) v(10)
print v(11) v(12) v(13) v(14) v(15) v(16) v(17) v(18) v(19) v(20)
print v(21) v(22) v(23) v(24)
print i(vs0) i(vs1) i(vs2) i(vs3) i(vs4) i(vs5) i(vs6) i(vs7) i(vs8) i(vs9)
print i(vs10) i(vs11) i(vs12) i(vs13) i(vs14) i(vs15) i(vs16) i(vs17) i(vs18) i(vs19)
print i(vs20) i(vs21) i(vs22) i(vs23) i(vs24) i(vs25) i(vs26) i(vs27) i(vs28) i(vs29)
print i(vs30) i(vs31) i(vs32) i(vs33) i(vs34) i(vs35) i(vs36) i(vs37) i(vs38)
.endc
.end
