controls oracle dc-0067
* Generated (plan F2.7, ADR 0012): do not edit; regenerate with `pnpm sim oracle regen`. dc seed 20261030 index 67 nodes 25 elements 44
.options sparse gmin=1e-12 noopac
RG1 1 0 1000000000000
RG2 2 0 1000000000000
RG3 3 0 1000000000000
RG4 4 0 1000000000000
RG5 5 0 1000000000000
RG6 6 0 1000000000000
RG7 7 0 1000000000000
RG8 8 0 1000000000000
RG9 9 0 1000000000000
RG10 10 0 1000000000000
RG11 11 0 1000000000000
RG12 12 0 1000000000000
RG13 13 0 1000000000000
RG14 14 0 1000000000000
RG15 15 0 1000000000000
RG16 16 0 1000000000000
RG17 17 0 1000000000000
RG18 18 0 1000000000000
RG19 19 0 1000000000000
RG20 20 0 1000000000000
RG21 21 0 1000000000000
RG22 22 0 1000000000000
RG23 23 0 1000000000000
RG24 24 0 1000000000000
VS0 16 s0 0
R0 s0 11 68e0
VS1 1 s1 0
R1 s1 9 18e2
VS2 22 s2 0
R2 s2 4 47e-2
VS3 0 s3 0
R3 s3 2 47e0
VS4 19 s4 0
R4 s4 9 68e-1
VS5 18 s5 0
R5 s5 7 82e2
VS6 0 s6 0
V6 e6 s6 DC 18e0
RI6 e6 15 22e-2
VS7 14 s7 0
R7 s7 6 47e2
VS8 0 s8 0
R8 s8 3 27e1
VS9 20 s9 0
R9 s9 17 27e-1
VS10 0 s10 0
R10 s10 5 56e2
VS11 1 s11 0
I11 s11 3 DC 82e-4
VS12 22 s12 0
R12 s12 13 82e2
VS13 4 s13 0
R13 s13 13 10e3
VS14 13 s14 0
R14 s14 6 82e2
VS15 9 s15 0
V15 e15 s15 DC 27e0
RI15 e15 2 10e-2
VS16 24 s16 0
V16 e16 s16 DC 39e-1
RI16 e16 20 56e-2
VS17 1 s17 0
R17 s17 23 22e3
VS18 12 s18 0
V18 e18 s18 DC 82e-1
RI18 e18 10 39e-1
VS19 12 s19 0
I19 s19 23 DC 39e-4
VS20 21 s20 0
V20 e20 s20 DC 15e-1
RI20 e20 7 56e-2
VS21 7 s21 0
R21 s21 3 47e3
VS22 20 s22 0
R22 s22 2 12e1
VS23 12 s23 0
R23 s23 15 47e-1
VS24 8 s24 0
V24 e24 s24 DC 27e0
RI24 e24 14 68e-1
VS25 2 s25 0
R25 s25 8 18e3
VS26 2 s26 0
R26 s26 6 22e2
VS27 15 s27 0
V27 e27 s27 DC 68e1
RI27 e27 16 10e-3
VS28 22 s28 0
R28 s28 13 47e-2
VS29 14 s29 0
R29 s29 18 33e-2
VS30 10 s30 0
R30 s30 1 27e0
VS31 7 s31 0
R31 s31 5 56e3
VS32 8 s32 0
R32 s32 17 68e0
VS33 19 s33 0
R33 s33 24 47e3
VS34 21 s34 0
I34 s34 4 DC 39e-1
VS35 0 s35 0
R35 s35 22 33e0
VS36 23 s36 0
I36 s36 13 DC 22e-2
VS37 16 s37 0
R37 s37 10 33e0
VS38 11 s38 0
I38 s38 23 DC 68e-1
VS39 20 s39 0
I39 s39 22 DC 12e-3
VS40 12 s40 0
R40 s40 14 47e0
VS41 20 s41 0
R41 s41 11 15e3
VS42 21 s42 0
R42 s42 17 68e2
VS43 10 s43 0
R43 s43 23 82e0
.control
set numdgt=17
op
print v(1) v(2) v(3) v(4) v(5) v(6) v(7) v(8) v(9) v(10)
print v(11) v(12) v(13) v(14) v(15) v(16) v(17) v(18) v(19) v(20)
print v(21) v(22) v(23) v(24)
print i(vs0) i(vs1) i(vs2) i(vs3) i(vs4) i(vs5) i(vs6) i(vs7) i(vs8) i(vs9)
print i(vs10) i(vs11) i(vs12) i(vs13) i(vs14) i(vs15) i(vs16) i(vs17) i(vs18) i(vs19)
print i(vs20) i(vs21) i(vs22) i(vs23) i(vs24) i(vs25) i(vs26) i(vs27) i(vs28) i(vs29)
print i(vs30) i(vs31) i(vs32) i(vs33) i(vs34) i(vs35) i(vs36) i(vs37) i(vs38) i(vs39)
print i(vs40) i(vs41) i(vs42) i(vs43)
.endc
.end
