controls oracle dc-0443
* Generated (plan F2.7, ADR 0012): do not edit; regenerate with `pnpm sim oracle regen`. dc seed 20261030 index 443 nodes 16 elements 25
.options sparse gmin=1e-12 noopac
RG1 1 0 1000000000000
RG2 2 0 1000000000000
RG3 3 0 1000000000000
RG4 4 0 1000000000000
RG5 5 0 1000000000000
RG6 6 0 1000000000000
RG7 7 0 1000000000000
RG8 8 0 1000000000000
RG9 9 0 1000000000000
RG10 10 0 1000000000000
RG11 11 0 1000000000000
RG12 12 0 1000000000000
RG13 13 0 1000000000000
RG14 14 0 1000000000000
RG15 15 0 1000000000000
VS0 0 s0 0
R0 s0 10 39e-1
VS1 0 s1 0
V1 e1 s1 DC 15e1
RI1 e1 11 47e-3
VS2 0 s2 0
R2 s2 7 12e0
VS3 9 s3 0
R3 s3 3 68e1
VS4 5 s4 0
I4 s4 13 DC 39e-1
VS5 15 s5 0
R5 s5 9 68e0
VS6 8 s6 0
R6 s6 13 22e1
VS7 8 s7 0
R7 s7 3 82e0
VS8 4 s8 0
R8 s8 14 68e3
VS9 6 s9 0
R9 s9 13 22e2
VS10 8 s10 0
R10 s10 11 27e-1
VS11 9 s11 0
V11 e11 s11 DC 12e-1
RI11 e11 1 82e-3
VS12 14 s12 0
R12 s12 8 47e-1
VS13 15 s13 0
R13 s13 1 56e2
VS14 9 s14 0
R14 s14 5 27e0
VS15 9 s15 0
V15 e15 s15 DC 47e0
RI15 e15 6 12e-3
VS16 7 s16 0
R16 s16 5 15e2
VS17 4 s17 0
R17 s17 5 18e-2
VS18 1 s18 0
R18 s18 2 68e-2
VS19 3 s19 0
V19 e19 s19 DC 39e-1
RI19 e19 1 10e-3
VS20 9 s20 0
I20 s20 15 DC 27e-2
VS21 10 s21 0
R21 s21 12 82e-1
VS22 4 s22 0
I22 s22 2 DC 10e-2
VS23 12 s23 0
V23 e23 s23 DC 27e-1
RI23 e23 13 68e-3
VS24 4 s24 0
R24 s24 2 27e1
.control
set numdgt=17
op
print v(1) v(2) v(3) v(4) v(5) v(6) v(7) v(8) v(9) v(10)
print v(11) v(12) v(13) v(14) v(15)
print i(vs0) i(vs1) i(vs2) i(vs3) i(vs4) i(vs5) i(vs6) i(vs7) i(vs8) i(vs9)
print i(vs10) i(vs11) i(vs12) i(vs13) i(vs14) i(vs15) i(vs16) i(vs17) i(vs18) i(vs19)
print i(vs20) i(vs21) i(vs22) i(vs23) i(vs24)
.endc
.end
