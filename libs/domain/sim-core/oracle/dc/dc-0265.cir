controls oracle dc-0265
* Generated (plan F2.7, ADR 0012): do not edit; regenerate with `pnpm sim oracle regen`. dc seed 20261030 index 265 nodes 5 elements 8
.options sparse gmin=1e-12 noopac
RG1 1 0 1000000000000
RG2 2 0 1000000000000
RG3 3 0 1000000000000
RG4 4 0 1000000000000
VS0 3 s0 0
R0 s0 2 12e1
VS1 2 s1 0
R1 s1 4 27e-2
VS2 1 s2 0
R2 s2 4 68e-2
VS3 1 s3 0
R3 s3 4 27e2
VS4 0 s4 0
V4 e4 s4 DC 56e-1
RI4 e4 3 68e-3
VS5 3 s5 0
R5 s5 4 47e3
VS6 0 s6 0
R6 s6 1 47e-2
VS7 4 s7 0
R7 s7 0 27e2
.control
set numdgt=17
op
print v(1) v(2) v(3) v(4)
print i(vs0) i(vs1) i(vs2) i(vs3) i(vs4) i(vs5) i(vs6) i(vs7)
.endc
.end
