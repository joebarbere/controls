controls oracle dc-0191
* Generated (plan F2.7, ADR 0012): do not edit; regenerate with `pnpm sim oracle regen`. dc seed 20261030 index 191 nodes 5 elements 6
.options sparse gmin=1e-12 noopac
RG1 1 0 1000000000000
RG2 2 0 1000000000000
RG3 3 0 1000000000000
RG4 4 0 1000000000000
VS0 1 s0 0
R0 s0 2 10e-2
VS1 0 s1 0
V1 e1 s1 DC 47e0
RI1 e1 3 22e-1
VS2 2 s2 0
R2 s2 3 18e-2
VS3 0 s3 0
R3 s3 4 22e2
VS4 2 s4 0
R4 s4 0 15e3
VS5 1 s5 0
V5 e5 s5 DC 56e-1
RI5 e5 4 15e-1
.control
set numdgt=17
op
print v(1) v(2) v(3) v(4)
print i(vs0) i(vs1) i(vs2) i(vs3) i(vs4) i(vs5)
.endc
.end
