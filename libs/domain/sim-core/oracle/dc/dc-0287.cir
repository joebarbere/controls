controls oracle dc-0287
* Generated (plan F2.7, ADR 0012): do not edit; regenerate with `pnpm sim oracle regen`. dc seed 20261030 index 287 nodes 4 elements 7
.options sparse gmin=1e-12 noopac
RG1 1 0 1000000000000
RG2 2 0 1000000000000
RG3 3 0 1000000000000
VS0 0 s0 0
V0 e0 s0 DC 39e1
RI0 e0 1 68e-3
VS1 3 s1 0
I1 s1 1 DC 12e-2
VS2 3 s2 0
R2 s2 0 33e2
VS3 1 s3 0
V3 e3 s3 DC 68e-1
RI3 e3 2 68e-3
VS4 3 s4 0
R4 s4 2 22e2
VS5 0 s5 0
R5 s5 2 27e-2
VS6 0 s6 0
R6 s6 1 10e-1
.control
set numdgt=17
op
print v(1) v(2) v(3)
print i(vs0) i(vs1) i(vs2) i(vs3) i(vs4) i(vs5) i(vs6)
.endc
.end
