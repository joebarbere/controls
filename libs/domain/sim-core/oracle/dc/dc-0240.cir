controls oracle dc-0240
* Generated (plan F2.7, ADR 0012): do not edit; regenerate with `pnpm sim oracle regen`. dc seed 20261030 index 240 nodes 18 elements 31
.options sparse gmin=1e-12 noopac
RG1 1 0 1000000000000
RG2 2 0 1000000000000
RG3 3 0 1000000000000
RG4 4 0 1000000000000
RG5 5 0 1000000000000
RG6 6 0 1000000000000
RG7 7 0 1000000000000
RG8 8 0 1000000000000
RG9 9 0 1000000000000
RG10 10 0 1000000000000
RG11 11 0 1000000000000
RG12 12 0 1000000000000
RG13 13 0 1000000000000
RG14 14 0 1000000000000
RG15 15 0 1000000000000
RG16 16 0 1000000000000
RG17 17 0 1000000000000
VS0 13 s0 0
R0 s0 4 27e2
VS1 0 s1 0
V1 e1 s1 DC 33e-1
RI1 e1 5 18e-1
VS2 6 s2 0
I2 s2 7 DC 39e-1
VS3 5 s3 0
R3 s3 14 12e-1
VS4 3 s4 0
V4 e4 s4 DC 10e1
RI4 e4 7 18e-2
VS5 8 s5 0
R5 s5 16 15e-2
VS6 7 s6 0
I6 s6 4 DC 22e-1
VS7 7 s7 0
R7 s7 14 47e-2
VS8 17 s8 0
R8 s8 15 15e2
VS9 2 s9 0
R9 s9 0 56e-1
VS10 6 s10 0
I10 s10 10 DC 10e-1
VS11 13 s11 0
R11 s11 5 10e-2
VS12 10 s12 0
R12 s12 9 22e-1
VS13 2 s13 0
R13 s13 10 56e-2
VS14 17 s14 0
R14 s14 9 56e3
VS15 2 s15 0
V15 e15 s15 DC 56e1
RI15 e15 17 39e-2
VS16 1 s16 0
R16 s16 10 12e-2
VS17 1 s17 0
R17 s17 6 39e-2
VS18 11 s18 0
V18 e18 s18 DC 33e-1
RI18 e18 6 22e-3
VS19 9 s19 0
R19 s19 5 56e0
VS20 4 s20 0
R20 s20 17 27e-2
VS21 12 s21 0
R21 s21 8 47e2
VS22 15 s22 0
R22 s22 1 22e2
VS23 15 s23 0
I23 s23 13 DC 27e-1
VS24 3 s24 0
R24 s24 14 33e0
VS25 12 s25 0
V25 e25 s25 DC 33e0
RI25 e25 13 18e-2
VS26 16 s26 0
R26 s26 14 22e2
VS27 3 s27 0
R27 s27 9 33e-2
VS28 11 s28 0
R28 s28 17 68e0
VS29 0 s29 0
I29 s29 17 DC 10e-4
VS30 1 s30 0
V30 e30 s30 DC 33e0
RI30 e30 5 39e-1
.control
set numdgt=17
op
print v(1) v(2) v(3) v(4) v(5) v(6) v(7) v(8) v(9) v(10)
print v(11) v(12) v(13) v(14) v(15) v(16) v(17)
print i(vs0) i(vs1) i(vs2) i(vs3) i(vs4) i(vs5) i(vs6) i(vs7) i(vs8) i(vs9)
print i(vs10) i(vs11) i(vs12) i(vs13) i(vs14) i(vs15) i(vs16) i(vs17) i(vs18) i(vs19)
print i(vs20) i(vs21) i(vs22) i(vs23) i(vs24) i(vs25) i(vs26) i(vs27) i(vs28) i(vs29)
print i(vs30)
.endc
.end
