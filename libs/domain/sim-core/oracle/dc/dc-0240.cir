controls oracle dc-0240
* Generated (plan F2.7, ADR 0012): do not edit; regenerate with `pnpm sim oracle regen`. dc seed 20261030 index 240 nodes 18 elements 30
.options sparse gmin=1e-12 noopac
RG1 1 0 1000000000000
RG2 2 0 1000000000000
RG3 3 0 1000000000000
RG4 4 0 1000000000000
RG5 5 0 1000000000000
RG6 6 0 1000000000000
RG7 7 0 1000000000000
RG8 8 0 1000000000000
RG9 9 0 1000000000000
RG10 10 0 1000000000000
RG11 11 0 1000000000000
RG12 12 0 1000000000000
RG13 13 0 1000000000000
RG14 14 0 1000000000000
RG15 15 0 1000000000000
RG16 16 0 1000000000000
RG17 17 0 1000000000000
VS0 9 s0 0
R0 s0 5 56e0
VS1 6 s1 0
I1 s1 7 DC 39e-1
VS2 8 s2 0
R2 s2 16 15e-2
VS3 7 s3 0
I3 s3 4 DC 22e-1
VS4 13 s4 0
R4 s4 4 27e2
VS5 1 s5 0
R5 s5 10 12e-2
VS6 17 s6 0
R6 s6 9 56e3
VS7 2 s7 0
R7 s7 0 56e-1
VS8 15 s8 0
I8 s8 13 DC 27e-1
VS9 0 s9 0
V9 e9 s9 DC 33e-1
RI9 e9 5 18e-1
VS10 6 s10 0
I10 s10 10 DC 10e-1
VS11 16 s11 0
R11 s11 14 22e2
VS12 4 s12 0
R12 s12 17 27e-2
VS13 12 s13 0
R13 s13 8 47e2
VS14 2 s14 0
V14 e14 s14 DC 56e1
RI14 e14 17 39e-2
VS15 1 s15 0
V15 e15 s15 DC 33e0
RI15 e15 5 39e-1
VS16 11 s16 0
V16 e16 s16 DC 33e-1
RI16 e16 6 22e-3
VS17 17 s17 0
R17 s17 15 15e2
VS18 2 s18 0
R18 s18 10 56e-2
VS19 12 s19 0
V19 e19 s19 DC 33e0
RI19 e19 13 18e-2
VS20 3 s20 0
R20 s20 9 33e-2
VS21 0 s21 0
I21 s21 17 DC 10e-4
VS22 11 s22 0
R22 s22 17 68e0
VS23 5 s23 0
R23 s23 14 12e-1
VS24 10 s24 0
R24 s24 9 22e-1
VS25 3 s25 0
R25 s25 14 33e0
VS26 13 s26 0
R26 s26 5 10e-2
VS27 3 s27 0
V27 e27 s27 DC 10e1
RI27 e27 7 18e-2
VS28 15 s28 0
R28 s28 1 22e2
VS29 1 s29 0
R29 s29 6 39e-2
.control
set numdgt=17
op
print v(1) v(2) v(3) v(4) v(5) v(6) v(7) v(8) v(9) v(10)
print v(11) v(12) v(13) v(14) v(15) v(16) v(17)
print i(vs0) i(vs1) i(vs2) i(vs3) i(vs4) i(vs5) i(vs6) i(vs7) i(vs8) i(vs9)
print i(vs10) i(vs11) i(vs12) i(vs13) i(vs14) i(vs15) i(vs16) i(vs17) i(vs18) i(vs19)
print i(vs20) i(vs21) i(vs22) i(vs23) i(vs24) i(vs25) i(vs26) i(vs27) i(vs28) i(vs29)
.endc
.end
