controls oracle dc-0414
* Generated (plan F2.7, ADR 0012): do not edit; regenerate with `pnpm sim oracle regen`. dc seed 20261030 index 414 nodes 25 elements 37
.options sparse gmin=1e-12 noopac
RG1 1 0 1000000000000
RG2 2 0 1000000000000
RG3 3 0 1000000000000
RG4 4 0 1000000000000
RG5 5 0 1000000000000
RG6 6 0 1000000000000
RG7 7 0 1000000000000
RG8 8 0 1000000000000
RG9 9 0 1000000000000
RG10 10 0 1000000000000
RG11 11 0 1000000000000
RG12 12 0 1000000000000
RG13 13 0 1000000000000
RG14 14 0 1000000000000
RG15 15 0 1000000000000
RG16 16 0 1000000000000
RG17 17 0 1000000000000
RG18 18 0 1000000000000
RG19 19 0 1000000000000
RG20 20 0 1000000000000
RG21 21 0 1000000000000
RG22 22 0 1000000000000
RG23 23 0 1000000000000
RG24 24 0 1000000000000
VS0 0 s0 0
V0 e0 s0 DC 15e0
RI0 e0 12 82e-1
VS1 6 s1 0
R1 s1 12 27e-2
VS2 13 s2 0
R2 s2 23 56e2
VS3 24 s3 0
R3 s3 8 82e1
VS4 2 s4 0
R4 s4 7 56e2
VS5 16 s5 0
R5 s5 2 68e3
VS6 7 s6 0
R6 s6 21 18e0
VS7 22 s7 0
V7 e7 s7 DC 22e0
RI7 e7 24 82e-1
VS8 20 s8 0
R8 s8 12 68e0
VS9 4 s9 0
V9 e9 s9 DC 82e-1
RI9 e9 1 39e-2
VS10 16 s10 0
R10 s10 21 39e2
VS11 20 s11 0
V11 e11 s11 DC 12e-1
RI11 e11 1 18e-3
VS12 1 s12 0
V12 e12 s12 DC 10e1
RI12 e12 8 33e-1
VS13 8 s13 0
V13 e13 s13 DC 15e0
RI13 e13 16 27e-1
VS14 0 s14 0
R14 s14 18 39e0
VS15 15 s15 0
R15 s15 7 47e2
VS16 0 s16 0
I16 s16 2 DC 47e-3
VS17 16 s17 0
R17 s17 9 15e0
VS18 5 s18 0
V18 e18 s18 DC 68e-1
RI18 e18 8 15e-3
VS19 20 s19 0
R19 s19 14 27e3
VS20 6 s20 0
R20 s20 1 15e1
VS21 14 s21 0
I21 s21 20 DC 10e-3
VS22 3 s22 0
R22 s22 4 18e3
VS23 8 s23 0
R23 s23 14 15e-1
VS24 15 s24 0
R24 s24 8 15e1
VS25 17 s25 0
V25 e25 s25 DC 47e1
RI25 e25 4 12e-3
VS26 23 s26 0
V26 e26 s26 DC 82e-1
RI26 e26 0 39e-1
VS27 5 s27 0
R27 s27 20 56e-2
VS28 4 s28 0
R28 s28 0 15e2
VS29 11 s29 0
R29 s29 17 68e-1
VS30 6 s30 0
R30 s30 19 39e0
VS31 17 s31 0
V31 e31 s31 DC 82e1
RI31 e31 19 12e-3
VS32 12 s32 0
I32 s32 3 DC 33e-1
VS33 14 s33 0
R33 s33 10 18e1
VS34 4 s34 0
R34 s34 11 47e0
VS35 24 s35 0
I35 s35 5 DC 82e-3
VS36 4 s36 0
R36 s36 24 56e-2
.control
set numdgt=17
op
print v(1) v(2) v(3) v(4) v(5) v(6) v(7) v(8) v(9) v(10)
print v(11) v(12) v(13) v(14) v(15) v(16) v(17) v(18) v(19) v(20)
print v(21) v(22) v(23) v(24)
print i(vs0) i(vs1) i(vs2) i(vs3) i(vs4) i(vs5) i(vs6) i(vs7) i(vs8) i(vs9)
print i(vs10) i(vs11) i(vs12) i(vs13) i(vs14) i(vs15) i(vs16) i(vs17) i(vs18) i(vs19)
print i(vs20) i(vs21) i(vs22) i(vs23) i(vs24) i(vs25) i(vs26) i(vs27) i(vs28) i(vs29)
print i(vs30) i(vs31) i(vs32) i(vs33) i(vs34) i(vs35) i(vs36)
.endc
.end
