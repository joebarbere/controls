controls oracle dc-0414
* Generated (plan F2.7, ADR 0012): do not edit; regenerate with `pnpm sim oracle regen`. dc seed 20261030 index 414 nodes 25 elements 43
.options sparse gmin=1e-12 noopac
RG1 1 0 1000000000000
RG2 2 0 1000000000000
RG3 3 0 1000000000000
RG4 4 0 1000000000000
RG5 5 0 1000000000000
RG6 6 0 1000000000000
RG7 7 0 1000000000000
RG8 8 0 1000000000000
RG9 9 0 1000000000000
RG10 10 0 1000000000000
RG11 11 0 1000000000000
RG12 12 0 1000000000000
RG13 13 0 1000000000000
RG14 14 0 1000000000000
RG15 15 0 1000000000000
RG16 16 0 1000000000000
RG17 17 0 1000000000000
RG18 18 0 1000000000000
RG19 19 0 1000000000000
RG20 20 0 1000000000000
RG21 21 0 1000000000000
RG22 22 0 1000000000000
RG23 23 0 1000000000000
RG24 24 0 1000000000000
VS0 5 s0 0
R0 s0 20 56e-2
VS1 3 s1 0
R1 s1 22 39e-1
VS2 0 s2 0
V2 e2 s2 DC 22e0
RI2 e2 24 82e-1
VS3 12 s3 0
V3 e3 s3 DC 12e1
RI3 e3 13 68e-3
VS4 16 s4 0
V4 e4 s4 DC 15e0
RI4 e4 12 82e-1
VS5 4 s5 0
R5 s5 24 56e-2
VS6 3 s6 0
R6 s6 4 18e3
VS7 12 s7 0
I7 s7 3 DC 33e-1
VS8 16 s8 0
I8 s8 2 DC 47e-3
VS9 4 s9 0
R9 s9 16 15e2
VS10 15 s10 0
R10 s10 7 47e2
VS11 7 s11 0
R11 s11 21 18e0
VS12 4 s12 0
V12 e12 s12 DC 82e-1
RI12 e12 1 39e-2
VS13 24 s13 0
I13 s13 5 DC 82e-3
VS14 1 s14 0
V14 e14 s14 DC 10e1
RI14 e14 8 33e-1
VS15 24 s15 0
R15 s15 8 82e1
VS16 14 s16 0
R16 s16 10 18e1
VS17 2 s17 0
R17 s17 7 56e2
VS18 17 s18 0
V18 e18 s18 DC 82e1
RI18 e18 19 12e-3
VS19 17 s19 0
V19 e19 s19 DC 47e1
RI19 e19 4 12e-3
VS20 3 s20 0
R20 s20 18 47e-2
VS21 20 s21 0
V21 e21 s21 DC 12e-1
RI21 e21 1 18e-3
VS22 6 s22 0
R22 s22 12 27e-2
VS23 16 s23 0
R23 s23 10 18e1
VS24 22 s24 0
R24 s24 9 15e0
VS25 5 s25 0
V25 e25 s25 DC 68e-1
RI25 e25 8 15e-3
VS26 22 s26 0
R26 s26 21 39e2
VS27 24 s27 0
R27 s27 9 22e0
VS28 16 s28 0
R28 s28 18 39e0
VS29 6 s29 0
R29 s29 19 39e0
VS30 4 s30 0
R30 s30 11 47e0
VS31 8 s31 0
R31 s31 14 15e-1
VS32 20 s32 0
R32 s32 12 68e0
VS33 13 s33 0
R33 s33 23 56e2
VS34 18 s34 0
R34 s34 0 68e0
VS35 6 s35 0
R35 s35 1 15e1
VS36 11 s36 0
R36 s36 17 68e-1
VS37 14 s37 0
I37 s37 20 DC 10e-3
VS38 23 s38 0
V38 e38 s38 DC 82e-1
RI38 e38 16 39e-1
VS39 22 s39 0
R39 s39 2 68e3
VS40 15 s40 0
R40 s40 8 15e1
VS41 20 s41 0
R41 s41 14 27e3
VS42 8 s42 0
V42 e42 s42 DC 15e0
RI42 e42 22 27e-1
.control
set numdgt=17
op
print v(1) v(2) v(3) v(4) v(5) v(6) v(7) v(8) v(9) v(10)
print v(11) v(12) v(13) v(14) v(15) v(16) v(17) v(18) v(19) v(20)
print v(21) v(22) v(23) v(24)
print i(vs0) i(vs1) i(vs2) i(vs3) i(vs4) i(vs5) i(vs6) i(vs7) i(vs8) i(vs9)
print i(vs10) i(vs11) i(vs12) i(vs13) i(vs14) i(vs15) i(vs16) i(vs17) i(vs18) i(vs19)
print i(vs20) i(vs21) i(vs22) i(vs23) i(vs24) i(vs25) i(vs26) i(vs27) i(vs28) i(vs29)
print i(vs30) i(vs31) i(vs32) i(vs33) i(vs34) i(vs35) i(vs36) i(vs37) i(vs38) i(vs39)
print i(vs40) i(vs41) i(vs42)
.endc
.end
