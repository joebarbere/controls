controls oracle dc-0135
* Generated (plan F2.7, ADR 0012): do not edit; regenerate with `pnpm sim oracle regen`. dc seed 20261030 index 135 nodes 13 elements 25
.options sparse gmin=1e-12 noopac
RG1 1 0 1000000000000
RG2 2 0 1000000000000
RG3 3 0 1000000000000
RG4 4 0 1000000000000
RG5 5 0 1000000000000
RG6 6 0 1000000000000
RG7 7 0 1000000000000
RG8 8 0 1000000000000
RG9 9 0 1000000000000
RG10 10 0 1000000000000
RG11 11 0 1000000000000
RG12 12 0 1000000000000
VS0 8 s0 0
I0 s0 1 DC 27e-3
VS1 6 s1 0
R1 s1 7 39e0
VS2 8 s2 0
R2 s2 2 27e2
VS3 10 s3 0
R3 s3 3 82e1
VS4 0 s4 0
V4 e4 s4 DC 33e-1
RI4 e4 1 10e-2
VS5 9 s5 0
R5 s5 5 82e0
VS6 4 s6 0
I6 s6 12 DC 33e-2
VS7 3 s7 0
R7 s7 12 33e0
VS8 8 s8 0
R8 s8 1 68e3
VS9 0 s9 0
V9 e9 s9 DC 68e0
RI9 e9 5 39e-1
VS10 7 s10 0
I10 s10 8 DC 82e-1
VS11 11 s11 0
R11 s11 0 22e3
VS12 4 s12 0
V12 e12 s12 DC 82e1
RI12 e12 1 22e-2
VS13 6 s13 0
R13 s13 11 22e1
VS14 4 s14 0
R14 s14 3 39e0
VS15 11 s15 0
V15 e15 s15 DC 27e-1
RI15 e15 10 47e-3
VS16 1 s16 0
R16 s16 7 82e3
VS17 5 s17 0
I17 s17 7 DC 15e-2
VS18 6 s18 0
R18 s18 2 27e-2
VS19 1 s19 0
R19 s19 3 27e0
VS20 10 s20 0
I20 s20 9 DC 12e-3
VS21 8 s21 0
R21 s21 0 10e2
VS22 12 s22 0
R22 s22 9 33e1
VS23 11 s23 0
V23 e23 s23 DC 82e-1
RI23 e23 6 33e-3
VS24 10 s24 0
R24 s24 8 27e0
.control
set numdgt=17
op
print v(1) v(2) v(3) v(4) v(5) v(6) v(7) v(8) v(9) v(10)
print v(11) v(12)
print i(vs0) i(vs1) i(vs2) i(vs3) i(vs4) i(vs5) i(vs6) i(vs7) i(vs8) i(vs9)
print i(vs10) i(vs11) i(vs12) i(vs13) i(vs14) i(vs15) i(vs16) i(vs17) i(vs18) i(vs19)
print i(vs20) i(vs21) i(vs22) i(vs23) i(vs24)
.endc
.end
