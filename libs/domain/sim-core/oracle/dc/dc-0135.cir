controls oracle dc-0135
* Generated (plan F2.7, ADR 0012): do not edit; regenerate with `pnpm sim oracle regen`. dc seed 20261030 index 135 nodes 13 elements 22
.options sparse gmin=1e-12 noopac
RG1 1 0 1000000000000
RG2 2 0 1000000000000
RG3 3 0 1000000000000
RG4 4 0 1000000000000
RG5 5 0 1000000000000
RG6 6 0 1000000000000
RG7 7 0 1000000000000
RG8 8 0 1000000000000
RG9 9 0 1000000000000
RG10 10 0 1000000000000
RG11 11 0 1000000000000
RG12 12 0 1000000000000
VS0 6 s0 0
R0 s0 11 22e1
VS1 8 s1 0
R1 s1 2 27e2
VS2 10 s2 0
R2 s2 8 27e0
VS3 10 s3 0
I3 s3 9 DC 12e-3
VS4 3 s4 0
R4 s4 12 33e0
VS5 8 s5 0
R5 s5 0 10e2
VS6 10 s6 0
R6 s6 3 82e1
VS7 5 s7 0
I7 s7 7 DC 15e-2
VS8 4 s8 0
R8 s8 3 39e0
VS9 1 s9 0
R9 s9 3 27e0
VS10 0 s10 0
V10 e10 s10 DC 68e0
RI10 e10 5 39e-1
VS11 12 s11 0
R11 s11 9 33e1
VS12 4 s12 0
I12 s12 12 DC 33e-2
VS13 0 s13 0
V13 e13 s13 DC 33e-1
RI13 e13 1 10e-2
VS14 11 s14 0
R14 s14 0 22e3
VS15 8 s15 0
I15 s15 1 DC 27e-3
VS16 6 s16 0
R16 s16 7 39e0
VS17 7 s17 0
I17 s17 8 DC 82e-1
VS18 8 s18 0
R18 s18 1 68e3
VS19 11 s19 0
V19 e19 s19 DC 27e-1
RI19 e19 10 47e-3
VS20 9 s20 0
R20 s20 5 82e0
VS21 11 s21 0
V21 e21 s21 DC 82e-1
RI21 e21 6 33e-3
.control
set numdgt=17
op
print v(1) v(2) v(3) v(4) v(5) v(6) v(7) v(8) v(9) v(10)
print v(11) v(12)
print i(vs0) i(vs1) i(vs2) i(vs3) i(vs4) i(vs5) i(vs6) i(vs7) i(vs8) i(vs9)
print i(vs10) i(vs11) i(vs12) i(vs13) i(vs14) i(vs15) i(vs16) i(vs17) i(vs18) i(vs19)
print i(vs20) i(vs21)
.endc
.end
