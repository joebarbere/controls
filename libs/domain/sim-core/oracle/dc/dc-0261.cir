controls oracle dc-0261
* Generated (plan F2.7, ADR 0012): do not edit; regenerate with `pnpm sim oracle regen`. dc seed 20261030 index 261 nodes 30 elements 57
.options sparse gmin=1e-12 noopac
RG1 1 0 1000000000000
RG2 2 0 1000000000000
RG3 3 0 1000000000000
RG4 4 0 1000000000000
RG5 5 0 1000000000000
RG6 6 0 1000000000000
RG7 7 0 1000000000000
RG8 8 0 1000000000000
RG9 9 0 1000000000000
RG10 10 0 1000000000000
RG11 11 0 1000000000000
RG12 12 0 1000000000000
RG13 13 0 1000000000000
RG14 14 0 1000000000000
RG15 15 0 1000000000000
RG16 16 0 1000000000000
RG17 17 0 1000000000000
RG18 18 0 1000000000000
RG19 19 0 1000000000000
RG20 20 0 1000000000000
RG21 21 0 1000000000000
RG22 22 0 1000000000000
RG23 23 0 1000000000000
RG24 24 0 1000000000000
RG25 25 0 1000000000000
RG26 26 0 1000000000000
RG27 27 0 1000000000000
RG28 28 0 1000000000000
RG29 29 0 1000000000000
VS0 16 s0 0
R0 s0 15 12e-2
VS1 19 s1 0
R1 s1 4 56e0
VS2 17 s2 0
I2 s2 5 DC 68e-2
VS3 14 s3 0
R3 s3 27 39e1
VS4 9 s4 0
R4 s4 11 56e1
VS5 0 s5 0
V5 e5 s5 DC 27e1
RI5 e5 10 82e-2
VS6 28 s6 0
R6 s6 5 56e1
VS7 24 s7 0
R7 s7 6 33e0
VS8 6 s8 0
R8 s8 8 12e3
VS9 5 s9 0
R9 s9 9 56e3
VS10 5 s10 0
I10 s10 9 DC 47e-4
VS11 7 s11 0
R11 s11 6 15e3
VS12 2 s12 0
R12 s12 19 27e0
VS13 14 s13 0
I13 s13 18 DC 18e-2
VS14 11 s14 0
R14 s14 6 22e1
VS15 4 s15 0
V15 e15 s15 DC 39e-1
RI15 e15 22 56e-3
VS16 15 s16 0
R16 s16 0 27e-1
VS17 4 s17 0
R17 s17 26 15e0
VS18 0 s18 0
R18 s18 20 12e0
VS19 18 s19 0
R19 s19 1 22e2
VS20 26 s20 0
I20 s20 5 DC 47e-1
VS21 18 s21 0
I21 s21 27 DC 15e-2
VS22 9 s22 0
R22 s22 13 15e1
VS23 29 s23 0
R23 s23 10 27e1
VS24 22 s24 0
R24 s24 25 12e-1
VS25 29 s25 0
I25 s25 22 DC 68e-1
VS26 5 s26 0
R26 s26 15 22e2
VS27 9 s27 0
R27 s27 16 22e2
VS28 25 s28 0
I28 s28 17 DC 68e-3
VS29 20 s29 0
I29 s29 21 DC 33e-1
VS30 29 s30 0
R30 s30 22 39e-2
VS31 21 s31 0
I31 s31 0 DC 12e-3
VS32 10 s32 0
R32 s32 24 12e-1
VS33 8 s33 0
I33 s33 28 DC 56e-4
VS34 26 s34 0
R34 s34 3 27e-1
VS35 19 s35 0
V35 e35 s35 DC 68e1
RI35 e35 10 39e-2
VS36 3 s36 0
R36 s36 8 56e0
VS37 6 s37 0
I37 s37 7 DC 12e-4
VS38 14 s38 0
R38 s38 9 33e0
VS39 28 s39 0
R39 s39 9 39e-2
VS40 11 s40 0
R40 s40 2 22e3
VS41 17 s41 0
V41 e41 s41 DC 82e1
RI41 e41 29 15e-2
VS42 6 s42 0
R42 s42 16 27e0
VS43 24 s43 0
V43 e43 s43 DC 12e0
RI43 e43 0 68e-3
VS44 1 s44 0
R44 s44 6 27e3
VS45 22 s45 0
R45 s45 20 68e2
VS46 27 s46 0
R46 s46 24 27e0
VS47 24 s47 0
R47 s47 6 27e-1
VS48 18 s48 0
R48 s48 12 12e0
VS49 6 s49 0
V49 e49 s49 DC 56e1
RI49 e49 9 18e-1
VS50 23 s50 0
R50 s50 1 22e1
VS51 23 s51 0
R51 s51 2 18e2
VS52 6 s52 0
R52 s52 20 10e1
VS53 23 s53 0
R53 s53 20 12e1
VS54 23 s54 0
R54 s54 21 22e2
VS55 17 s55 0
I55 s55 24 DC 10e-2
VS56 9 s56 0
R56 s56 13 15e-2
.control
set numdgt=17
op
print v(1) v(2) v(3) v(4) v(5) v(6) v(7) v(8) v(9) v(10)
print v(11) v(12) v(13) v(14) v(15) v(16) v(17) v(18) v(19) v(20)
print v(21) v(22) v(23) v(24) v(25) v(26) v(27) v(28) v(29)
print i(vs0) i(vs1) i(vs2) i(vs3) i(vs4) i(vs5) i(vs6) i(vs7) i(vs8) i(vs9)
print i(vs10) i(vs11) i(vs12) i(vs13) i(vs14) i(vs15) i(vs16) i(vs17) i(vs18) i(vs19)
print i(vs20) i(vs21) i(vs22) i(vs23) i(vs24) i(vs25) i(vs26) i(vs27) i(vs28) i(vs29)
print i(vs30) i(vs31) i(vs32) i(vs33) i(vs34) i(vs35) i(vs36) i(vs37) i(vs38) i(vs39)
print i(vs40) i(vs41) i(vs42) i(vs43) i(vs44) i(vs45) i(vs46) i(vs47) i(vs48) i(vs49)
print i(vs50) i(vs51) i(vs52) i(vs53) i(vs54) i(vs55) i(vs56)
.endc
.end
