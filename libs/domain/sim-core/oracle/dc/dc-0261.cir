controls oracle dc-0261
* Generated (plan F2.7, ADR 0012): do not edit; regenerate with `pnpm sim oracle regen`. dc seed 20261030 index 261 nodes 30 elements 63
.options sparse gmin=1e-12 noopac
RG1 1 0 1000000000000
RG2 2 0 1000000000000
RG3 3 0 1000000000000
RG4 4 0 1000000000000
RG5 5 0 1000000000000
RG6 6 0 1000000000000
RG7 7 0 1000000000000
RG8 8 0 1000000000000
RG9 9 0 1000000000000
RG10 10 0 1000000000000
RG11 11 0 1000000000000
RG12 12 0 1000000000000
RG13 13 0 1000000000000
RG14 14 0 1000000000000
RG15 15 0 1000000000000
RG16 16 0 1000000000000
RG17 17 0 1000000000000
RG18 18 0 1000000000000
RG19 19 0 1000000000000
RG20 20 0 1000000000000
RG21 21 0 1000000000000
RG22 22 0 1000000000000
RG23 23 0 1000000000000
RG24 24 0 1000000000000
RG25 25 0 1000000000000
RG26 26 0 1000000000000
RG27 27 0 1000000000000
RG28 28 0 1000000000000
RG29 29 0 1000000000000
VS0 16 s0 0
R0 s0 15 12e-2
VS1 12 s1 0
R1 s1 17 39e0
VS2 24 s2 0
R2 s2 6 27e-1
VS3 11 s3 0
R3 s3 2 22e3
VS4 18 s4 0
R4 s4 12 12e0
VS5 28 s5 0
R5 s5 9 39e-2
VS6 5 s6 0
R6 s6 9 56e3
VS7 0 s7 0
V7 e7 s7 DC 27e1
RI7 e7 10 82e-2
VS8 26 s8 0
I8 s8 5 DC 47e-1
VS9 17 s9 0
V9 e9 s9 DC 82e1
RI9 e9 29 15e-2
VS10 9 s10 0
R10 s10 11 56e1
VS11 19 s11 0
R11 s11 4 56e0
VS12 15 s12 0
R12 s12 0 27e-1
VS13 18 s13 0
R13 s13 1 22e2
VS14 7 s14 0
V14 e14 s14 DC 68e1
RI14 e14 0 12e-3
VS15 21 s15 0
I15 s15 0 DC 12e-3
VS16 6 s16 0
R16 s16 8 12e3
VS17 28 s17 0
R17 s17 5 56e1
VS18 24 s18 0
V18 e18 s18 DC 12e0
RI18 e18 0 68e-3
VS19 9 s19 0
R19 s19 16 22e2
VS20 17 s20 0
I20 s20 5 DC 68e-2
VS21 23 s21 0
R21 s21 12 15e-2
VS22 6 s22 0
R22 s22 20 10e1
VS23 17 s23 0
I23 s23 24 DC 10e-2
VS24 2 s24 0
R24 s24 19 27e0
VS25 22 s25 0
R25 s25 20 68e2
VS26 4 s26 0
R26 s26 26 15e0
VS27 14 s27 0
I27 s27 18 DC 18e-2
VS28 20 s28 0
I28 s28 21 DC 33e-1
VS29 23 s29 0
R29 s29 1 22e1
VS30 9 s30 0
R30 s30 13 15e-2
VS31 9 s31 0
R31 s31 13 15e1
VS32 7 s32 0
R32 s32 6 15e3
VS33 0 s33 0
R33 s33 20 12e0
VS34 11 s34 0
R34 s34 6 22e1
VS35 29 s35 0
I35 s35 22 DC 68e-1
VS36 14 s36 0
R36 s36 27 39e1
VS37 3 s37 0
R37 s37 8 56e0
VS38 23 s38 0
R38 s38 21 22e2
VS39 5 s39 0
I39 s39 9 DC 47e-4
VS40 8 s40 0
I40 s40 28 DC 56e-4
VS41 29 s41 0
R41 s41 10 27e1
VS42 1 s42 0
R42 s42 6 27e3
VS43 13 s43 0
R43 s43 6 39e2
VS44 23 s44 0
R44 s44 20 12e1
VS45 22 s45 0
R45 s45 25 12e-1
VS46 19 s46 0
V46 e46 s46 DC 68e1
RI46 e46 10 39e-2
VS47 26 s47 0
R47 s47 3 27e-1
VS48 14 s48 0
R48 s48 9 33e0
VS49 6 s49 0
R49 s49 16 27e0
VS50 18 s50 0
I50 s50 27 DC 15e-2
VS51 29 s51 0
R51 s51 22 39e-2
VS52 6 s52 0
I52 s52 7 DC 12e-4
VS53 25 s53 0
V53 e53 s53 DC 82e0
RI53 e53 12 82e-2
VS54 24 s54 0
R54 s54 6 33e0
VS55 5 s55 0
R55 s55 15 22e2
VS56 6 s56 0
V56 e56 s56 DC 56e1
RI56 e56 9 18e-1
VS57 10 s57 0
R57 s57 24 12e-1
VS58 21 s58 0
V58 e58 s58 DC 15e1
RI58 e58 2 47e-1
VS59 27 s59 0
R59 s59 24 27e0
VS60 4 s60 0
V60 e60 s60 DC 39e-1
RI60 e60 22 56e-3
VS61 23 s61 0
R61 s61 2 18e2
VS62 25 s62 0
I62 s62 17 DC 68e-3
.control
set numdgt=17
op
print v(1) v(2) v(3) v(4) v(5) v(6) v(7) v(8) v(9) v(10)
print v(11) v(12) v(13) v(14) v(15) v(16) v(17) v(18) v(19) v(20)
print v(21) v(22) v(23) v(24) v(25) v(26) v(27) v(28) v(29)
print i(vs0) i(vs1) i(vs2) i(vs3) i(vs4) i(vs5) i(vs6) i(vs7) i(vs8) i(vs9)
print i(vs10) i(vs11) i(vs12) i(vs13) i(vs14) i(vs15) i(vs16) i(vs17) i(vs18) i(vs19)
print i(vs20) i(vs21) i(vs22) i(vs23) i(vs24) i(vs25) i(vs26) i(vs27) i(vs28) i(vs29)
print i(vs30) i(vs31) i(vs32) i(vs33) i(vs34) i(vs35) i(vs36) i(vs37) i(vs38) i(vs39)
print i(vs40) i(vs41) i(vs42) i(vs43) i(vs44) i(vs45) i(vs46) i(vs47) i(vs48) i(vs49)
print i(vs50) i(vs51) i(vs52) i(vs53) i(vs54) i(vs55) i(vs56) i(vs57) i(vs58) i(vs59)
print i(vs60) i(vs61) i(vs62)
.endc
.end
