controls oracle dc-0250
* Generated (plan F2.7, ADR 0012): do not edit; regenerate with `pnpm sim oracle regen`. dc seed 20261030 index 250 nodes 7 elements 7
.options sparse gmin=1e-12 noopac
RG1 1 0 1000000000000
RG2 2 0 1000000000000
RG3 3 0 1000000000000
RG4 4 0 1000000000000
RG5 5 0 1000000000000
RG6 6 0 1000000000000
VS0 3 s0 0
R0 s0 1 39e3
VS1 6 s1 0
R1 s1 5 33e-1
VS2 5 s2 0
R2 s2 0 33e-1
VS3 2 s3 0
R3 s3 5 56e0
VS4 6 s4 0
R4 s4 1 68e0
VS5 0 s5 0
V5 e5 s5 DC 12e0
RI5 e5 5 39e-1
VS6 4 s6 0
R6 s6 5 12e1
.control
set numdgt=17
op
print v(1) v(2) v(3) v(4) v(5) v(6)
print i(vs0) i(vs1) i(vs2) i(vs3) i(vs4) i(vs5) i(vs6)
.endc
.end
