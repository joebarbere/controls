controls oracle dc-0017
* Generated (plan F2.7, ADR 0012): do not edit; regenerate with `pnpm sim oracle regen`. dc seed 20261030 index 17 nodes 30 elements 60
.options sparse gmin=1e-12 noopac
RG1 1 0 1000000000000
RG2 2 0 1000000000000
RG3 3 0 1000000000000
RG4 4 0 1000000000000
RG5 5 0 1000000000000
RG6 6 0 1000000000000
RG7 7 0 1000000000000
RG8 8 0 1000000000000
RG9 9 0 1000000000000
RG10 10 0 1000000000000
RG11 11 0 1000000000000
RG12 12 0 1000000000000
RG13 13 0 1000000000000
RG14 14 0 1000000000000
RG15 15 0 1000000000000
RG16 16 0 1000000000000
RG17 17 0 1000000000000
RG18 18 0 1000000000000
RG19 19 0 1000000000000
RG20 20 0 1000000000000
RG21 21 0 1000000000000
RG22 22 0 1000000000000
RG23 23 0 1000000000000
RG24 24 0 1000000000000
RG25 25 0 1000000000000
RG26 26 0 1000000000000
RG27 27 0 1000000000000
RG28 28 0 1000000000000
RG29 29 0 1000000000000
VS0 3 s0 0
R0 s0 9 39e2
VS1 23 s1 0
R1 s1 22 47e1
VS2 25 s2 0
R2 s2 10 27e-2
VS3 13 s3 0
R3 s3 5 82e0
VS4 28 s4 0
I4 s4 27 DC 22e-3
VS5 3 s5 0
R5 s5 9 68e2
VS6 22 s6 0
R6 s6 11 39e0
VS7 15 s7 0
R7 s7 17 33e2
VS8 0 s8 0
R8 s8 8 68e3
VS9 12 s9 0
I9 s9 0 DC 18e-3
VS10 0 s10 0
V10 e10 s10 DC 15e-1
RI10 e10 6 10e-1
VS11 2 s11 0
R11 s11 25 10e1
VS12 15 s12 0
V12 e12 s12 DC 18e0
RI12 e12 22 82e-3
VS13 16 s13 0
R13 s13 8 39e0
VS14 26 s14 0
R14 s14 12 39e-1
VS15 3 s15 0
V15 e15 s15 DC 22e-1
RI15 e15 19 39e-1
VS16 5 s16 0
R16 s16 4 22e3
VS17 25 s17 0
R17 s17 17 68e2
VS18 29 s18 0
V18 e18 s18 DC 10e1
RI18 e18 12 10e-2
VS19 0 s19 0
R19 s19 29 12e0
VS20 27 s20 0
R20 s20 2 18e-2
VS21 10 s21 0
R21 s21 8 39e-2
VS22 10 s22 0
R22 s22 24 56e3
VS23 25 s23 0
R23 s23 12 27e2
VS24 24 s24 0
R24 s24 12 10e2
VS25 9 s25 0
R25 s25 8 10e-2
VS26 25 s26 0
R26 s26 21 22e3
VS27 27 s27 0
V27 e27 s27 DC 22e0
RI27 e27 5 18e-1
VS28 16 s28 0
I28 s28 28 DC 39e-1
VS29 28 s29 0
V29 e29 s29 DC 12e0
RI29 e29 14 56e-3
VS30 13 s30 0
R30 s30 22 15e-2
VS31 21 s31 0
R31 s31 1 68e3
VS32 1 s32 0
R32 s32 8 33e1
VS33 24 s33 0
R33 s33 18 12e0
VS34 14 s34 0
R34 s34 6 18e0
VS35 2 s35 0
V35 e35 s35 DC 33e1
RI35 e35 3 56e-3
VS36 29 s36 0
R36 s36 25 15e3
VS37 22 s37 0
I37 s37 18 DC 27e-3
VS38 28 s38 0
R38 s38 21 10e1
VS39 5 s39 0
R39 s39 11 12e-2
VS40 23 s40 0
R40 s40 20 15e3
VS41 0 s41 0
R41 s41 7 27e-2
VS42 14 s42 0
V42 e42 s42 DC 22e1
RI42 e42 17 33e-3
VS43 4 s43 0
R43 s43 21 39e0
VS44 7 s44 0
R44 s44 9 15e0
VS45 13 s45 0
I45 s45 12 DC 68e-3
VS46 4 s46 0
R46 s46 8 18e-1
VS47 13 s47 0
R47 s47 16 68e2
VS48 7 s48 0
V48 e48 s48 DC 33e-1
RI48 e48 23 15e-2
VS49 5 s49 0
R49 s49 20 22e1
VS50 18 s50 0
I50 s50 17 DC 47e-4
VS51 27 s51 0
I51 s51 13 DC 15e-2
VS52 13 s52 0
V52 e52 s52 DC 56e0
RI52 e52 1 27e-2
VS53 2 s53 0
R53 s53 26 82e2
VS54 13 s54 0
R54 s54 15 47e-1
VS55 18 s55 0
R55 s55 21 68e2
VS56 24 s56 0
V56 e56 s56 DC 82e0
RI56 e56 9 39e-3
VS57 9 s57 0
R57 s57 19 27e0
VS58 20 s58 0
I58 s58 12 DC 68e-1
VS59 18 s59 0
R59 s59 23 39e0
.control
set numdgt=17
op
print v(1) v(2) v(3) v(4) v(5) v(6) v(7) v(8) v(9) v(10)
print v(11) v(12) v(13) v(14) v(15) v(16) v(17) v(18) v(19) v(20)
print v(21) v(22) v(23) v(24) v(25) v(26) v(27) v(28) v(29)
print i(vs0) i(vs1) i(vs2) i(vs3) i(vs4) i(vs5) i(vs6) i(vs7) i(vs8) i(vs9)
print i(vs10) i(vs11) i(vs12) i(vs13) i(vs14) i(vs15) i(vs16) i(vs17) i(vs18) i(vs19)
print i(vs20) i(vs21) i(vs22) i(vs23) i(vs24) i(vs25) i(vs26) i(vs27) i(vs28) i(vs29)
print i(vs30) i(vs31) i(vs32) i(vs33) i(vs34) i(vs35) i(vs36) i(vs37) i(vs38) i(vs39)
print i(vs40) i(vs41) i(vs42) i(vs43) i(vs44) i(vs45) i(vs46) i(vs47) i(vs48) i(vs49)
print i(vs50) i(vs51) i(vs52) i(vs53) i(vs54) i(vs55) i(vs56) i(vs57) i(vs58) i(vs59)
.endc
.end
