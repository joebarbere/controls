controls oracle dc-0017
* Generated (plan F2.7, ADR 0012): do not edit; regenerate with `pnpm sim oracle regen`. dc seed 20261030 index 17 nodes 30 elements 56
.options sparse gmin=1e-12 noopac
RG1 1 0 1000000000000
RG2 2 0 1000000000000
RG3 3 0 1000000000000
RG4 4 0 1000000000000
RG5 5 0 1000000000000
RG6 6 0 1000000000000
RG7 7 0 1000000000000
RG8 8 0 1000000000000
RG9 9 0 1000000000000
RG10 10 0 1000000000000
RG11 11 0 1000000000000
RG12 12 0 1000000000000
RG13 13 0 1000000000000
RG14 14 0 1000000000000
RG15 15 0 1000000000000
RG16 16 0 1000000000000
RG17 17 0 1000000000000
RG18 18 0 1000000000000
RG19 19 0 1000000000000
RG20 20 0 1000000000000
RG21 21 0 1000000000000
RG22 22 0 1000000000000
RG23 23 0 1000000000000
RG24 24 0 1000000000000
RG25 25 0 1000000000000
RG26 26 0 1000000000000
RG27 27 0 1000000000000
RG28 28 0 1000000000000
RG29 29 0 1000000000000
VS0 16 s0 0
I0 s0 28 DC 39e-1
VS1 29 s1 0
R1 s1 25 15e3
VS2 22 s2 0
I2 s2 18 DC 27e-3
VS3 0 s3 0
V3 e3 s3 DC 22e-1
RI3 e3 19 39e-1
VS4 10 s4 0
R4 s4 3 39e-2
VS5 29 s5 0
V5 e5 s5 DC 10e1
RI5 e5 12 10e-2
VS6 25 s6 0
R6 s6 17 68e2
VS7 14 s7 0
V7 e7 s7 DC 22e1
RI7 e7 17 33e-3
VS8 13 s8 0
R8 s8 16 68e2
VS9 24 s9 0
R9 s9 12 10e2
VS10 24 s10 0
R10 s10 18 12e0
VS11 21 s11 0
R11 s11 1 68e3
VS12 20 s12 0
I12 s12 12 DC 68e-1
VS13 0 s13 0
R13 s13 9 39e2
VS14 26 s14 0
R14 s14 12 39e-1
VS15 15 s15 0
R15 s15 17 33e2
VS16 0 s16 0
R16 s16 9 68e2
VS17 8 s17 0
R17 s17 7 27e-2
VS18 15 s18 0
V18 e18 s18 DC 18e0
RI18 e18 22 82e-3
VS19 18 s19 0
R19 s19 21 68e2
VS20 18 s20 0
R20 s20 23 39e0
VS21 12 s21 0
I21 s21 8 DC 18e-3
VS22 7 s22 0
R22 s22 9 15e0
VS23 24 s23 0
V23 e23 s23 DC 82e0
RI23 e23 9 39e-3
VS24 25 s24 0
R24 s24 21 22e3
VS25 7 s25 0
V25 e25 s25 DC 33e-1
RI25 e25 23 15e-2
VS26 4 s26 0
R26 s26 3 18e-1
VS27 2 s27 0
R27 s27 25 10e1
VS28 13 s28 0
R28 s28 15 47e-1
VS29 4 s29 0
R29 s29 21 39e0
VS30 28 s30 0
V30 e30 s30 DC 12e0
RI30 e30 14 56e-3
VS31 18 s31 0
I31 s31 17 DC 47e-4
VS32 27 s32 0
I32 s32 13 DC 15e-2
VS33 13 s33 0
R33 s33 5 82e0
VS34 14 s34 0
R34 s34 6 18e0
VS35 25 s35 0
R35 s35 12 27e2
VS36 28 s36 0
I36 s36 27 DC 22e-3
VS37 25 s37 0
R37 s37 10 27e-2
VS38 23 s38 0
R38 s38 22 47e1
VS39 13 s39 0
R39 s39 22 15e-2
VS40 5 s40 0
R40 s40 4 22e3
VS41 22 s41 0
R41 s41 11 39e0
VS42 5 s42 0
R42 s42 20 22e1
VS43 16 s43 0
R43 s43 3 39e0
VS44 27 s44 0
V44 e44 s44 DC 22e0
RI44 e44 5 18e-1
VS45 27 s45 0
R45 s45 2 18e-2
VS46 28 s46 0
R46 s46 21 10e1
VS47 9 s47 0
R47 s47 19 27e0
VS48 13 s48 0
V48 e48 s48 DC 56e0
RI48 e48 1 27e-2
VS49 1 s49 0
R49 s49 3 33e1
VS50 8 s50 0
R50 s50 29 12e0
VS51 10 s51 0
R51 s51 24 56e3
VS52 5 s52 0
R52 s52 11 12e-2
VS53 8 s53 0
R53 s53 3 68e3
VS54 13 s54 0
I54 s54 12 DC 68e-3
VS55 9 s55 0
R55 s55 3 10e-2
.control
set numdgt=17
op
print v(1) v(2) v(3) v(4) v(5) v(6) v(7) v(8) v(9) v(10)
print v(11) v(12) v(13) v(14) v(15) v(16) v(17) v(18) v(19) v(20)
print v(21) v(22) v(23) v(24) v(25) v(26) v(27) v(28) v(29)
print i(vs0) i(vs1) i(vs2) i(vs3) i(vs4) i(vs5) i(vs6) i(vs7) i(vs8) i(vs9)
print i(vs10) i(vs11) i(vs12) i(vs13) i(vs14) i(vs15) i(vs16) i(vs17) i(vs18) i(vs19)
print i(vs20) i(vs21) i(vs22) i(vs23) i(vs24) i(vs25) i(vs26) i(vs27) i(vs28) i(vs29)
print i(vs30) i(vs31) i(vs32) i(vs33) i(vs34) i(vs35) i(vs36) i(vs37) i(vs38) i(vs39)
print i(vs40) i(vs41) i(vs42) i(vs43) i(vs44) i(vs45) i(vs46) i(vs47) i(vs48) i(vs49)
print i(vs50) i(vs51) i(vs52) i(vs53) i(vs54) i(vs55)
.endc
.end
