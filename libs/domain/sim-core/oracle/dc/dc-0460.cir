controls oracle dc-0460
* Generated (plan F2.7, ADR 0012): do not edit; regenerate with `pnpm sim oracle regen`. dc seed 20261030 index 460 nodes 28 elements 45
.options sparse gmin=1e-12 noopac
RG1 1 0 1000000000000
RG2 2 0 1000000000000
RG3 3 0 1000000000000
RG4 4 0 1000000000000
RG5 5 0 1000000000000
RG6 6 0 1000000000000
RG7 7 0 1000000000000
RG8 8 0 1000000000000
RG9 9 0 1000000000000
RG10 10 0 1000000000000
RG11 11 0 1000000000000
RG12 12 0 1000000000000
RG13 13 0 1000000000000
RG14 14 0 1000000000000
RG15 15 0 1000000000000
RG16 16 0 1000000000000
RG17 17 0 1000000000000
RG18 18 0 1000000000000
RG19 19 0 1000000000000
RG20 20 0 1000000000000
RG21 21 0 1000000000000
RG22 22 0 1000000000000
RG23 23 0 1000000000000
RG24 24 0 1000000000000
RG25 25 0 1000000000000
RG26 26 0 1000000000000
RG27 27 0 1000000000000
VS0 18 s0 0
R0 s0 26 15e0
VS1 1 s1 0
R1 s1 11 15e-2
VS2 17 s2 0
R2 s2 26 33e1
VS3 15 s3 0
R3 s3 6 56e2
VS4 8 s4 0
R4 s4 7 15e3
VS5 0 s5 0
V5 e5 s5 DC 47e1
RI5 e5 15 10e-2
VS6 25 s6 0
R6 s6 12 22e-1
VS7 20 s7 0
R7 s7 14 10e-1
VS8 0 s8 0
R8 s8 2 27e-2
VS9 11 s9 0
R9 s9 23 56e-1
VS10 3 s10 0
R10 s10 21 39e0
VS11 4 s11 0
R11 s11 27 56e0
VS12 7 s12 0
R12 s12 10 56e-1
VS13 24 s13 0
R13 s13 1 56e1
VS14 20 s14 0
V14 e14 s14 DC 18e1
RI14 e14 15 56e-2
VS15 26 s15 0
R15 s15 16 22e2
VS16 3 s16 0
R16 s16 19 15e-1
VS17 6 s17 0
R17 s17 1 33e0
VS18 19 s18 0
R18 s18 22 15e3
VS19 8 s19 0
V19 e19 s19 DC 47e0
RI19 e19 18 47e-3
VS20 16 s20 0
I20 s20 23 DC 39e-4
VS21 13 s21 0
V21 e21 s21 DC 82e0
RI21 e21 26 12e-1
VS22 22 s22 0
R22 s22 26 47e0
VS23 4 s23 0
R23 s23 15 56e1
VS24 9 s24 0
V24 e24 s24 DC 27e-1
RI24 e24 25 56e-1
VS25 6 s25 0
R25 s25 9 68e0
VS26 16 s26 0
R26 s26 12 12e1
VS27 24 s27 0
V27 e27 s27 DC 33e0
RI27 e27 19 18e-3
VS28 8 s28 0
R28 s28 23 10e-1
VS29 23 s29 0
V29 e29 s29 DC 39e-1
RI29 e29 20 47e-3
VS30 2 s30 0
V30 e30 s30 DC 12e-1
RI30 e30 27 47e-2
VS31 15 s31 0
V31 e31 s31 DC 47e1
RI31 e31 26 15e-1
VS32 0 s32 0
R32 s32 4 39e-1
VS33 22 s33 0
R33 s33 20 22e2
VS34 5 s34 0
R34 s34 8 82e-1
VS35 15 s35 0
R35 s35 26 47e1
VS36 12 s36 0
R36 s36 14 68e2
VS37 27 s37 0
R37 s37 26 68e-1
VS38 1 s38 0
R38 s38 5 12e3
VS39 15 s39 0
R39 s39 17 10e2
VS40 9 s40 0
R40 s40 13 56e1
VS41 26 s41 0
R41 s41 21 33e-2
VS42 21 s42 0
R42 s42 24 56e3
VS43 22 s43 0
R43 s43 12 82e-1
VS44 18 s44 0
R44 s44 10 12e1
.control
set numdgt=17
op
print v(1) v(2) v(3) v(4) v(5) v(6) v(7) v(8) v(9) v(10)
print v(11) v(12) v(13) v(14) v(15) v(16) v(17) v(18) v(19) v(20)
print v(21) v(22) v(23) v(24) v(25) v(26) v(27)
print i(vs0) i(vs1) i(vs2) i(vs3) i(vs4) i(vs5) i(vs6) i(vs7) i(vs8) i(vs9)
print i(vs10) i(vs11) i(vs12) i(vs13) i(vs14) i(vs15) i(vs16) i(vs17) i(vs18) i(vs19)
print i(vs20) i(vs21) i(vs22) i(vs23) i(vs24) i(vs25) i(vs26) i(vs27) i(vs28) i(vs29)
print i(vs30) i(vs31) i(vs32) i(vs33) i(vs34) i(vs35) i(vs36) i(vs37) i(vs38) i(vs39)
print i(vs40) i(vs41) i(vs42) i(vs43) i(vs44)
.endc
.end
