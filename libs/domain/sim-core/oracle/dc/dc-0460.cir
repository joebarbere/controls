controls oracle dc-0460
* Generated (plan F2.7, ADR 0012): do not edit; regenerate with `pnpm sim oracle regen`. dc seed 20261030 index 460 nodes 28 elements 38
.options sparse gmin=1e-12 noopac
RG1 1 0 1000000000000
RG2 2 0 1000000000000
RG3 3 0 1000000000000
RG4 4 0 1000000000000
RG5 5 0 1000000000000
RG6 6 0 1000000000000
RG7 7 0 1000000000000
RG8 8 0 1000000000000
RG9 9 0 1000000000000
RG10 10 0 1000000000000
RG11 11 0 1000000000000
RG12 12 0 1000000000000
RG13 13 0 1000000000000
RG14 14 0 1000000000000
RG15 15 0 1000000000000
RG16 16 0 1000000000000
RG17 17 0 1000000000000
RG18 18 0 1000000000000
RG19 19 0 1000000000000
RG20 20 0 1000000000000
RG21 21 0 1000000000000
RG22 22 0 1000000000000
RG23 23 0 1000000000000
RG24 24 0 1000000000000
RG25 25 0 1000000000000
RG26 26 0 1000000000000
RG27 27 0 1000000000000
VS0 15 s0 0
R0 s0 26 47e1
VS1 0 s1 0
V1 e1 s1 DC 33e0
RI1 e1 19 18e-3
VS2 1 s2 0
R2 s2 11 15e-2
VS3 20 s3 0
R3 s3 14 10e-1
VS4 26 s4 0
R4 s4 16 22e2
VS5 19 s5 0
R5 s5 22 15e3
VS6 22 s6 0
R6 s6 20 22e2
VS7 15 s7 0
R7 s7 24 56e2
VS8 3 s8 0
R8 s8 19 15e-1
VS9 0 s9 0
R9 s9 1 56e1
VS10 4 s10 0
R10 s10 27 56e0
VS11 8 s11 0
R11 s11 7 15e3
VS12 22 s12 0
R12 s12 12 82e-1
VS13 11 s13 0
R13 s13 23 56e-1
VS14 23 s14 0
V14 e14 s14 DC 39e-1
RI14 e14 20 47e-3
VS15 7 s15 0
R15 s15 10 56e-1
VS16 24 s16 0
R16 s16 9 68e0
VS17 15 s17 0
V17 e17 s17 DC 47e1
RI17 e17 26 15e-1
VS18 13 s18 0
V18 e18 s18 DC 82e0
RI18 e18 26 12e-1
VS19 6 s19 0
R19 s19 4 39e-1
VS20 8 s20 0
R20 s20 23 10e-1
VS21 17 s21 0
R21 s21 26 33e1
VS22 22 s22 0
R22 s22 26 47e0
VS23 18 s23 0
R23 s23 26 15e0
VS24 26 s24 0
R24 s24 21 33e-2
VS25 3 s25 0
R25 s25 21 39e0
VS26 4 s26 0
R26 s26 15 56e1
VS27 18 s27 0
R27 s27 10 12e1
VS28 6 s28 0
R28 s28 2 27e-2
VS29 24 s29 0
R29 s29 1 33e0
VS30 1 s30 0
R30 s30 5 12e3
VS31 21 s31 0
R31 s31 0 56e3
VS32 9 s32 0
V32 e32 s32 DC 27e-1
RI32 e32 25 56e-1
VS33 20 s33 0
V33 e33 s33 DC 18e1
RI33 e33 15 56e-2
VS34 9 s34 0
R34 s34 13 56e1
VS35 16 s35 0
I35 s35 23 DC 39e-4
VS36 8 s36 0
V36 e36 s36 DC 47e0
RI36 e36 18 47e-3
VS37 6 s37 0
V37 e37 s37 DC 47e1
RI37 e37 15 10e-2
.control
set numdgt=17
op
print v(1) v(2) v(3) v(4) v(5) v(6) v(7) v(8) v(9) v(10)
print v(11) v(12) v(13) v(14) v(15) v(16) v(17) v(18) v(19) v(20)
print v(21) v(22) v(23) v(24) v(25) v(26) v(27)
print i(vs0) i(vs1) i(vs2) i(vs3) i(vs4) i(vs5) i(vs6) i(vs7) i(vs8) i(vs9)
print i(vs10) i(vs11) i(vs12) i(vs13) i(vs14) i(vs15) i(vs16) i(vs17) i(vs18) i(vs19)
print i(vs20) i(vs21) i(vs22) i(vs23) i(vs24) i(vs25) i(vs26) i(vs27) i(vs28) i(vs29)
print i(vs30) i(vs31) i(vs32) i(vs33) i(vs34) i(vs35) i(vs36) i(vs37)
.endc
.end
