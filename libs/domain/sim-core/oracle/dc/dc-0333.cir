controls oracle dc-0333
* Generated (plan F2.7, ADR 0012): do not edit; regenerate with `pnpm sim oracle regen`. dc seed 20261030 index 333 nodes 6 elements 7
.options sparse gmin=1e-12 noopac
RG1 1 0 1000000000000
RG2 2 0 1000000000000
RG3 3 0 1000000000000
RG4 4 0 1000000000000
RG5 5 0 1000000000000
VS0 5 s0 0
R0 s0 2 56e-1
VS1 0 s1 0
V1 e1 s1 DC 15e1
RI1 e1 3 56e-1
VS2 3 s2 0
R2 s2 5 68e1
VS3 2 s3 0
V3 e3 s3 DC 18e1
RI3 e3 1 12e-1
VS4 1 s4 0
I4 s4 0 DC 68e-1
VS5 4 s5 0
V5 e5 s5 DC 12e0
RI5 e5 5 12e-2
VS6 0 s6 0
V6 e6 s6 DC 68e1
RI6 e6 1 12e-2
.control
set numdgt=17
op
print v(1) v(2) v(3) v(4) v(5)
print i(vs0) i(vs1) i(vs2) i(vs3) i(vs4) i(vs5) i(vs6)
.endc
.end
