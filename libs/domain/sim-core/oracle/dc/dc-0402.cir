controls oracle dc-0402
* Generated (plan F2.7, ADR 0012): do not edit; regenerate with `pnpm sim oracle regen`. dc seed 20261030 index 402 nodes 24 elements 43
.options sparse gmin=1e-12 noopac
RG1 1 0 1000000000000
RG2 2 0 1000000000000
RG3 3 0 1000000000000
RG4 4 0 1000000000000
RG5 5 0 1000000000000
RG6 6 0 1000000000000
RG7 7 0 1000000000000
RG8 8 0 1000000000000
RG9 9 0 1000000000000
RG10 10 0 1000000000000
RG11 11 0 1000000000000
RG12 12 0 1000000000000
RG13 13 0 1000000000000
RG14 14 0 1000000000000
RG15 15 0 1000000000000
RG16 16 0 1000000000000
RG17 17 0 1000000000000
RG18 18 0 1000000000000
RG19 19 0 1000000000000
RG20 20 0 1000000000000
RG21 21 0 1000000000000
RG22 22 0 1000000000000
RG23 23 0 1000000000000
VS0 0 s0 0
V0 e0 s0 DC 22e0
RI0 e0 14 10e-3
VS1 7 s1 0
I1 s1 21 DC 47e-2
VS2 15 s2 0
R2 s2 13 39e2
VS3 16 s3 0
R3 s3 0 10e0
VS4 2 s4 0
V4 e4 s4 DC 12e0
RI4 e4 13 47e-1
VS5 8 s5 0
R5 s5 22 56e-2
VS6 17 s6 0
R6 s6 1 68e0
VS7 16 s7 0
V7 e7 s7 DC 22e-1
RI7 e7 9 18e-2
VS8 22 s8 0
V8 e8 s8 DC 18e0
RI8 e8 4 15e-2
VS9 0 s9 0
I9 s9 4 DC 68e-2
VS10 6 s10 0
R10 s10 23 10e-1
VS11 11 s11 0
R11 s11 20 15e2
VS12 6 s12 0
R12 s12 5 33e3
VS13 13 s13 0
R13 s13 8 10e3
VS14 22 s14 0
R14 s14 19 27e3
VS15 22 s15 0
R15 s15 5 15e3
VS16 10 s16 0
R16 s16 21 56e0
VS17 9 s17 0
R17 s17 11 56e1
VS18 22 s18 0
R18 s18 12 12e-2
VS19 8 s19 0
R19 s19 10 39e3
VS20 16 s20 0
R20 s20 2 39e3
VS21 0 s21 0
R21 s21 18 27e1
VS22 10 s22 0
R22 s22 12 39e3
VS23 11 s23 0
R23 s23 2 82e-1
VS24 21 s24 0
R24 s24 23 56e-1
VS25 11 s25 0
R25 s25 4 22e1
VS26 11 s26 0
R26 s26 3 27e0
VS27 17 s27 0
R27 s27 11 39e-2
VS28 11 s28 0
R28 s28 18 15e0
VS29 1 s29 0
R29 s29 11 82e-2
VS30 2 s30 0
R30 s30 3 12e2
VS31 13 s31 0
I31 s31 12 DC 15e-1
VS32 9 s32 0
R32 s32 14 68e-1
VS33 5 s33 0
R33 s33 15 47e-2
VS34 18 s34 0
V34 e34 s34 DC 47e-1
RI34 e34 7 56e-2
VS35 4 s35 0
R35 s35 13 47e3
VS36 5 s36 0
V36 e36 s36 DC 22e-1
RI36 e36 19 82e-2
VS37 8 s37 0
V37 e37 s37 DC 27e1
RI37 e37 5 33e-3
VS38 20 s38 0
R38 s38 11 10e1
VS39 2 s39 0
R39 s39 7 10e1
VS40 5 s40 0
V40 e40 s40 DC 18e1
RI40 e40 2 22e-1
VS41 17 s41 0
R41 s41 5 39e2
VS42 6 s42 0
R42 s42 20 47e0
.control
set numdgt=17
op
print v(1) v(2) v(3) v(4) v(5) v(6) v(7) v(8) v(9) v(10)
print v(11) v(12) v(13) v(14) v(15) v(16) v(17) v(18) v(19) v(20)
print v(21) v(22) v(23)
print i(vs0) i(vs1) i(vs2) i(vs3) i(vs4) i(vs5) i(vs6) i(vs7) i(vs8) i(vs9)
print i(vs10) i(vs11) i(vs12) i(vs13) i(vs14) i(vs15) i(vs16) i(vs17) i(vs18) i(vs19)
print i(vs20) i(vs21) i(vs22) i(vs23) i(vs24) i(vs25) i(vs26) i(vs27) i(vs28) i(vs29)
print i(vs30) i(vs31) i(vs32) i(vs33) i(vs34) i(vs35) i(vs36) i(vs37) i(vs38) i(vs39)
print i(vs40) i(vs41) i(vs42)
.endc
.end
