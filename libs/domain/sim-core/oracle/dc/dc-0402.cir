controls oracle dc-0402
* Generated (plan F2.7, ADR 0012): do not edit; regenerate with `pnpm sim oracle regen`. dc seed 20261030 index 402 nodes 24 elements 37
.options sparse gmin=1e-12 noopac
RG1 1 0 1000000000000
RG2 2 0 1000000000000
RG3 3 0 1000000000000
RG4 4 0 1000000000000
RG5 5 0 1000000000000
RG6 6 0 1000000000000
RG7 7 0 1000000000000
RG8 8 0 1000000000000
RG9 9 0 1000000000000
RG10 10 0 1000000000000
RG11 11 0 1000000000000
RG12 12 0 1000000000000
RG13 13 0 1000000000000
RG14 14 0 1000000000000
RG15 15 0 1000000000000
RG16 16 0 1000000000000
RG17 17 0 1000000000000
RG18 18 0 1000000000000
RG19 19 0 1000000000000
RG20 20 0 1000000000000
RG21 21 0 1000000000000
RG22 22 0 1000000000000
RG23 23 0 1000000000000
VS0 0 s0 0
V0 e0 s0 DC 12e0
RI0 e0 13 47e-1
VS1 9 s1 0
R1 s1 11 56e1
VS2 11 s2 0
R2 s2 0 82e-1
VS3 18 s3 0
V3 e3 s3 DC 47e-1
RI3 e3 7 56e-2
VS4 9 s4 0
R4 s4 14 68e-1
VS5 2 s5 0
V5 e5 s5 DC 27e1
RI5 e5 5 33e-3
VS6 16 s6 0
R6 s6 0 39e3
VS7 8 s7 0
R7 s7 18 27e1
VS8 2 s8 0
R8 s8 10 39e3
VS9 8 s9 0
I9 s9 4 DC 68e-2
VS10 6 s10 0
R10 s10 5 33e3
VS11 5 s11 0
V11 e11 s11 DC 18e1
RI11 e11 0 22e-1
VS12 5 s12 0
R12 s12 15 47e-2
VS13 10 s13 0
R13 s13 21 56e0
VS14 16 s14 0
R14 s14 8 10e0
VS15 4 s15 0
R15 s15 13 47e3
VS16 20 s16 0
R16 s16 11 10e1
VS17 22 s17 0
R17 s17 12 12e-2
VS18 6 s18 0
R18 s18 23 10e-1
VS19 22 s19 0
R19 s19 5 15e3
VS20 17 s20 0
R20 s20 11 39e-2
VS21 0 s21 0
R21 s21 7 10e1
VS22 8 s22 0
V22 e22 s22 DC 22e0
RI22 e22 14 10e-3
VS23 13 s23 0
R23 s23 2 10e3
VS24 5 s24 0
V24 e24 s24 DC 22e-1
RI24 e24 19 82e-2
VS25 6 s25 0
R25 s25 20 47e0
VS26 16 s26 0
V26 e26 s26 DC 22e-1
RI26 e26 9 18e-2
VS27 7 s27 0
I27 s27 21 DC 47e-2
VS28 13 s28 0
I28 s28 12 DC 15e-1
VS29 11 s29 0
R29 s29 4 22e1
VS30 17 s30 0
R30 s30 1 68e0
VS31 0 s31 0
R31 s31 3 12e2
VS32 2 s32 0
R32 s32 22 56e-2
VS33 11 s33 0
R33 s33 20 15e2
VS34 11 s34 0
R34 s34 18 15e0
VS35 10 s35 0
R35 s35 12 39e3
VS36 22 s36 0
V36 e36 s36 DC 18e0
RI36 e36 4 15e-2
.control
set numdgt=17
op
print v(1) v(2) v(3) v(4) v(5) v(6) v(7) v(8) v(9) v(10)
print v(11) v(12) v(13) v(14) v(15) v(16) v(17) v(18) v(19) v(20)
print v(21) v(22) v(23)
print i(vs0) i(vs1) i(vs2) i(vs3) i(vs4) i(vs5) i(vs6) i(vs7) i(vs8) i(vs9)
print i(vs10) i(vs11) i(vs12) i(vs13) i(vs14) i(vs15) i(vs16) i(vs17) i(vs18) i(vs19)
print i(vs20) i(vs21) i(vs22) i(vs23) i(vs24) i(vs25) i(vs26) i(vs27) i(vs28) i(vs29)
print i(vs30) i(vs31) i(vs32) i(vs33) i(vs34) i(vs35) i(vs36)
.endc
.end
