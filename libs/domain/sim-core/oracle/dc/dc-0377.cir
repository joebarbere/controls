controls oracle dc-0377
* Generated (plan F2.7, ADR 0012): do not edit; regenerate with `pnpm sim oracle regen`. dc seed 20261030 index 377 nodes 29 elements 49
.options sparse gmin=1e-12 noopac
RG1 1 0 1000000000000
RG2 2 0 1000000000000
RG3 3 0 1000000000000
RG4 4 0 1000000000000
RG5 5 0 1000000000000
RG6 6 0 1000000000000
RG7 7 0 1000000000000
RG8 8 0 1000000000000
RG9 9 0 1000000000000
RG10 10 0 1000000000000
RG11 11 0 1000000000000
RG12 12 0 1000000000000
RG13 13 0 1000000000000
RG14 14 0 1000000000000
RG15 15 0 1000000000000
RG16 16 0 1000000000000
RG17 17 0 1000000000000
RG18 18 0 1000000000000
RG19 19 0 1000000000000
RG20 20 0 1000000000000
RG21 21 0 1000000000000
RG22 22 0 1000000000000
RG23 23 0 1000000000000
RG24 24 0 1000000000000
RG25 25 0 1000000000000
RG26 26 0 1000000000000
RG27 27 0 1000000000000
RG28 28 0 1000000000000
VS0 8 s0 0
R0 s0 9 27e0
VS1 27 s1 0
R1 s1 23 56e2
VS2 0 s2 0
V2 e2 s2 DC 15e0
RI2 e2 14 15e-1
VS3 19 s3 0
R3 s3 11 22e2
VS4 10 s4 0
R4 s4 13 10e3
VS5 21 s5 0
R5 s5 8 68e0
VS6 21 s6 0
R6 s6 27 68e2
VS7 0 s7 0
R7 s7 7 68e3
VS8 0 s8 0
R8 s8 20 10e-2
VS9 18 s9 0
R9 s9 2 12e2
VS10 8 s10 0
R10 s10 14 10e2
VS11 5 s11 0
R11 s11 27 39e-2
VS12 14 s12 0
I12 s12 20 DC 47e-1
VS13 1 s13 0
R13 s13 24 82e1
VS14 2 s14 0
R14 s14 6 27e3
VS15 25 s15 0
R15 s15 27 22e-2
VS16 25 s16 0
R16 s16 16 68e-2
VS17 17 s17 0
R17 s17 9 22e-2
VS18 4 s18 0
R18 s18 5 10e-1
VS19 27 s19 0
R19 s19 25 22e-1
VS20 11 s20 0
R20 s20 4 15e-2
VS21 27 s21 0
R21 s21 20 10e0
VS22 28 s22 0
V22 e22 s22 DC 12e-1
RI22 e22 12 68e-1
VS23 23 s23 0
R23 s23 22 27e3
VS24 3 s24 0
V24 e24 s24 DC 47e-1
RI24 e24 1 18e-2
VS25 13 s25 0
R25 s25 24 47e0
VS26 19 s26 0
R26 s26 2 68e1
VS27 2 s27 0
R27 s27 14 56e-1
VS28 1 s28 0
R28 s28 18 56e2
VS29 16 s29 0
V29 e29 s29 DC 22e1
RI29 e29 15 12e-1
VS30 26 s30 0
R30 s30 7 22e-1
VS31 22 s31 0
R31 s31 3 18e2
VS32 27 s32 0
R32 s32 2 15e-1
VS33 26 s33 0
R33 s33 12 82e-2
VS34 19 s34 0
I34 s34 1 DC 27e-3
VS35 26 s35 0
I35 s35 3 DC 15e-2
VS36 17 s36 0
V36 e36 s36 DC 12e1
RI36 e36 6 56e-2
VS37 10 s37 0
I37 s37 16 DC 68e-2
VS38 12 s38 0
V38 e38 s38 DC 47e-1
RI38 e38 0 39e-3
VS39 9 s39 0
V39 e39 s39 DC 39e0
RI39 e39 12 47e-3
VS40 14 s40 0
R40 s40 28 68e2
VS41 5 s41 0
R41 s41 0 68e0
VS42 21 s42 0
R42 s42 27 10e2
VS43 28 s43 0
I43 s43 10 DC 82e-3
VS44 2 s44 0
R44 s44 10 47e2
VS45 3 s45 0
V45 e45 s45 DC 68e-1
RI45 e45 0 18e-2
VS46 19 s46 0
R46 s46 12 12e-2
VS47 24 s47 0
R47 s47 11 68e0
VS48 15 s48 0
R48 s48 26 82e1
.control
set numdgt=17
op
print v(1) v(2) v(3) v(4) v(5) v(6) v(7) v(8) v(9) v(10)
print v(11) v(12) v(13) v(14) v(15) v(16) v(17) v(18) v(19) v(20)
print v(21) v(22) v(23) v(24) v(25) v(26) v(27) v(28)
print i(vs0) i(vs1) i(vs2) i(vs3) i(vs4) i(vs5) i(vs6) i(vs7) i(vs8) i(vs9)
print i(vs10) i(vs11) i(vs12) i(vs13) i(vs14) i(vs15) i(vs16) i(vs17) i(vs18) i(vs19)
print i(vs20) i(vs21) i(vs22) i(vs23) i(vs24) i(vs25) i(vs26) i(vs27) i(vs28) i(vs29)
print i(vs30) i(vs31) i(vs32) i(vs33) i(vs34) i(vs35) i(vs36) i(vs37) i(vs38) i(vs39)
print i(vs40) i(vs41) i(vs42) i(vs43) i(vs44) i(vs45) i(vs46) i(vs47) i(vs48)
.endc
.end
