controls oracle dc-0377
* Generated (plan F2.7, ADR 0012): do not edit; regenerate with `pnpm sim oracle regen`. dc seed 20261030 index 377 nodes 29 elements 41
.options sparse gmin=1e-12 noopac
RG1 1 0 1000000000000
RG2 2 0 1000000000000
RG3 3 0 1000000000000
RG4 4 0 1000000000000
RG5 5 0 1000000000000
RG6 6 0 1000000000000
RG7 7 0 1000000000000
RG8 8 0 1000000000000
RG9 9 0 1000000000000
RG10 10 0 1000000000000
RG11 11 0 1000000000000
RG12 12 0 1000000000000
RG13 13 0 1000000000000
RG14 14 0 1000000000000
RG15 15 0 1000000000000
RG16 16 0 1000000000000
RG17 17 0 1000000000000
RG18 18 0 1000000000000
RG19 19 0 1000000000000
RG20 20 0 1000000000000
RG21 21 0 1000000000000
RG22 22 0 1000000000000
RG23 23 0 1000000000000
RG24 24 0 1000000000000
RG25 25 0 1000000000000
RG26 26 0 1000000000000
RG27 27 0 1000000000000
RG28 28 0 1000000000000
VS0 18 s0 0
R0 s0 2 12e2
VS1 0 s1 0
V1 e1 s1 DC 68e-1
RI1 e1 27 18e-2
VS2 25 s2 0
R2 s2 3 22e-2
VS3 10 s3 0
I3 s3 16 DC 68e-2
VS4 21 s4 0
R4 s4 3 10e2
VS5 25 s5 0
R5 s5 16 68e-2
VS6 14 s6 0
R6 s6 28 68e2
VS7 3 s7 0
R7 s7 2 15e-1
VS8 3 s8 0
R8 s8 23 56e2
VS9 1 s9 0
R9 s9 24 82e1
VS10 19 s10 0
R10 s10 2 68e1
VS11 26 s11 0
I11 s11 0 DC 15e-2
VS12 14 s12 0
I12 s12 20 DC 47e-1
VS13 19 s13 0
I13 s13 1 DC 27e-3
VS14 28 s14 0
I14 s14 10 DC 82e-3
VS15 19 s15 0
R15 s15 12 12e-2
VS16 5 s16 0
R16 s16 3 39e-2
VS17 27 s17 0
R17 s17 20 10e-2
VS18 12 s18 0
V18 e18 s18 DC 47e-1
RI18 e18 27 39e-3
VS19 11 s19 0
R19 s19 4 15e-2
VS20 27 s20 0
V20 e20 s20 DC 15e0
RI20 e20 14 15e-1
VS21 19 s21 0
R21 s21 11 22e2
VS22 9 s22 0
V22 e22 s22 DC 39e0
RI22 e22 12 47e-3
VS23 3 s23 0
R23 s23 20 10e0
VS24 10 s24 0
R24 s24 13 10e3
VS25 28 s25 0
V25 e25 s25 DC 12e-1
RI25 e25 12 68e-1
VS26 2 s26 0
R26 s26 6 27e3
VS27 13 s27 0
R27 s27 24 47e0
VS28 2 s28 0
R28 s28 14 56e-1
VS29 15 s29 0
R29 s29 26 82e1
VS30 2 s30 0
R30 s30 10 47e2
VS31 21 s31 0
R31 s31 3 68e2
VS32 17 s32 0
V32 e32 s32 DC 12e1
RI32 e32 6 56e-2
VS33 8 s33 0
R33 s33 14 10e2
VS34 23 s34 0
R34 s34 22 27e3
VS35 3 s35 0
R35 s35 25 22e-1
VS36 26 s36 0
R36 s36 12 82e-2
VS37 24 s37 0
R37 s37 11 68e0
VS38 26 s38 0
R38 s38 7 22e-1
VS39 16 s39 0
V39 e39 s39 DC 22e1
RI39 e39 15 12e-1
VS40 5 s40 0
R40 s40 27 68e0
.control
set numdgt=17
op
print v(1) v(2) v(3) v(4) v(5) v(6) v(7) v(8) v(9) v(10)
print v(11) v(12) v(13) v(14) v(15) v(16) v(17) v(18) v(19) v(20)
print v(21) v(22) v(23) v(24) v(25) v(26) v(27) v(28)
print i(vs0) i(vs1) i(vs2) i(vs3) i(vs4) i(vs5) i(vs6) i(vs7) i(vs8) i(vs9)
print i(vs10) i(vs11) i(vs12) i(vs13) i(vs14) i(vs15) i(vs16) i(vs17) i(vs18) i(vs19)
print i(vs20) i(vs21) i(vs22) i(vs23) i(vs24) i(vs25) i(vs26) i(vs27) i(vs28) i(vs29)
print i(vs30) i(vs31) i(vs32) i(vs33) i(vs34) i(vs35) i(vs36) i(vs37) i(vs38) i(vs39)
print i(vs40)
.endc
.end
