controls oracle dc-0025
* Generated (plan F2.7, ADR 0012): do not edit; regenerate with `pnpm sim oracle regen`. dc seed 20261030 index 25 nodes 28 elements 46
.options sparse gmin=1e-12 noopac
RG1 1 0 1000000000000
RG2 2 0 1000000000000
RG3 3 0 1000000000000
RG4 4 0 1000000000000
RG5 5 0 1000000000000
RG6 6 0 1000000000000
RG7 7 0 1000000000000
RG8 8 0 1000000000000
RG9 9 0 1000000000000
RG10 10 0 1000000000000
RG11 11 0 1000000000000
RG12 12 0 1000000000000
RG13 13 0 1000000000000
RG14 14 0 1000000000000
RG15 15 0 1000000000000
RG16 16 0 1000000000000
RG17 17 0 1000000000000
RG18 18 0 1000000000000
RG19 19 0 1000000000000
RG20 20 0 1000000000000
RG21 21 0 1000000000000
RG22 22 0 1000000000000
RG23 23 0 1000000000000
RG24 24 0 1000000000000
RG25 25 0 1000000000000
RG26 26 0 1000000000000
RG27 27 0 1000000000000
VS0 0 s0 0
V0 e0 s0 DC 18e-1
RI0 e0 7 10e-3
VS1 0 s1 0
R1 s1 13 82e3
VS2 12 s2 0
R2 s2 16 22e2
VS3 9 s3 0
R3 s3 4 39e-1
VS4 14 s4 0
R4 s4 6 47e-1
VS5 22 s5 0
R5 s5 16 15e1
VS6 24 s6 0
R6 s6 21 22e-2
VS7 14 s7 0
R7 s7 15 39e2
VS8 5 s8 0
R8 s8 15 22e1
VS9 21 s9 0
I9 s9 13 DC 12e-2
VS10 24 s10 0
R10 s10 10 22e-2
VS11 24 s11 0
R11 s11 21 18e2
VS12 9 s12 0
R12 s12 20 15e2
VS13 2 s13 0
R13 s13 4 56e0
VS14 26 s14 0
V14 e14 s14 DC 56e0
RI14 e14 17 10e-2
VS15 19 s15 0
R15 s15 16 68e-1
VS16 4 s16 0
I16 s16 2 DC 56e-3
VS17 23 s17 0
V17 e17 s17 DC 33e1
RI17 e17 21 47e-1
VS18 12 s18 0
R18 s18 4 18e3
VS19 15 s19 0
R19 s19 4 27e2
VS20 22 s20 0
R20 s20 4 33e1
VS21 13 s21 0
R21 s21 22 56e0
VS22 26 s22 0
I22 s22 27 DC 47e-2
VS23 6 s23 0
R23 s23 15 27e-2
VS24 10 s24 0
R24 s24 25 15e3
VS25 27 s25 0
R25 s25 19 27e-1
VS26 23 s26 0
R26 s26 12 22e0
VS27 18 s27 0
V27 e27 s27 DC 18e-1
RI27 e27 7 39e-3
VS28 3 s28 0
R28 s28 8 47e-2
VS29 11 s29 0
V29 e29 s29 DC 82e-1
RI29 e29 22 27e-2
VS30 27 s30 0
R30 s30 23 47e2
VS31 23 s31 0
R31 s31 8 39e0
VS32 26 s32 0
V32 e32 s32 DC 39e1
RI32 e32 11 15e-2
VS33 5 s33 0
R33 s33 7 39e-2
VS34 10 s34 0
R34 s34 22 56e0
VS35 4 s35 0
R35 s35 26 12e-1
VS36 7 s36 0
R36 s36 6 47e0
VS37 17 s37 0
R37 s37 2 56e1
VS38 6 s38 0
R38 s38 26 22e2
VS39 1 s39 0
R39 s39 18 27e2
VS40 27 s40 0
I40 s40 14 DC 12e-3
VS41 23 s41 0
R41 s41 3 10e1
VS42 3 s42 0
R42 s42 20 12e0
VS43 23 s43 0
R43 s43 25 33e-1
VS44 19 s44 0
R44 s44 10 15e0
VS45 1 s45 0
R45 s45 15 68e3
.control
set numdgt=17
op
print v(1) v(2) v(3) v(4) v(5) v(6) v(7) v(8) v(9) v(10)
print v(11) v(12) v(13) v(14) v(15) v(16) v(17) v(18) v(19) v(20)
print v(21) v(22) v(23) v(24) v(25) v(26) v(27)
print i(vs0) i(vs1) i(vs2) i(vs3) i(vs4) i(vs5) i(vs6) i(vs7) i(vs8) i(vs9)
print i(vs10) i(vs11) i(vs12) i(vs13) i(vs14) i(vs15) i(vs16) i(vs17) i(vs18) i(vs19)
print i(vs20) i(vs21) i(vs22) i(vs23) i(vs24) i(vs25) i(vs26) i(vs27) i(vs28) i(vs29)
print i(vs30) i(vs31) i(vs32) i(vs33) i(vs34) i(vs35) i(vs36) i(vs37) i(vs38) i(vs39)
print i(vs40) i(vs41) i(vs42) i(vs43) i(vs44) i(vs45)
.endc
.end
