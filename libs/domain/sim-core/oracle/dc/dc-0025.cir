controls oracle dc-0025
* Generated (plan F2.7, ADR 0012): do not edit; regenerate with `pnpm sim oracle regen`. dc seed 20261030 index 25 nodes 28 elements 42
.options sparse gmin=1e-12 noopac
RG1 1 0 1000000000000
RG2 2 0 1000000000000
RG3 3 0 1000000000000
RG4 4 0 1000000000000
RG5 5 0 1000000000000
RG6 6 0 1000000000000
RG7 7 0 1000000000000
RG8 8 0 1000000000000
RG9 9 0 1000000000000
RG10 10 0 1000000000000
RG11 11 0 1000000000000
RG12 12 0 1000000000000
RG13 13 0 1000000000000
RG14 14 0 1000000000000
RG15 15 0 1000000000000
RG16 16 0 1000000000000
RG17 17 0 1000000000000
RG18 18 0 1000000000000
RG19 19 0 1000000000000
RG20 20 0 1000000000000
RG21 21 0 1000000000000
RG22 22 0 1000000000000
RG23 23 0 1000000000000
RG24 24 0 1000000000000
RG25 25 0 1000000000000
RG26 26 0 1000000000000
RG27 27 0 1000000000000
VS0 14 s0 0
R0 s0 15 39e2
VS1 6 s1 0
R1 s1 15 27e-2
VS2 4 s2 0
R2 s2 26 12e-1
VS3 23 s3 0
R3 s3 12 22e0
VS4 23 s4 0
R4 s4 25 33e-1
VS5 3 s5 0
R5 s5 8 47e-2
VS6 24 s6 0
R6 s6 21 18e2
VS7 23 s7 0
R7 s7 3 10e1
VS8 21 s8 0
I8 s8 13 DC 12e-2
VS9 1 s9 0
R9 s9 18 27e2
VS10 5 s10 0
R10 s10 7 39e-2
VS11 4 s11 0
I11 s11 2 DC 56e-3
VS12 0 s12 0
V12 e12 s12 DC 18e-1
RI12 e12 7 10e-3
VS13 1 s13 0
R13 s13 15 68e3
VS14 3 s14 0
R14 s14 20 12e0
VS15 12 s15 0
R15 s15 16 22e2
VS16 27 s16 0
R16 s16 23 47e2
VS17 22 s17 0
R17 s17 16 15e1
VS18 22 s18 0
R18 s18 4 33e1
VS19 26 s19 0
I19 s19 27 DC 47e-2
VS20 7 s20 0
R20 s20 6 47e0
VS21 9 s21 0
R21 s21 20 15e2
VS22 10 s22 0
R22 s22 22 56e0
VS23 24 s23 0
R23 s23 10 22e-2
VS24 27 s24 0
I24 s24 14 DC 12e-3
VS25 11 s25 0
V25 e25 s25 DC 82e-1
RI25 e25 22 27e-2
VS26 23 s26 0
V26 e26 s26 DC 33e1
RI26 e26 21 47e-1
VS27 15 s27 0
R27 s27 4 27e2
VS28 12 s28 0
R28 s28 4 18e3
VS29 24 s29 0
R29 s29 21 22e-2
VS30 27 s30 0
R30 s30 19 27e-1
VS31 26 s31 0
V31 e31 s31 DC 56e0
RI31 e31 17 10e-2
VS32 6 s32 0
R32 s32 26 22e2
VS33 2 s33 0
R33 s33 4 56e0
VS34 13 s34 0
R34 s34 22 56e0
VS35 23 s35 0
R35 s35 8 39e0
VS36 9 s36 0
R36 s36 4 39e-1
VS37 18 s37 0
V37 e37 s37 DC 18e-1
RI37 e37 7 39e-3
VS38 0 s38 0
R38 s38 13 82e3
VS39 19 s39 0
R39 s39 10 15e0
VS40 19 s40 0
R40 s40 16 68e-1
VS41 26 s41 0
V41 e41 s41 DC 39e1
RI41 e41 11 15e-2
.control
set numdgt=17
op
print v(1) v(2) v(3) v(4) v(5) v(6) v(7) v(8) v(9) v(10)
print v(11) v(12) v(13) v(14) v(15) v(16) v(17) v(18) v(19) v(20)
print v(21) v(22) v(23) v(24) v(25) v(26) v(27)
print i(vs0) i(vs1) i(vs2) i(vs3) i(vs4) i(vs5) i(vs6) i(vs7) i(vs8) i(vs9)
print i(vs10) i(vs11) i(vs12) i(vs13) i(vs14) i(vs15) i(vs16) i(vs17) i(vs18) i(vs19)
print i(vs20) i(vs21) i(vs22) i(vs23) i(vs24) i(vs25) i(vs26) i(vs27) i(vs28) i(vs29)
print i(vs30) i(vs31) i(vs32) i(vs33) i(vs34) i(vs35) i(vs36) i(vs37) i(vs38) i(vs39)
print i(vs40) i(vs41)
.endc
.end
