controls oracle dc-0075
* Generated (plan F2.7, ADR 0012): do not edit; regenerate with `pnpm sim oracle regen`. dc seed 20261030 index 75 nodes 28 elements 44
.options sparse gmin=1e-12 noopac
RG1 1 0 1000000000000
RG2 2 0 1000000000000
RG3 3 0 1000000000000
RG4 4 0 1000000000000
RG5 5 0 1000000000000
RG6 6 0 1000000000000
RG7 7 0 1000000000000
RG8 8 0 1000000000000
RG9 9 0 1000000000000
RG10 10 0 1000000000000
RG11 11 0 1000000000000
RG12 12 0 1000000000000
RG13 13 0 1000000000000
RG14 14 0 1000000000000
RG15 15 0 1000000000000
RG16 16 0 1000000000000
RG17 17 0 1000000000000
RG18 18 0 1000000000000
RG19 19 0 1000000000000
RG20 20 0 1000000000000
RG21 21 0 1000000000000
RG22 22 0 1000000000000
RG23 23 0 1000000000000
RG24 24 0 1000000000000
RG25 25 0 1000000000000
RG26 26 0 1000000000000
RG27 27 0 1000000000000
VS0 27 s0 0
R0 s0 24 33e2
VS1 17 s1 0
I1 s1 2 DC 12e-3
VS2 19 s2 0
R2 s2 15 33e-1
VS3 8 s3 0
R3 s3 22 18e-2
VS4 0 s4 0
V4 e4 s4 DC 22e1
RI4 e4 4 33e-2
VS5 15 s5 0
V5 e5 s5 DC 18e1
RI5 e5 24 47e-3
VS6 4 s6 0
R6 s6 16 10e-2
VS7 9 s7 0
R7 s7 1 82e-1
VS8 19 s8 0
R8 s8 8 10e-2
VS9 22 s9 0
R9 s9 1 27e1
VS10 19 s10 0
R10 s10 1 33e-2
VS11 18 s11 0
V11 e11 s11 DC 27e-1
RI11 e11 12 22e-2
VS12 15 s12 0
R12 s12 0 56e0
VS13 19 s13 0
V13 e13 s13 DC 33e0
RI13 e13 24 56e-2
VS14 14 s14 0
R14 s14 8 12e1
VS15 2 s15 0
I15 s15 0 DC 27e-1
VS16 10 s16 0
V16 e16 s16 DC 33e0
RI16 e16 8 56e-3
VS17 8 s17 0
R17 s17 13 82e0
VS18 5 s18 0
R18 s18 7 27e-2
VS19 1 s19 0
V19 e19 s19 DC 12e-1
RI19 e19 6 22e-1
VS20 2 s20 0
R20 s20 4 68e-1
VS21 0 s21 0
V21 e21 s21 DC 22e1
RI21 e21 21 18e-1
VS22 7 s22 0
I22 s22 19 DC 15e-1
VS23 18 s23 0
R23 s23 25 82e-2
VS24 20 s24 0
I24 s24 19 DC 15e-1
VS25 2 s25 0
V25 e25 s25 DC 15e0
RI25 e25 12 56e-3
VS26 27 s26 0
R26 s26 17 68e0
VS27 8 s27 0
R27 s27 15 10e-1
VS28 5 s28 0
R28 s28 19 82e-1
VS29 13 s29 0
I29 s29 26 DC 68e-2
VS30 8 s30 0
R30 s30 23 68e-1
VS31 23 s31 0
R31 s31 19 56e-2
VS32 20 s32 0
R32 s32 8 82e2
VS33 4 s33 0
R33 s33 1 82e-2
VS34 15 s34 0
R34 s34 3 27e3
VS35 10 s35 0
R35 s35 27 82e-1
VS36 14 s36 0
R36 s36 4 82e-1
VS37 8 s37 0
R37 s37 3 15e0
VS38 12 s38 0
I38 s38 4 DC 56e-3
VS39 19 s39 0
R39 s39 26 82e2
VS40 17 s40 0
R40 s40 20 68e-1
VS41 6 s41 0
V41 e41 s41 DC 22e0
RI41 e41 12 39e-2
VS42 22 s42 0
V42 e42 s42 DC 33e-1
RI42 e42 13 56e-3
VS43 6 s43 0
R43 s43 11 68e0
.control
set numdgt=17
op
print v(1) v(2) v(3) v(4) v(5) v(6) v(7) v(8) v(9) v(10)
print v(11) v(12) v(13) v(14) v(15) v(16) v(17) v(18) v(19) v(20)
print v(21) v(22) v(23) v(24) v(25) v(26) v(27)
print i(vs0) i(vs1) i(vs2) i(vs3) i(vs4) i(vs5) i(vs6) i(vs7) i(vs8) i(vs9)
print i(vs10) i(vs11) i(vs12) i(vs13) i(vs14) i(vs15) i(vs16) i(vs17) i(vs18) i(vs19)
print i(vs20) i(vs21) i(vs22) i(vs23) i(vs24) i(vs25) i(vs26) i(vs27) i(vs28) i(vs29)
print i(vs30) i(vs31) i(vs32) i(vs33) i(vs34) i(vs35) i(vs36) i(vs37) i(vs38) i(vs39)
print i(vs40) i(vs41) i(vs42) i(vs43)
.endc
.end
