controls oracle dc-0075
* Generated (plan F2.7, ADR 0012): do not edit; regenerate with `pnpm sim oracle regen`. dc seed 20261030 index 75 nodes 28 elements 49
.options sparse gmin=1e-12 noopac
RG1 1 0 1000000000000
RG2 2 0 1000000000000
RG3 3 0 1000000000000
RG4 4 0 1000000000000
RG5 5 0 1000000000000
RG6 6 0 1000000000000
RG7 7 0 1000000000000
RG8 8 0 1000000000000
RG9 9 0 1000000000000
RG10 10 0 1000000000000
RG11 11 0 1000000000000
RG12 12 0 1000000000000
RG13 13 0 1000000000000
RG14 14 0 1000000000000
RG15 15 0 1000000000000
RG16 16 0 1000000000000
RG17 17 0 1000000000000
RG18 18 0 1000000000000
RG19 19 0 1000000000000
RG20 20 0 1000000000000
RG21 21 0 1000000000000
RG22 22 0 1000000000000
RG23 23 0 1000000000000
RG24 24 0 1000000000000
RG25 25 0 1000000000000
RG26 26 0 1000000000000
RG27 27 0 1000000000000
VS0 5 s0 0
R0 s0 0 82e-1
VS1 14 s1 0
R1 s1 19 12e1
VS2 0 s2 0
R2 s2 15 33e-1
VS3 5 s3 0
R3 s3 7 27e-2
VS4 18 s4 0
R4 s4 25 82e-2
VS5 0 s5 0
V5 e5 s5 DC 33e0
RI5 e5 24 56e-2
VS6 19 s6 0
R6 s6 23 68e-1
VS7 2 s7 0
I7 s7 8 DC 27e-1
VS8 4 s8 0
R8 s8 16 10e-2
VS9 0 s9 0
R9 s9 19 10e-2
VS10 12 s10 0
I10 s10 4 DC 56e-3
VS11 23 s11 0
R11 s11 0 56e-2
VS12 7 s12 0
R12 s12 11 22e3
VS13 20 s13 0
I13 s13 0 DC 15e-1
VS14 19 s14 0
R14 s14 13 82e0
VS15 10 s15 0
V15 e15 s15 DC 33e0
RI15 e15 19 56e-3
VS16 15 s16 0
V16 e16 s16 DC 18e1
RI16 e16 24 47e-3
VS17 2 s17 0
V17 e17 s17 DC 15e0
RI17 e17 12 56e-3
VS18 26 s18 0
R18 s18 11 15e0
VS19 9 s19 0
R19 s19 1 82e-1
VS20 15 s20 0
R20 s20 3 27e3
VS21 6 s21 0
V21 e21 s21 DC 22e0
RI21 e21 12 39e-2
VS22 25 s22 0
R22 s22 0 27e-1
VS23 17 s23 0
R23 s23 20 68e-1
VS24 19 s24 0
R24 s24 3 15e0
VS25 18 s25 0
V25 e25 s25 DC 27e-1
RI25 e25 12 22e-2
VS26 1 s26 0
V26 e26 s26 DC 12e-1
RI26 e26 6 22e-1
VS27 22 s27 0
V27 e27 s27 DC 33e-1
RI27 e27 13 56e-3
VS28 13 s28 0
I28 s28 26 DC 68e-2
VS29 8 s29 0
V29 e29 s29 DC 22e1
RI29 e29 4 33e-2
VS30 6 s30 0
R30 s30 11 68e0
VS31 4 s31 0
R31 s31 1 82e-2
VS32 22 s32 0
R32 s32 1 27e1
VS33 19 s33 0
R33 s33 22 18e-2
VS34 19 s34 0
R34 s34 15 10e-1
VS35 0 s35 0
R35 s35 26 82e2
VS36 15 s36 0
R36 s36 8 56e0
VS37 14 s37 0
R37 s37 4 82e-1
VS38 16 s38 0
R38 s38 21 12e3
VS39 10 s39 0
R39 s39 27 82e-1
VS40 27 s40 0
R40 s40 17 68e0
VS41 20 s41 0
R41 s41 19 82e2
VS42 2 s42 0
R42 s42 4 68e-1
VS43 8 s43 0
V43 e43 s43 DC 22e1
RI43 e43 21 18e-1
VS44 27 s44 0
R44 s44 24 33e2
VS45 17 s45 0
I45 s45 2 DC 12e-3
VS46 0 s46 0
R46 s46 1 33e-2
VS47 7 s47 0
I47 s47 0 DC 15e-1
VS48 7 s48 0
V48 e48 s48 DC 22e1
RI48 e48 9 15e-1
.control
set numdgt=17
op
print v(1) v(2) v(3) v(4) v(5) v(6) v(7) v(8) v(9) v(10)
print v(11) v(12) v(13) v(14) v(15) v(16) v(17) v(18) v(19) v(20)
print v(21) v(22) v(23) v(24) v(25) v(26) v(27)
print i(vs0) i(vs1) i(vs2) i(vs3) i(vs4) i(vs5) i(vs6) i(vs7) i(vs8) i(vs9)
print i(vs10) i(vs11) i(vs12) i(vs13) i(vs14) i(vs15) i(vs16) i(vs17) i(vs18) i(vs19)
print i(vs20) i(vs21) i(vs22) i(vs23) i(vs24) i(vs25) i(vs26) i(vs27) i(vs28) i(vs29)
print i(vs30) i(vs31) i(vs32) i(vs33) i(vs34) i(vs35) i(vs36) i(vs37) i(vs38) i(vs39)
print i(vs40) i(vs41) i(vs42) i(vs43) i(vs44) i(vs45) i(vs46) i(vs47) i(vs48)
.endc
.end
