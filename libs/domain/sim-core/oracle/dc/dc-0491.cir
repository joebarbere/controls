controls oracle dc-0491
* Generated (plan F2.7, ADR 0012): do not edit; regenerate with `pnpm sim oracle regen`. dc seed 20261030 index 491 nodes 12 elements 24
.options sparse gmin=1e-12 noopac
RG1 1 0 1000000000000
RG2 2 0 1000000000000
RG3 3 0 1000000000000
RG4 4 0 1000000000000
RG5 5 0 1000000000000
RG6 6 0 1000000000000
RG7 7 0 1000000000000
RG8 8 0 1000000000000
RG9 9 0 1000000000000
RG10 10 0 1000000000000
RG11 11 0 1000000000000
VS0 11 s0 0
R0 s0 2 10e-1
VS1 0 s1 0
V1 e1 s1 DC 47e1
RI1 e1 10 68e-2
VS2 2 s2 0
R2 s2 8 27e0
VS3 4 s3 0
V3 e3 s3 DC 39e1
RI3 e3 0 12e-1
VS4 6 s4 0
R4 s4 9 56e3
VS5 0 s5 0
V5 e5 s5 DC 39e1
RI5 e5 1 18e-3
VS6 0 s6 0
R6 s6 5 56e1
VS7 1 s7 0
V7 e7 s7 DC 33e1
RI7 e7 7 33e-1
VS8 2 s8 0
V8 e8 s8 DC 18e-1
RI8 e8 7 18e-2
VS9 7 s9 0
R9 s9 8 33e-1
VS10 6 s10 0
R10 s10 11 47e0
VS11 6 s11 0
R11 s11 8 15e-2
VS12 0 s12 0
R12 s12 3 15e-1
VS13 5 s13 0
R13 s13 0 68e3
VS14 11 s14 0
V14 e14 s14 DC 18e0
RI14 e14 4 56e-2
VS15 7 s15 0
I15 s15 10 DC 18e-3
VS16 1 s16 0
I16 s16 11 DC 10e-1
VS17 3 s17 0
R17 s17 6 33e0
VS18 5 s18 0
V18 e18 s18 DC 12e0
RI18 e18 1 18e-1
VS19 6 s19 0
I19 s19 4 DC 39e-4
VS20 5 s20 0
V20 e20 s20 DC 12e0
RI20 e20 4 47e-3
VS21 7 s21 0
R21 s21 11 47e-1
VS22 10 s22 0
R22 s22 7 15e3
VS23 9 s23 0
R23 s23 11 33e-1
.control
set numdgt=17
op
print v(1) v(2) v(3) v(4) v(5) v(6) v(7) v(8) v(9) v(10)
print v(11)
print i(vs0) i(vs1) i(vs2) i(vs3) i(vs4) i(vs5) i(vs6) i(vs7) i(vs8) i(vs9)
print i(vs10) i(vs11) i(vs12) i(vs13) i(vs14) i(vs15) i(vs16) i(vs17) i(vs18) i(vs19)
print i(vs20) i(vs21) i(vs22) i(vs23)
.endc
.end
