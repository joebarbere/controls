controls oracle dc-0143
* Generated (plan F2.7, ADR 0012): do not edit; regenerate with `pnpm sim oracle regen`. dc seed 20261030 index 143 nodes 9 elements 15
.options sparse gmin=1e-12 noopac
RG1 1 0 1000000000000
RG2 2 0 1000000000000
RG3 3 0 1000000000000
RG4 4 0 1000000000000
RG5 5 0 1000000000000
RG6 6 0 1000000000000
RG7 7 0 1000000000000
RG8 8 0 1000000000000
VS0 4 s0 0
R0 s0 2 68e2
VS1 0 s1 0
R1 s1 6 12e3
VS2 6 s2 0
R2 s2 2 18e1
VS3 6 s3 0
R3 s3 1 82e-2
VS4 1 s4 0
R4 s4 5 47e-1
VS5 0 s5 0
V5 e5 s5 DC 15e0
RI5 e5 4 68e-3
VS6 3 s6 0
R6 s6 8 18e1
VS7 1 s7 0
R7 s7 6 18e2
VS8 8 s8 0
R8 s8 1 27e-1
VS9 6 s9 0
R9 s9 7 47e0
VS10 2 s10 0
R10 s10 1 56e3
VS11 5 s11 0
V11 e11 s11 DC 39e-1
RI11 e11 7 18e-2
VS12 0 s12 0
R12 s12 7 22e-1
VS13 7 s13 0
R13 s13 3 15e1
VS14 8 s14 0
R14 s14 3 82e0
.control
set numdgt=17
op
print v(1) v(2) v(3) v(4) v(5) v(6) v(7) v(8)
print i(vs0) i(vs1) i(vs2) i(vs3) i(vs4) i(vs5) i(vs6) i(vs7) i(vs8) i(vs9)
print i(vs10) i(vs11) i(vs12) i(vs13) i(vs14)
.endc
.end
