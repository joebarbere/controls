controls oracle dc-0143
* Generated (plan F2.7, ADR 0012): do not edit; regenerate with `pnpm sim oracle regen`. dc seed 20261030 index 143 nodes 9 elements 14
.options sparse gmin=1e-12 noopac
RG1 1 0 1000000000000
RG2 2 0 1000000000000
RG3 3 0 1000000000000
RG4 4 0 1000000000000
RG5 5 0 1000000000000
RG6 6 0 1000000000000
RG7 7 0 1000000000000
RG8 8 0 1000000000000
VS0 5 s0 0
R0 s0 7 47e0
VS1 3 s1 0
R1 s1 8 18e1
VS2 0 s2 0
V2 e2 s2 DC 39e-1
RI2 e2 7 18e-2
VS3 5 s3 0
R3 s3 2 18e1
VS4 4 s4 0
R4 s4 2 68e2
VS5 6 s5 0
R5 s5 7 22e-1
VS6 5 s6 0
R6 s6 1 82e-2
VS7 6 s7 0
V7 e7 s7 DC 15e0
RI7 e7 4 68e-3
VS8 8 s8 0
R8 s8 3 82e0
VS9 2 s9 0
R9 s9 1 56e3
VS10 7 s10 0
R10 s10 3 15e1
VS11 1 s11 0
R11 s11 5 18e2
VS12 6 s12 0
R12 s12 5 12e3
VS13 1 s13 0
R13 s13 0 47e-1
.control
set numdgt=17
op
print v(1) v(2) v(3) v(4) v(5) v(6) v(7) v(8)
print i(vs0) i(vs1) i(vs2) i(vs3) i(vs4) i(vs5) i(vs6) i(vs7) i(vs8) i(vs9)
print i(vs10) i(vs11) i(vs12) i(vs13)
.endc
.end
