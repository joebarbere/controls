controls oracle dc-0397
* Generated (plan F2.7, ADR 0012): do not edit; regenerate with `pnpm sim oracle regen`. dc seed 20261030 index 397 nodes 3 elements 4
.options sparse gmin=1e-12 noopac
RG1 1 0 1000000000000
RG2 2 0 1000000000000
VS0 1 s0 0
R0 s0 0 22e3
VS1 0 s1 0
R1 s1 2 82e1
VS2 2 s2 0
R2 s2 1 27e-1
VS3 2 s3 0
I3 s3 1 DC 12e-4
.control
set numdgt=17
op
print v(1) v(2)
print i(vs0) i(vs1) i(vs2) i(vs3)
.endc
.end
