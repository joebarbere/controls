controls oracle dc-0151
* Generated (plan F2.7, ADR 0012): do not edit; regenerate with `pnpm sim oracle regen`. dc seed 20261030 index 151 nodes 6 elements 8
.options sparse gmin=1e-12 noopac
RG1 1 0 1000000000000
RG2 2 0 1000000000000
RG3 3 0 1000000000000
RG4 4 0 1000000000000
RG5 5 0 1000000000000
VS0 0 s0 0
V0 e0 s0 DC 56e-1
RI0 e0 3 12e-3
VS1 4 s1 0
R1 s1 2 33e1
VS2 1 s2 0
R2 s2 0 10e-2
VS3 3 s3 0
V3 e3 s3 DC 47e0
RI3 e3 5 33e-3
VS4 0 s4 0
R4 s4 5 27e1
VS5 2 s5 0
R5 s5 1 18e-2
VS6 4 s6 0
V6 e6 s6 DC 82e-1
RI6 e6 5 12e-1
VS7 4 s7 0
R7 s7 0 39e-1
.control
set numdgt=17
op
print v(1) v(2) v(3) v(4) v(5)
print i(vs0) i(vs1) i(vs2) i(vs3) i(vs4) i(vs5) i(vs6) i(vs7)
.endc
.end
