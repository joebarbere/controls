controls oracle dc-0151
* Generated (plan F2.7, ADR 0012): do not edit; regenerate with `pnpm sim oracle regen`. dc seed 20261030 index 151 nodes 6 elements 6
.options sparse gmin=1e-12 noopac
RG1 1 0 1000000000000
RG2 2 0 1000000000000
RG3 3 0 1000000000000
RG4 4 0 1000000000000
RG5 5 0 1000000000000
VS0 0 s0 0
V0 e0 s0 DC 82e-1
RI0 e0 5 12e-1
VS1 4 s1 0
R1 s1 1 10e-2
VS2 0 s2 0
R2 s2 1 39e-1
VS3 0 s3 0
R3 s3 2 33e1
VS4 1 s4 0
V4 e4 s4 DC 56e-1
RI4 e4 3 12e-3
VS5 3 s5 0
R5 s5 1 10e-2
.control
set numdgt=17
op
print v(1) v(2) v(3) v(4) v(5)
print i(vs0) i(vs1) i(vs2) i(vs3) i(vs4) i(vs5)
.endc
.end
