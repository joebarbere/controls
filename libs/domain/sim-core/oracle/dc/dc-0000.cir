controls oracle dc-0000
* Generated (plan F2.7, ADR 0012): do not edit; regenerate with `pnpm sim oracle regen`. dc seed 20261030 index 0 nodes 7 elements 9
.options sparse gmin=1e-12 noopac
RG1 1 0 1000000000000
RG2 2 0 1000000000000
RG3 3 0 1000000000000
RG4 4 0 1000000000000
RG5 5 0 1000000000000
RG6 6 0 1000000000000
VS0 0 s0 0
V0 e0 s0 DC 15e1
RI0 e0 2 18e-1
VS1 4 s1 0
R1 s1 6 15e3
VS2 1 s2 0
R2 s2 0 56e-1
VS3 3 s3 0
R3 s3 6 22e2
VS4 2 s4 0
R4 s4 1 33e1
VS5 4 s5 0
R5 s5 3 18e0
VS6 4 s6 0
R6 s6 1 22e-2
VS7 5 s7 0
V7 e7 s7 DC 39e0
RI7 e7 6 47e-2
VS8 0 s8 0
R8 s8 5 82e1
.control
set numdgt=17
op
print v(1) v(2) v(3) v(4) v(5) v(6)
print i(vs0) i(vs1) i(vs2) i(vs3) i(vs4) i(vs5) i(vs6) i(vs7) i(vs8)
.endc
.end
