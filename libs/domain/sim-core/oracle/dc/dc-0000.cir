controls oracle dc-0000
* Generated (plan F2.7, ADR 0012): do not edit; regenerate with `pnpm sim oracle regen`. dc seed 20261030 index 0 nodes 7 elements 7
.options sparse gmin=1e-12 noopac
RG1 1 0 1000000000000
RG2 2 0 1000000000000
RG3 3 0 1000000000000
RG4 4 0 1000000000000
RG5 5 0 1000000000000
RG6 6 0 1000000000000
VS0 4 s0 0
R0 s0 6 15e3
VS1 0 s1 0
V1 e1 s1 DC 15e1
RI1 e1 2 18e-1
VS2 5 s2 0
V2 e2 s2 DC 39e0
RI2 e2 6 47e-2
VS3 0 s3 0
R3 s3 5 82e1
VS4 2 s4 0
R4 s4 1 33e1
VS5 3 s5 0
R5 s5 6 22e2
VS6 5 s6 0
R6 s6 6 39e-1
.control
set numdgt=17
op
print v(1) v(2) v(3) v(4) v(5) v(6)
print i(vs0) i(vs1) i(vs2) i(vs3) i(vs4) i(vs5) i(vs6)
.endc
.end
