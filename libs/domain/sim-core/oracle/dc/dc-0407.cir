controls oracle dc-0407
* Generated (plan F2.7, ADR 0012): do not edit; regenerate with `pnpm sim oracle regen`. dc seed 20261030 index 407 nodes 30 elements 54
.options sparse gmin=1e-12 noopac
RG1 1 0 1000000000000
RG2 2 0 1000000000000
RG3 3 0 1000000000000
RG4 4 0 1000000000000
RG5 5 0 1000000000000
RG6 6 0 1000000000000
RG7 7 0 1000000000000
RG8 8 0 1000000000000
RG9 9 0 1000000000000
RG10 10 0 1000000000000
RG11 11 0 1000000000000
RG12 12 0 1000000000000
RG13 13 0 1000000000000
RG14 14 0 1000000000000
RG15 15 0 1000000000000
RG16 16 0 1000000000000
RG17 17 0 1000000000000
RG18 18 0 1000000000000
RG19 19 0 1000000000000
RG20 20 0 1000000000000
RG21 21 0 1000000000000
RG22 22 0 1000000000000
RG23 23 0 1000000000000
RG24 24 0 1000000000000
RG25 25 0 1000000000000
RG26 26 0 1000000000000
RG27 27 0 1000000000000
RG28 28 0 1000000000000
RG29 29 0 1000000000000
VS0 0 s0 0
V0 e0 s0 DC 82e0
RI0 e0 21 18e-2
VS1 25 s1 0
I1 s1 20 DC 56e-4
VS2 20 s2 0
R2 s2 22 22e-1
VS3 18 s3 0
R3 s3 16 39e-1
VS4 29 s4 0
I4 s4 17 DC 39e-2
VS5 22 s5 0
R5 s5 1 10e-2
VS6 0 s6 0
R6 s6 1 12e3
VS7 29 s7 0
R7 s7 20 56e-1
VS8 14 s8 0
V8 e8 s8 DC 47e-1
RI8 e8 3 82e-3
VS9 24 s9 0
V9 e9 s9 DC 47e-1
RI9 e9 10 33e-3
VS10 12 s10 0
R10 s10 11 56e-2
VS11 11 s11 0
R11 s11 16 15e0
VS12 5 s12 0
R12 s12 19 47e-1
VS13 15 s13 0
R13 s13 27 12e-2
VS14 6 s14 0
R14 s14 8 56e2
VS15 2 s15 0
V15 e15 s15 DC 33e0
RI15 e15 14 33e-2
VS16 4 s16 0
R16 s16 9 10e-1
VS17 2 s17 0
I17 s17 1 DC 15e-4
VS18 29 s18 0
R18 s18 17 15e3
VS19 18 s19 0
R19 s19 0 39e1
VS20 3 s20 0
R20 s20 24 47e-2
VS21 19 s21 0
R21 s21 5 33e-2
VS22 26 s22 0
R22 s22 0 33e-2
VS23 4 s23 0
R23 s23 20 15e-2
VS24 4 s24 0
R24 s24 23 82e2
VS25 2 s25 0
V25 e25 s25 DC 68e1
RI25 e25 19 47e-2
VS26 18 s26 0
R26 s26 24 39e2
VS27 25 s27 0
R27 s27 16 33e-2
VS28 20 s28 0
R28 s28 17 56e1
VS29 6 s29 0
V29 e29 s29 DC 22e1
RI29 e29 27 12e-2
VS30 22 s30 0
R30 s30 21 18e-2
VS31 25 s31 0
R31 s31 28 56e2
VS32 29 s32 0
R32 s32 21 22e0
VS33 23 s33 0
R33 s33 7 56e-2
VS34 23 s34 0
R34 s34 21 56e3
VS35 13 s35 0
R35 s35 29 12e-1
VS36 8 s36 0
I36 s36 1 DC 27e-4
VS37 16 s37 0
R37 s37 4 15e3
VS38 10 s38 0
R38 s38 25 12e-2
VS39 18 s39 0
R39 s39 13 27e2
VS40 9 s40 0
V40 e40 s40 DC 22e1
RI40 e40 6 56e-3
VS41 6 s41 0
R41 s41 7 47e1
VS42 12 s42 0
R42 s42 13 33e-2
VS43 23 s43 0
R43 s43 18 33e3
VS44 23 s44 0
R44 s44 8 56e0
VS45 20 s45 0
R45 s45 5 68e0
VS46 29 s46 0
I46 s46 4 DC 68e-3
VS47 20 s47 0
R47 s47 12 27e2
VS48 26 s48 0
V48 e48 s48 DC 27e-1
RI48 e48 29 27e-2
VS49 25 s49 0
V49 e49 s49 DC 39e-1
RI49 e49 27 82e-3
VS50 15 s50 0
R50 s50 26 68e2
VS51 22 s51 0
I51 s51 8 DC 68e-2
VS52 15 s52 0
R52 s52 3 47e2
VS53 3 s53 0
R53 s53 28 39e3
.control
set numdgt=17
op
print v(1) v(2) v(3) v(4) v(5) v(6) v(7) v(8) v(9) v(10)
print v(11) v(12) v(13) v(14) v(15) v(16) v(17) v(18) v(19) v(20)
print v(21) v(22) v(23) v(24) v(25) v(26) v(27) v(28) v(29)
print i(vs0) i(vs1) i(vs2) i(vs3) i(vs4) i(vs5) i(vs6) i(vs7) i(vs8) i(vs9)
print i(vs10) i(vs11) i(vs12) i(vs13) i(vs14) i(vs15) i(vs16) i(vs17) i(vs18) i(vs19)
print i(vs20) i(vs21) i(vs22) i(vs23) i(vs24) i(vs25) i(vs26) i(vs27) i(vs28) i(vs29)
print i(vs30) i(vs31) i(vs32) i(vs33) i(vs34) i(vs35) i(vs36) i(vs37) i(vs38) i(vs39)
print i(vs40) i(vs41) i(vs42) i(vs43) i(vs44) i(vs45) i(vs46) i(vs47) i(vs48) i(vs49)
print i(vs50) i(vs51) i(vs52) i(vs53)
.endc
.end
