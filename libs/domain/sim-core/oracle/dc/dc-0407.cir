controls oracle dc-0407
* Generated (plan F2.7, ADR 0012): do not edit; regenerate with `pnpm sim oracle regen`. dc seed 20261030 index 407 nodes 30 elements 48
.options sparse gmin=1e-12 noopac
RG1 1 0 1000000000000
RG2 2 0 1000000000000
RG3 3 0 1000000000000
RG4 4 0 1000000000000
RG5 5 0 1000000000000
RG6 6 0 1000000000000
RG7 7 0 1000000000000
RG8 8 0 1000000000000
RG9 9 0 1000000000000
RG10 10 0 1000000000000
RG11 11 0 1000000000000
RG12 12 0 1000000000000
RG13 13 0 1000000000000
RG14 14 0 1000000000000
RG15 15 0 1000000000000
RG16 16 0 1000000000000
RG17 17 0 1000000000000
RG18 18 0 1000000000000
RG19 19 0 1000000000000
RG20 20 0 1000000000000
RG21 21 0 1000000000000
RG22 22 0 1000000000000
RG23 23 0 1000000000000
RG24 24 0 1000000000000
RG25 25 0 1000000000000
RG26 26 0 1000000000000
RG27 27 0 1000000000000
RG28 28 0 1000000000000
RG29 29 0 1000000000000
VS0 25 s0 0
R0 s0 4 15e3
VS1 18 s1 0
R1 s1 24 39e2
VS2 0 s2 0
V2 e2 s2 DC 39e-1
RI2 e2 27 82e-3
VS3 22 s3 0
I3 s3 8 DC 68e-2
VS4 23 s4 0
R4 s4 21 56e3
VS5 0 s5 0
R5 s5 28 56e2
VS6 13 s6 0
R6 s6 29 12e-1
VS7 15 s7 0
R7 s7 27 12e-2
VS8 18 s8 0
R8 s8 13 27e2
VS9 19 s9 0
R9 s9 5 33e-2
VS10 6 s10 0
V10 e10 s10 DC 22e1
RI10 e10 27 12e-2
VS11 3 s11 0
R11 s11 24 47e-2
VS12 26 s12 0
V12 e12 s12 DC 27e-1
RI12 e12 29 27e-2
VS13 18 s13 0
R13 s13 16 39e1
VS14 4 s14 0
R14 s14 20 15e-2
VS15 18 s15 0
R15 s15 25 39e-1
VS16 4 s16 0
R16 s16 9 10e-1
VS17 23 s17 0
R17 s17 18 33e3
VS18 15 s18 0
R18 s18 3 47e2
VS19 22 s19 0
R19 s19 21 18e-2
VS20 0 s20 0
I20 s20 20 DC 56e-4
VS21 16 s21 0
V21 e21 s21 DC 82e0
RI21 e21 21 18e-2
VS22 8 s22 0
I22 s22 1 DC 27e-4
VS23 20 s23 0
R23 s23 5 68e0
VS24 4 s24 0
R24 s24 23 82e2
VS25 6 s25 0
R25 s25 7 47e1
VS26 23 s26 0
R26 s26 8 56e0
VS27 2 s27 0
I27 s27 1 DC 15e-4
VS28 0 s28 0
R28 s28 25 33e-2
VS29 24 s29 0
V29 e29 s29 DC 47e-1
RI29 e29 10 33e-3
VS30 5 s30 0
R30 s30 19 47e-1
VS31 29 s31 0
R31 s31 21 22e0
VS32 14 s32 0
V32 e32 s32 DC 47e-1
RI32 e32 3 82e-3
VS33 26 s33 0
R33 s33 16 33e-2
VS34 11 s34 0
R34 s34 25 15e0
VS35 16 s35 0
R35 s35 1 12e3
VS36 22 s36 0
R36 s36 1 10e-2
VS37 20 s37 0
R37 s37 22 22e-1
VS38 23 s38 0
R38 s38 7 56e-2
VS39 15 s39 0
R39 s39 26 68e2
VS40 29 s40 0
I40 s40 4 DC 68e-3
VS41 2 s41 0
V41 e41 s41 DC 68e1
RI41 e41 19 47e-2
VS42 29 s42 0
R42 s42 20 56e-1
VS43 12 s43 0
R43 s43 13 33e-2
VS44 20 s44 0
R44 s44 17 56e1
VS45 12 s45 0
R45 s45 11 56e-2
VS46 20 s46 0
R46 s46 12 27e2
VS47 29 s47 0
I47 s47 17 DC 39e-2
.control
set numdgt=17
op
print v(1) v(2) v(3) v(4) v(5) v(6) v(7) v(8) v(9) v(10)
print v(11) v(12) v(13) v(14) v(15) v(16) v(17) v(18) v(19) v(20)
print v(21) v(22) v(23) v(24) v(25) v(26) v(27) v(28) v(29)
print i(vs0) i(vs1) i(vs2) i(vs3) i(vs4) i(vs5) i(vs6) i(vs7) i(vs8) i(vs9)
print i(vs10) i(vs11) i(vs12) i(vs13) i(vs14) i(vs15) i(vs16) i(vs17) i(vs18) i(vs19)
print i(vs20) i(vs21) i(vs22) i(vs23) i(vs24) i(vs25) i(vs26) i(vs27) i(vs28) i(vs29)
print i(vs30) i(vs31) i(vs32) i(vs33) i(vs34) i(vs35) i(vs36) i(vs37) i(vs38) i(vs39)
print i(vs40) i(vs41) i(vs42) i(vs43) i(vs44) i(vs45) i(vs46) i(vs47)
.endc
.end
