controls oracle dc-0451
* Generated (plan F2.7, ADR 0012): do not edit; regenerate with `pnpm sim oracle regen`. dc seed 20261030 index 451 nodes 23 elements 42
.options sparse gmin=1e-12 noopac
RG1 1 0 1000000000000
RG2 2 0 1000000000000
RG3 3 0 1000000000000
RG4 4 0 1000000000000
RG5 5 0 1000000000000
RG6 6 0 1000000000000
RG7 7 0 1000000000000
RG8 8 0 1000000000000
RG9 9 0 1000000000000
RG10 10 0 1000000000000
RG11 11 0 1000000000000
RG12 12 0 1000000000000
RG13 13 0 1000000000000
RG14 14 0 1000000000000
RG15 15 0 1000000000000
RG16 16 0 1000000000000
RG17 17 0 1000000000000
RG18 18 0 1000000000000
RG19 19 0 1000000000000
RG20 20 0 1000000000000
RG21 21 0 1000000000000
RG22 22 0 1000000000000
VS0 2 s0 0
R0 s0 22 47e-1
VS1 0 s1 0
R1 s1 7 27e0
VS2 18 s2 0
R2 s2 5 12e1
VS3 16 s3 0
R3 s3 2 22e0
VS4 0 s4 0
R4 s4 14 18e2
VS5 0 s5 0
R5 s5 9 10e-2
VS6 22 s6 0
R6 s6 1 27e2
VS7 20 s7 0
R7 s7 11 12e2
VS8 0 s8 0
V8 e8 s8 DC 27e0
RI8 e8 4 39e-2
VS9 1 s9 0
R9 s9 13 68e2
VS10 16 s10 0
R10 s10 3 47e2
VS11 13 s11 0
R11 s11 6 68e3
VS12 5 s12 0
R12 s12 21 33e3
VS13 5 s13 0
R13 s13 13 56e3
VS14 15 s14 0
R14 s14 4 18e-2
VS15 22 s15 0
R15 s15 21 15e3
VS16 9 s16 0
R16 s16 5 27e3
VS17 11 s17 0
V17 e17 s17 DC 33e0
RI17 e17 2 68e-3
VS18 2 s18 0
R18 s18 17 68e3
VS19 8 s19 0
R19 s19 9 56e2
VS20 8 s20 0
R20 s20 5 12e3
VS21 16 s21 0
R21 s21 17 33e0
VS22 17 s22 0
V22 e22 s22 DC 27e1
RI22 e22 13 33e-2
VS23 19 s23 0
R23 s23 10 10e-2
VS24 12 s24 0
I24 s24 18 DC 56e-3
VS25 17 s25 0
R25 s25 19 39e2
VS26 21 s26 0
R26 s26 12 18e2
VS27 20 s27 0
V27 e27 s27 DC 22e-1
RI27 e27 10 15e-1
VS28 14 s28 0
R28 s28 16 39e-1
VS29 4 s29 0
I29 s29 7 DC 68e-1
VS30 21 s30 0
R30 s30 3 10e3
VS31 12 s31 0
R31 s31 15 15e-1
VS32 5 s32 0
R32 s32 4 47e3
VS33 0 s33 0
R33 s33 22 56e-2
VS34 20 s34 0
R34 s34 21 82e2
VS35 18 s35 0
V35 e35 s35 DC 18e-1
RI35 e35 7 56e-2
VS36 14 s36 0
I36 s36 5 DC 15e-3
VS37 4 s37 0
R37 s37 18 18e-2
VS38 22 s38 0
V38 e38 s38 DC 33e1
RI38 e38 18 33e-3
VS39 5 s39 0
V39 e39 s39 DC 56e0
RI39 e39 4 10e-3
VS40 6 s40 0
V40 e40 s40 DC 33e-1
RI40 e40 14 39e-1
VS41 10 s41 0
V41 e41 s41 DC 47e0
RI41 e41 17 18e-3
.control
set numdgt=17
op
print v(1) v(2) v(3) v(4) v(5) v(6) v(7) v(8) v(9) v(10)
print v(11) v(12) v(13) v(14) v(15) v(16) v(17) v(18) v(19) v(20)
print v(21) v(22)
print i(vs0) i(vs1) i(vs2) i(vs3) i(vs4) i(vs5) i(vs6) i(vs7) i(vs8) i(vs9)
print i(vs10) i(vs11) i(vs12) i(vs13) i(vs14) i(vs15) i(vs16) i(vs17) i(vs18) i(vs19)
print i(vs20) i(vs21) i(vs22) i(vs23) i(vs24) i(vs25) i(vs26) i(vs27) i(vs28) i(vs29)
print i(vs30) i(vs31) i(vs32) i(vs33) i(vs34) i(vs35) i(vs36) i(vs37) i(vs38) i(vs39)
print i(vs40) i(vs41)
.endc
.end
