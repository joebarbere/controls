controls oracle dc-0153
* Generated (plan F2.7, ADR 0012): do not edit; regenerate with `pnpm sim oracle regen`. dc seed 20261030 index 153 nodes 3 elements 5
.options sparse gmin=1e-12 noopac
RG1 1 0 1000000000000
RG2 2 0 1000000000000
VS0 0 s0 0
V0 e0 s0 DC 82e-1
RI0 e0 1 15e-1
VS1 2 s1 0
V1 e1 s1 DC 68e1
RI1 e1 1 12e-1
VS2 0 s2 0
R2 s2 1 68e-2
VS3 0 s3 0
R3 s3 2 33e3
VS4 2 s4 0
R4 s4 0 82e-1
.control
set numdgt=17
op
print v(1) v(2)
print i(vs0) i(vs1) i(vs2) i(vs3) i(vs4)
.endc
.end
