controls oracle dc-0159
* Generated (plan F2.7, ADR 0012): do not edit; regenerate with `pnpm sim oracle regen`. dc seed 20261030 index 159 nodes 3 elements 3
.options sparse gmin=1e-12 noopac
RG1 1 0 1000000000000
RG2 2 0 1000000000000
VS0 0 s0 0
R0 s0 1 10e3
VS1 0 s1 0
V1 e1 s1 DC 27e1
RI1 e1 2 39e-1
VS2 2 s2 0
R2 s2 0 82e3
.control
set numdgt=17
op
print v(1) v(2)
print i(vs0) i(vs1) i(vs2)
.endc
.end
