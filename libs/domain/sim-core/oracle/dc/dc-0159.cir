controls oracle dc-0159
* Generated (plan F2.7, ADR 0012): do not edit; regenerate with `pnpm sim oracle regen`. dc seed 20261030 index 159 nodes 3 elements 3
.options sparse gmin=1e-12 noopac
RG1 1 0 1000000000000
RG2 2 0 1000000000000
VS0 0 s0 0
V0 e0 s0 DC 27e1
RI0 e0 2 39e-1
VS1 0 s1 0
R1 s1 1 10e3
VS2 1 s2 0
R2 s2 2 82e2
.control
set numdgt=17
op
print v(1) v(2)
print i(vs0) i(vs1) i(vs2)
.endc
.end
