controls oracle dc-0376
* Generated (plan F2.7, ADR 0012): do not edit; regenerate with `pnpm sim oracle regen`. dc seed 20261030 index 376 nodes 20 elements 35
.options sparse gmin=1e-12 noopac
RG1 1 0 1000000000000
RG2 2 0 1000000000000
RG3 3 0 1000000000000
RG4 4 0 1000000000000
RG5 5 0 1000000000000
RG6 6 0 1000000000000
RG7 7 0 1000000000000
RG8 8 0 1000000000000
RG9 9 0 1000000000000
RG10 10 0 1000000000000
RG11 11 0 1000000000000
RG12 12 0 1000000000000
RG13 13 0 1000000000000
RG14 14 0 1000000000000
RG15 15 0 1000000000000
RG16 16 0 1000000000000
RG17 17 0 1000000000000
RG18 18 0 1000000000000
RG19 19 0 1000000000000
VS0 4 s0 0
R0 s0 8 27e2
VS1 8 s1 0
R1 s1 7 22e-1
VS2 7 s2 0
R2 s2 8 56e3
VS3 0 s3 0
R3 s3 5 12e-1
VS4 15 s4 0
R4 s4 1 22e3
VS5 2 s5 0
R5 s5 14 10e-1
VS6 9 s6 0
R6 s6 15 68e1
VS7 4 s7 0
R7 s7 18 18e0
VS8 13 s8 0
R8 s8 2 56e-1
VS9 3 s9 0
R9 s9 6 82e2
VS10 12 s10 0
R10 s10 3 12e2
VS11 0 s11 0
V11 e11 s11 DC 33e1
RI11 e11 2 56e-1
VS12 11 s12 0
R12 s12 3 82e-2
VS13 3 s13 0
R13 s13 16 10e0
VS14 17 s14 0
R14 s14 1 39e-1
VS15 5 s15 0
R15 s15 12 68e3
VS16 4 s16 0
R16 s16 0 12e0
VS17 0 s17 0
R17 s17 18 18e-2
VS18 3 s18 0
R18 s18 7 82e-2
VS19 4 s19 0
R19 s19 6 39e-1
VS20 3 s20 0
R20 s20 14 18e3
VS21 5 s21 0
I21 s21 13 DC 15e-1
VS22 11 s22 0
R22 s22 0 10e-2
VS23 19 s23 0
R23 s23 18 82e-1
VS24 14 s24 0
R24 s24 2 10e-2
VS25 5 s25 0
R25 s25 12 47e0
VS26 15 s26 0
R26 s26 9 39e0
VS27 10 s27 0
R27 s27 4 12e2
VS28 7 s28 0
R28 s28 13 15e3
VS29 12 s29 0
R29 s29 4 68e2
VS30 15 s30 0
V30 e30 s30 DC 47e1
RI30 e30 10 47e-2
VS31 7 s31 0
R31 s31 19 47e-2
VS32 12 s32 0
R32 s32 17 15e2
VS33 9 s33 0
R33 s33 17 22e-2
VS34 18 s34 0
R34 s34 16 12e3
.control
set numdgt=17
op
print v(1) v(2) v(3) v(4) v(5) v(6) v(7) v(8) v(9) v(10)
print v(11) v(12) v(13) v(14) v(15) v(16) v(17) v(18) v(19)
print i(vs0) i(vs1) i(vs2) i(vs3) i(vs4) i(vs5) i(vs6) i(vs7) i(vs8) i(vs9)
print i(vs10) i(vs11) i(vs12) i(vs13) i(vs14) i(vs15) i(vs16) i(vs17) i(vs18) i(vs19)
print i(vs20) i(vs21) i(vs22) i(vs23) i(vs24) i(vs25) i(vs26) i(vs27) i(vs28) i(vs29)
print i(vs30) i(vs31) i(vs32) i(vs33) i(vs34)
.endc
.end
