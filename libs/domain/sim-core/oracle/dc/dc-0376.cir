controls oracle dc-0376
* Generated (plan F2.7, ADR 0012): do not edit; regenerate with `pnpm sim oracle regen`. dc seed 20261030 index 376 nodes 20 elements 29
.options sparse gmin=1e-12 noopac
RG1 1 0 1000000000000
RG2 2 0 1000000000000
RG3 3 0 1000000000000
RG4 4 0 1000000000000
RG5 5 0 1000000000000
RG6 6 0 1000000000000
RG7 7 0 1000000000000
RG8 8 0 1000000000000
RG9 9 0 1000000000000
RG10 10 0 1000000000000
RG11 11 0 1000000000000
RG12 12 0 1000000000000
RG13 13 0 1000000000000
RG14 14 0 1000000000000
RG15 15 0 1000000000000
RG16 16 0 1000000000000
RG17 17 0 1000000000000
RG18 18 0 1000000000000
RG19 19 0 1000000000000
VS0 18 s0 0
R0 s0 16 12e3
VS1 4 s1 0
R1 s1 0 12e0
VS2 2 s2 0
R2 s2 14 10e-1
VS3 0 s3 0
V3 e3 s3 DC 33e1
RI3 e3 2 56e-1
VS4 13 s4 0
R4 s4 2 56e-1
VS5 5 s5 0
R5 s5 12 68e3
VS6 3 s6 0
R6 s6 14 18e3
VS7 15 s7 0
R7 s7 9 39e0
VS8 3 s8 0
R8 s8 7 82e-2
VS9 0 s9 0
R9 s9 18 18e-2
VS10 4 s10 0
R10 s10 18 18e0
VS11 10 s11 0
R11 s11 4 12e2
VS12 14 s12 0
R12 s12 2 10e-2
VS13 12 s13 0
R13 s13 17 15e2
VS14 11 s14 0
R14 s14 0 10e-2
VS15 8 s15 0
R15 s15 7 22e-1
VS16 7 s16 0
R16 s16 8 56e3
VS17 7 s17 0
R17 s17 19 47e-2
VS18 11 s18 0
R18 s18 3 82e-2
VS19 4 s19 0
R19 s19 8 27e2
VS20 9 s20 0
R20 s20 17 22e-2
VS21 12 s21 0
R21 s21 3 12e2
VS22 3 s22 0
R22 s22 16 10e0
VS23 5 s23 0
I23 s23 13 DC 15e-1
VS24 4 s24 0
R24 s24 6 39e-1
VS25 5 s25 0
R25 s25 12 47e0
VS26 9 s26 0
R26 s26 15 68e1
VS27 17 s27 0
R27 s27 1 39e-1
VS28 12 s28 0
R28 s28 4 68e2
.control
set numdgt=17
op
print v(1) v(2) v(3) v(4) v(5) v(6) v(7) v(8) v(9) v(10)
print v(11) v(12) v(13) v(14) v(15) v(16) v(17) v(18) v(19)
print i(vs0) i(vs1) i(vs2) i(vs3) i(vs4) i(vs5) i(vs6) i(vs7) i(vs8) i(vs9)
print i(vs10) i(vs11) i(vs12) i(vs13) i(vs14) i(vs15) i(vs16) i(vs17) i(vs18) i(vs19)
print i(vs20) i(vs21) i(vs22) i(vs23) i(vs24) i(vs25) i(vs26) i(vs27) i(vs28)
.endc
.end
