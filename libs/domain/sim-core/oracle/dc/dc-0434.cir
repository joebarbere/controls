controls oracle dc-0434
* Generated (plan F2.7, ADR 0012): do not edit; regenerate with `pnpm sim oracle regen`. dc seed 20261030 index 434 nodes 2 elements 3
.options sparse gmin=1e-12 noopac
RG1 1 0 1000000000000
VS0 1 s0 0
R0 s0 0 27e-2
VS1 0 s1 0
R1 s1 1 33e3
VS2 0 s2 0
V2 e2 s2 DC 22e-1
RI2 e2 1 39e-1
.control
set numdgt=17
op
print v(1)
print i(vs0) i(vs1) i(vs2)
.endc
.end
