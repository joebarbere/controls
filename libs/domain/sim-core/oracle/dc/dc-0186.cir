controls oracle dc-0186
* Generated (plan F2.7, ADR 0012): do not edit; regenerate with `pnpm sim oracle regen`. dc seed 20261030 index 186 nodes 14 elements 23
.options sparse gmin=1e-12 noopac
RG1 1 0 1000000000000
RG2 2 0 1000000000000
RG3 3 0 1000000000000
RG4 4 0 1000000000000
RG5 5 0 1000000000000
RG6 6 0 1000000000000
RG7 7 0 1000000000000
RG8 8 0 1000000000000
RG9 9 0 1000000000000
RG10 10 0 1000000000000
RG11 11 0 1000000000000
RG12 12 0 1000000000000
RG13 13 0 1000000000000
VS0 12 s0 0
R0 s0 11 68e1
VS1 1 s1 0
R1 s1 10 68e2
VS2 13 s2 0
R2 s2 4 12e-1
VS3 12 s3 0
I3 s3 4 DC 15e-3
VS4 12 s4 0
R4 s4 2 33e2
VS5 12 s5 0
R5 s5 13 15e-1
VS6 5 s6 0
R6 s6 3 12e3
VS7 5 s7 0
R7 s7 3 39e3
VS8 5 s8 0
R8 s8 1 12e2
VS9 7 s9 0
R9 s9 5 22e0
VS10 8 s10 0
I10 s10 4 DC 22e-1
VS11 10 s11 0
R11 s11 9 22e1
VS12 6 s12 0
R12 s12 8 39e1
VS13 0 s13 0
V13 e13 s13 DC 82e1
RI13 e13 5 18e-3
VS14 6 s14 0
R14 s14 4 68e3
VS15 2 s15 0
V15 e15 s15 DC 12e0
RI15 e15 7 18e-1
VS16 7 s16 0
I16 s16 13 DC 47e-3
VS17 10 s17 0
V17 e17 s17 DC 33e-1
RI17 e17 8 82e-1
VS18 11 s18 0
R18 s18 5 15e-2
VS19 12 s19 0
R19 s19 4 22e-1
VS20 6 s20 0
R20 s20 10 82e-2
VS21 2 s21 0
I21 s21 0 DC 68e-4
VS22 2 s22 0
R22 s22 4 15e0
.control
set numdgt=17
op
print v(1) v(2) v(3) v(4) v(5) v(6) v(7) v(8) v(9) v(10)
print v(11) v(12) v(13)
print i(vs0) i(vs1) i(vs2) i(vs3) i(vs4) i(vs5) i(vs6) i(vs7) i(vs8) i(vs9)
print i(vs10) i(vs11) i(vs12) i(vs13) i(vs14) i(vs15) i(vs16) i(vs17) i(vs18) i(vs19)
print i(vs20) i(vs21) i(vs22)
.endc
.end
