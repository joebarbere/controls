controls oracle dc-0091
* Generated (plan F2.7, ADR 0012): do not edit; regenerate with `pnpm sim oracle regen`. dc seed 20261030 index 91 nodes 4 elements 4
.options sparse gmin=1e-12 noopac
RG1 1 0 1000000000000
RG2 2 0 1000000000000
RG3 3 0 1000000000000
VS0 0 s0 0
R0 s0 3 27e2
VS1 0 s1 0
V1 e1 s1 DC 82e1
RI1 e1 1 56e-3
VS2 3 s2 0
R2 s2 2 27e0
VS3 0 s3 0
R3 s3 1 82e-1
.control
set numdgt=17
op
print v(1) v(2) v(3)
print i(vs0) i(vs1) i(vs2) i(vs3)
.endc
.end
