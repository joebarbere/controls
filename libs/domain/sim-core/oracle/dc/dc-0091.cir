controls oracle dc-0091
* Generated (plan F2.7, ADR 0012): do not edit; regenerate with `pnpm sim oracle regen`. dc seed 20261030 index 91 nodes 4 elements 6
.options sparse gmin=1e-12 noopac
RG1 1 0 1000000000000
RG2 2 0 1000000000000
RG3 3 0 1000000000000
VS0 0 s0 0
V0 e0 s0 DC 15e0
RI0 e0 1 82e-2
VS1 3 s1 0
R1 s1 0 27e2
VS2 0 s2 0
R2 s2 2 27e0
VS3 3 s3 0
V3 e3 s3 DC 82e1
RI3 e3 1 56e-3
VS4 3 s4 0
R4 s4 1 82e-1
VS5 3 s5 0
R5 s5 2 15e0
.control
set numdgt=17
op
print v(1) v(2) v(3)
print i(vs0) i(vs1) i(vs2) i(vs3) i(vs4) i(vs5)
.endc
.end
