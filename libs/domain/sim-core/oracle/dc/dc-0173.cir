controls oracle dc-0173
* Generated (plan F2.7, ADR 0012): do not edit; regenerate with `pnpm sim oracle regen`. dc seed 20261030 index 173 nodes 29 elements 42
.options sparse gmin=1e-12 noopac
RG1 1 0 1000000000000
RG2 2 0 1000000000000
RG3 3 0 1000000000000
RG4 4 0 1000000000000
RG5 5 0 1000000000000
RG6 6 0 1000000000000
RG7 7 0 1000000000000
RG8 8 0 1000000000000
RG9 9 0 1000000000000
RG10 10 0 1000000000000
RG11 11 0 1000000000000
RG12 12 0 1000000000000
RG13 13 0 1000000000000
RG14 14 0 1000000000000
RG15 15 0 1000000000000
RG16 16 0 1000000000000
RG17 17 0 1000000000000
RG18 18 0 1000000000000
RG19 19 0 1000000000000
RG20 20 0 1000000000000
RG21 21 0 1000000000000
RG22 22 0 1000000000000
RG23 23 0 1000000000000
RG24 24 0 1000000000000
RG25 25 0 1000000000000
RG26 26 0 1000000000000
RG27 27 0 1000000000000
RG28 28 0 1000000000000
VS0 0 s0 0
V0 e0 s0 DC 56e-1
RI0 e0 21 68e-3
VS1 17 s1 0
V1 e1 s1 DC 82e-1
RI1 e1 24 10e-1
VS2 13 s2 0
R2 s2 28 22e-2
VS3 4 s3 0
V3 e3 s3 DC 27e1
RI3 e3 8 47e-2
VS4 0 s4 0
R4 s4 8 12e2
VS5 23 s5 0
R5 s5 8 10e0
VS6 24 s6 0
R6 s6 5 33e0
VS7 12 s7 0
R7 s7 1 15e1
VS8 4 s8 0
R8 s8 16 10e2
VS9 17 s9 0
V9 e9 s9 DC 68e0
RI9 e9 11 33e-2
VS10 25 s10 0
R10 s10 17 22e1
VS11 12 s11 0
R11 s11 8 82e0
VS12 4 s12 0
R12 s12 8 15e3
VS13 6 s13 0
R13 s13 23 10e-2
VS14 8 s14 0
I14 s14 19 DC 39e-3
VS15 4 s15 0
R15 s15 14 39e1
VS16 14 s16 0
R16 s16 10 22e-2
VS17 4 s17 0
R17 s17 11 82e2
VS18 22 s18 0
R18 s18 17 15e-2
VS19 4 s19 0
R19 s19 25 39e0
VS20 28 s20 0
V20 e20 s20 DC 18e1
RI20 e20 26 18e-1
VS21 4 s21 0
V21 e21 s21 DC 12e1
RI21 e21 24 39e-2
VS22 13 s22 0
R22 s22 22 82e-2
VS23 15 s23 0
I23 s23 6 DC 12e-1
VS24 2 s24 0
I24 s24 17 DC 18e-2
VS25 8 s25 0
R25 s25 20 39e-1
VS26 0 s26 0
R26 s26 27 33e-2
VS27 5 s27 0
R27 s27 11 47e3
VS28 14 s28 0
R28 s28 15 22e1
VS29 15 s29 0
R29 s29 2 15e3
VS30 21 s30 0
V30 e30 s30 DC 27e1
RI30 e30 1 12e-1
VS31 13 s31 0
R31 s31 8 18e2
VS32 21 s32 0
R32 s32 3 39e3
VS33 22 s33 0
I33 s33 27 DC 68e-2
VS34 4 s34 0
R34 s34 2 10e2
VS35 9 s35 0
V35 e35 s35 DC 22e-1
RI35 e35 8 47e-3
VS36 20 s36 0
I36 s36 1 DC 22e-2
VS37 12 s37 0
R37 s37 7 33e-2
VS38 24 s38 0
R38 s38 18 56e0
VS39 3 s39 0
R39 s39 17 18e0
VS40 1 s40 0
R40 s40 17 22e1
VS41 19 s41 0
R41 s41 18 39e-2
.control
set numdgt=17
op
print v(1) v(2) v(3) v(4) v(5) v(6) v(7) v(8) v(9) v(10)
print v(11) v(12) v(13) v(14) v(15) v(16) v(17) v(18) v(19) v(20)
print v(21) v(22) v(23) v(24) v(25) v(26) v(27) v(28)
print i(vs0) i(vs1) i(vs2) i(vs3) i(vs4) i(vs5) i(vs6) i(vs7) i(vs8) i(vs9)
print i(vs10) i(vs11) i(vs12) i(vs13) i(vs14) i(vs15) i(vs16) i(vs17) i(vs18) i(vs19)
print i(vs20) i(vs21) i(vs22) i(vs23) i(vs24) i(vs25) i(vs26) i(vs27) i(vs28) i(vs29)
print i(vs30) i(vs31) i(vs32) i(vs33) i(vs34) i(vs35) i(vs36) i(vs37) i(vs38) i(vs39)
print i(vs40) i(vs41)
.endc
.end
