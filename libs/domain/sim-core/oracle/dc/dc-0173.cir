controls oracle dc-0173
* Generated (plan F2.7, ADR 0012): do not edit; regenerate with `pnpm sim oracle regen`. dc seed 20261030 index 173 nodes 29 elements 50
.options sparse gmin=1e-12 noopac
RG1 1 0 1000000000000
RG2 2 0 1000000000000
RG3 3 0 1000000000000
RG4 4 0 1000000000000
RG5 5 0 1000000000000
RG6 6 0 1000000000000
RG7 7 0 1000000000000
RG8 8 0 1000000000000
RG9 9 0 1000000000000
RG10 10 0 1000000000000
RG11 11 0 1000000000000
RG12 12 0 1000000000000
RG13 13 0 1000000000000
RG14 14 0 1000000000000
RG15 15 0 1000000000000
RG16 16 0 1000000000000
RG17 17 0 1000000000000
RG18 18 0 1000000000000
RG19 19 0 1000000000000
RG20 20 0 1000000000000
RG21 21 0 1000000000000
RG22 22 0 1000000000000
RG23 23 0 1000000000000
RG24 24 0 1000000000000
RG25 25 0 1000000000000
RG26 26 0 1000000000000
RG27 27 0 1000000000000
RG28 28 0 1000000000000
VS0 27 s0 0
R0 s0 13 82e3
VS1 8 s1 0
R1 s1 26 33e1
VS2 0 s2 0
V2 e2 s2 DC 27e1
RI2 e2 8 47e-2
VS3 2 s3 0
I3 s3 17 DC 18e-2
VS4 12 s4 0
R4 s4 8 82e0
VS5 8 s5 0
I5 s5 19 DC 39e-3
VS6 12 s6 0
R6 s6 1 15e1
VS7 21 s7 0
V7 e7 s7 DC 27e1
RI7 e7 1 12e-1
VS8 23 s8 0
R8 s8 8 10e0
VS9 4 s9 0
V9 e9 s9 DC 56e-1
RI9 e9 21 68e-3
VS10 22 s10 0
I10 s10 27 DC 68e-2
VS11 19 s11 0
R11 s11 18 39e-2
VS12 20 s12 0
I12 s12 1 DC 22e-2
VS13 4 s13 0
R13 s13 27 33e-2
VS14 28 s14 0
V14 e14 s14 DC 18e1
RI14 e14 26 18e-1
VS15 1 s15 0
R15 s15 17 22e1
VS16 13 s16 0
R16 s16 22 82e-2
VS17 13 s17 0
R17 s17 28 22e-2
VS18 25 s18 0
R18 s18 17 22e1
VS19 7 s19 0
R19 s19 6 15e3
VS20 17 s20 0
V20 e20 s20 DC 68e0
RI20 e20 11 33e-2
VS21 21 s21 0
R21 s21 3 39e3
VS22 13 s22 0
R22 s22 8 18e2
VS23 15 s23 0
I23 s23 6 DC 12e-1
VS24 14 s24 0
R24 s24 15 22e1
VS25 0 s25 0
R25 s25 11 82e2
VS26 12 s26 0
R26 s26 7 33e-2
VS27 14 s27 0
R27 s27 10 22e-2
VS28 10 s28 0
R28 s28 9 15e2
VS29 3 s29 0
R29 s29 17 18e0
VS30 17 s30 0
V30 e30 s30 DC 82e-1
RI30 e30 24 10e-1
VS31 9 s31 0
V31 e31 s31 DC 22e-1
RI31 e31 8 47e-3
VS32 8 s32 0
R32 s32 20 39e-1
VS33 20 s33 0
R33 s33 23 68e-1
VS34 24 s34 0
R34 s34 5 33e0
VS35 0 s35 0
R35 s35 25 39e0
VS36 0 s36 0
R36 s36 14 39e1
VS37 0 s37 0
R37 s37 16 10e2
VS38 24 s38 0
R38 s38 18 56e0
VS39 22 s39 0
R39 s39 17 15e-2
VS40 0 s40 0
R40 s40 8 15e3
VS41 0 s41 0
R41 s41 2 10e2
VS42 6 s42 0
R42 s42 23 10e-2
VS43 0 s43 0
R43 s43 9 27e3
VS44 5 s44 0
R44 s44 11 47e3
VS45 0 s45 0
V45 e45 s45 DC 12e1
RI45 e45 24 39e-2
VS46 4 s46 0
R46 s46 8 12e2
VS47 15 s47 0
R47 s47 2 15e3
VS48 6 s48 0
R48 s48 16 33e2
VS49 12 s49 0
V49 e49 s49 DC 47e1
RI49 e49 19 68e-3
.control
set numdgt=17
op
print v(1) v(2) v(3) v(4) v(5) v(6) v(7) v(8) v(9) v(10)
print v(11) v(12) v(13) v(14) v(15) v(16) v(17) v(18) v(19) v(20)
print v(21) v(22) v(23) v(24) v(25) v(26) v(27) v(28)
print i(vs0) i(vs1) i(vs2) i(vs3) i(vs4) i(vs5) i(vs6) i(vs7) i(vs8) i(vs9)
print i(vs10) i(vs11) i(vs12) i(vs13) i(vs14) i(vs15) i(vs16) i(vs17) i(vs18) i(vs19)
print i(vs20) i(vs21) i(vs22) i(vs23) i(vs24) i(vs25) i(vs26) i(vs27) i(vs28) i(vs29)
print i(vs30) i(vs31) i(vs32) i(vs33) i(vs34) i(vs35) i(vs36) i(vs37) i(vs38) i(vs39)
print i(vs40) i(vs41) i(vs42) i(vs43) i(vs44) i(vs45) i(vs46) i(vs47) i(vs48) i(vs49)
.endc
.end
