controls oracle dc-0352
* Generated (plan F2.7, ADR 0012): do not edit; regenerate with `pnpm sim oracle regen`. dc seed 20261030 index 352 nodes 4 elements 6
.options sparse gmin=1e-12 noopac
RG1 1 0 1000000000000
RG2 2 0 1000000000000
RG3 3 0 1000000000000
VS0 1 s0 0
R0 s0 3 68e-2
VS1 3 s1 0
R1 s1 2 39e-1
VS2 2 s2 0
R2 s2 0 39e-2
VS3 0 s3 0
R3 s3 1 68e-2
VS4 0 s4 0
V4 e4 s4 DC 82e0
RI4 e4 3 82e-2
VS5 1 s5 0
R5 s5 0 33e3
.control
set numdgt=17
op
print v(1) v(2) v(3)
print i(vs0) i(vs1) i(vs2) i(vs3) i(vs4) i(vs5)
.endc
.end
