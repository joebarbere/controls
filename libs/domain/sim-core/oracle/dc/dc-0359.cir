controls oracle dc-0359
* Generated (plan F2.7, ADR 0012): do not edit; regenerate with `pnpm sim oracle regen`. dc seed 20261030 index 359 nodes 28 elements 50
.options sparse gmin=1e-12 noopac
RG1 1 0 1000000000000
RG2 2 0 1000000000000
RG3 3 0 1000000000000
RG4 4 0 1000000000000
RG5 5 0 1000000000000
RG6 6 0 1000000000000
RG7 7 0 1000000000000
RG8 8 0 1000000000000
RG9 9 0 1000000000000
RG10 10 0 1000000000000
RG11 11 0 1000000000000
RG12 12 0 1000000000000
RG13 13 0 1000000000000
RG14 14 0 1000000000000
RG15 15 0 1000000000000
RG16 16 0 1000000000000
RG17 17 0 1000000000000
RG18 18 0 1000000000000
RG19 19 0 1000000000000
RG20 20 0 1000000000000
RG21 21 0 1000000000000
RG22 22 0 1000000000000
RG23 23 0 1000000000000
RG24 24 0 1000000000000
RG25 25 0 1000000000000
RG26 26 0 1000000000000
RG27 27 0 1000000000000
VS0 7 s0 0
R0 s0 6 15e2
VS1 3 s1 0
I1 s1 21 DC 47e-2
VS2 8 s2 0
R2 s2 23 56e2
VS3 17 s3 0
R3 s3 13 39e1
VS4 5 s4 0
R4 s4 13 22e0
VS5 7 s5 0
R5 s5 13 22e-1
VS6 19 s6 0
R6 s6 15 39e-1
VS7 19 s7 0
R7 s7 27 47e3
VS8 0 s8 0
V8 e8 s8 DC 18e1
RI8 e8 2 15e-1
VS9 12 s9 0
V9 e9 s9 DC 18e1
RI9 e9 27 39e-1
VS10 13 s10 0
R10 s10 21 82e1
VS11 27 s11 0
R11 s11 4 27e-1
VS12 14 s12 0
R12 s12 20 47e-1
VS13 17 s13 0
R13 s13 25 10e3
VS14 18 s14 0
I14 s14 6 DC 82e-2
VS15 2 s15 0
I15 s15 21 DC 27e-4
VS16 14 s16 0
I16 s16 0 DC 27e-4
VS17 3 s17 0
R17 s17 5 12e2
VS18 16 s18 0
R18 s18 19 56e0
VS19 18 s19 0
R19 s19 26 39e-2
VS20 9 s20 0
R20 s20 19 33e3
VS21 14 s21 0
R21 s21 10 18e-2
VS22 4 s22 0
R22 s22 11 12e0
VS23 5 s23 0
V23 e23 s23 DC 33e-1
RI23 e23 1 39e-2
VS24 11 s24 0
R24 s24 6 15e3
VS25 8 s25 0
I25 s25 20 DC 27e-2
VS26 9 s26 0
I26 s26 5 DC 39e-2
VS27 2 s27 0
V27 e27 s27 DC 33e1
RI27 e27 18 12e-3
VS28 8 s28 0
V28 e28 s28 DC 22e1
RI28 e28 25 39e-1
VS29 27 s29 0
R29 s29 12 12e3
VS30 10 s30 0
R30 s30 7 33e-1
VS31 1 s31 0
R31 s31 16 82e-1
VS32 3 s32 0
V32 e32 s32 DC 12e0
RI32 e32 27 33e-3
VS33 15 s33 0
R33 s33 27 47e2
VS34 10 s34 0
V34 e34 s34 DC 18e1
RI34 e34 0 15e-2
VS35 8 s35 0
R35 s35 21 56e-2
VS36 0 s36 0
R36 s36 18 12e1
VS37 24 s37 0
R37 s37 21 56e2
VS38 15 s38 0
V38 e38 s38 DC 39e1
RI38 e38 10 10e-1
VS39 7 s39 0
R39 s39 15 39e2
VS40 9 s40 0
R40 s40 24 82e-2
VS41 20 s41 0
R41 s41 12 82e1
VS42 7 s42 0
R42 s42 18 12e2
VS43 22 s43 0
V43 e43 s43 DC 82e0
RI43 e43 15 82e-1
VS44 23 s44 0
R44 s44 13 27e1
VS45 26 s45 0
V45 e45 s45 DC 27e1
RI45 e45 22 82e-3
VS46 18 s46 0
R46 s46 9 33e-1
VS47 27 s47 0
R47 s47 21 56e3
VS48 16 s48 0
V48 e48 s48 DC 15e-1
RI48 e48 15 68e-2
VS49 11 s49 0
R49 s49 3 68e1
.control
set numdgt=17
op
print v(1) v(2) v(3) v(4) v(5) v(6) v(7) v(8) v(9) v(10)
print v(11) v(12) v(13) v(14) v(15) v(16) v(17) v(18) v(19) v(20)
print v(21) v(22) v(23) v(24) v(25) v(26) v(27)
print i(vs0) i(vs1) i(vs2) i(vs3) i(vs4) i(vs5) i(vs6) i(vs7) i(vs8) i(vs9)
print i(vs10) i(vs11) i(vs12) i(vs13) i(vs14) i(vs15) i(vs16) i(vs17) i(vs18) i(vs19)
print i(vs20) i(vs21) i(vs22) i(vs23) i(vs24) i(vs25) i(vs26) i(vs27) i(vs28) i(vs29)
print i(vs30) i(vs31) i(vs32) i(vs33) i(vs34) i(vs35) i(vs36) i(vs37) i(vs38) i(vs39)
print i(vs40) i(vs41) i(vs42) i(vs43) i(vs44) i(vs45) i(vs46) i(vs47) i(vs48) i(vs49)
.endc
.end
