controls oracle dc-0359
* Generated (plan F2.7, ADR 0012): do not edit; regenerate with `pnpm sim oracle regen`. dc seed 20261030 index 359 nodes 28 elements 46
.options sparse gmin=1e-12 noopac
RG1 1 0 1000000000000
RG2 2 0 1000000000000
RG3 3 0 1000000000000
RG4 4 0 1000000000000
RG5 5 0 1000000000000
RG6 6 0 1000000000000
RG7 7 0 1000000000000
RG8 8 0 1000000000000
RG9 9 0 1000000000000
RG10 10 0 1000000000000
RG11 11 0 1000000000000
RG12 12 0 1000000000000
RG13 13 0 1000000000000
RG14 14 0 1000000000000
RG15 15 0 1000000000000
RG16 16 0 1000000000000
RG17 17 0 1000000000000
RG18 18 0 1000000000000
RG19 19 0 1000000000000
RG20 20 0 1000000000000
RG21 21 0 1000000000000
RG22 22 0 1000000000000
RG23 23 0 1000000000000
RG24 24 0 1000000000000
RG25 25 0 1000000000000
RG26 26 0 1000000000000
RG27 27 0 1000000000000
VS0 3 s0 0
I0 s0 21 DC 47e-2
VS1 0 s1 0
V1 e1 s1 DC 82e0
RI1 e1 15 82e-1
VS2 27 s2 0
R2 s2 4 27e-1
VS3 19 s3 0
R3 s3 15 39e-1
VS4 19 s4 0
R4 s4 27 47e3
VS5 17 s5 0
R5 s5 25 10e3
VS6 12 s6 0
V6 e6 s6 DC 18e1
RI6 e6 27 39e-1
VS7 18 s7 0
I7 s7 6 DC 82e-2
VS8 18 s8 0
R8 s8 9 33e-1
VS9 5 s9 0
V9 e9 s9 DC 33e-1
RI9 e9 1 39e-2
VS10 18 s10 0
R10 s10 22 39e-2
VS11 1 s11 0
R11 s11 16 82e-1
VS12 4 s12 0
R12 s12 11 12e0
VS13 8 s13 0
I13 s13 20 DC 27e-2
VS14 3 s14 0
V14 e14 s14 DC 12e0
RI14 e14 27 33e-3
VS15 14 s15 0
R15 s15 10 18e-2
VS16 3 s16 0
R16 s16 5 12e2
VS17 16 s17 0
R17 s17 19 56e0
VS18 14 s18 0
R18 s18 20 47e-1
VS19 11 s19 0
R19 s19 6 15e3
VS20 16 s20 0
V20 e20 s20 DC 15e-1
RI20 e20 15 68e-2
VS21 26 s21 0
R21 s21 18 12e1
VS22 2 s22 0
V22 e22 s22 DC 33e1
RI22 e22 18 12e-3
VS23 10 s23 0
V23 e23 s23 DC 18e1
RI23 e23 26 15e-2
VS24 11 s24 0
R24 s24 3 68e1
VS25 7 s25 0
R25 s25 15 39e2
VS26 15 s26 0
V26 e26 s26 DC 39e1
RI26 e26 10 10e-1
VS27 27 s27 0
R27 s27 21 56e3
VS28 17 s28 0
R28 s28 13 39e1
VS29 8 s29 0
R29 s29 21 56e-2
VS30 23 s30 0
R30 s30 13 27e1
VS31 27 s31 0
R31 s31 12 12e3
VS32 7 s32 0
R32 s32 6 15e2
VS33 9 s33 0
I33 s33 5 DC 39e-2
VS34 24 s34 0
R34 s34 21 56e2
VS35 2 s35 0
I35 s35 21 DC 27e-4
VS36 9 s36 0
R36 s36 19 33e3
VS37 20 s37 0
R37 s37 12 82e1
VS38 14 s38 0
I38 s38 26 DC 27e-4
VS39 13 s39 0
R39 s39 21 82e1
VS40 5 s40 0
R40 s40 13 22e0
VS41 9 s41 0
R41 s41 24 82e-2
VS42 7 s42 0
R42 s42 13 22e-1
VS43 15 s43 0
R43 s43 27 47e2
VS44 7 s44 0
R44 s44 18 12e2
VS45 10 s45 0
R45 s45 7 33e-1
.control
set numdgt=17
op
print v(1) v(2) v(3) v(4) v(5) v(6) v(7) v(8) v(9) v(10)
print v(11) v(12) v(13) v(14) v(15) v(16) v(17) v(18) v(19) v(20)
print v(21) v(22) v(23) v(24) v(25) v(26) v(27)
print i(vs0) i(vs1) i(vs2) i(vs3) i(vs4) i(vs5) i(vs6) i(vs7) i(vs8) i(vs9)
print i(vs10) i(vs11) i(vs12) i(vs13) i(vs14) i(vs15) i(vs16) i(vs17) i(vs18) i(vs19)
print i(vs20) i(vs21) i(vs22) i(vs23) i(vs24) i(vs25) i(vs26) i(vs27) i(vs28) i(vs29)
print i(vs30) i(vs31) i(vs32) i(vs33) i(vs34) i(vs35) i(vs36) i(vs37) i(vs38) i(vs39)
print i(vs40) i(vs41) i(vs42) i(vs43) i(vs44) i(vs45)
.endc
.end
