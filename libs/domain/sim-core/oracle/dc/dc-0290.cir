controls oracle dc-0290
* Generated (plan F2.7, ADR 0012): do not edit; regenerate with `pnpm sim oracle regen`. dc seed 20261030 index 290 nodes 8 elements 11
.options sparse gmin=1e-12 noopac
RG1 1 0 1000000000000
RG2 2 0 1000000000000
RG3 3 0 1000000000000
RG4 4 0 1000000000000
RG5 5 0 1000000000000
RG6 6 0 1000000000000
RG7 7 0 1000000000000
VS0 7 s0 0
R0 s0 2 68e2
VS1 0 s1 0
V1 e1 s1 DC 27e1
RI1 e1 7 27e-2
VS2 6 s2 0
R2 s2 0 47e2
VS3 5 s3 0
R3 s3 3 27e2
VS4 1 s4 0
R4 s4 5 82e1
VS5 0 s5 0
R5 s5 1 15e-2
VS6 2 s6 0
R6 s6 0 12e3
VS7 2 s7 0
R7 s7 1 27e-1
VS8 1 s8 0
R8 s8 4 68e-2
VS9 1 s9 0
R9 s9 4 68e-1
VS10 3 s10 0
R10 s10 7 39e2
.control
set numdgt=17
op
print v(1) v(2) v(3) v(4) v(5) v(6) v(7)
print i(vs0) i(vs1) i(vs2) i(vs3) i(vs4) i(vs5) i(vs6) i(vs7) i(vs8) i(vs9)
print i(vs10)
.endc
.end
