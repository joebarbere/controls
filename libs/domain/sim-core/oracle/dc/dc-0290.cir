controls oracle dc-0290
* Generated (plan F2.7, ADR 0012): do not edit; regenerate with `pnpm sim oracle regen`. dc seed 20261030 index 290 nodes 8 elements 13
.options sparse gmin=1e-12 noopac
RG1 1 0 1000000000000
RG2 2 0 1000000000000
RG3 3 0 1000000000000
RG4 4 0 1000000000000
RG5 5 0 1000000000000
RG6 6 0 1000000000000
RG7 7 0 1000000000000
VS0 3 s0 0
R0 s0 7 39e2
VS1 1 s1 0
R1 s1 5 82e1
VS2 5 s2 0
R2 s2 3 27e2
VS3 2 s3 0
R3 s3 1 27e-1
VS4 1 s4 0
R4 s4 4 68e-2
VS5 7 s5 0
R5 s5 2 68e2
VS6 1 s6 0
R6 s6 4 68e-1
VS7 6 s7 0
R7 s7 0 47e2
VS8 6 s8 0
R8 s8 5 82e-2
VS9 0 s9 0
V9 e9 s9 DC 27e1
RI9 e9 7 27e-2
VS10 2 s10 0
R10 s10 0 12e3
VS11 6 s11 0
R11 s11 4 82e-1
VS12 0 s12 0
R12 s12 1 15e-2
.control
set numdgt=17
op
print v(1) v(2) v(3) v(4) v(5) v(6) v(7)
print i(vs0) i(vs1) i(vs2) i(vs3) i(vs4) i(vs5) i(vs6) i(vs7) i(vs8) i(vs9)
print i(vs10) i(vs11) i(vs12)
.endc
.end
