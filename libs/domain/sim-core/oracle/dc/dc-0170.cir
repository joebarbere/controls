controls oracle dc-0170
* Generated (plan F2.7, ADR 0012): do not edit; regenerate with `pnpm sim oracle regen`. dc seed 20261030 index 170 nodes 22 elements 39
.options sparse gmin=1e-12 noopac
RG1 1 0 1000000000000
RG2 2 0 1000000000000
RG3 3 0 1000000000000
RG4 4 0 1000000000000
RG5 5 0 1000000000000
RG6 6 0 1000000000000
RG7 7 0 1000000000000
RG8 8 0 1000000000000
RG9 9 0 1000000000000
RG10 10 0 1000000000000
RG11 11 0 1000000000000
RG12 12 0 1000000000000
RG13 13 0 1000000000000
RG14 14 0 1000000000000
RG15 15 0 1000000000000
RG16 16 0 1000000000000
RG17 17 0 1000000000000
RG18 18 0 1000000000000
RG19 19 0 1000000000000
RG20 20 0 1000000000000
RG21 21 0 1000000000000
VS0 0 s0 0
R0 s0 19 47e3
VS1 0 s1 0
V1 e1 s1 DC 82e1
RI1 e1 21 18e-2
VS2 0 s2 0
R2 s2 18 10e1
VS3 6 s3 0
R3 s3 12 33e2
VS4 4 s4 0
R4 s4 2 10e-2
VS5 19 s5 0
R5 s5 3 39e1
VS6 19 s6 0
R6 s6 3 47e2
VS7 20 s7 0
R7 s7 15 18e-2
VS8 7 s8 0
R8 s8 10 56e1
VS9 21 s9 0
R9 s9 11 68e3
VS10 8 s10 0
R10 s10 19 22e-1
VS11 5 s11 0
R11 s11 6 27e3
VS12 10 s12 0
R12 s12 9 10e-1
VS13 17 s13 0
R13 s13 19 15e-1
VS14 18 s14 0
R14 s14 3 47e3
VS15 15 s15 0
I15 s15 17 DC 47e-2
VS16 15 s16 0
R16 s16 1 27e1
VS17 2 s17 0
V17 e17 s17 DC 33e-1
RI17 e17 15 12e-1
VS18 7 s18 0
V18 e18 s18 DC 68e1
RI18 e18 13 15e-3
VS19 20 s19 0
R19 s19 11 27e2
VS20 17 s20 0
R20 s20 0 68e3
VS21 4 s21 0
V21 e21 s21 DC 22e1
RI21 e21 3 18e-3
VS22 20 s22 0
R22 s22 11 56e3
VS23 5 s23 0
R23 s23 2 82e2
VS24 1 s24 0
I24 s24 14 DC 22e-2
VS25 9 s25 0
R25 s25 3 56e2
VS26 8 s26 0
I26 s26 16 DC 10e-1
VS27 3 s27 0
V27 e27 s27 DC 33e-1
RI27 e27 16 12e-3
VS28 6 s28 0
R28 s28 19 33e-2
VS29 17 s29 0
R29 s29 20 18e2
VS30 2 s30 0
R30 s30 1 68e2
VS31 14 s31 0
I31 s31 4 DC 33e-4
VS32 19 s32 0
R32 s32 2 15e1
VS33 14 s33 0
R33 s33 4 39e-1
VS34 8 s34 0
R34 s34 20 47e-1
VS35 13 s35 0
R35 s35 11 27e0
VS36 12 s36 0
R36 s36 16 12e3
VS37 7 s37 0
V37 e37 s37 DC 33e-1
RI37 e37 14 12e-1
VS38 9 s38 0
R38 s38 6 22e1
.control
set numdgt=17
op
print v(1) v(2) v(3) v(4) v(5) v(6) v(7) v(8) v(9) v(10)
print v(11) v(12) v(13) v(14) v(15) v(16) v(17) v(18) v(19) v(20)
print v(21)
print i(vs0) i(vs1) i(vs2) i(vs3) i(vs4) i(vs5) i(vs6) i(vs7) i(vs8) i(vs9)
print i(vs10) i(vs11) i(vs12) i(vs13) i(vs14) i(vs15) i(vs16) i(vs17) i(vs18) i(vs19)
print i(vs20) i(vs21) i(vs22) i(vs23) i(vs24) i(vs25) i(vs26) i(vs27) i(vs28) i(vs29)
print i(vs30) i(vs31) i(vs32) i(vs33) i(vs34) i(vs35) i(vs36) i(vs37) i(vs38)
.endc
.end
