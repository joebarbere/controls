controls oracle dc-0170
* Generated (plan F2.7, ADR 0012): do not edit; regenerate with `pnpm sim oracle regen`. dc seed 20261030 index 170 nodes 22 elements 33
.options sparse gmin=1e-12 noopac
RG1 1 0 1000000000000
RG2 2 0 1000000000000
RG3 3 0 1000000000000
RG4 4 0 1000000000000
RG5 5 0 1000000000000
RG6 6 0 1000000000000
RG7 7 0 1000000000000
RG8 8 0 1000000000000
RG9 9 0 1000000000000
RG10 10 0 1000000000000
RG11 11 0 1000000000000
RG12 12 0 1000000000000
RG13 13 0 1000000000000
RG14 14 0 1000000000000
RG15 15 0 1000000000000
RG16 16 0 1000000000000
RG17 17 0 1000000000000
RG18 18 0 1000000000000
RG19 19 0 1000000000000
RG20 20 0 1000000000000
RG21 21 0 1000000000000
VS0 0 s0 0
V0 e0 s0 DC 33e-1
RI0 e0 15 12e-1
VS1 0 s1 0
R1 s1 1 68e2
VS2 14 s2 0
I2 s2 4 DC 33e-4
VS3 15 s3 0
I3 s3 17 DC 47e-2
VS4 17 s4 0
R4 s4 2 68e3
VS5 17 s5 0
R5 s5 20 18e2
VS6 10 s6 0
R6 s6 9 10e-1
VS7 20 s7 0
R7 s7 15 18e-2
VS8 2 s8 0
R8 s8 18 10e1
VS9 19 s9 0
R9 s9 0 15e1
VS10 13 s10 0
R10 s10 11 27e0
VS11 8 s11 0
R11 s11 19 22e-1
VS12 2 s12 0
R12 s12 19 47e3
VS13 18 s13 0
R13 s13 3 47e3
VS14 1 s14 0
I14 s14 14 DC 22e-2
VS15 19 s15 0
R15 s15 3 39e1
VS16 9 s16 0
R16 s16 6 22e1
VS17 14 s17 0
R17 s17 4 39e-1
VS18 21 s18 0
R18 s18 11 68e3
VS19 20 s19 0
R19 s19 11 27e2
VS20 7 s20 0
V20 e20 s20 DC 33e-1
RI20 e20 14 12e-1
VS21 17 s21 0
R21 s21 19 15e-1
VS22 6 s22 0
R22 s22 12 33e2
VS23 4 s23 0
V23 e23 s23 DC 22e1
RI23 e23 3 18e-3
VS24 19 s24 0
R24 s24 3 47e2
VS25 6 s25 0
R25 s25 19 33e-2
VS26 8 s26 0
I26 s26 16 DC 10e-1
VS27 12 s27 0
R27 s27 16 12e3
VS28 9 s28 0
R28 s28 3 56e2
VS29 15 s29 0
R29 s29 1 27e1
VS30 4 s30 0
R30 s30 0 10e-2
VS31 5 s31 0
R31 s31 6 27e3
VS32 20 s32 0
R32 s32 11 56e3
.control
set numdgt=17
op
print v(1) v(2) v(3) v(4) v(5) v(6) v(7) v(8) v(9) v(10)
print v(11) v(12) v(13) v(14) v(15) v(16) v(17) v(18) v(19) v(20)
print v(21)
print i(vs0) i(vs1) i(vs2) i(vs3) i(vs4) i(vs5) i(vs6) i(vs7) i(vs8) i(vs9)
print i(vs10) i(vs11) i(vs12) i(vs13) i(vs14) i(vs15) i(vs16) i(vs17) i(vs18) i(vs19)
print i(vs20) i(vs21) i(vs22) i(vs23) i(vs24) i(vs25) i(vs26) i(vs27) i(vs28) i(vs29)
print i(vs30) i(vs31) i(vs32)
.endc
.end
