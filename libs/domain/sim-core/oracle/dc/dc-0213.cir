controls oracle dc-0213
* Generated (plan F2.7, ADR 0012): do not edit; regenerate with `pnpm sim oracle regen`. dc seed 20261030 index 213 nodes 23 elements 35
.options sparse gmin=1e-12 noopac
RG1 1 0 1000000000000
RG2 2 0 1000000000000
RG3 3 0 1000000000000
RG4 4 0 1000000000000
RG5 5 0 1000000000000
RG6 6 0 1000000000000
RG7 7 0 1000000000000
RG8 8 0 1000000000000
RG9 9 0 1000000000000
RG10 10 0 1000000000000
RG11 11 0 1000000000000
RG12 12 0 1000000000000
RG13 13 0 1000000000000
RG14 14 0 1000000000000
RG15 15 0 1000000000000
RG16 16 0 1000000000000
RG17 17 0 1000000000000
RG18 18 0 1000000000000
RG19 19 0 1000000000000
RG20 20 0 1000000000000
RG21 21 0 1000000000000
RG22 22 0 1000000000000
VS0 20 s0 0
R0 s0 0 27e0
VS1 13 s1 0
R1 s1 8 68e0
VS2 3 s2 0
I2 s2 15 DC 22e-4
VS3 12 s3 0
I3 s3 18 DC 15e-1
VS4 9 s4 0
R4 s4 3 68e-2
VS5 4 s5 0
I5 s5 12 DC 47e-4
VS6 16 s6 0
R6 s6 13 10e3
VS7 5 s7 0
R7 s7 11 47e3
VS8 1 s8 0
R8 s8 17 68e3
VS9 20 s9 0
R9 s9 1 39e-2
VS10 22 s10 0
R10 s10 7 18e1
VS11 17 s11 0
R11 s11 12 39e-2
VS12 14 s12 0
R12 s12 22 68e0
VS13 13 s13 0
R13 s13 12 18e0
VS14 22 s14 0
R14 s14 5 18e2
VS15 0 s15 0
V15 e15 s15 DC 33e1
RI15 e15 11 27e-2
VS16 17 s16 0
I16 s16 19 DC 47e-3
VS17 0 s17 0
I17 s17 19 DC 27e-2
VS18 1 s18 0
R18 s18 2 18e1
VS19 4 s19 0
R19 s19 12 56e0
VS20 21 s20 0
V20 e20 s20 DC 12e1
RI20 e20 10 12e-1
VS21 6 s21 0
V21 e21 s21 DC 47e1
RI21 e21 22 68e-3
VS22 17 s22 0
R22 s22 12 10e-2
VS23 13 s23 0
R23 s23 4 12e1
VS24 21 s24 0
R24 s24 9 12e1
VS25 18 s25 0
R25 s25 17 18e1
VS26 13 s26 0
R26 s26 18 56e2
VS27 6 s27 0
R27 s27 19 12e-2
VS28 18 s28 0
R28 s28 5 10e3
VS29 10 s29 0
R29 s29 13 22e-2
VS30 17 s30 0
R30 s30 0 47e-1
VS31 10 s31 0
R31 s31 6 22e0
VS32 22 s32 0
R32 s32 15 33e-1
VS33 4 s33 0
R33 s33 16 39e1
VS34 13 s34 0
R34 s34 3 47e2
.control
set numdgt=17
op
print v(1) v(2) v(3) v(4) v(5) v(6) v(7) v(8) v(9) v(10)
print v(11) v(12) v(13) v(14) v(15) v(16) v(17) v(18) v(19) v(20)
print v(21) v(22)
print i(vs0) i(vs1) i(vs2) i(vs3) i(vs4) i(vs5) i(vs6) i(vs7) i(vs8) i(vs9)
print i(vs10) i(vs11) i(vs12) i(vs13) i(vs14) i(vs15) i(vs16) i(vs17) i(vs18) i(vs19)
print i(vs20) i(vs21) i(vs22) i(vs23) i(vs24) i(vs25) i(vs26) i(vs27) i(vs28) i(vs29)
print i(vs30) i(vs31) i(vs32) i(vs33) i(vs34)
.endc
.end
