controls oracle dc-0213
* Generated (plan F2.7, ADR 0012): do not edit; regenerate with `pnpm sim oracle regen`. dc seed 20261030 index 213 nodes 23 elements 41
.options sparse gmin=1e-12 noopac
RG1 1 0 1000000000000
RG2 2 0 1000000000000
RG3 3 0 1000000000000
RG4 4 0 1000000000000
RG5 5 0 1000000000000
RG6 6 0 1000000000000
RG7 7 0 1000000000000
RG8 8 0 1000000000000
RG9 9 0 1000000000000
RG10 10 0 1000000000000
RG11 11 0 1000000000000
RG12 12 0 1000000000000
RG13 13 0 1000000000000
RG14 14 0 1000000000000
RG15 15 0 1000000000000
RG16 16 0 1000000000000
RG17 17 0 1000000000000
RG18 18 0 1000000000000
RG19 19 0 1000000000000
RG20 20 0 1000000000000
RG21 21 0 1000000000000
RG22 22 0 1000000000000
VS0 18 s0 0
I0 s0 19 DC 27e-2
VS1 1 s1 0
R1 s1 17 68e3
VS2 12 s2 0
R2 s2 17 18e1
VS3 0 s3 0
I3 s3 12 DC 15e-1
VS4 0 s4 0
V4 e4 s4 DC 33e1
RI4 e4 15 47e-3
VS5 17 s5 0
R5 s5 18 47e-1
VS6 19 s6 0
V6 e6 s6 DC 22e1
RI6 e6 13 12e-2
VS7 6 s7 0
R7 s7 19 12e-2
VS8 4 s8 0
R8 s8 16 39e1
VS9 22 s9 0
R9 s9 7 18e1
VS10 21 s10 0
V10 e10 s10 DC 12e1
RI10 e10 10 12e-1
VS11 12 s11 0
R11 s11 5 10e3
VS12 13 s12 0
R12 s12 3 47e2
VS13 3 s13 0
I13 s13 15 DC 22e-4
VS14 13 s14 0
R14 s14 4 12e1
VS15 17 s15 0
R15 s15 0 10e-2
VS16 2 s16 0
R16 s16 18 12e-2
VS17 17 s17 0
R17 s17 0 39e-2
VS18 1 s18 0
R18 s18 2 18e1
VS19 13 s19 0
R19 s19 0 18e0
VS20 19 s20 0
R20 s20 14 27e0
VS21 8 s21 0
V21 e21 s21 DC 56e1
RI21 e21 18 33e-1
VS22 4 s22 0
I22 s22 0 DC 47e-4
VS23 20 s23 0
R23 s23 18 27e0
VS24 14 s24 0
R24 s24 22 68e0
VS25 5 s25 0
R25 s25 11 47e3
VS26 22 s26 0
R26 s26 15 33e-1
VS27 22 s27 0
R27 s27 5 18e2
VS28 21 s28 0
R28 s28 9 12e1
VS29 20 s29 0
R29 s29 1 39e-2
VS30 2 s30 0
V30 e30 s30 DC 22e0
RI30 e30 7 15e-3
VS31 13 s31 0
R31 s31 12 56e2
VS32 9 s32 0
R32 s32 3 68e-2
VS33 6 s33 0
V33 e33 s33 DC 47e1
RI33 e33 22 68e-3
VS34 4 s34 0
R34 s34 0 56e0
VS35 13 s35 0
R35 s35 8 68e0
VS36 17 s36 0
I36 s36 19 DC 47e-3
VS37 18 s37 0
V37 e37 s37 DC 33e1
RI37 e37 11 27e-2
VS38 16 s38 0
R38 s38 13 10e3
VS39 10 s39 0
R39 s39 13 22e-2
VS40 10 s40 0
R40 s40 6 22e0
.control
set numdgt=17
op
print v(1) v(2) v(3) v(4) v(5) v(6) v(7) v(8) v(9) v(10)
print v(11) v(12) v(13) v(14) v(15) v(16) v(17) v(18) v(19) v(20)
print v(21) v(22)
print i(vs0) i(vs1) i(vs2) i(vs3) i(vs4) i(vs5) i(vs6) i(vs7) i(vs8) i(vs9)
print i(vs10) i(vs11) i(vs12) i(vs13) i(vs14) i(vs15) i(vs16) i(vs17) i(vs18) i(vs19)
print i(vs20) i(vs21) i(vs22) i(vs23) i(vs24) i(vs25) i(vs26) i(vs27) i(vs28) i(vs29)
print i(vs30) i(vs31) i(vs32) i(vs33) i(vs34) i(vs35) i(vs36) i(vs37) i(vs38) i(vs39)
print i(vs40)
.endc
.end
