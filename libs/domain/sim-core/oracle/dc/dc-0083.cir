controls oracle dc-0083
* Generated (plan F2.7, ADR 0012): do not edit; regenerate with `pnpm sim oracle regen`. dc seed 20261030 index 83 nodes 20 elements 37
.options sparse gmin=1e-12 noopac
RG1 1 0 1000000000000
RG2 2 0 1000000000000
RG3 3 0 1000000000000
RG4 4 0 1000000000000
RG5 5 0 1000000000000
RG6 6 0 1000000000000
RG7 7 0 1000000000000
RG8 8 0 1000000000000
RG9 9 0 1000000000000
RG10 10 0 1000000000000
RG11 11 0 1000000000000
RG12 12 0 1000000000000
RG13 13 0 1000000000000
RG14 14 0 1000000000000
RG15 15 0 1000000000000
RG16 16 0 1000000000000
RG17 17 0 1000000000000
RG18 18 0 1000000000000
RG19 19 0 1000000000000
VS0 5 s0 0
I0 s0 3 DC 27e-4
VS1 0 s1 0
V1 e1 s1 DC 56e-1
RI1 e1 2 27e-3
VS2 3 s2 0
V2 e2 s2 DC 47e-1
RI2 e2 13 10e-3
VS3 1 s3 0
R3 s3 15 27e1
VS4 4 s4 0
R4 s4 13 47e-2
VS5 14 s5 0
R5 s5 6 15e1
VS6 14 s6 0
R6 s6 0 12e1
VS7 1 s7 0
R7 s7 16 68e-2
VS8 16 s8 0
I8 s8 0 DC 47e-1
VS9 9 s9 0
I9 s9 3 DC 33e-3
VS10 13 s10 0
R10 s10 15 27e3
VS11 9 s11 0
R11 s11 16 56e0
VS12 0 s12 0
I12 s12 8 DC 22e-4
VS13 2 s13 0
R13 s13 11 27e2
VS14 12 s14 0
V14 e14 s14 DC 27e1
RI14 e14 4 18e-3
VS15 8 s15 0
R15 s15 7 12e-2
VS16 13 s16 0
R16 s16 10 15e-1
VS17 7 s17 0
R17 s17 5 18e1
VS18 1 s18 0
R18 s18 8 10e-2
VS19 10 s19 0
I19 s19 12 DC 47e-1
VS20 12 s20 0
R20 s20 8 12e1
VS21 16 s21 0
R21 s21 19 82e-1
VS22 5 s22 0
R22 s22 3 82e1
VS23 19 s23 0
R23 s23 4 12e3
VS24 15 s24 0
V24 e24 s24 DC 39e0
RI24 e24 12 15e-2
VS25 18 s25 0
R25 s25 7 18e2
VS26 17 s26 0
R26 s26 3 39e0
VS27 9 s27 0
R27 s27 15 10e-1
VS28 16 s28 0
R28 s28 17 22e1
VS29 0 s29 0
R29 s29 13 22e-1
VS30 12 s30 0
R30 s30 18 82e1
VS31 11 s31 0
I31 s31 8 DC 82e-4
VS32 0 s32 0
I32 s32 12 DC 82e-4
VS33 10 s33 0
V33 e33 s33 DC 27e-1
RI33 e33 18 27e-1
VS34 7 s34 0
R34 s34 3 33e0
VS35 9 s35 0
R35 s35 11 10e-2
VS36 1 s36 0
R36 s36 6 68e1
.control
set numdgt=17
op
print v(1) v(2) v(3) v(4) v(5) v(6) v(7) v(8) v(9) v(10)
print v(11) v(12) v(13) v(14) v(15) v(16) v(17) v(18) v(19)
print i(vs0) i(vs1) i(vs2) i(vs3) i(vs4) i(vs5) i(vs6) i(vs7) i(vs8) i(vs9)
print i(vs10) i(vs11) i(vs12) i(vs13) i(vs14) i(vs15) i(vs16) i(vs17) i(vs18) i(vs19)
print i(vs20) i(vs21) i(vs22) i(vs23) i(vs24) i(vs25) i(vs26) i(vs27) i(vs28) i(vs29)
print i(vs30) i(vs31) i(vs32) i(vs33) i(vs34) i(vs35) i(vs36)
.endc
.end
