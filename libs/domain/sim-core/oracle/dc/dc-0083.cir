controls oracle dc-0083
* Generated (plan F2.7, ADR 0012): do not edit; regenerate with `pnpm sim oracle regen`. dc seed 20261030 index 83 nodes 20 elements 33
.options sparse gmin=1e-12 noopac
RG1 1 0 1000000000000
RG2 2 0 1000000000000
RG3 3 0 1000000000000
RG4 4 0 1000000000000
RG5 5 0 1000000000000
RG6 6 0 1000000000000
RG7 7 0 1000000000000
RG8 8 0 1000000000000
RG9 9 0 1000000000000
RG10 10 0 1000000000000
RG11 11 0 1000000000000
RG12 12 0 1000000000000
RG13 13 0 1000000000000
RG14 14 0 1000000000000
RG15 15 0 1000000000000
RG16 16 0 1000000000000
RG17 17 0 1000000000000
RG18 18 0 1000000000000
RG19 19 0 1000000000000
VS0 17 s0 0
R0 s0 3 39e0
VS1 16 s1 0
R1 s1 17 22e1
VS2 1 s2 0
R2 s2 0 27e1
VS3 9 s3 0
R3 s3 11 10e-2
VS4 18 s4 0
R4 s4 7 18e2
VS5 1 s5 0
R5 s5 8 10e-2
VS6 9 s6 0
R6 s6 0 10e-1
VS7 10 s7 0
R7 s7 13 22e-1
VS8 0 s8 0
V8 e8 s8 DC 39e0
RI8 e8 12 15e-2
VS9 12 s9 0
R9 s9 8 12e1
VS10 9 s10 0
I10 s10 3 DC 33e-3
VS11 16 s11 0
I11 s11 10 DC 47e-1
VS12 13 s12 0
R12 s12 0 27e3
VS13 4 s13 0
R13 s13 13 47e-2
VS14 15 s14 0
V14 e14 s14 DC 27e-1
RI14 e14 18 27e-1
VS15 3 s15 0
V15 e15 s15 DC 47e-1
RI15 e15 13 10e-3
VS16 5 s16 0
I16 s16 3 DC 27e-4
VS17 10 s17 0
I17 s17 12 DC 82e-4
VS18 12 s18 0
R18 s18 18 82e1
VS19 19 s19 0
R19 s19 4 12e3
VS20 1 s20 0
R20 s20 16 68e-2
VS21 12 s21 0
V21 e21 s21 DC 27e1
RI21 e21 4 18e-3
VS22 11 s22 0
I22 s22 8 DC 82e-4
VS23 9 s23 0
R23 s23 16 56e0
VS24 1 s24 0
R24 s24 6 68e1
VS25 5 s25 0
R25 s25 3 82e1
VS26 10 s26 0
I26 s26 8 DC 22e-4
VS27 7 s27 0
R27 s27 3 33e0
VS28 2 s28 0
R28 s28 11 27e2
VS29 13 s29 0
R29 s29 15 15e-1
VS30 14 s30 0
R30 s30 10 12e1
VS31 15 s31 0
I31 s31 12 DC 47e-1
VS32 8 s32 0
R32 s32 7 12e-2
.control
set numdgt=17
op
print v(1) v(2) v(3) v(4) v(5) v(6) v(7) v(8) v(9) v(10)
print v(11) v(12) v(13) v(14) v(15) v(16) v(17) v(18) v(19)
print i(vs0) i(vs1) i(vs2) i(vs3) i(vs4) i(vs5) i(vs6) i(vs7) i(vs8) i(vs9)
print i(vs10) i(vs11) i(vs12) i(vs13) i(vs14) i(vs15) i(vs16) i(vs17) i(vs18) i(vs19)
print i(vs20) i(vs21) i(vs22) i(vs23) i(vs24) i(vs25) i(vs26) i(vs27) i(vs28) i(vs29)
print i(vs30) i(vs31) i(vs32)
.endc
.end
