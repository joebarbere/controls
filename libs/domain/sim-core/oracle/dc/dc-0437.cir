controls oracle dc-0437
* Generated (plan F2.7, ADR 0012): do not edit; regenerate with `pnpm sim oracle regen`. dc seed 20261030 index 437 nodes 23 elements 35
.options sparse gmin=1e-12 noopac
RG1 1 0 1000000000000
RG2 2 0 1000000000000
RG3 3 0 1000000000000
RG4 4 0 1000000000000
RG5 5 0 1000000000000
RG6 6 0 1000000000000
RG7 7 0 1000000000000
RG8 8 0 1000000000000
RG9 9 0 1000000000000
RG10 10 0 1000000000000
RG11 11 0 1000000000000
RG12 12 0 1000000000000
RG13 13 0 1000000000000
RG14 14 0 1000000000000
RG15 15 0 1000000000000
RG16 16 0 1000000000000
RG17 17 0 1000000000000
RG18 18 0 1000000000000
RG19 19 0 1000000000000
RG20 20 0 1000000000000
RG21 21 0 1000000000000
RG22 22 0 1000000000000
VS0 21 s0 0
R0 s0 7 68e2
VS1 0 s1 0
V1 e1 s1 DC 27e-1
RI1 e1 19 12e-3
VS2 6 s2 0
R2 s2 7 22e2
VS3 15 s3 0
R3 s3 14 82e2
VS4 8 s4 0
R4 s4 21 27e2
VS5 7 s5 0
R5 s5 0 10e1
VS6 16 s6 0
R6 s6 20 47e-2
VS7 3 s7 0
R7 s7 4 22e0
VS8 10 s8 0
R8 s8 17 56e3
VS9 5 s9 0
R9 s9 4 12e1
VS10 16 s10 0
I10 s10 11 DC 47e-4
VS11 22 s11 0
V11 e11 s11 DC 68e0
RI11 e11 12 68e-3
VS12 3 s12 0
I12 s12 9 DC 39e-1
VS13 14 s13 0
R13 s13 13 39e-1
VS14 15 s14 0
I14 s14 14 DC 39e-4
VS15 2 s15 0
R15 s15 22 18e3
VS16 14 s16 0
R16 s16 7 68e1
VS17 9 s17 0
I17 s17 1 DC 68e-2
VS18 19 s18 0
R18 s18 7 10e0
VS19 12 s19 0
I19 s19 8 DC 68e-1
VS20 9 s20 0
R20 s20 17 56e-1
VS21 11 s21 0
R21 s21 16 33e2
VS22 16 s22 0
R22 s22 0 82e2
VS23 5 s23 0
V23 e23 s23 DC 10e1
RI23 e23 9 82e-3
VS24 15 s24 0
V24 e24 s24 DC 56e0
RI24 e24 17 56e-1
VS25 2 s25 0
R25 s25 9 56e-1
VS26 7 s26 0
R26 s26 3 27e0
VS27 9 s27 0
R27 s27 20 15e3
VS28 4 s28 0
R28 s28 1 18e-2
VS29 7 s29 0
I29 s29 20 DC 15e-4
VS30 18 s30 0
R30 s30 3 56e3
VS31 19 s31 0
R31 s31 21 33e-1
VS32 12 s32 0
R32 s32 18 56e0
VS33 7 s33 0
I33 s33 12 DC 22e-2
VS34 15 s34 0
R34 s34 22 18e0
.control
set numdgt=17
op
print v(1) v(2) v(3) v(4) v(5) v(6) v(7) v(8) v(9) v(10)
print v(11) v(12) v(13) v(14) v(15) v(16) v(17) v(18) v(19) v(20)
print v(21) v(22)
print i(vs0) i(vs1) i(vs2) i(vs3) i(vs4) i(vs5) i(vs6) i(vs7) i(vs8) i(vs9)
print i(vs10) i(vs11) i(vs12) i(vs13) i(vs14) i(vs15) i(vs16) i(vs17) i(vs18) i(vs19)
print i(vs20) i(vs21) i(vs22) i(vs23) i(vs24) i(vs25) i(vs26) i(vs27) i(vs28) i(vs29)
print i(vs30) i(vs31) i(vs32) i(vs33) i(vs34)
.endc
.end
