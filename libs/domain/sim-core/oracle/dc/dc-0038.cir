controls oracle dc-0038
* Generated (plan F2.7, ADR 0012): do not edit; regenerate with `pnpm sim oracle regen`. dc seed 20261030 index 38 nodes 28 elements 42
.options sparse gmin=1e-12 noopac
RG1 1 0 1000000000000
RG2 2 0 1000000000000
RG3 3 0 1000000000000
RG4 4 0 1000000000000
RG5 5 0 1000000000000
RG6 6 0 1000000000000
RG7 7 0 1000000000000
RG8 8 0 1000000000000
RG9 9 0 1000000000000
RG10 10 0 1000000000000
RG11 11 0 1000000000000
RG12 12 0 1000000000000
RG13 13 0 1000000000000
RG14 14 0 1000000000000
RG15 15 0 1000000000000
RG16 16 0 1000000000000
RG17 17 0 1000000000000
RG18 18 0 1000000000000
RG19 19 0 1000000000000
RG20 20 0 1000000000000
RG21 21 0 1000000000000
RG22 22 0 1000000000000
RG23 23 0 1000000000000
RG24 24 0 1000000000000
RG25 25 0 1000000000000
RG26 26 0 1000000000000
RG27 27 0 1000000000000
VS0 0 s0 0
V0 e0 s0 DC 27e1
RI0 e0 18 33e-3
VS1 22 s1 0
V1 e1 s1 DC 27e1
RI1 e1 3 12e-1
VS2 16 s2 0
R2 s2 21 18e-2
VS3 18 s3 0
R3 s3 24 47e0
VS4 6 s4 0
R4 s4 2 22e3
VS5 13 s5 0
R5 s5 24 82e-2
VS6 26 s6 0
R6 s6 13 27e2
VS7 18 s7 0
R7 s7 19 22e0
VS8 12 s8 0
R8 s8 2 27e1
VS9 15 s9 0
I9 s9 14 DC 12e-2
VS10 27 s10 0
R10 s10 15 82e-2
VS11 27 s11 0
R11 s11 12 12e0
VS12 14 s12 0
R12 s12 26 33e2
VS13 20 s13 0
V13 e13 s13 DC 68e-1
RI13 e13 18 39e-3
VS14 23 s14 0
R14 s14 15 56e2
VS15 4 s15 0
V15 e15 s15 DC 82e-1
RI15 e15 22 12e-3
VS16 12 s16 0
I16 s16 25 DC 27e-1
VS17 20 s17 0
R17 s17 6 10e1
VS18 23 s18 0
R18 s18 7 10e-1
VS19 26 s19 0
I19 s19 6 DC 39e-1
VS20 25 s20 0
R20 s20 18 56e0
VS21 1 s21 0
I21 s21 24 DC 39e-2
VS22 2 s22 0
R22 s22 12 47e-2
VS23 18 s23 0
I23 s23 21 DC 15e-2
VS24 19 s24 0
R24 s24 21 39e2
VS25 11 s25 0
R25 s25 8 27e-1
VS26 1 s26 0
R26 s26 24 39e1
VS27 18 s27 0
R27 s27 26 82e0
VS28 17 s28 0
R28 s28 2 33e-2
VS29 0 s29 0
R29 s29 22 12e-2
VS30 0 s30 0
R30 s30 24 10e-1
VS31 10 s31 0
R31 s31 2 27e-2
VS32 19 s32 0
R32 s32 5 22e-1
VS33 4 s33 0
R33 s33 2 10e3
VS34 10 s34 0
V34 e34 s34 DC 82e-1
RI34 e34 26 56e-2
VS35 10 s35 0
R35 s35 14 12e3
VS36 6 s36 0
V36 e36 s36 DC 10e0
RI36 e36 5 15e-1
VS37 14 s37 0
R37 s37 15 47e-1
VS38 5 s38 0
R38 s38 17 68e2
VS39 25 s39 0
R39 s39 7 68e2
VS40 8 s40 0
R40 s40 17 12e0
VS41 9 s41 0
V41 e41 s41 DC 22e0
RI41 e41 23 68e-2
.control
set numdgt=17
op
print v(1) v(2) v(3) v(4) v(5) v(6) v(7) v(8) v(9) v(10)
print v(11) v(12) v(13) v(14) v(15) v(16) v(17) v(18) v(19) v(20)
print v(21) v(22) v(23) v(24) v(25) v(26) v(27)
print i(vs0) i(vs1) i(vs2) i(vs3) i(vs4) i(vs5) i(vs6) i(vs7) i(vs8) i(vs9)
print i(vs10) i(vs11) i(vs12) i(vs13) i(vs14) i(vs15) i(vs16) i(vs17) i(vs18) i(vs19)
print i(vs20) i(vs21) i(vs22) i(vs23) i(vs24) i(vs25) i(vs26) i(vs27) i(vs28) i(vs29)
print i(vs30) i(vs31) i(vs32) i(vs33) i(vs34) i(vs35) i(vs36) i(vs37) i(vs38) i(vs39)
print i(vs40) i(vs41)
.endc
.end
