controls oracle dc-0354
* Generated (plan F2.7, ADR 0012): do not edit; regenerate with `pnpm sim oracle regen`. dc seed 20261030 index 354 nodes 3 elements 4
.options sparse gmin=1e-12 noopac
RG1 1 0 1000000000000
RG2 2 0 1000000000000
VS0 1 s0 0
I0 s0 2 DC 12e-4
VS1 2 s1 0
R1 s1 1 68e-1
VS2 0 s2 0
R2 s2 2 18e0
VS3 0 s3 0
V3 e3 s3 DC 68e-1
RI3 e3 2 18e-2
.control
set numdgt=17
op
print v(1) v(2)
print i(vs0) i(vs1) i(vs2) i(vs3)
.endc
.end
