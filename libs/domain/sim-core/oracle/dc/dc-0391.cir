controls oracle dc-0391
* Generated (plan F2.7, ADR 0012): do not edit; regenerate with `pnpm sim oracle regen`. dc seed 20261030 index 391 nodes 30 elements 44
.options sparse gmin=1e-12 noopac
RG1 1 0 1000000000000
RG2 2 0 1000000000000
RG3 3 0 1000000000000
RG4 4 0 1000000000000
RG5 5 0 1000000000000
RG6 6 0 1000000000000
RG7 7 0 1000000000000
RG8 8 0 1000000000000
RG9 9 0 1000000000000
RG10 10 0 1000000000000
RG11 11 0 1000000000000
RG12 12 0 1000000000000
RG13 13 0 1000000000000
RG14 14 0 1000000000000
RG15 15 0 1000000000000
RG16 16 0 1000000000000
RG17 17 0 1000000000000
RG18 18 0 1000000000000
RG19 19 0 1000000000000
RG20 20 0 1000000000000
RG21 21 0 1000000000000
RG22 22 0 1000000000000
RG23 23 0 1000000000000
RG24 24 0 1000000000000
RG25 25 0 1000000000000
RG26 26 0 1000000000000
RG27 27 0 1000000000000
RG28 28 0 1000000000000
RG29 29 0 1000000000000
VS0 0 s0 0
V0 e0 s0 DC 56e-1
RI0 e0 14 82e-2
VS1 26 s1 0
R1 s1 18 15e0
VS2 21 s2 0
R2 s2 26 22e-2
VS3 13 s3 0
V3 e3 s3 DC 47e0
RI3 e3 24 27e-1
VS4 15 s4 0
R4 s4 21 39e-2
VS5 1 s5 0
V5 e5 s5 DC 10e-1
RI5 e5 21 27e-2
VS6 18 s6 0
R6 s6 8 10e-1
VS7 12 s7 0
R7 s7 6 22e0
VS8 5 s8 0
V8 e8 s8 DC 18e0
RI8 e8 7 47e-1
VS9 11 s9 0
R9 s9 18 33e-2
VS10 17 s10 0
R10 s10 2 39e3
VS11 18 s11 0
V11 e11 s11 DC 15e0
RI11 e11 4 12e-3
VS12 17 s12 0
R12 s12 3 18e-2
VS13 29 s13 0
I13 s13 10 DC 33e-2
VS14 17 s14 0
R14 s14 10 10e2
VS15 27 s15 0
V15 e15 s15 DC 22e0
RI15 e15 15 82e-3
VS16 29 s16 0
R16 s16 2 18e0
VS17 22 s17 0
R17 s17 25 47e1
VS18 12 s18 0
V18 e18 s18 DC 10e0
RI18 e18 19 12e-2
VS19 19 s19 0
R19 s19 14 15e-1
VS20 19 s20 0
V20 e20 s20 DC 12e1
RI20 e20 4 15e-3
VS21 10 s21 0
R21 s21 11 12e0
VS22 1 s22 0
R22 s22 14 15e-2
VS23 26 s23 0
R23 s23 22 56e0
VS24 9 s24 0
R24 s24 5 22e0
VS25 9 s25 0
V25 e25 s25 DC 15e1
RI25 e25 7 39e-1
VS26 28 s26 0
R26 s26 29 10e-1
VS27 10 s27 0
V27 e27 s27 DC 22e0
RI27 e27 20 47e-2
VS28 11 s28 0
R28 s28 24 68e-2
VS29 16 s29 0
R29 s29 22 39e1
VS30 19 s30 0
V30 e30 s30 DC 10e1
RI30 e30 6 33e-2
VS31 3 s31 0
R31 s31 29 15e-1
VS32 14 s32 0
R32 s32 26 56e-2
VS33 27 s33 0
R33 s33 21 33e3
VS34 9 s34 0
R34 s34 17 18e2
VS35 14 s35 0
R35 s35 3 56e1
VS36 21 s36 0
R36 s36 25 12e3
VS37 22 s37 0
R37 s37 13 10e2
VS38 8 s38 0
R38 s38 6 56e-1
VS39 5 s39 0
V39 e39 s39 DC 68e-1
RI39 e39 23 10e-3
VS40 28 s40 0
R40 s40 16 39e0
VS41 10 s41 0
R41 s41 0 56e0
VS42 20 s42 0
R42 s42 18 18e2
VS43 23 s43 0
V43 e43 s43 DC 39e1
RI43 e43 27 10e-1
.control
set numdgt=17
op
print v(1) v(2) v(3) v(4) v(5) v(6) v(7) v(8) v(9) v(10)
print v(11) v(12) v(13) v(14) v(15) v(16) v(17) v(18) v(19) v(20)
print v(21) v(22) v(23) v(24) v(25) v(26) v(27) v(28) v(29)
print i(vs0) i(vs1) i(vs2) i(vs3) i(vs4) i(vs5) i(vs6) i(vs7) i(vs8) i(vs9)
print i(vs10) i(vs11) i(vs12) i(vs13) i(vs14) i(vs15) i(vs16) i(vs17) i(vs18) i(vs19)
print i(vs20) i(vs21) i(vs22) i(vs23) i(vs24) i(vs25) i(vs26) i(vs27) i(vs28) i(vs29)
print i(vs30) i(vs31) i(vs32) i(vs33) i(vs34) i(vs35) i(vs36) i(vs37) i(vs38) i(vs39)
print i(vs40) i(vs41) i(vs42) i(vs43)
.endc
.end
