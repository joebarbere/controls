controls oracle dc-0391
* Generated (plan F2.7, ADR 0012): do not edit; regenerate with `pnpm sim oracle regen`. dc seed 20261030 index 391 nodes 30 elements 30
.options sparse gmin=1e-12 noopac
RG1 1 0 1000000000000
RG2 2 0 1000000000000
RG3 3 0 1000000000000
RG4 4 0 1000000000000
RG5 5 0 1000000000000
RG6 6 0 1000000000000
RG7 7 0 1000000000000
RG8 8 0 1000000000000
RG9 9 0 1000000000000
RG10 10 0 1000000000000
RG11 11 0 1000000000000
RG12 12 0 1000000000000
RG13 13 0 1000000000000
RG14 14 0 1000000000000
RG15 15 0 1000000000000
RG16 16 0 1000000000000
RG17 17 0 1000000000000
RG18 18 0 1000000000000
RG19 19 0 1000000000000
RG20 20 0 1000000000000
RG21 21 0 1000000000000
RG22 22 0 1000000000000
RG23 23 0 1000000000000
RG24 24 0 1000000000000
RG25 25 0 1000000000000
RG26 26 0 1000000000000
RG27 27 0 1000000000000
RG28 28 0 1000000000000
RG29 29 0 1000000000000
VS0 15 s0 0
R0 s0 21 39e-2
VS1 11 s1 0
R1 s1 18 33e-2
VS2 29 s2 0
R2 s2 2 18e0
VS3 21 s3 0
R3 s3 25 12e3
VS4 20 s4 0
R4 s4 18 18e2
VS5 0 s5 0
V5 e5 s5 DC 68e-1
RI5 e5 23 10e-3
VS6 29 s6 0
I6 s6 10 DC 33e-2
VS7 17 s7 0
R7 s7 10 10e2
VS8 18 s8 0
V8 e8 s8 DC 15e0
RI8 e8 4 12e-3
VS9 28 s9 0
R9 s9 16 39e0
VS10 1 s10 0
R10 s10 5 15e-2
VS11 9 s11 0
R11 s11 17 18e2
VS12 8 s12 0
R12 s12 6 56e-1
VS13 9 s13 0
R13 s13 0 22e0
VS14 22 s14 0
R14 s14 13 10e2
VS15 13 s15 0
V15 e15 s15 DC 47e0
RI15 e15 24 27e-1
VS16 16 s16 0
R16 s16 22 39e1
VS17 19 s17 0
V17 e17 s17 DC 10e1
RI17 e17 6 33e-2
VS18 26 s18 0
R18 s18 18 15e0
VS19 26 s19 0
R19 s19 22 56e0
VS20 17 s20 0
R20 s20 3 18e-2
VS21 27 s21 0
R21 s21 21 33e3
VS22 12 s22 0
R22 s22 6 22e0
VS23 5 s23 0
R23 s23 26 56e-2
VS24 3 s24 0
R24 s24 29 15e-1
VS25 19 s25 0
R25 s25 5 15e-1
VS26 9 s26 0
V26 e26 s26 DC 15e1
RI26 e26 7 39e-1
VS27 10 s27 0
R27 s27 14 56e0
VS28 5 s28 0
R28 s28 3 56e1
VS29 21 s29 0
R29 s29 26 22e-2
.control
set numdgt=17
op
print v(1) v(2) v(3) v(4) v(5) v(6) v(7) v(8) v(9) v(10)
print v(11) v(12) v(13) v(14) v(15) v(16) v(17) v(18) v(19) v(20)
print v(21) v(22) v(23) v(24) v(25) v(26) v(27) v(28) v(29)
print i(vs0) i(vs1) i(vs2) i(vs3) i(vs4) i(vs5) i(vs6) i(vs7) i(vs8) i(vs9)
print i(vs10) i(vs11) i(vs12) i(vs13) i(vs14) i(vs15) i(vs16) i(vs17) i(vs18) i(vs19)
print i(vs20) i(vs21) i(vs22) i(vs23) i(vs24) i(vs25) i(vs26) i(vs27) i(vs28) i(vs29)
.endc
.end
