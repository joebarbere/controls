controls oracle dc-0084
* Generated (plan F2.7, ADR 0012): do not edit; regenerate with `pnpm sim oracle regen`. dc seed 20261030 index 84 nodes 5 elements 5
.options sparse gmin=1e-12 noopac
RG1 1 0 1000000000000
RG2 2 0 1000000000000
RG3 3 0 1000000000000
RG4 4 0 1000000000000
VS0 0 s0 0
V0 e0 s0 DC 18e1
RI0 e0 1 56e-3
VS1 2 s1 0
V1 e1 s1 DC 22e0
RI1 e1 0 15e-3
VS2 0 s2 0
R2 s2 3 15e3
VS3 0 s3 0
V3 e3 s3 DC 47e1
RI3 e3 1 18e-3
VS4 0 s4 0
R4 s4 4 47e-2
.control
set numdgt=17
op
print v(1) v(2) v(3) v(4)
print i(vs0) i(vs1) i(vs2) i(vs3) i(vs4)
.endc
.end
