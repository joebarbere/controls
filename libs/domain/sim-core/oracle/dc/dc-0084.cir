controls oracle dc-0084
* Generated (plan F2.7, ADR 0012): do not edit; regenerate with `pnpm sim oracle regen`. dc seed 20261030 index 84 nodes 5 elements 8
.options sparse gmin=1e-12 noopac
RG1 1 0 1000000000000
RG2 2 0 1000000000000
RG3 3 0 1000000000000
RG4 4 0 1000000000000
VS0 3 s0 0
R0 s0 2 33e0
VS1 4 s1 0
R1 s1 3 39e0
VS2 0 s2 0
V2 e2 s2 DC 18e1
RI2 e2 1 56e-3
VS3 0 s3 0
R3 s3 3 15e3
VS4 0 s4 0
V4 e4 s4 DC 47e1
RI4 e4 1 18e-3
VS5 3 s5 0
R5 s5 1 27e0
VS6 2 s6 0
V6 e6 s6 DC 22e0
RI6 e6 0 15e-3
VS7 0 s7 0
R7 s7 4 47e-2
.control
set numdgt=17
op
print v(1) v(2) v(3) v(4)
print i(vs0) i(vs1) i(vs2) i(vs3) i(vs4) i(vs5) i(vs6) i(vs7)
.endc
.end
