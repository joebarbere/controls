controls oracle dc-0385
* Generated (plan F2.7, ADR 0012): do not edit; regenerate with `pnpm sim oracle regen`. dc seed 20261030 index 385 nodes 15 elements 26
.options sparse gmin=1e-12 noopac
RG1 1 0 1000000000000
RG2 2 0 1000000000000
RG3 3 0 1000000000000
RG4 4 0 1000000000000
RG5 5 0 1000000000000
RG6 6 0 1000000000000
RG7 7 0 1000000000000
RG8 8 0 1000000000000
RG9 9 0 1000000000000
RG10 10 0 1000000000000
RG11 11 0 1000000000000
RG12 12 0 1000000000000
RG13 13 0 1000000000000
RG14 14 0 1000000000000
VS0 11 s0 0
R0 s0 0 68e0
VS1 11 s1 0
R1 s1 14 10e1
VS2 4 s2 0
R2 s2 0 68e0
VS3 1 s3 0
R3 s3 12 12e-1
VS4 10 s4 0
I4 s4 2 DC 33e-3
VS5 0 s5 0
R5 s5 8 18e0
VS6 13 s6 0
R6 s6 7 56e-1
VS7 0 s7 0
R7 s7 3 15e3
VS8 14 s8 0
R8 s8 8 15e-1
VS9 0 s9 0
V9 e9 s9 DC 33e1
RI9 e9 5 39e-3
VS10 2 s10 0
V10 e10 s10 DC 15e-1
RI10 e10 6 15e-3
VS11 6 s11 0
R11 s11 7 68e2
VS12 9 s12 0
R12 s12 12 18e0
VS13 3 s13 0
R13 s13 2 56e2
VS14 4 s14 0
R14 s14 10 12e2
VS15 0 s15 0
R15 s15 13 10e3
VS16 2 s16 0
R16 s16 12 47e2
VS17 11 s17 0
R17 s17 10 33e2
VS18 6 s18 0
I18 s18 10 DC 15e-4
VS19 3 s19 0
R19 s19 9 33e0
VS20 3 s20 0
I20 s20 14 DC 18e-3
VS21 11 s21 0
R21 s21 8 22e-1
VS22 14 s22 0
R22 s22 4 39e2
VS23 7 s23 0
R23 s23 0 47e3
VS24 8 s24 0
R24 s24 4 18e-1
VS25 1 s25 0
V25 e25 s25 DC 82e-1
RI25 e25 4 33e-1
.control
set numdgt=17
op
print v(1) v(2) v(3) v(4) v(5) v(6) v(7) v(8) v(9) v(10)
print v(11) v(12) v(13) v(14)
print i(vs0) i(vs1) i(vs2) i(vs3) i(vs4) i(vs5) i(vs6) i(vs7) i(vs8) i(vs9)
print i(vs10) i(vs11) i(vs12) i(vs13) i(vs14) i(vs15) i(vs16) i(vs17) i(vs18) i(vs19)
print i(vs20) i(vs21) i(vs22) i(vs23) i(vs24) i(vs25)
.endc
.end
