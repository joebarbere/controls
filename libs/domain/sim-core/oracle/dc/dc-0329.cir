controls oracle dc-0329
* Generated (plan F2.7, ADR 0012): do not edit; regenerate with `pnpm sim oracle regen`. dc seed 20261030 index 329 nodes 21 elements 29
.options sparse gmin=1e-12 noopac
RG1 1 0 1000000000000
RG2 2 0 1000000000000
RG3 3 0 1000000000000
RG4 4 0 1000000000000
RG5 5 0 1000000000000
RG6 6 0 1000000000000
RG7 7 0 1000000000000
RG8 8 0 1000000000000
RG9 9 0 1000000000000
RG10 10 0 1000000000000
RG11 11 0 1000000000000
RG12 12 0 1000000000000
RG13 13 0 1000000000000
RG14 14 0 1000000000000
RG15 15 0 1000000000000
RG16 16 0 1000000000000
RG17 17 0 1000000000000
RG18 18 0 1000000000000
RG19 19 0 1000000000000
RG20 20 0 1000000000000
VS0 10 s0 0
R0 s0 13 22e0
VS1 4 s1 0
R1 s1 3 10e-2
VS2 19 s2 0
R2 s2 10 10e-1
VS3 20 s3 0
R3 s3 15 27e-2
VS4 0 s4 0
R4 s4 13 22e3
VS5 5 s5 0
R5 s5 2 82e0
VS6 13 s6 0
R6 s6 9 22e0
VS7 8 s7 0
R7 s7 19 18e2
VS8 0 s8 0
V8 e8 s8 DC 27e0
RI8 e8 1 47e-2
VS9 16 s9 0
R9 s9 20 22e-2
VS10 17 s10 0
V10 e10 s10 DC 12e0
RI10 e10 11 68e-3
VS11 2 s11 0
R11 s11 1 47e2
VS12 19 s12 0
V12 e12 s12 DC 47e0
RI12 e12 6 22e-1
VS13 15 s13 0
R13 s13 1 15e0
VS14 11 s14 0
R14 s14 1 18e0
VS15 3 s15 0
V15 e15 s15 DC 10e-1
RI15 e15 0 33e-1
VS16 16 s16 0
R16 s16 1 82e0
VS17 14 s17 0
R17 s17 7 15e3
VS18 8 s18 0
R18 s18 16 39e-1
VS19 18 s19 0
R19 s19 13 12e1
VS20 10 s20 0
R20 s20 16 10e-2
VS21 2 s21 0
R21 s21 14 22e-2
VS22 12 s22 0
R22 s22 3 18e2
VS23 4 s23 0
R23 s23 5 18e3
VS24 6 s24 0
R24 s24 16 82e-2
VS25 7 s25 0
V25 e25 s25 DC 18e0
RI25 e25 17 27e-1
VS26 12 s26 0
R26 s26 18 15e-2
VS27 16 s27 0
R27 s27 9 68e0
VS28 11 s28 0
R28 s28 12 10e1
.control
set numdgt=17
op
print v(1) v(2) v(3) v(4) v(5) v(6) v(7) v(8) v(9) v(10)
print v(11) v(12) v(13) v(14) v(15) v(16) v(17) v(18) v(19) v(20)
print i(vs0) i(vs1) i(vs2) i(vs3) i(vs4) i(vs5) i(vs6) i(vs7) i(vs8) i(vs9)
print i(vs10) i(vs11) i(vs12) i(vs13) i(vs14) i(vs15) i(vs16) i(vs17) i(vs18) i(vs19)
print i(vs20) i(vs21) i(vs22) i(vs23) i(vs24) i(vs25) i(vs26) i(vs27) i(vs28)
.endc
.end
