controls oracle dc-0329
* Generated (plan F2.7, ADR 0012): do not edit; regenerate with `pnpm sim oracle regen`. dc seed 20261030 index 329 nodes 21 elements 21
.options sparse gmin=1e-12 noopac
RG1 1 0 1000000000000
RG2 2 0 1000000000000
RG3 3 0 1000000000000
RG4 4 0 1000000000000
RG5 5 0 1000000000000
RG6 6 0 1000000000000
RG7 7 0 1000000000000
RG8 8 0 1000000000000
RG9 9 0 1000000000000
RG10 10 0 1000000000000
RG11 11 0 1000000000000
RG12 12 0 1000000000000
RG13 13 0 1000000000000
RG14 14 0 1000000000000
RG15 15 0 1000000000000
RG16 16 0 1000000000000
RG17 17 0 1000000000000
RG18 18 0 1000000000000
RG19 19 0 1000000000000
RG20 20 0 1000000000000
VS0 15 s0 0
R0 s0 1 15e0
VS1 2 s1 0
R1 s1 14 22e-2
VS2 16 s2 0
R2 s2 1 82e0
VS3 0 s3 0
V3 e3 s3 DC 27e0
RI3 e3 1 47e-2
VS4 19 s4 0
R4 s4 10 10e-1
VS5 13 s5 0
R5 s5 9 22e0
VS6 0 s6 0
R6 s6 13 22e3
VS7 18 s7 0
R7 s7 13 12e1
VS8 6 s8 0
R8 s8 16 82e-2
VS9 3 s9 0
V9 e9 s9 DC 10e-1
RI9 e9 0 33e-1
VS10 12 s10 0
R10 s10 3 18e2
VS11 8 s11 0
R11 s11 16 39e-1
VS12 14 s12 0
R12 s12 7 15e3
VS13 17 s13 0
V13 e13 s13 DC 12e0
RI13 e13 11 68e-3
VS14 16 s14 0
R14 s14 20 22e-2
VS15 10 s15 0
R15 s15 16 10e-2
VS16 11 s16 0
R16 s16 1 18e0
VS17 0 s17 0
R17 s17 1 39e3
VS18 4 s18 0
R18 s18 3 10e-2
VS19 5 s19 0
R19 s19 2 82e0
VS20 2 s20 0
R20 s20 1 47e2
.control
set numdgt=17
op
print v(1) v(2) v(3) v(4) v(5) v(6) v(7) v(8) v(9) v(10)
print v(11) v(12) v(13) v(14) v(15) v(16) v(17) v(18) v(19) v(20)
print i(vs0) i(vs1) i(vs2) i(vs3) i(vs4) i(vs5) i(vs6) i(vs7) i(vs8) i(vs9)
print i(vs10) i(vs11) i(vs12) i(vs13) i(vs14) i(vs15) i(vs16) i(vs17) i(vs18) i(vs19)
print i(vs20)
.endc
.end
