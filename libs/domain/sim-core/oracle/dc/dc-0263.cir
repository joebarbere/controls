controls oracle dc-0263
* Generated (plan F2.7, ADR 0012): do not edit; regenerate with `pnpm sim oracle regen`. dc seed 20261030 index 263 nodes 23 elements 34
.options sparse gmin=1e-12 noopac
RG1 1 0 1000000000000
RG2 2 0 1000000000000
RG3 3 0 1000000000000
RG4 4 0 1000000000000
RG5 5 0 1000000000000
RG6 6 0 1000000000000
RG7 7 0 1000000000000
RG8 8 0 1000000000000
RG9 9 0 1000000000000
RG10 10 0 1000000000000
RG11 11 0 1000000000000
RG12 12 0 1000000000000
RG13 13 0 1000000000000
RG14 14 0 1000000000000
RG15 15 0 1000000000000
RG16 16 0 1000000000000
RG17 17 0 1000000000000
RG18 18 0 1000000000000
RG19 19 0 1000000000000
RG20 20 0 1000000000000
RG21 21 0 1000000000000
RG22 22 0 1000000000000
VS0 14 s0 0
R0 s0 10 33e2
VS1 0 s1 0
V1 e1 s1 DC 33e0
RI1 e1 5 15e-1
VS2 2 s2 0
V2 e2 s2 DC 68e1
RI2 e2 22 33e-3
VS3 19 s3 0
R3 s3 14 68e0
VS4 21 s4 0
R4 s4 0 12e3
VS5 5 s5 0
R5 s5 10 18e-1
VS6 20 s6 0
R6 s6 16 47e2
VS7 3 s7 0
V7 e7 s7 DC 22e-1
RI7 e7 19 68e-3
VS8 8 s8 0
R8 s8 6 82e-1
VS9 19 s9 0
R9 s9 11 68e2
VS10 20 s10 0
R10 s10 10 39e-2
VS11 17 s11 0
R11 s11 5 82e2
VS12 1 s12 0
R12 s12 0 10e3
VS13 2 s13 0
R13 s13 20 15e1
VS14 17 s14 0
R14 s14 3 68e1
VS15 0 s15 0
V15 e15 s15 DC 33e-1
RI15 e15 15 56e-3
VS16 18 s16 0
R16 s16 4 33e1
VS17 13 s17 0
R17 s17 17 56e3
VS18 16 s18 0
R18 s18 13 68e-2
VS19 5 s19 0
R19 s19 12 27e3
VS20 21 s20 0
I20 s20 16 DC 15e-2
VS21 11 s21 0
R21 s21 1 18e1
VS22 9 s22 0
R22 s22 13 39e2
VS23 17 s23 0
R23 s23 15 15e-1
VS24 7 s24 0
R24 s24 10 22e0
VS25 3 s25 0
R25 s25 8 47e3
VS26 10 s26 0
R26 s26 5 56e2
VS27 12 s27 0
R27 s27 21 18e0
VS28 7 s28 0
R28 s28 3 15e-2
VS29 10 s29 0
R29 s29 13 82e3
VS30 10 s30 0
R30 s30 4 12e-1
VS31 22 s31 0
R31 s31 10 18e3
VS32 9 s32 0
R32 s32 18 56e1
VS33 10 s33 0
R33 s33 6 68e3
.control
set numdgt=17
op
print v(1) v(2) v(3) v(4) v(5) v(6) v(7) v(8) v(9) v(10)
print v(11) v(12) v(13) v(14) v(15) v(16) v(17) v(18) v(19) v(20)
print v(21) v(22)
print i(vs0) i(vs1) i(vs2) i(vs3) i(vs4) i(vs5) i(vs6) i(vs7) i(vs8) i(vs9)
print i(vs10) i(vs11) i(vs12) i(vs13) i(vs14) i(vs15) i(vs16) i(vs17) i(vs18) i(vs19)
print i(vs20) i(vs21) i(vs22) i(vs23) i(vs24) i(vs25) i(vs26) i(vs27) i(vs28) i(vs29)
print i(vs30) i(vs31) i(vs32) i(vs33)
.endc
.end
