controls oracle dc-0164
* Generated (plan F2.7, ADR 0012): do not edit; regenerate with `pnpm sim oracle regen`. dc seed 20261030 index 164 nodes 4 elements 5
.options sparse gmin=1e-12 noopac
RG1 1 0 1000000000000
RG2 2 0 1000000000000
RG3 3 0 1000000000000
VS0 0 s0 0
R0 s0 3 27e2
VS1 0 s1 0
V1 e1 s1 DC 47e-1
RI1 e1 1 22e-1
VS2 2 s2 0
R2 s2 3 68e2
VS3 1 s3 0
V3 e3 s3 DC 18e1
RI3 e3 2 27e-2
VS4 1 s4 0
R4 s4 2 10e-2
.control
set numdgt=17
op
print v(1) v(2) v(3)
print i(vs0) i(vs1) i(vs2) i(vs3) i(vs4)
.endc
.end
