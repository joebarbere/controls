controls oracle dc-0298
* Generated (plan F2.7, ADR 0012): do not edit; regenerate with `pnpm sim oracle regen`. dc seed 20261030 index 298 nodes 21 elements 36
.options sparse gmin=1e-12 noopac
RG1 1 0 1000000000000
RG2 2 0 1000000000000
RG3 3 0 1000000000000
RG4 4 0 1000000000000
RG5 5 0 1000000000000
RG6 6 0 1000000000000
RG7 7 0 1000000000000
RG8 8 0 1000000000000
RG9 9 0 1000000000000
RG10 10 0 1000000000000
RG11 11 0 1000000000000
RG12 12 0 1000000000000
RG13 13 0 1000000000000
RG14 14 0 1000000000000
RG15 15 0 1000000000000
RG16 16 0 1000000000000
RG17 17 0 1000000000000
RG18 18 0 1000000000000
RG19 19 0 1000000000000
RG20 20 0 1000000000000
VS0 2 s0 0
R0 s0 18 15e3
VS1 20 s1 0
R1 s1 12 22e3
VS2 18 s2 0
R2 s2 3 47e-1
VS3 19 s3 0
R3 s3 10 39e-1
VS4 20 s4 0
R4 s4 16 12e2
VS5 13 s5 0
R5 s5 6 27e1
VS6 11 s6 0
R6 s6 3 47e-1
VS7 0 s7 0
V7 e7 s7 DC 15e0
RI7 e7 3 47e-3
VS8 9 s8 0
R8 s8 3 33e-2
VS9 0 s9 0
V9 e9 s9 DC 15e-1
RI9 e9 20 47e-1
VS10 2 s10 0
I10 s10 13 DC 33e-4
VS11 14 s11 0
I11 s11 1 DC 56e-3
VS12 18 s12 0
R12 s12 10 22e3
VS13 4 s13 0
V13 e13 s13 DC 10e0
RI13 e13 7 33e-1
VS14 7 s14 0
V14 e14 s14 DC 56e0
RI14 e14 6 82e-3
VS15 20 s15 0
R15 s15 3 12e0
VS16 9 s16 0
R16 s16 16 18e2
VS17 13 s17 0
R17 s17 10 47e2
VS18 15 s18 0
R18 s18 9 33e3
VS19 20 s19 0
V19 e19 s19 DC 10e1
RI19 e19 12 56e-1
VS20 1 s20 0
R20 s20 17 22e1
VS21 12 s21 0
R21 s21 18 15e0
VS22 7 s22 0
R22 s22 1 56e3
VS23 12 s23 0
R23 s23 14 10e3
VS24 14 s24 0
R24 s24 18 33e-1
VS25 20 s25 0
I25 s25 3 DC 15e-4
VS26 4 s26 0
R26 s26 8 56e-2
VS27 18 s27 0
I27 s27 5 DC 10e-2
VS28 9 s28 0
V28 e28 s28 DC 12e-1
RI28 e28 15 27e-1
VS29 19 s29 0
V29 e29 s29 DC 12e0
RI29 e29 1 33e-2
VS30 14 s30 0
V30 e30 s30 DC 39e0
RI30 e30 5 12e-2
VS31 15 s31 0
V31 e31 s31 DC 82e0
RI31 e31 20 12e-2
VS32 16 s32 0
R32 s32 17 15e-2
VS33 2 s33 0
R33 s33 7 12e2
VS34 5 s34 0
R34 s34 11 15e-1
VS35 13 s35 0
R35 s35 8 82e0
.control
set numdgt=17
op
print v(1) v(2) v(3) v(4) v(5) v(6) v(7) v(8) v(9) v(10)
print v(11) v(12) v(13) v(14) v(15) v(16) v(17) v(18) v(19) v(20)
print i(vs0) i(vs1) i(vs2) i(vs3) i(vs4) i(vs5) i(vs6) i(vs7) i(vs8) i(vs9)
print i(vs10) i(vs11) i(vs12) i(vs13) i(vs14) i(vs15) i(vs16) i(vs17) i(vs18) i(vs19)
print i(vs20) i(vs21) i(vs22) i(vs23) i(vs24) i(vs25) i(vs26) i(vs27) i(vs28) i(vs29)
print i(vs30) i(vs31) i(vs32) i(vs33) i(vs34) i(vs35)
.endc
.end
