controls oracle dc-0298
* Generated (plan F2.7, ADR 0012): do not edit; regenerate with `pnpm sim oracle regen`. dc seed 20261030 index 298 nodes 21 elements 34
.options sparse gmin=1e-12 noopac
RG1 1 0 1000000000000
RG2 2 0 1000000000000
RG3 3 0 1000000000000
RG4 4 0 1000000000000
RG5 5 0 1000000000000
RG6 6 0 1000000000000
RG7 7 0 1000000000000
RG8 8 0 1000000000000
RG9 9 0 1000000000000
RG10 10 0 1000000000000
RG11 11 0 1000000000000
RG12 12 0 1000000000000
RG13 13 0 1000000000000
RG14 14 0 1000000000000
RG15 15 0 1000000000000
RG16 16 0 1000000000000
RG17 17 0 1000000000000
RG18 18 0 1000000000000
RG19 19 0 1000000000000
RG20 20 0 1000000000000
VS0 2 s0 0
I0 s0 13 DC 33e-4
VS1 0 s1 0
V1 e1 s1 DC 56e0
RI1 e1 6 82e-3
VS2 14 s2 0
I2 s2 1 DC 56e-3
VS3 2 s3 0
R3 s3 7 15e3
VS4 9 s4 0
V4 e4 s4 DC 12e-1
RI4 e4 15 27e-1
VS5 14 s5 0
V5 e5 s5 DC 39e0
RI5 e5 5 12e-2
VS6 19 s6 0
R6 s6 10 39e-1
VS7 9 s7 0
R7 s7 16 18e2
VS8 7 s8 0
R8 s8 3 47e-1
VS9 18 s9 0
V9 e9 s9 DC 15e0
RI9 e9 3 47e-3
VS10 18 s10 0
V10 e10 s10 DC 15e-1
RI10 e10 20 47e-1
VS11 5 s11 0
R11 s11 11 15e-1
VS12 20 s12 0
R12 s12 16 12e2
VS13 4 s13 0
R13 s13 8 56e-2
VS14 20 s14 0
I14 s14 3 DC 15e-4
VS15 20 s15 0
R15 s15 12 22e3
VS16 7 s16 0
R16 s16 10 22e3
VS17 15 s17 0
V17 e17 s17 DC 82e0
RI17 e17 20 12e-2
VS18 12 s18 0
R18 s18 14 10e3
VS19 13 s19 0
R19 s19 6 27e1
VS20 20 s20 0
V20 e20 s20 DC 10e1
RI20 e20 12 56e-1
VS21 11 s21 0
R21 s21 3 47e-1
VS22 19 s22 0
V22 e22 s22 DC 12e0
RI22 e22 1 33e-2
VS23 16 s23 0
R23 s23 17 15e-2
VS24 20 s24 0
R24 s24 3 12e0
VS25 12 s25 0
R25 s25 7 15e0
VS26 9 s26 0
R26 s26 3 33e-2
VS27 0 s27 0
R27 s27 1 56e3
VS28 15 s28 0
R28 s28 9 33e3
VS29 14 s29 0
R29 s29 7 33e-1
VS30 7 s30 0
I30 s30 5 DC 10e-2
VS31 2 s31 0
R31 s31 0 12e2
VS32 13 s32 0
R32 s32 10 47e2
VS33 4 s33 0
V33 e33 s33 DC 10e0
RI33 e33 0 33e-1
.control
set numdgt=17
op
print v(1) v(2) v(3) v(4) v(5) v(6) v(7) v(8) v(9) v(10)
print v(11) v(12) v(13) v(14) v(15) v(16) v(17) v(18) v(19) v(20)
print i(vs0) i(vs1) i(vs2) i(vs3) i(vs4) i(vs5) i(vs6) i(vs7) i(vs8) i(vs9)
print i(vs10) i(vs11) i(vs12) i(vs13) i(vs14) i(vs15) i(vs16) i(vs17) i(vs18) i(vs19)
print i(vs20) i(vs21) i(vs22) i(vs23) i(vs24) i(vs25) i(vs26) i(vs27) i(vs28) i(vs29)
print i(vs30) i(vs31) i(vs32) i(vs33)
.endc
.end
