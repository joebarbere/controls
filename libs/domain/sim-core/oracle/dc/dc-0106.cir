controls oracle dc-0106
* Generated (plan F2.7, ADR 0012): do not edit; regenerate with `pnpm sim oracle regen`. dc seed 20261030 index 106 nodes 3 elements 6
.options sparse gmin=1e-12 noopac
RG1 1 0 1000000000000
RG2 2 0 1000000000000
VS0 2 s0 0
R0 s0 0 68e1
VS1 1 s1 0
R1 s1 2 82e1
VS2 0 s2 0
R2 s2 2 82e3
VS3 1 s3 0
I3 s3 0 DC 82e-4
VS4 2 s4 0
R4 s4 1 22e1
VS5 0 s5 0
V5 e5 s5 DC 47e1
RI5 e5 1 10e-2
.control
set numdgt=17
op
print v(1) v(2)
print i(vs0) i(vs1) i(vs2) i(vs3) i(vs4) i(vs5)
.endc
.end
