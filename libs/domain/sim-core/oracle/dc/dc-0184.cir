controls oracle dc-0184
* Generated (plan F2.7, ADR 0012): do not edit; regenerate with `pnpm sim oracle regen`. dc seed 20261030 index 184 nodes 25 elements 46
.options sparse gmin=1e-12 noopac
RG1 1 0 1000000000000
RG2 2 0 1000000000000
RG3 3 0 1000000000000
RG4 4 0 1000000000000
RG5 5 0 1000000000000
RG6 6 0 1000000000000
RG7 7 0 1000000000000
RG8 8 0 1000000000000
RG9 9 0 1000000000000
RG10 10 0 1000000000000
RG11 11 0 1000000000000
RG12 12 0 1000000000000
RG13 13 0 1000000000000
RG14 14 0 1000000000000
RG15 15 0 1000000000000
RG16 16 0 1000000000000
RG17 17 0 1000000000000
RG18 18 0 1000000000000
RG19 19 0 1000000000000
RG20 20 0 1000000000000
RG21 21 0 1000000000000
RG22 22 0 1000000000000
RG23 23 0 1000000000000
RG24 24 0 1000000000000
VS0 24 s0 0
R0 s0 11 33e-2
VS1 24 s1 0
R1 s1 14 39e0
VS2 7 s2 0
R2 s2 24 47e3
VS3 21 s3 0
R3 s3 3 18e3
VS4 5 s4 0
R4 s4 7 18e-2
VS5 0 s5 0
R5 s5 18 56e-2
VS6 0 s6 0
V6 e6 s6 DC 33e1
RI6 e6 12 47e-1
VS7 10 s7 0
V7 e7 s7 DC 39e0
RI7 e7 19 56e-2
VS8 24 s8 0
R8 s8 17 10e2
VS9 4 s9 0
R9 s9 24 33e2
VS10 7 s10 0
V10 e10 s10 DC 56e0
RI10 e10 12 12e-2
VS11 14 s11 0
R11 s11 19 56e3
VS12 18 s12 0
V12 e12 s12 DC 82e1
RI12 e12 19 33e-3
VS13 3 s13 0
R13 s13 22 47e3
VS14 6 s14 0
V14 e14 s14 DC 39e0
RI14 e14 14 10e-1
VS15 4 s15 0
R15 s15 3 27e3
VS16 17 s16 0
R16 s16 3 39e-2
VS17 16 s17 0
R17 s17 0 47e1
VS18 5 s18 0
R18 s18 15 68e3
VS19 9 s19 0
R19 s19 13 68e-2
VS20 22 s20 0
R20 s20 13 56e2
VS21 9 s21 0
I21 s21 19 DC 82e-4
VS22 22 s22 0
I22 s22 15 DC 18e-2
VS23 15 s23 0
R23 s23 17 47e2
VS24 9 s24 0
R24 s24 10 12e3
VS25 0 s25 0
R25 s25 6 15e2
VS26 23 s26 0
V26 e26 s26 DC 10e-1
RI26 e26 12 33e-3
VS27 24 s27 0
V27 e27 s27 DC 10e1
RI27 e27 20 68e-3
VS28 8 s28 0
R28 s28 4 27e0
VS29 18 s29 0
R29 s29 5 39e-1
VS30 7 s30 0
R30 s30 10 33e-2
VS31 8 s31 0
R31 s31 16 27e3
VS32 13 s32 0
R32 s32 6 18e3
VS33 24 s33 0
R33 s33 4 68e-1
VS34 19 s34 0
I34 s34 14 DC 27e-2
VS35 15 s35 0
R35 s35 8 33e0
VS36 24 s36 0
I36 s36 17 DC 56e-3
VS37 5 s37 0
I37 s37 12 DC 12e-1
VS38 2 s38 0
R38 s38 9 47e2
VS39 14 s39 0
R39 s39 1 33e2
VS40 2 s40 0
R40 s40 21 33e3
VS41 12 s41 0
R41 s41 6 47e1
VS42 13 s42 0
R42 s42 10 47e-1
VS43 20 s43 0
R43 s43 23 22e-1
VS44 1 s44 0
R44 s44 0 12e-2
VS45 9 s45 0
R45 s45 11 10e1
.control
set numdgt=17
op
print v(1) v(2) v(3) v(4) v(5) v(6) v(7) v(8) v(9) v(10)
print v(11) v(12) v(13) v(14) v(15) v(16) v(17) v(18) v(19) v(20)
print v(21) v(22) v(23) v(24)
print i(vs0) i(vs1) i(vs2) i(vs3) i(vs4) i(vs5) i(vs6) i(vs7) i(vs8) i(vs9)
print i(vs10) i(vs11) i(vs12) i(vs13) i(vs14) i(vs15) i(vs16) i(vs17) i(vs18) i(vs19)
print i(vs20) i(vs21) i(vs22) i(vs23) i(vs24) i(vs25) i(vs26) i(vs27) i(vs28) i(vs29)
print i(vs30) i(vs31) i(vs32) i(vs33) i(vs34) i(vs35) i(vs36) i(vs37) i(vs38) i(vs39)
print i(vs40) i(vs41) i(vs42) i(vs43) i(vs44) i(vs45)
.endc
.end
