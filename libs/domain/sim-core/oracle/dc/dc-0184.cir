controls oracle dc-0184
* Generated (plan F2.7, ADR 0012): do not edit; regenerate with `pnpm sim oracle regen`. dc seed 20261030 index 184 nodes 25 elements 44
.options sparse gmin=1e-12 noopac
RG1 1 0 1000000000000
RG2 2 0 1000000000000
RG3 3 0 1000000000000
RG4 4 0 1000000000000
RG5 5 0 1000000000000
RG6 6 0 1000000000000
RG7 7 0 1000000000000
RG8 8 0 1000000000000
RG9 9 0 1000000000000
RG10 10 0 1000000000000
RG11 11 0 1000000000000
RG12 12 0 1000000000000
RG13 13 0 1000000000000
RG14 14 0 1000000000000
RG15 15 0 1000000000000
RG16 16 0 1000000000000
RG17 17 0 1000000000000
RG18 18 0 1000000000000
RG19 19 0 1000000000000
RG20 20 0 1000000000000
RG21 21 0 1000000000000
RG22 22 0 1000000000000
RG23 23 0 1000000000000
RG24 24 0 1000000000000
VS0 24 s0 0
I0 s0 17 DC 56e-3
VS1 8 s1 0
R1 s1 4 27e0
VS2 17 s2 0
R2 s2 3 39e-2
VS3 10 s3 0
R3 s3 0 12e3
VS4 9 s4 0
R4 s4 18 56e-2
VS5 0 s5 0
V5 e5 s5 DC 39e0
RI5 e5 19 56e-2
VS6 5 s6 0
R6 s6 15 68e3
VS7 4 s7 0
R7 s7 24 33e2
VS8 15 s8 0
R8 s8 17 47e2
VS9 3 s9 0
R9 s9 22 47e3
VS10 24 s10 0
R10 s10 14 39e0
VS11 21 s11 0
R11 s11 3 18e3
VS12 22 s12 0
I12 s12 15 DC 18e-2
VS13 22 s13 0
R13 s13 13 56e2
VS14 7 s14 0
R14 s14 0 33e-2
VS15 10 s15 0
R15 s15 13 68e-2
VS16 13 s16 0
R16 s16 6 18e3
VS17 23 s17 0
V17 e17 s17 DC 10e-1
RI17 e17 12 33e-3
VS18 7 s18 0
V18 e18 s18 DC 56e0
RI18 e18 12 12e-2
VS19 2 s19 0
R19 s19 10 47e2
VS20 4 s20 0
R20 s20 3 27e3
VS21 24 s21 0
R21 s21 11 33e-2
VS22 7 s22 0
R22 s22 24 47e3
VS23 13 s23 0
R23 s23 0 47e-1
VS24 24 s24 0
V24 e24 s24 DC 10e1
RI24 e24 20 68e-3
VS25 18 s25 0
V25 e25 s25 DC 82e1
RI25 e25 19 33e-3
VS26 6 s26 0
V26 e26 s26 DC 39e0
RI26 e26 14 10e-1
VS27 1 s27 0
R27 s27 9 12e-2
VS28 16 s28 0
R28 s28 9 47e1
VS29 5 s29 0
R29 s29 7 18e-2
VS30 15 s30 0
R30 s30 8 33e0
VS31 9 s31 0
V31 e31 s31 DC 33e1
RI31 e31 12 47e-1
VS32 10 s32 0
R32 s32 11 10e1
VS33 8 s33 0
R33 s33 16 27e3
VS34 9 s34 0
R34 s34 6 15e2
VS35 14 s35 0
R35 s35 19 56e3
VS36 10 s36 0
I36 s36 19 DC 82e-4
VS37 24 s37 0
R37 s37 4 68e-1
VS38 24 s38 0
R38 s38 17 10e2
VS39 5 s39 0
I39 s39 12 DC 12e-1
VS40 19 s40 0
I40 s40 14 DC 27e-2
VS41 20 s41 0
R41 s41 23 22e-1
VS42 18 s42 0
R42 s42 5 39e-1
VS43 12 s43 0
R43 s43 6 47e1
.control
set numdgt=17
op
print v(1) v(2) v(3) v(4) v(5) v(6) v(7) v(8) v(9) v(10)
print v(11) v(12) v(13) v(14) v(15) v(16) v(17) v(18) v(19) v(20)
print v(21) v(22) v(23) v(24)
print i(vs0) i(vs1) i(vs2) i(vs3) i(vs4) i(vs5) i(vs6) i(vs7) i(vs8) i(vs9)
print i(vs10) i(vs11) i(vs12) i(vs13) i(vs14) i(vs15) i(vs16) i(vs17) i(vs18) i(vs19)
print i(vs20) i(vs21) i(vs22) i(vs23) i(vs24) i(vs25) i(vs26) i(vs27) i(vs28) i(vs29)
print i(vs30) i(vs31) i(vs32) i(vs33) i(vs34) i(vs35) i(vs36) i(vs37) i(vs38) i(vs39)
print i(vs40) i(vs41) i(vs42) i(vs43)
.endc
.end
