controls oracle dc-0019
* Generated (plan F2.7, ADR 0012): do not edit; regenerate with `pnpm sim oracle regen`. dc seed 20261030 index 19 nodes 6 elements 9
.options sparse gmin=1e-12 noopac
RG1 1 0 1000000000000
RG2 2 0 1000000000000
RG3 3 0 1000000000000
RG4 4 0 1000000000000
RG5 5 0 1000000000000
VS0 0 s0 0
V0 e0 s0 DC 18e1
RI0 e0 2 68e-1
VS1 4 s1 0
R1 s1 0 56e-1
VS2 0 s2 0
R2 s2 3 12e3
VS3 1 s3 0
R3 s3 3 47e3
VS4 2 s4 0
R4 s4 1 39e-2
VS5 1 s5 0
R5 s5 5 68e0
VS6 5 s6 0
R6 s6 2 82e0
VS7 4 s7 0
R7 s7 1 18e0
VS8 0 s8 0
R8 s8 5 18e-1
.control
set numdgt=17
op
print v(1) v(2) v(3) v(4) v(5)
print i(vs0) i(vs1) i(vs2) i(vs3) i(vs4) i(vs5) i(vs6) i(vs7) i(vs8)
.endc
.end
