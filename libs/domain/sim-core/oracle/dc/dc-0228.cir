controls oracle dc-0228
* Generated (plan F2.7, ADR 0012): do not edit; regenerate with `pnpm sim oracle regen`. dc seed 20261030 index 228 nodes 9 elements 12
.options sparse gmin=1e-12 noopac
RG1 1 0 1000000000000
RG2 2 0 1000000000000
RG3 3 0 1000000000000
RG4 4 0 1000000000000
RG5 5 0 1000000000000
RG6 6 0 1000000000000
RG7 7 0 1000000000000
RG8 8 0 1000000000000
VS0 5 s0 0
R0 s0 4 15e3
VS1 0 s1 0
V1 e1 s1 DC 12e0
RI1 e1 1 33e-3
VS2 3 s2 0
R2 s2 7 10e2
VS3 8 s3 0
R3 s3 3 68e0
VS4 7 s4 0
V4 e4 s4 DC 82e1
RI4 e4 4 22e-2
VS5 2 s5 0
R5 s5 1 15e1
VS6 2 s6 0
R6 s6 0 56e2
VS7 5 s7 0
R7 s7 2 18e2
VS8 0 s8 0
R8 s8 6 82e1
VS9 5 s9 0
R9 s9 6 56e-2
VS10 0 s10 0
R10 s10 7 33e3
VS11 8 s11 0
V11 e11 s11 DC 68e0
RI11 e11 0 12e-1
.control
set numdgt=17
op
print v(1) v(2) v(3) v(4) v(5) v(6) v(7) v(8)
print i(vs0) i(vs1) i(vs2) i(vs3) i(vs4) i(vs5) i(vs6) i(vs7) i(vs8) i(vs9)
print i(vs10) i(vs11)
.endc
.end
