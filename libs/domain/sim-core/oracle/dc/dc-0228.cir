controls oracle dc-0228
* Generated (plan F2.7, ADR 0012): do not edit; regenerate with `pnpm sim oracle regen`. dc seed 20261030 index 228 nodes 9 elements 9
.options sparse gmin=1e-12 noopac
RG1 1 0 1000000000000
RG2 2 0 1000000000000
RG3 3 0 1000000000000
RG4 4 0 1000000000000
RG5 5 0 1000000000000
RG6 6 0 1000000000000
RG7 7 0 1000000000000
RG8 8 0 1000000000000
VS0 0 s0 0
V0 e0 s0 DC 68e0
RI0 e0 8 12e-1
VS1 8 s1 0
R1 s1 7 33e3
VS2 2 s2 0
R2 s2 1 15e1
VS3 8 s3 0
V3 e3 s3 DC 12e0
RI3 e3 1 33e-3
VS4 0 s4 0
R4 s4 3 68e0
VS5 7 s5 0
V5 e5 s5 DC 82e1
RI5 e5 4 22e-2
VS6 5 s6 0
R6 s6 4 15e3
VS7 2 s7 0
R7 s7 8 56e2
VS8 8 s8 0
R8 s8 6 82e1
.control
set numdgt=17
op
print v(1) v(2) v(3) v(4) v(5) v(6) v(7) v(8)
print i(vs0) i(vs1) i(vs2) i(vs3) i(vs4) i(vs5) i(vs6) i(vs7) i(vs8)
.endc
.end
