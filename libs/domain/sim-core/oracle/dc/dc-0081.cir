controls oracle dc-0081
* Generated (plan F2.7, ADR 0012): do not edit; regenerate with `pnpm sim oracle regen`. dc seed 20261030 index 81 nodes 4 elements 7
.options sparse gmin=1e-12 noopac
RG1 1 0 1000000000000
RG2 2 0 1000000000000
RG3 3 0 1000000000000
VS0 2 s0 0
I0 s0 1 DC 18e-2
VS1 0 s1 0
V1 e1 s1 DC 39e-1
RI1 e1 1 18e-3
VS2 1 s2 0
R2 s2 2 27e1
VS3 1 s3 0
R3 s3 3 39e3
VS4 0 s4 0
R4 s4 2 56e1
VS5 3 s5 0
R5 s5 0 68e-2
VS6 1 s6 0
R6 s6 2 33e2
.control
set numdgt=17
op
print v(1) v(2) v(3)
print i(vs0) i(vs1) i(vs2) i(vs3) i(vs4) i(vs5) i(vs6)
.endc
.end
