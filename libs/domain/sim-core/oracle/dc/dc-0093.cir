controls oracle dc-0093
* Generated (plan F2.7, ADR 0012): do not edit; regenerate with `pnpm sim oracle regen`. dc seed 20261030 index 93 nodes 12 elements 22
.options sparse gmin=1e-12 noopac
RG1 1 0 1000000000000
RG2 2 0 1000000000000
RG3 3 0 1000000000000
RG4 4 0 1000000000000
RG5 5 0 1000000000000
RG6 6 0 1000000000000
RG7 7 0 1000000000000
RG8 8 0 1000000000000
RG9 9 0 1000000000000
RG10 10 0 1000000000000
RG11 11 0 1000000000000
VS0 0 s0 0
V0 e0 s0 DC 33e0
RI0 e0 1 56e-1
VS1 5 s1 0
R1 s1 7 39e-2
VS2 1 s2 0
V2 e2 s2 DC 18e1
RI2 e2 9 47e-3
VS3 9 s3 0
R3 s3 8 33e3
VS4 0 s4 0
V4 e4 s4 DC 47e1
RI4 e4 9 15e-1
VS5 8 s5 0
R5 s5 6 56e3
VS6 0 s6 0
R6 s6 10 39e-2
VS7 6 s7 0
R7 s7 1 33e-1
VS8 5 s8 0
I8 s8 6 DC 10e-1
VS9 3 s9 0
R9 s9 8 15e1
VS10 4 s10 0
I10 s10 2 DC 68e-3
VS11 2 s11 0
R11 s11 1 33e-2
VS12 8 s12 0
R12 s12 11 22e1
VS13 7 s13 0
R13 s13 4 18e1
VS14 0 s14 0
R14 s14 5 68e0
VS15 11 s15 0
R15 s15 5 68e0
VS16 2 s16 0
R16 s16 10 27e-2
VS17 5 s17 0
I17 s17 0 DC 12e-1
VS18 4 s18 0
R18 s18 1 39e2
VS19 2 s19 0
R19 s19 0 10e-1
VS20 3 s20 0
R20 s20 1 10e-2
VS21 5 s21 0
R21 s21 1 18e-2
.control
set numdgt=17
op
print v(1) v(2) v(3) v(4) v(5) v(6) v(7) v(8) v(9) v(10)
print v(11)
print i(vs0) i(vs1) i(vs2) i(vs3) i(vs4) i(vs5) i(vs6) i(vs7) i(vs8) i(vs9)
print i(vs10) i(vs11) i(vs12) i(vs13) i(vs14) i(vs15) i(vs16) i(vs17) i(vs18) i(vs19)
print i(vs20) i(vs21)
.endc
.end
