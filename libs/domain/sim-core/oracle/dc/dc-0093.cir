controls oracle dc-0093
* Generated (plan F2.7, ADR 0012): do not edit; regenerate with `pnpm sim oracle regen`. dc seed 20261030 index 93 nodes 12 elements 18
.options sparse gmin=1e-12 noopac
RG1 1 0 1000000000000
RG2 2 0 1000000000000
RG3 3 0 1000000000000
RG4 4 0 1000000000000
RG5 5 0 1000000000000
RG6 6 0 1000000000000
RG7 7 0 1000000000000
RG8 8 0 1000000000000
RG9 9 0 1000000000000
RG10 10 0 1000000000000
RG11 11 0 1000000000000
VS0 2 s0 0
R0 s0 0 10e-1
VS1 7 s1 0
R1 s1 4 18e1
VS2 8 s2 0
R2 s2 11 22e1
VS3 0 s3 0
V3 e3 s3 DC 33e0
RI3 e3 1 56e-1
VS4 5 s4 0
I4 s4 0 DC 12e-1
VS5 4 s5 0
I5 s5 2 DC 68e-3
VS6 3 s6 0
R6 s6 8 15e1
VS7 2 s7 0
R7 s7 10 27e-2
VS8 11 s8 0
R8 s8 5 68e0
VS9 5 s9 0
R9 s9 1 18e-2
VS10 5 s10 0
R10 s10 7 39e-2
VS11 0 s11 0
V11 e11 s11 DC 47e1
RI11 e11 9 15e-1
VS12 8 s12 0
R12 s12 6 56e3
VS13 9 s13 0
R13 s13 8 33e3
VS14 1 s14 0
V14 e14 s14 DC 18e1
RI14 e14 9 47e-3
VS15 2 s15 0
R15 s15 1 33e-2
VS16 5 s16 0
I16 s16 6 DC 10e-1
VS17 0 s17 0
R17 s17 5 68e0
.control
set numdgt=17
op
print v(1) v(2) v(3) v(4) v(5) v(6) v(7) v(8) v(9) v(10)
print v(11)
print i(vs0) i(vs1) i(vs2) i(vs3) i(vs4) i(vs5) i(vs6) i(vs7) i(vs8) i(vs9)
print i(vs10) i(vs11) i(vs12) i(vs13) i(vs14) i(vs15) i(vs16) i(vs17)
.endc
.end
