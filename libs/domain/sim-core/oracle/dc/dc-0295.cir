controls oracle dc-0295
* Generated (plan F2.7, ADR 0012): do not edit; regenerate with `pnpm sim oracle regen`. dc seed 20261030 index 295 nodes 7 elements 12
.options sparse gmin=1e-12 noopac
RG1 1 0 1000000000000
RG2 2 0 1000000000000
RG3 3 0 1000000000000
RG4 4 0 1000000000000
RG5 5 0 1000000000000
RG6 6 0 1000000000000
VS0 6 s0 0
R0 s0 4 12e1
VS1 1 s1 0
R1 s1 2 39e1
VS2 0 s2 0
R2 s2 1 12e-1
VS3 0 s3 0
V3 e3 s3 DC 39e-1
RI3 e3 6 27e-1
VS4 4 s4 0
R4 s4 3 27e0
VS5 5 s5 0
R5 s5 1 33e-1
VS6 2 s6 0
R6 s6 1 15e3
VS7 1 s7 0
R7 s7 5 15e-2
VS8 2 s8 0
R8 s8 4 12e3
VS9 5 s9 0
R9 s9 3 18e0
VS10 0 s10 0
R10 s10 5 33e-1
VS11 2 s11 0
R11 s11 4 47e-1
.control
set numdgt=17
op
print v(1) v(2) v(3) v(4) v(5) v(6)
print i(vs0) i(vs1) i(vs2) i(vs3) i(vs4) i(vs5) i(vs6) i(vs7) i(vs8) i(vs9)
print i(vs10) i(vs11)
.endc
.end
