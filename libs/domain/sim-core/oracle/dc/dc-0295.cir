controls oracle dc-0295
* Generated (plan F2.7, ADR 0012): do not edit; regenerate with `pnpm sim oracle regen`. dc seed 20261030 index 295 nodes 7 elements 11
.options sparse gmin=1e-12 noopac
RG1 1 0 1000000000000
RG2 2 0 1000000000000
RG3 3 0 1000000000000
RG4 4 0 1000000000000
RG5 5 0 1000000000000
RG6 6 0 1000000000000
VS0 1 s0 0
R0 s0 2 39e1
VS1 2 s1 0
R1 s1 4 12e3
VS2 2 s2 0
R2 s2 1 15e3
VS3 0 s3 0
V3 e3 s3 DC 39e-1
RI3 e3 6 27e-1
VS4 1 s4 0
R4 s4 5 15e-2
VS5 0 s5 0
R5 s5 1 12e-1
VS6 0 s6 0
R6 s6 5 33e-1
VS7 6 s7 0
R7 s7 0 18e1
VS8 5 s8 0
R8 s8 1 33e-1
VS9 2 s9 0
R9 s9 4 47e-1
VS10 4 s10 0
R10 s10 3 27e0
.control
set numdgt=17
op
print v(1) v(2) v(3) v(4) v(5) v(6)
print i(vs0) i(vs1) i(vs2) i(vs3) i(vs4) i(vs5) i(vs6) i(vs7) i(vs8) i(vs9)
print i(vs10)
.endc
.end
