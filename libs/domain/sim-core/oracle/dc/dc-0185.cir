controls oracle dc-0185
* Generated (plan F2.7, ADR 0012): do not edit; regenerate with `pnpm sim oracle regen`. dc seed 20261030 index 185 nodes 16 elements 22
.options sparse gmin=1e-12 noopac
RG1 1 0 1000000000000
RG2 2 0 1000000000000
RG3 3 0 1000000000000
RG4 4 0 1000000000000
RG5 5 0 1000000000000
RG6 6 0 1000000000000
RG7 7 0 1000000000000
RG8 8 0 1000000000000
RG9 9 0 1000000000000
RG10 10 0 1000000000000
RG11 11 0 1000000000000
RG12 12 0 1000000000000
RG13 13 0 1000000000000
RG14 14 0 1000000000000
RG15 15 0 1000000000000
VS0 0 s0 0
V0 e0 s0 DC 56e1
RI0 e0 12 68e-3
VS1 14 s1 0
V1 e1 s1 DC 10e1
RI1 e1 5 15e-2
VS2 6 s2 0
R2 s2 12 68e-2
VS3 7 s3 0
R3 s3 12 12e0
VS4 6 s4 0
R4 s4 15 18e-2
VS5 5 s5 0
R5 s5 9 22e-1
VS6 7 s6 0
R6 s6 11 15e3
VS7 6 s7 0
V7 e7 s7 DC 22e-1
RI7 e7 4 18e-1
VS8 0 s8 0
V8 e8 s8 DC 39e0
RI8 e8 8 10e-2
VS9 12 s9 0
R9 s9 3 47e0
VS10 1 s10 0
R10 s10 2 68e-2
VS11 3 s11 0
V11 e11 s11 DC 12e-1
RI11 e11 13 12e-2
VS12 5 s12 0
V12 e12 s12 DC 22e0
RI12 e12 12 33e-1
VS13 5 s13 0
R13 s13 1 47e1
VS14 9 s14 0
V14 e14 s14 DC 82e-1
RI14 e14 7 22e-2
VS15 6 s15 0
V15 e15 s15 DC 82e1
RI15 e15 8 18e-1
VS16 2 s16 0
R16 s16 7 68e1
VS17 11 s17 0
V17 e17 s17 DC 18e1
RI17 e17 13 22e-1
VS18 10 s18 0
R18 s18 7 47e0
VS19 10 s19 0
V19 e19 s19 DC 22e0
RI19 e19 15 47e-3
VS20 14 s20 0
V20 e20 s20 DC 12e1
RI20 e20 4 12e-1
VS21 15 s21 0
R21 s21 7 56e3
.control
set numdgt=17
op
print v(1) v(2) v(3) v(4) v(5) v(6) v(7) v(8) v(9) v(10)
print v(11) v(12) v(13) v(14) v(15)
print i(vs0) i(vs1) i(vs2) i(vs3) i(vs4) i(vs5) i(vs6) i(vs7) i(vs8) i(vs9)
print i(vs10) i(vs11) i(vs12) i(vs13) i(vs14) i(vs15) i(vs16) i(vs17) i(vs18) i(vs19)
print i(vs20) i(vs21)
.endc
.end
