controls oracle dc-0185
* Generated (plan F2.7, ADR 0012): do not edit; regenerate with `pnpm sim oracle regen`. dc seed 20261030 index 185 nodes 16 elements 17
.options sparse gmin=1e-12 noopac
RG1 1 0 1000000000000
RG2 2 0 1000000000000
RG3 3 0 1000000000000
RG4 4 0 1000000000000
RG5 5 0 1000000000000
RG6 6 0 1000000000000
RG7 7 0 1000000000000
RG8 8 0 1000000000000
RG9 9 0 1000000000000
RG10 10 0 1000000000000
RG11 11 0 1000000000000
RG12 12 0 1000000000000
RG13 13 0 1000000000000
RG14 14 0 1000000000000
RG15 15 0 1000000000000
VS0 6 s0 0
R0 s0 15 18e-2
VS1 9 s1 0
R1 s1 3 47e0
VS2 0 s2 0
V2 e2 s2 DC 82e-1
RI2 e2 7 22e-2
VS3 7 s3 0
R3 s3 11 15e3
VS4 11 s4 0
V4 e4 s4 DC 18e1
RI4 e4 13 22e-1
VS5 14 s5 0
V5 e5 s5 DC 10e1
RI5 e5 5 15e-2
VS6 7 s6 0
R6 s6 9 12e0
VS7 12 s7 0
V7 e7 s7 DC 56e1
RI7 e7 9 68e-3
VS8 2 s8 0
R8 s8 7 68e1
VS9 1 s9 0
R9 s9 2 68e-2
VS10 5 s10 0
V10 e10 s10 DC 22e0
RI10 e10 9 33e-1
VS11 14 s11 0
V11 e11 s11 DC 12e1
RI11 e11 4 12e-1
VS12 6 s12 0
V12 e12 s12 DC 82e1
RI12 e12 8 18e-1
VS13 10 s13 0
R13 s13 7 47e0
VS14 6 s14 0
V14 e14 s14 DC 22e-1
RI14 e14 4 18e-1
VS15 5 s15 0
R15 s15 0 22e-1
VS16 6 s16 0
R16 s16 9 68e-2
.control
set numdgt=17
op
print v(1) v(2) v(3) v(4) v(5) v(6) v(7) v(8) v(9) v(10)
print v(11) v(12) v(13) v(14) v(15)
print i(vs0) i(vs1) i(vs2) i(vs3) i(vs4) i(vs5) i(vs6) i(vs7) i(vs8) i(vs9)
print i(vs10) i(vs11) i(vs12) i(vs13) i(vs14) i(vs15) i(vs16)
.endc
.end
