controls oracle dc-0311
* Generated (plan F2.7, ADR 0012): do not edit; regenerate with `pnpm sim oracle regen`. dc seed 20261030 index 311 nodes 24 elements 34
.options sparse gmin=1e-12 noopac
RG1 1 0 1000000000000
RG2 2 0 1000000000000
RG3 3 0 1000000000000
RG4 4 0 1000000000000
RG5 5 0 1000000000000
RG6 6 0 1000000000000
RG7 7 0 1000000000000
RG8 8 0 1000000000000
RG9 9 0 1000000000000
RG10 10 0 1000000000000
RG11 11 0 1000000000000
RG12 12 0 1000000000000
RG13 13 0 1000000000000
RG14 14 0 1000000000000
RG15 15 0 1000000000000
RG16 16 0 1000000000000
RG17 17 0 1000000000000
RG18 18 0 1000000000000
RG19 19 0 1000000000000
RG20 20 0 1000000000000
RG21 21 0 1000000000000
RG22 22 0 1000000000000
RG23 23 0 1000000000000
VS0 0 s0 0
V0 e0 s0 DC 15e0
RI0 e0 9 18e-1
VS1 22 s1 0
R1 s1 21 33e-1
VS2 8 s2 0
R2 s2 16 15e2
VS3 15 s3 0
R3 s3 6 33e3
VS4 9 s4 0
I4 s4 21 DC 27e-4
VS5 15 s5 0
R5 s5 6 12e-2
VS6 21 s6 0
R6 s6 11 39e2
VS7 22 s7 0
R7 s7 7 12e2
VS8 1 s8 0
I8 s8 9 DC 33e-1
VS9 5 s9 0
R9 s9 17 27e0
VS10 11 s10 0
R10 s10 19 56e0
VS11 7 s11 0
R11 s11 22 10e1
VS12 16 s12 0
R12 s12 3 39e1
VS13 19 s13 0
I13 s13 3 DC 18e-3
VS14 1 s14 0
V14 e14 s14 DC 12e1
RI14 e14 13 18e-1
VS15 21 s15 0
R15 s15 12 47e2
VS16 18 s16 0
R16 s16 16 47e-1
VS17 0 s17 0
I17 s17 8 DC 56e-3
VS18 9 s18 0
I18 s18 17 DC 82e-2
VS19 14 s19 0
R19 s19 5 22e2
VS20 12 s20 0
R20 s20 16 47e0
VS21 12 s21 0
I21 s21 21 DC 39e-2
VS22 21 s22 0
R22 s22 4 47e1
VS23 9 s23 0
R23 s23 12 33e3
VS24 23 s24 0
R24 s24 18 18e-1
VS25 16 s25 0
R25 s25 2 10e2
VS26 7 s26 0
V26 e26 s26 DC 47e1
RI26 e26 15 18e-1
VS27 9 s27 0
R27 s27 20 22e1
VS28 13 s28 0
R28 s28 9 22e0
VS29 11 s29 0
R29 s29 6 15e1
VS30 14 s30 0
R30 s30 16 27e-1
VS31 7 s31 0
R31 s31 11 47e1
VS32 10 s32 0
V32 e32 s32 DC 12e-1
RI32 e32 11 47e-2
VS33 11 s33 0
R33 s33 20 56e2
.control
set numdgt=17
op
print v(1) v(2) v(3) v(4) v(5) v(6) v(7) v(8) v(9) v(10)
print v(11) v(12) v(13) v(14) v(15) v(16) v(17) v(18) v(19) v(20)
print v(21) v(22) v(23)
print i(vs0) i(vs1) i(vs2) i(vs3) i(vs4) i(vs5) i(vs6) i(vs7) i(vs8) i(vs9)
print i(vs10) i(vs11) i(vs12) i(vs13) i(vs14) i(vs15) i(vs16) i(vs17) i(vs18) i(vs19)
print i(vs20) i(vs21) i(vs22) i(vs23) i(vs24) i(vs25) i(vs26) i(vs27) i(vs28) i(vs29)
print i(vs30) i(vs31) i(vs32) i(vs33)
.endc
.end
