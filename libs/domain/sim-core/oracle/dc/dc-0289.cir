controls oracle dc-0289
* Generated (plan F2.7, ADR 0012): do not edit; regenerate with `pnpm sim oracle regen`. dc seed 20261030 index 289 nodes 12 elements 17
.options sparse gmin=1e-12 noopac
RG1 1 0 1000000000000
RG2 2 0 1000000000000
RG3 3 0 1000000000000
RG4 4 0 1000000000000
RG5 5 0 1000000000000
RG6 6 0 1000000000000
RG7 7 0 1000000000000
RG8 8 0 1000000000000
RG9 9 0 1000000000000
RG10 10 0 1000000000000
RG11 11 0 1000000000000
VS0 7 s0 0
R0 s0 1 15e3
VS1 1 s1 0
R1 s1 10 56e1
VS2 0 s2 0
V2 e2 s2 DC 68e-1
RI2 e2 5 47e-3
VS3 8 s3 0
V3 e3 s3 DC 68e0
RI3 e3 1 56e-1
VS4 6 s4 0
R4 s4 1 39e2
VS5 2 s5 0
R5 s5 1 33e-1
VS6 2 s6 0
R6 s6 4 12e3
VS7 7 s7 0
R7 s7 5 47e2
VS8 10 s8 0
V8 e8 s8 DC 82e1
RI8 e8 3 82e-1
VS9 1 s9 0
V9 e9 s9 DC 33e1
RI9 e9 11 27e-1
VS10 9 s10 0
V10 e10 s10 DC 27e-1
RI10 e10 5 33e-1
VS11 10 s11 0
R11 s11 0 27e3
VS12 6 s12 0
R12 s12 9 56e-2
VS13 4 s13 0
R13 s13 9 10e-1
VS14 8 s14 0
R14 s14 9 33e1
VS15 5 s15 0
R15 s15 3 27e-1
VS16 5 s16 0
R16 s16 11 39e2
.control
set numdgt=17
op
print v(1) v(2) v(3) v(4) v(5) v(6) v(7) v(8) v(9) v(10)
print v(11)
print i(vs0) i(vs1) i(vs2) i(vs3) i(vs4) i(vs5) i(vs6) i(vs7) i(vs8) i(vs9)
print i(vs10) i(vs11) i(vs12) i(vs13) i(vs14) i(vs15) i(vs16)
.endc
.end
