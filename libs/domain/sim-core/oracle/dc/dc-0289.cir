controls oracle dc-0289
* Generated (plan F2.7, ADR 0012): do not edit; regenerate with `pnpm sim oracle regen`. dc seed 20261030 index 289 nodes 12 elements 12
.options sparse gmin=1e-12 noopac
RG1 1 0 1000000000000
RG2 2 0 1000000000000
RG3 3 0 1000000000000
RG4 4 0 1000000000000
RG5 5 0 1000000000000
RG6 6 0 1000000000000
RG7 7 0 1000000000000
RG8 8 0 1000000000000
RG9 9 0 1000000000000
RG10 10 0 1000000000000
RG11 11 0 1000000000000
VS0 0 s0 0
V0 e0 s0 DC 33e1
RI0 e0 11 27e-1
VS1 4 s1 0
R1 s1 1 10e-1
VS2 8 s2 0
R2 s2 1 33e1
VS3 7 s3 0
R3 s3 0 15e3
VS4 1 s4 0
V4 e4 s4 DC 27e-1
RI4 e4 5 33e-1
VS5 2 s5 0
R5 s5 0 33e-1
VS6 6 s6 0
R6 s6 0 39e2
VS7 9 s7 0
V7 e7 s7 DC 68e-1
RI7 e7 5 47e-3
VS8 5 s8 0
R8 s8 11 39e2
VS9 6 s9 0
R9 s9 1 56e-2
VS10 5 s10 0
R10 s10 3 27e-1
VS11 0 s11 0
R11 s11 10 56e1
.control
set numdgt=17
op
print v(1) v(2) v(3) v(4) v(5) v(6) v(7) v(8) v(9) v(10)
print v(11)
print i(vs0) i(vs1) i(vs2) i(vs3) i(vs4) i(vs5) i(vs6) i(vs7) i(vs8) i(vs9)
print i(vs10) i(vs11)
.endc
.end
