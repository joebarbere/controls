controls oracle dc-0413
* Generated (plan F2.7, ADR 0012): do not edit; regenerate with `pnpm sim oracle regen`. dc seed 20261030 index 413 nodes 15 elements 24
.options sparse gmin=1e-12 noopac
RG1 1 0 1000000000000
RG2 2 0 1000000000000
RG3 3 0 1000000000000
RG4 4 0 1000000000000
RG5 5 0 1000000000000
RG6 6 0 1000000000000
RG7 7 0 1000000000000
RG8 8 0 1000000000000
RG9 9 0 1000000000000
RG10 10 0 1000000000000
RG11 11 0 1000000000000
RG12 12 0 1000000000000
RG13 13 0 1000000000000
RG14 14 0 1000000000000
VS0 4 s0 0
R0 s0 7 68e2
VS1 3 s1 0
I1 s1 6 DC 15e-1
VS2 13 s2 0
R2 s2 12 68e-2
VS3 4 s3 0
R3 s3 12 18e0
VS4 6 s4 0
R4 s4 2 47e-2
VS5 6 s5 0
R5 s5 10 22e-1
VS6 5 s6 0
R6 s6 11 18e-2
VS7 2 s7 0
R7 s7 8 68e3
VS8 8 s8 0
I8 s8 12 DC 12e-2
VS9 0 s9 0
V9 e9 s9 DC 47e1
RI9 e9 13 82e-1
VS10 11 s10 0
R10 s10 7 33e2
VS11 3 s11 0
R11 s11 5 10e1
VS12 14 s12 0
V12 e12 s12 DC 56e1
RI12 e12 13 18e-3
VS13 1 s13 0
R13 s13 2 39e0
VS14 14 s14 0
R14 s14 9 10e1
VS15 12 s15 0
I15 s15 7 DC 47e-3
VS16 2 s16 0
R16 s16 5 15e3
VS17 14 s17 0
R17 s17 7 82e2
VS18 12 s18 0
R18 s18 11 12e2
VS19 6 s19 0
R19 s19 14 56e0
VS20 4 s20 0
R20 s20 7 15e-2
VS21 10 s21 0
R21 s21 3 15e-1
VS22 14 s22 0
R22 s22 11 10e-2
VS23 4 s23 0
I23 s23 6 DC 15e-4
.control
set numdgt=17
op
print v(1) v(2) v(3) v(4) v(5) v(6) v(7) v(8) v(9) v(10)
print v(11) v(12) v(13) v(14)
print i(vs0) i(vs1) i(vs2) i(vs3) i(vs4) i(vs5) i(vs6) i(vs7) i(vs8) i(vs9)
print i(vs10) i(vs11) i(vs12) i(vs13) i(vs14) i(vs15) i(vs16) i(vs17) i(vs18) i(vs19)
print i(vs20) i(vs21) i(vs22) i(vs23)
.endc
.end
