controls oracle dc-0413
* Generated (plan F2.7, ADR 0012): do not edit; regenerate with `pnpm sim oracle regen`. dc seed 20261030 index 413 nodes 15 elements 28
.options sparse gmin=1e-12 noopac
RG1 1 0 1000000000000
RG2 2 0 1000000000000
RG3 3 0 1000000000000
RG4 4 0 1000000000000
RG5 5 0 1000000000000
RG6 6 0 1000000000000
RG7 7 0 1000000000000
RG8 8 0 1000000000000
RG9 9 0 1000000000000
RG10 10 0 1000000000000
RG11 11 0 1000000000000
RG12 12 0 1000000000000
RG13 13 0 1000000000000
RG14 14 0 1000000000000
VS0 0 s0 0
R0 s0 5 82e0
VS1 11 s1 0
R1 s1 7 33e2
VS2 0 s2 0
V2 e2 s2 DC 47e1
RI2 e2 13 82e-1
VS3 1 s3 0
R3 s3 7 12e1
VS4 13 s4 0
R4 s4 12 68e-2
VS5 4 s5 0
R5 s5 7 68e2
VS6 1 s6 0
R6 s6 2 39e0
VS7 12 s7 0
R7 s7 11 12e2
VS8 8 s8 0
I8 s8 12 DC 12e-2
VS9 2 s9 0
R9 s9 5 15e3
VS10 6 s10 0
R10 s10 14 56e0
VS11 14 s11 0
R11 s11 11 10e-2
VS12 2 s12 0
R12 s12 8 68e3
VS13 10 s13 0
R13 s13 3 15e-1
VS14 5 s14 0
R14 s14 11 18e-2
VS15 4 s15 0
R15 s15 12 18e0
VS16 12 s16 0
I16 s16 7 DC 47e-3
VS17 3 s17 0
V17 e17 s17 DC 10e-1
RI17 e17 9 82e-1
VS18 4 s18 0
R18 s18 7 15e-2
VS19 14 s19 0
V19 e19 s19 DC 56e1
RI19 e19 13 18e-3
VS20 4 s20 0
I20 s20 6 DC 15e-4
VS21 3 s21 0
R21 s21 5 10e1
VS22 6 s22 0
R22 s22 10 22e-1
VS23 3 s23 0
I23 s23 6 DC 15e-1
VS24 9 s24 0
R24 s24 8 56e0
VS25 14 s25 0
R25 s25 7 82e2
VS26 14 s26 0
R26 s26 9 10e1
VS27 6 s27 0
R27 s27 2 47e-2
.control
set numdgt=17
op
print v(1) v(2) v(3) v(4) v(5) v(6) v(7) v(8) v(9) v(10)
print v(11) v(12) v(13) v(14)
print i(vs0) i(vs1) i(vs2) i(vs3) i(vs4) i(vs5) i(vs6) i(vs7) i(vs8) i(vs9)
print i(vs10) i(vs11) i(vs12) i(vs13) i(vs14) i(vs15) i(vs16) i(vs17) i(vs18) i(vs19)
print i(vs20) i(vs21) i(vs22) i(vs23) i(vs24) i(vs25) i(vs26) i(vs27)
.endc
.end
