controls oracle dc-0132
* Generated (plan F2.7, ADR 0012): do not edit; regenerate with `pnpm sim oracle regen`. dc seed 20261030 index 132 nodes 16 elements 21
.options sparse gmin=1e-12 noopac
RG1 1 0 1000000000000
RG2 2 0 1000000000000
RG3 3 0 1000000000000
RG4 4 0 1000000000000
RG5 5 0 1000000000000
RG6 6 0 1000000000000
RG7 7 0 1000000000000
RG8 8 0 1000000000000
RG9 9 0 1000000000000
RG10 10 0 1000000000000
RG11 11 0 1000000000000
RG12 12 0 1000000000000
RG13 13 0 1000000000000
RG14 14 0 1000000000000
RG15 15 0 1000000000000
VS0 12 s0 0
R0 s0 3 39e-2
VS1 0 s1 0
V1 e1 s1 DC 82e0
RI1 e1 7 15e-2
VS2 2 s2 0
R2 s2 8 10e-2
VS3 10 s3 0
R3 s3 2 39e1
VS4 8 s4 0
R4 s4 13 39e0
VS5 3 s5 0
R5 s5 13 68e-2
VS6 13 s6 0
R6 s6 1 47e0
VS7 0 s7 0
R7 s7 6 22e3
VS8 15 s8 0
R8 s8 7 33e0
VS9 13 s9 0
R9 s9 4 22e1
VS10 14 s10 0
R10 s10 0 10e0
VS11 13 s11 0
R11 s11 6 33e-2
VS12 1 s12 0
R12 s12 4 47e1
VS13 11 s13 0
V13 e13 s13 DC 10e-1
RI13 e13 3 33e-2
VS14 13 s14 0
I14 s14 4 DC 39e-3
VS15 11 s15 0
R15 s15 8 15e2
VS16 1 s16 0
V16 e16 s16 DC 82e-1
RI16 e16 14 47e-1
VS17 12 s17 0
R17 s17 3 47e-1
VS18 9 s18 0
R18 s18 6 18e-2
VS19 4 s19 0
I19 s19 13 DC 56e-2
VS20 5 s20 0
R20 s20 0 68e-1
.control
set numdgt=17
op
print v(1) v(2) v(3) v(4) v(5) v(6) v(7) v(8) v(9) v(10)
print v(11) v(12) v(13) v(14) v(15)
print i(vs0) i(vs1) i(vs2) i(vs3) i(vs4) i(vs5) i(vs6) i(vs7) i(vs8) i(vs9)
print i(vs10) i(vs11) i(vs12) i(vs13) i(vs14) i(vs15) i(vs16) i(vs17) i(vs18) i(vs19)
print i(vs20)
.endc
.end
