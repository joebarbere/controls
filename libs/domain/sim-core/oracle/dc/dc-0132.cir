controls oracle dc-0132
* Generated (plan F2.7, ADR 0012): do not edit; regenerate with `pnpm sim oracle regen`. dc seed 20261030 index 132 nodes 16 elements 25
.options sparse gmin=1e-12 noopac
RG1 1 0 1000000000000
RG2 2 0 1000000000000
RG3 3 0 1000000000000
RG4 4 0 1000000000000
RG5 5 0 1000000000000
RG6 6 0 1000000000000
RG7 7 0 1000000000000
RG8 8 0 1000000000000
RG9 9 0 1000000000000
RG10 10 0 1000000000000
RG11 11 0 1000000000000
RG12 12 0 1000000000000
RG13 13 0 1000000000000
RG14 14 0 1000000000000
RG15 15 0 1000000000000
VS0 1 s0 0
R0 s0 6 18e-2
VS1 0 s1 0
V1 e1 s1 DC 82e-1
RI1 e1 14 47e-1
VS2 13 s2 0
I2 s2 4 DC 39e-3
VS3 14 s3 0
R3 s3 9 10e0
VS4 5 s4 0
R4 s4 9 68e-1
VS5 0 s5 0
R5 s5 4 47e1
VS6 15 s6 0
R6 s6 7 33e0
VS7 12 s7 0
R7 s7 3 39e-2
VS8 12 s8 0
V8 e8 s8 DC 15e1
RI8 e8 15 82e-1
VS9 9 s9 0
V9 e9 s9 DC 82e0
RI9 e9 7 15e-2
VS10 9 s10 0
R10 s10 6 22e3
VS11 8 s11 0
R11 s11 13 39e0
VS12 11 s12 0
R12 s12 8 15e2
VS13 12 s13 0
R13 s13 3 47e-1
VS14 15 s14 0
V14 e14 s14 DC 56e-1
RI14 e14 6 33e-2
VS15 13 s15 0
R15 s15 4 22e1
VS16 13 s16 0
R16 s16 0 47e0
VS17 2 s17 0
R17 s17 8 10e-2
VS18 5 s18 0
V18 e18 s18 DC 15e0
RI18 e18 10 82e-1
VS19 11 s19 0
V19 e19 s19 DC 10e-1
RI19 e19 3 33e-2
VS20 13 s20 0
R20 s20 6 33e-2
VS21 3 s21 0
R21 s21 13 68e-2
VS22 4 s22 0
I22 s22 13 DC 56e-2
VS23 1 s23 0
R23 s23 4 39e0
VS24 10 s24 0
R24 s24 2 39e1
.control
set numdgt=17
op
print v(1) v(2) v(3) v(4) v(5) v(6) v(7) v(8) v(9) v(10)
print v(11) v(12) v(13) v(14) v(15)
print i(vs0) i(vs1) i(vs2) i(vs3) i(vs4) i(vs5) i(vs6) i(vs7) i(vs8) i(vs9)
print i(vs10) i(vs11) i(vs12) i(vs13) i(vs14) i(vs15) i(vs16) i(vs17) i(vs18) i(vs19)
print i(vs20) i(vs21) i(vs22) i(vs23) i(vs24)
.endc
.end
