controls oracle dc-0495
* Generated (plan F2.7, ADR 0012): do not edit; regenerate with `pnpm sim oracle regen`. dc seed 20261030 index 495 nodes 24 elements 34
.options sparse gmin=1e-12 noopac
RG1 1 0 1000000000000
RG2 2 0 1000000000000
RG3 3 0 1000000000000
RG4 4 0 1000000000000
RG5 5 0 1000000000000
RG6 6 0 1000000000000
RG7 7 0 1000000000000
RG8 8 0 1000000000000
RG9 9 0 1000000000000
RG10 10 0 1000000000000
RG11 11 0 1000000000000
RG12 12 0 1000000000000
RG13 13 0 1000000000000
RG14 14 0 1000000000000
RG15 15 0 1000000000000
RG16 16 0 1000000000000
RG17 17 0 1000000000000
RG18 18 0 1000000000000
RG19 19 0 1000000000000
RG20 20 0 1000000000000
RG21 21 0 1000000000000
RG22 22 0 1000000000000
RG23 23 0 1000000000000
VS0 22 s0 0
R0 s0 1 47e-2
VS1 0 s1 0
V1 e1 s1 DC 18e1
RI1 e1 12 15e-2
VS2 20 s2 0
R2 s2 23 68e2
VS3 0 s3 0
R3 s3 11 22e-2
VS4 14 s4 0
V4 e4 s4 DC 27e1
RI4 e4 6 15e-3
VS5 22 s5 0
R5 s5 13 56e1
VS6 20 s6 0
I6 s6 13 DC 47e-3
VS7 3 s7 0
R7 s7 19 22e-1
VS8 18 s8 0
R8 s8 15 68e3
VS9 17 s9 0
V9 e9 s9 DC 33e0
RI9 e9 5 12e-2
VS10 4 s10 0
R10 s10 1 39e-1
VS11 17 s11 0
V11 e11 s11 DC 15e0
RI11 e11 21 39e-3
VS12 13 s12 0
R12 s12 9 68e2
VS13 8 s13 0
V13 e13 s13 DC 39e-1
RI13 e13 23 27e-2
VS14 5 s14 0
R14 s14 9 39e-1
VS15 0 s15 0
R15 s15 8 33e-1
VS16 9 s16 0
R16 s16 20 18e0
VS17 18 s17 0
V17 e17 s17 DC 22e-1
RI17 e17 6 68e-2
VS18 10 s18 0
R18 s18 21 82e2
VS19 12 s19 0
R19 s19 7 10e0
VS20 23 s20 0
R20 s20 14 12e-1
VS21 19 s21 0
R21 s21 11 12e1
VS22 18 s22 0
V22 e22 s22 DC 82e-1
RI22 e22 19 15e-1
VS23 7 s23 0
R23 s23 15 68e2
VS24 23 s24 0
R24 s24 2 33e1
VS25 15 s25 0
R25 s25 0 68e3
VS26 2 s26 0
R26 s26 16 68e2
VS27 0 s27 0
R27 s27 5 82e2
VS28 3 s28 0
R28 s28 10 47e3
VS29 16 s29 0
R29 s29 1 39e-2
VS30 16 s30 0
R30 s30 5 22e3
VS31 0 s31 0
R31 s31 23 10e0
VS32 3 s32 0
R32 s32 6 56e2
VS33 4 s33 0
V33 e33 s33 DC 18e1
RI33 e33 21 15e-3
.control
set numdgt=17
op
print v(1) v(2) v(3) v(4) v(5) v(6) v(7) v(8) v(9) v(10)
print v(11) v(12) v(13) v(14) v(15) v(16) v(17) v(18) v(19) v(20)
print v(21) v(22) v(23)
print i(vs0) i(vs1) i(vs2) i(vs3) i(vs4) i(vs5) i(vs6) i(vs7) i(vs8) i(vs9)
print i(vs10) i(vs11) i(vs12) i(vs13) i(vs14) i(vs15) i(vs16) i(vs17) i(vs18) i(vs19)
print i(vs20) i(vs21) i(vs22) i(vs23) i(vs24) i(vs25) i(vs26) i(vs27) i(vs28) i(vs29)
print i(vs30) i(vs31) i(vs32) i(vs33)
.endc
.end
