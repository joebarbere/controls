controls oracle dc-0495
* Generated (plan F2.7, ADR 0012): do not edit; regenerate with `pnpm sim oracle regen`. dc seed 20261030 index 495 nodes 24 elements 25
.options sparse gmin=1e-12 noopac
RG1 1 0 1000000000000
RG2 2 0 1000000000000
RG3 3 0 1000000000000
RG4 4 0 1000000000000
RG5 5 0 1000000000000
RG6 6 0 1000000000000
RG7 7 0 1000000000000
RG8 8 0 1000000000000
RG9 9 0 1000000000000
RG10 10 0 1000000000000
RG11 11 0 1000000000000
RG12 12 0 1000000000000
RG13 13 0 1000000000000
RG14 14 0 1000000000000
RG15 15 0 1000000000000
RG16 16 0 1000000000000
RG17 17 0 1000000000000
RG18 18 0 1000000000000
RG19 19 0 1000000000000
RG20 20 0 1000000000000
RG21 21 0 1000000000000
RG22 22 0 1000000000000
RG23 23 0 1000000000000
VS0 19 s0 0
R0 s0 11 12e1
VS1 0 s1 0
V1 e1 s1 DC 33e0
RI1 e1 5 12e-2
VS2 0 s2 0
V2 e2 s2 DC 15e0
RI2 e2 21 39e-3
VS3 23 s3 0
R3 s3 2 33e1
VS4 23 s4 0
R4 s4 14 12e-1
VS5 20 s5 0
I5 s5 13 DC 47e-3
VS6 9 s6 0
R6 s6 20 18e0
VS7 13 s7 0
R7 s7 9 68e2
VS8 16 s8 0
R8 s8 5 22e3
VS9 14 s9 0
V9 e9 s9 DC 27e1
RI9 e9 6 15e-3
VS10 20 s10 0
R10 s10 23 68e2
VS11 12 s11 0
R11 s11 7 10e0
VS12 16 s12 0
R12 s12 1 39e-2
VS13 17 s13 0
R13 s13 23 10e0
VS14 3 s14 0
R14 s14 10 47e3
VS15 17 s15 0
R15 s15 5 82e2
VS16 22 s16 0
R16 s16 13 56e1
VS17 15 s17 0
R17 s17 17 68e3
VS18 4 s18 0
V18 e18 s18 DC 18e1
RI18 e18 21 15e-3
VS19 5 s19 0
R19 s19 9 39e-1
VS20 17 s20 0
V20 e20 s20 DC 18e1
RI20 e20 12 15e-2
VS21 17 s21 0
R21 s21 8 33e-1
VS22 18 s22 0
V22 e22 s22 DC 22e-1
RI22 e22 6 68e-2
VS23 3 s23 0
R23 s23 19 22e-1
VS24 3 s24 0
R24 s24 6 56e2
.control
set numdgt=17
op
print v(1) v(2) v(3) v(4) v(5) v(6) v(7) v(8) v(9) v(10)
print v(11) v(12) v(13) v(14) v(15) v(16) v(17) v(18) v(19) v(20)
print v(21) v(22) v(23)
print i(vs0) i(vs1) i(vs2) i(vs3) i(vs4) i(vs5) i(vs6) i(vs7) i(vs8) i(vs9)
print i(vs10) i(vs11) i(vs12) i(vs13) i(vs14) i(vs15) i(vs16) i(vs17) i(vs18) i(vs19)
print i(vs20) i(vs21) i(vs22) i(vs23) i(vs24)
.endc
.end
