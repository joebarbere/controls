controls oracle dc-0225
* Generated (plan F2.7, ADR 0012): do not edit; regenerate with `pnpm sim oracle regen`. dc seed 20261030 index 225 nodes 20 elements 33
.options sparse gmin=1e-12 noopac
RG1 1 0 1000000000000
RG2 2 0 1000000000000
RG3 3 0 1000000000000
RG4 4 0 1000000000000
RG5 5 0 1000000000000
RG6 6 0 1000000000000
RG7 7 0 1000000000000
RG8 8 0 1000000000000
RG9 9 0 1000000000000
RG10 10 0 1000000000000
RG11 11 0 1000000000000
RG12 12 0 1000000000000
RG13 13 0 1000000000000
RG14 14 0 1000000000000
RG15 15 0 1000000000000
RG16 16 0 1000000000000
RG17 17 0 1000000000000
RG18 18 0 1000000000000
RG19 19 0 1000000000000
VS0 12 s0 0
R0 s0 15 12e-2
VS1 3 s1 0
R1 s1 8 12e-2
VS2 3 s2 0
R2 s2 18 27e-1
VS3 11 s3 0
R3 s3 4 22e3
VS4 17 s4 0
I4 s4 18 DC 39e-4
VS5 19 s5 0
R5 s5 7 15e2
VS6 0 s6 0
I6 s6 6 DC 33e-1
VS7 7 s7 0
R7 s7 3 12e2
VS8 1 s8 0
R8 s8 2 39e1
VS9 19 s9 0
R9 s9 0 39e-2
VS10 0 s10 0
V10 e10 s10 DC 12e0
RI10 e10 7 27e-2
VS11 16 s11 0
R11 s11 18 10e3
VS12 2 s12 0
R12 s12 10 68e2
VS13 9 s13 0
R13 s13 0 22e-1
VS14 5 s14 0
R14 s14 14 10e-1
VS15 5 s15 0
R15 s15 11 33e2
VS16 0 s16 0
R16 s16 3 18e0
VS17 6 s17 0
R17 s17 1 12e1
VS18 2 s18 0
I18 s18 1 DC 68e-3
VS19 19 s19 0
R19 s19 13 10e2
VS20 9 s20 0
R20 s20 16 39e3
VS21 7 s21 0
V21 e21 s21 DC 18e-1
RI21 e21 10 82e-3
VS22 17 s22 0
R22 s22 10 15e-2
VS23 9 s23 0
V23 e23 s23 DC 15e-1
RI23 e23 15 18e-2
VS24 18 s24 0
R24 s24 2 39e0
VS25 10 s25 0
V25 e25 s25 DC 18e1
RI25 e25 11 12e-3
VS26 13 s26 0
R26 s26 18 56e1
VS27 15 s27 0
R27 s27 5 68e3
VS28 1 s28 0
V28 e28 s28 DC 18e1
RI28 e28 19 15e-3
VS29 17 s29 0
V29 e29 s29 DC 47e1
RI29 e29 14 27e-1
VS30 19 s30 0
R30 s30 4 39e0
VS31 19 s31 0
V31 e31 s31 DC 27e1
RI31 e31 12 47e-1
VS32 16 s32 0
R32 s32 0 22e-1
.control
set numdgt=17
op
print v(1) v(2) v(3) v(4) v(5) v(6) v(7) v(8) v(9) v(10)
print v(11) v(12) v(13) v(14) v(15) v(16) v(17) v(18) v(19)
print i(vs0) i(vs1) i(vs2) i(vs3) i(vs4) i(vs5) i(vs6) i(vs7) i(vs8) i(vs9)
print i(vs10) i(vs11) i(vs12) i(vs13) i(vs14) i(vs15) i(vs16) i(vs17) i(vs18) i(vs19)
print i(vs20) i(vs21) i(vs22) i(vs23) i(vs24) i(vs25) i(vs26) i(vs27) i(vs28) i(vs29)
print i(vs30) i(vs31) i(vs32)
.endc
.end
