controls oracle dc-0122
* Generated (plan F2.7, ADR 0012): do not edit; regenerate with `pnpm sim oracle regen`. dc seed 20261030 index 122 nodes 21 elements 45
.options sparse gmin=1e-12 noopac
RG1 1 0 1000000000000
RG2 2 0 1000000000000
RG3 3 0 1000000000000
RG4 4 0 1000000000000
RG5 5 0 1000000000000
RG6 6 0 1000000000000
RG7 7 0 1000000000000
RG8 8 0 1000000000000
RG9 9 0 1000000000000
RG10 10 0 1000000000000
RG11 11 0 1000000000000
RG12 12 0 1000000000000
RG13 13 0 1000000000000
RG14 14 0 1000000000000
RG15 15 0 1000000000000
RG16 16 0 1000000000000
RG17 17 0 1000000000000
RG18 18 0 1000000000000
RG19 19 0 1000000000000
RG20 20 0 1000000000000
VS0 6 s0 0
R0 s0 18 22e1
VS1 8 s1 0
R1 s1 6 27e3
VS2 1 s2 0
R2 s2 18 33e-2
VS3 7 s3 0
R3 s3 3 39e-1
VS4 11 s4 0
R4 s4 8 68e1
VS5 16 s5 0
R5 s5 9 82e2
VS6 12 s6 0
R6 s6 10 47e-2
VS7 0 s7 0
V7 e7 s7 DC 39e0
RI7 e7 11 68e-2
VS8 3 s8 0
V8 e8 s8 DC 47e-1
RI8 e8 5 39e-2
VS9 20 s9 0
R9 s9 12 33e0
VS10 15 s10 0
I10 s10 16 DC 56e-3
VS11 4 s11 0
V11 e11 s11 DC 47e0
RI11 e11 15 18e-1
VS12 19 s12 0
R12 s12 12 82e0
VS13 3 s13 0
R13 s13 9 68e0
VS14 3 s14 0
R14 s14 15 18e3
VS15 19 s15 0
R15 s15 3 12e2
VS16 13 s16 0
R16 s16 0 33e3
VS17 7 s17 0
I17 s17 19 DC 68e-4
VS18 1 s18 0
R18 s18 4 33e-1
VS19 4 s19 0
R19 s19 11 33e-2
VS20 18 s20 0
R20 s20 16 33e2
VS21 15 s21 0
R21 s21 9 15e2
VS22 0 s22 0
I22 s22 18 DC 56e-1
VS23 6 s23 0
R23 s23 18 18e-1
VS24 12 s24 0
R24 s24 15 82e1
VS25 15 s25 0
R25 s25 11 33e2
VS26 2 s26 0
R26 s26 20 15e1
VS27 6 s27 0
I27 s27 3 DC 10e-1
VS28 3 s28 0
R28 s28 0 39e3
VS29 5 s29 0
R29 s29 2 10e1
VS30 11 s30 0
R30 s30 20 47e2
VS31 20 s31 0
R31 s31 11 68e1
VS32 17 s32 0
V32 e32 s32 DC 82e1
RI32 e32 6 47e-3
VS33 7 s33 0
R33 s33 14 47e-1
VS34 20 s34 0
I34 s34 7 DC 68e-1
VS35 12 s35 0
R35 s35 13 47e2
VS36 20 s36 0
R36 s36 13 82e-1
VS37 6 s37 0
R37 s37 18 56e1
VS38 1 s38 0
I38 s38 0 DC 18e-3
VS39 11 s39 0
R39 s39 14 22e0
VS40 6 s40 0
R40 s40 15 33e-2
VS41 7 s41 0
R41 s41 1 27e0
VS42 16 s42 0
I42 s42 14 DC 22e-1
VS43 10 s43 0
R43 s43 0 68e2
VS44 17 s44 0
V44 e44 s44 DC 68e1
RI44 e44 13 27e-2
.control
set numdgt=17
op
print v(1) v(2) v(3) v(4) v(5) v(6) v(7) v(8) v(9) v(10)
print v(11) v(12) v(13) v(14) v(15) v(16) v(17) v(18) v(19) v(20)
print i(vs0) i(vs1) i(vs2) i(vs3) i(vs4) i(vs5) i(vs6) i(vs7) i(vs8) i(vs9)
print i(vs10) i(vs11) i(vs12) i(vs13) i(vs14) i(vs15) i(vs16) i(vs17) i(vs18) i(vs19)
print i(vs20) i(vs21) i(vs22) i(vs23) i(vs24) i(vs25) i(vs26) i(vs27) i(vs28) i(vs29)
print i(vs30) i(vs31) i(vs32) i(vs33) i(vs34) i(vs35) i(vs36) i(vs37) i(vs38) i(vs39)
print i(vs40) i(vs41) i(vs42) i(vs43) i(vs44)
.endc
.end
