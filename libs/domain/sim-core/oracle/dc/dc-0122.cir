controls oracle dc-0122
* Generated (plan F2.7, ADR 0012): do not edit; regenerate with `pnpm sim oracle regen`. dc seed 20261030 index 122 nodes 21 elements 40
.options sparse gmin=1e-12 noopac
RG1 1 0 1000000000000
RG2 2 0 1000000000000
RG3 3 0 1000000000000
RG4 4 0 1000000000000
RG5 5 0 1000000000000
RG6 6 0 1000000000000
RG7 7 0 1000000000000
RG8 8 0 1000000000000
RG9 9 0 1000000000000
RG10 10 0 1000000000000
RG11 11 0 1000000000000
RG12 12 0 1000000000000
RG13 13 0 1000000000000
RG14 14 0 1000000000000
RG15 15 0 1000000000000
RG16 16 0 1000000000000
RG17 17 0 1000000000000
RG18 18 0 1000000000000
RG19 19 0 1000000000000
RG20 20 0 1000000000000
VS0 3 s0 0
R0 s0 15 82e1
VS1 0 s1 0
V1 e1 s1 DC 47e-1
RI1 e1 5 39e-2
VS2 16 s2 0
I2 s2 14 DC 22e-1
VS3 17 s3 0
V3 e3 s3 DC 68e1
RI3 e3 13 27e-2
VS4 3 s4 0
R4 s4 10 47e-2
VS5 7 s5 0
R5 s5 0 39e-1
VS6 3 s6 0
R6 s6 13 47e2
VS7 5 s7 0
R7 s7 2 10e1
VS8 11 s8 0
R8 s8 8 68e1
VS9 4 s9 0
V9 e9 s9 DC 47e0
RI9 e9 15 18e-1
VS10 20 s10 0
R10 s10 3 33e0
VS11 1 s11 0
R11 s11 18 33e-2
VS12 20 s12 0
I12 s12 7 DC 68e-1
VS13 7 s13 0
R13 s13 1 27e0
VS14 6 s14 0
R14 s14 18 22e1
VS15 6 s15 0
R15 s15 15 33e-2
VS16 15 s16 0
R16 s16 11 33e2
VS17 19 s17 0
R17 s17 0 12e2
VS18 17 s18 0
V18 e18 s18 DC 82e1
RI18 e18 6 47e-3
VS19 0 s19 0
R19 s19 12 39e3
VS20 7 s20 0
R20 s20 14 47e-1
VS21 4 s21 0
R21 s21 11 33e-2
VS22 0 s22 0
R22 s22 9 68e0
VS23 20 s23 0
R23 s23 13 82e-1
VS24 1 s24 0
I24 s24 12 DC 18e-3
VS25 15 s25 0
I25 s25 16 DC 56e-3
VS26 12 s26 0
V26 e26 s26 DC 39e0
RI26 e26 11 68e-2
VS27 6 s27 0
I27 s27 0 DC 10e-1
VS28 1 s28 0
R28 s28 4 33e-1
VS29 11 s29 0
R29 s29 14 22e0
VS30 13 s30 0
R30 s30 12 33e3
VS31 6 s31 0
R31 s31 18 18e-1
VS32 0 s32 0
R32 s32 15 18e3
VS33 11 s33 0
R33 s33 20 47e2
VS34 6 s34 0
R34 s34 18 56e1
VS35 12 s35 0
I35 s35 18 DC 56e-1
VS36 20 s36 0
R36 s36 11 68e1
VS37 7 s37 0
I37 s37 19 DC 68e-4
VS38 18 s38 0
R38 s38 16 33e2
VS39 2 s39 0
R39 s39 20 15e1
.control
set numdgt=17
op
print v(1) v(2) v(3) v(4) v(5) v(6) v(7) v(8) v(9) v(10)
print v(11) v(12) v(13) v(14) v(15) v(16) v(17) v(18) v(19) v(20)
print i(vs0) i(vs1) i(vs2) i(vs3) i(vs4) i(vs5) i(vs6) i(vs7) i(vs8) i(vs9)
print i(vs10) i(vs11) i(vs12) i(vs13) i(vs14) i(vs15) i(vs16) i(vs17) i(vs18) i(vs19)
print i(vs20) i(vs21) i(vs22) i(vs23) i(vs24) i(vs25) i(vs26) i(vs27) i(vs28) i(vs29)
print i(vs30) i(vs31) i(vs32) i(vs33) i(vs34) i(vs35) i(vs36) i(vs37) i(vs38) i(vs39)
.endc
.end
