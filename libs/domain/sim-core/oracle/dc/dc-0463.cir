controls oracle dc-0463
* Generated (plan F2.7, ADR 0012): do not edit; regenerate with `pnpm sim oracle regen`. dc seed 20261030 index 463 nodes 24 elements 40
.options sparse gmin=1e-12 noopac
RG1 1 0 1000000000000
RG2 2 0 1000000000000
RG3 3 0 1000000000000
RG4 4 0 1000000000000
RG5 5 0 1000000000000
RG6 6 0 1000000000000
RG7 7 0 1000000000000
RG8 8 0 1000000000000
RG9 9 0 1000000000000
RG10 10 0 1000000000000
RG11 11 0 1000000000000
RG12 12 0 1000000000000
RG13 13 0 1000000000000
RG14 14 0 1000000000000
RG15 15 0 1000000000000
RG16 16 0 1000000000000
RG17 17 0 1000000000000
RG18 18 0 1000000000000
RG19 19 0 1000000000000
RG20 20 0 1000000000000
RG21 21 0 1000000000000
RG22 22 0 1000000000000
RG23 23 0 1000000000000
VS0 1 s0 0
R0 s0 21 15e0
VS1 1 s1 0
R1 s1 0 22e3
VS2 17 s2 0
R2 s2 18 56e0
VS3 0 s3 0
V3 e3 s3 DC 10e-1
RI3 e3 22 82e-1
VS4 20 s4 0
R4 s4 2 15e3
VS5 7 s5 0
R5 s5 8 22e3
VS6 4 s6 0
R6 s6 13 22e-2
VS7 11 s7 0
R7 s7 21 68e1
VS8 5 s8 0
V8 e8 s8 DC 10e0
RI8 e8 22 56e-1
VS9 13 s9 0
R9 s9 20 12e3
VS10 8 s10 0
R10 s10 21 27e-2
VS11 3 s11 0
R11 s11 23 22e3
VS12 6 s12 0
R12 s12 1 10e1
VS13 16 s13 0
R13 s13 2 82e-1
VS14 15 s14 0
R14 s14 1 39e2
VS15 16 s15 0
R15 s15 10 33e3
VS16 18 s16 0
R16 s16 6 33e-1
VS17 11 s17 0
R17 s17 9 27e-2
VS18 14 s18 0
R18 s18 5 15e-1
VS19 18 s19 0
R19 s19 12 10e-1
VS20 5 s20 0
R20 s20 17 56e3
VS21 4 s21 0
R21 s21 6 82e-1
VS22 10 s22 0
R22 s22 1 68e-1
VS23 6 s23 0
R23 s23 18 47e1
VS24 1 s24 0
R24 s24 2 39e2
VS25 5 s25 0
R25 s25 6 47e2
VS26 3 s26 0
I26 s26 9 DC 15e-3
VS27 14 s27 0
R27 s27 15 10e-1
VS28 3 s28 0
R28 s28 14 56e1
VS29 4 s29 0
V29 e29 s29 DC 12e1
RI29 e29 6 27e-1
VS30 12 s30 0
I30 s30 20 DC 56e-4
VS31 7 s31 0
R31 s31 21 18e-2
VS32 10 s32 0
R32 s32 8 12e-2
VS33 5 s33 0
V33 e33 s33 DC 39e-1
RI33 e33 9 33e-1
VS34 10 s34 0
R34 s34 23 22e2
VS35 8 s35 0
V35 e35 s35 DC 22e0
RI35 e35 9 12e-1
VS36 1 s36 0
V36 e36 s36 DC 15e-1
RI36 e36 19 12e-1
VS37 20 s37 0
R37 s37 4 12e-2
VS38 12 s38 0
R38 s38 19 68e1
VS39 5 s39 0
R39 s39 21 68e2
.control
set numdgt=17
op
print v(1) v(2) v(3) v(4) v(5) v(6) v(7) v(8) v(9) v(10)
print v(11) v(12) v(13) v(14) v(15) v(16) v(17) v(18) v(19) v(20)
print v(21) v(22) v(23)
print i(vs0) i(vs1) i(vs2) i(vs3) i(vs4) i(vs5) i(vs6) i(vs7) i(vs8) i(vs9)
print i(vs10) i(vs11) i(vs12) i(vs13) i(vs14) i(vs15) i(vs16) i(vs17) i(vs18) i(vs19)
print i(vs20) i(vs21) i(vs22) i(vs23) i(vs24) i(vs25) i(vs26) i(vs27) i(vs28) i(vs29)
print i(vs30) i(vs31) i(vs32) i(vs33) i(vs34) i(vs35) i(vs36) i(vs37) i(vs38) i(vs39)
.endc
.end
