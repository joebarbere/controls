controls oracle dc-0463
* Generated (plan F2.7, ADR 0012): do not edit; regenerate with `pnpm sim oracle regen`. dc seed 20261030 index 463 nodes 24 elements 35
.options sparse gmin=1e-12 noopac
RG1 1 0 1000000000000
RG2 2 0 1000000000000
RG3 3 0 1000000000000
RG4 4 0 1000000000000
RG5 5 0 1000000000000
RG6 6 0 1000000000000
RG7 7 0 1000000000000
RG8 8 0 1000000000000
RG9 9 0 1000000000000
RG10 10 0 1000000000000
RG11 11 0 1000000000000
RG12 12 0 1000000000000
RG13 13 0 1000000000000
RG14 14 0 1000000000000
RG15 15 0 1000000000000
RG16 16 0 1000000000000
RG17 17 0 1000000000000
RG18 18 0 1000000000000
RG19 19 0 1000000000000
RG20 20 0 1000000000000
RG21 21 0 1000000000000
RG22 22 0 1000000000000
RG23 23 0 1000000000000
VS0 4 s0 0
R0 s0 1 82e-1
VS1 0 s1 0
V1 e1 s1 DC 15e-1
RI1 e1 19 12e-1
VS2 16 s2 0
R2 s2 10 33e3
VS3 15 s3 0
R3 s3 0 39e2
VS4 13 s4 0
R4 s4 20 12e3
VS5 5 s5 0
V5 e5 s5 DC 10e0
RI5 e5 22 56e-1
VS6 1 s6 0
R6 s6 18 47e1
VS7 0 s7 0
R7 s7 2 39e2
VS8 4 s8 0
V8 e8 s8 DC 12e1
RI8 e8 1 27e-1
VS9 5 s9 0
V9 e9 s9 DC 39e-1
RI9 e9 9 33e-1
VS10 20 s10 0
R10 s10 2 15e3
VS11 17 s11 0
R11 s11 18 56e0
VS12 0 s12 0
R12 s12 21 15e0
VS13 12 s13 0
I13 s13 20 DC 56e-4
VS14 5 s14 0
R14 s14 17 56e3
VS15 8 s15 0
R15 s15 21 27e-2
VS16 7 s16 0
R16 s16 8 22e3
VS17 3 s17 0
I17 s17 9 DC 15e-3
VS18 14 s18 0
R18 s18 5 15e-1
VS19 10 s19 0
R19 s19 23 22e2
VS20 0 s20 0
R20 s20 6 22e3
VS21 5 s21 0
R21 s21 1 47e2
VS22 20 s22 0
R22 s22 4 12e-2
VS23 8 s23 0
V23 e23 s23 DC 22e0
RI23 e23 9 12e-1
VS24 10 s24 0
R24 s24 0 68e-1
VS25 6 s25 0
V25 e25 s25 DC 10e-1
RI25 e25 22 82e-1
VS26 11 s26 0
R26 s26 9 27e-2
VS27 4 s27 0
R27 s27 13 22e-2
VS28 5 s28 0
R28 s28 21 68e2
VS29 10 s29 0
R29 s29 8 12e-2
VS30 3 s30 0
R30 s30 14 56e1
VS31 7 s31 0
R31 s31 21 18e-2
VS32 18 s32 0
R32 s32 1 33e-1
VS33 1 s33 0
R33 s33 0 10e1
VS34 12 s34 0
R34 s34 19 68e1
.control
set numdgt=17
op
print v(1) v(2) v(3) v(4) v(5) v(6) v(7) v(8) v(9) v(10)
print v(11) v(12) v(13) v(14) v(15) v(16) v(17) v(18) v(19) v(20)
print v(21) v(22) v(23)
print i(vs0) i(vs1) i(vs2) i(vs3) i(vs4) i(vs5) i(vs6) i(vs7) i(vs8) i(vs9)
print i(vs10) i(vs11) i(vs12) i(vs13) i(vs14) i(vs15) i(vs16) i(vs17) i(vs18) i(vs19)
print i(vs20) i(vs21) i(vs22) i(vs23) i(vs24) i(vs25) i(vs26) i(vs27) i(vs28) i(vs29)
print i(vs30) i(vs31) i(vs32) i(vs33) i(vs34)
.endc
.end
