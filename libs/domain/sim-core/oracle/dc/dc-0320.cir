controls oracle dc-0320
* Generated (plan F2.7, ADR 0012): do not edit; regenerate with `pnpm sim oracle regen`. dc seed 20261030 index 320 nodes 26 elements 48
.options sparse gmin=1e-12 noopac
RG1 1 0 1000000000000
RG2 2 0 1000000000000
RG3 3 0 1000000000000
RG4 4 0 1000000000000
RG5 5 0 1000000000000
RG6 6 0 1000000000000
RG7 7 0 1000000000000
RG8 8 0 1000000000000
RG9 9 0 1000000000000
RG10 10 0 1000000000000
RG11 11 0 1000000000000
RG12 12 0 1000000000000
RG13 13 0 1000000000000
RG14 14 0 1000000000000
RG15 15 0 1000000000000
RG16 16 0 1000000000000
RG17 17 0 1000000000000
RG18 18 0 1000000000000
RG19 19 0 1000000000000
RG20 20 0 1000000000000
RG21 21 0 1000000000000
RG22 22 0 1000000000000
RG23 23 0 1000000000000
RG24 24 0 1000000000000
RG25 25 0 1000000000000
VS0 22 s0 0
R0 s0 4 18e1
VS1 25 s1 0
R1 s1 8 68e0
VS2 0 s2 0
V2 e2 s2 DC 27e-1
RI2 e2 16 18e-2
VS3 5 s3 0
V3 e3 s3 DC 47e-1
RI3 e3 7 15e-2
VS4 0 s4 0
V4 e4 s4 DC 15e-1
RI4 e4 13 22e-1
VS5 10 s5 0
R5 s5 24 18e0
VS6 9 s6 0
R6 s6 3 22e0
VS7 21 s7 0
R7 s7 11 68e0
VS8 7 s8 0
V8 e8 s8 DC 68e-1
RI8 e8 21 22e-3
VS9 19 s9 0
R9 s9 25 12e-2
VS10 9 s10 0
I10 s10 0 DC 12e-4
VS11 20 s11 0
R11 s11 8 47e0
VS12 25 s12 0
R12 s12 23 15e0
VS13 7 s13 0
R13 s13 17 47e0
VS14 8 s14 0
R14 s14 2 12e2
VS15 25 s15 0
R15 s15 10 10e2
VS16 10 s16 0
I16 s16 19 DC 27e-1
VS17 12 s17 0
I17 s17 10 DC 27e-1
VS18 13 s18 0
R18 s18 24 12e3
VS19 10 s19 0
V19 e19 s19 DC 12e0
RI19 e19 7 56e-3
VS20 21 s20 0
R20 s20 5 56e1
VS21 22 s21 0
I21 s21 3 DC 22e-1
VS22 8 s22 0
I22 s22 0 DC 68e-4
VS23 7 s23 0
R23 s23 4 27e1
VS24 19 s24 0
R24 s24 9 12e-2
VS25 1 s25 0
R25 s25 4 12e-1
VS26 24 s26 0
R26 s26 19 27e1
VS27 15 s27 0
R27 s27 20 27e2
VS28 1 s28 0
R28 s28 4 82e0
VS29 18 s29 0
R29 s29 16 39e0
VS30 14 s30 0
R30 s30 2 33e2
VS31 23 s31 0
R31 s31 9 56e3
VS32 18 s32 0
R32 s32 22 10e0
VS33 5 s33 0
R33 s33 21 47e-2
VS34 7 s34 0
R34 s34 19 82e-1
VS35 1 s35 0
R35 s35 12 12e-2
VS36 3 s36 0
V36 e36 s36 DC 18e1
RI36 e36 20 82e-1
VS37 15 s37 0
R37 s37 11 18e1
VS38 14 s38 0
I38 s38 17 DC 10e-4
VS39 5 s39 0
R39 s39 14 22e-1
VS40 3 s40 0
I40 s40 11 DC 10e-2
VS41 13 s41 0
R41 s41 6 47e-1
VS42 2 s42 0
R42 s42 5 27e2
VS43 25 s43 0
R43 s43 6 10e-1
VS44 18 s44 0
R44 s44 21 10e2
VS45 17 s45 0
R45 s45 15 10e1
VS46 22 s46 0
R46 s46 6 82e3
VS47 12 s47 0
R47 s47 20 47e-2
.control
set numdgt=17
op
print v(1) v(2) v(3) v(4) v(5) v(6) v(7) v(8) v(9) v(10)
print v(11) v(12) v(13) v(14) v(15) v(16) v(17) v(18) v(19) v(20)
print v(21) v(22) v(23) v(24) v(25)
print i(vs0) i(vs1) i(vs2) i(vs3) i(vs4) i(vs5) i(vs6) i(vs7) i(vs8) i(vs9)
print i(vs10) i(vs11) i(vs12) i(vs13) i(vs14) i(vs15) i(vs16) i(vs17) i(vs18) i(vs19)
print i(vs20) i(vs21) i(vs22) i(vs23) i(vs24) i(vs25) i(vs26) i(vs27) i(vs28) i(vs29)
print i(vs30) i(vs31) i(vs32) i(vs33) i(vs34) i(vs35) i(vs36) i(vs37) i(vs38) i(vs39)
print i(vs40) i(vs41) i(vs42) i(vs43) i(vs44) i(vs45) i(vs46) i(vs47)
.endc
.end
