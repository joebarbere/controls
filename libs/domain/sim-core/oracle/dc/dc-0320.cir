controls oracle dc-0320
* Generated (plan F2.7, ADR 0012): do not edit; regenerate with `pnpm sim oracle regen`. dc seed 20261030 index 320 nodes 26 elements 45
.options sparse gmin=1e-12 noopac
RG1 1 0 1000000000000
RG2 2 0 1000000000000
RG3 3 0 1000000000000
RG4 4 0 1000000000000
RG5 5 0 1000000000000
RG6 6 0 1000000000000
RG7 7 0 1000000000000
RG8 8 0 1000000000000
RG9 9 0 1000000000000
RG10 10 0 1000000000000
RG11 11 0 1000000000000
RG12 12 0 1000000000000
RG13 13 0 1000000000000
RG14 14 0 1000000000000
RG15 15 0 1000000000000
RG16 16 0 1000000000000
RG17 17 0 1000000000000
RG18 18 0 1000000000000
RG19 19 0 1000000000000
RG20 20 0 1000000000000
RG21 21 0 1000000000000
RG22 22 0 1000000000000
RG23 23 0 1000000000000
RG24 24 0 1000000000000
RG25 25 0 1000000000000
VS0 3 s0 0
I0 s0 11 DC 10e-2
VS1 7 s1 0
R1 s1 4 27e1
VS2 1 s2 0
R2 s2 12 12e-2
VS3 0 s3 0
V3 e3 s3 DC 12e0
RI3 e3 7 56e-3
VS4 5 s4 0
V4 e4 s4 DC 47e-1
RI4 e4 7 15e-2
VS5 21 s5 0
R5 s5 5 56e1
VS6 19 s6 0
R6 s6 25 12e-2
VS7 12 s7 0
I7 s7 0 DC 27e-1
VS8 22 s8 0
R8 s8 4 18e1
VS9 22 s9 0
R9 s9 10 82e3
VS10 1 s10 0
R10 s10 4 82e0
VS11 15 s11 0
R11 s11 11 18e1
VS12 18 s12 0
R12 s12 22 10e0
VS13 15 s13 0
R13 s13 20 27e2
VS14 5 s14 0
R14 s14 21 47e-2
VS15 25 s15 0
R15 s15 0 10e2
VS16 13 s16 0
R16 s16 10 47e-1
VS17 7 s17 0
R17 s17 19 82e-1
VS18 0 s18 0
R18 s18 24 18e0
VS19 14 s19 0
R19 s19 2 33e2
VS20 9 s20 0
I20 s20 6 DC 12e-4
VS21 13 s21 0
R21 s21 24 12e3
VS22 17 s22 0
R22 s22 15 10e1
VS23 21 s23 0
R23 s23 11 68e0
VS24 1 s24 0
R24 s24 4 12e-1
VS25 18 s25 0
R25 s25 16 39e0
VS26 5 s26 0
R26 s26 14 22e-1
VS27 9 s27 0
R27 s27 3 22e0
VS28 2 s28 0
R28 s28 5 27e2
VS29 7 s29 0
V29 e29 s29 DC 68e-1
RI29 e29 21 22e-3
VS30 0 s30 0
I30 s30 19 DC 27e-1
VS31 8 s31 0
I31 s31 6 DC 68e-4
VS32 23 s32 0
R32 s32 9 56e3
VS33 25 s33 0
R33 s33 23 15e0
VS34 25 s34 0
R34 s34 8 68e0
VS35 6 s35 0
V35 e35 s35 DC 15e-1
RI35 e35 13 22e-1
VS36 25 s36 0
R36 s36 10 10e-1
VS37 19 s37 0
R37 s37 9 12e-2
VS38 3 s38 0
V38 e38 s38 DC 18e1
RI38 e38 20 82e-1
VS39 18 s39 0
R39 s39 21 10e2
VS40 7 s40 0
R40 s40 17 47e0
VS41 22 s41 0
I41 s41 3 DC 22e-1
VS42 24 s42 0
R42 s42 19 27e1
VS43 14 s43 0
I43 s43 17 DC 10e-4
VS44 20 s44 0
R44 s44 8 47e0
.control
set numdgt=17
op
print v(1) v(2) v(3) v(4) v(5) v(6) v(7) v(8) v(9) v(10)
print v(11) v(12) v(13) v(14) v(15) v(16) v(17) v(18) v(19) v(20)
print v(21) v(22) v(23) v(24) v(25)
print i(vs0) i(vs1) i(vs2) i(vs3) i(vs4) i(vs5) i(vs6) i(vs7) i(vs8) i(vs9)
print i(vs10) i(vs11) i(vs12) i(vs13) i(vs14) i(vs15) i(vs16) i(vs17) i(vs18) i(vs19)
print i(vs20) i(vs21) i(vs22) i(vs23) i(vs24) i(vs25) i(vs26) i(vs27) i(vs28) i(vs29)
print i(vs30) i(vs31) i(vs32) i(vs33) i(vs34) i(vs35) i(vs36) i(vs37) i(vs38) i(vs39)
print i(vs40) i(vs41) i(vs42) i(vs43) i(vs44)
.endc
.end
