controls oracle dc-0210
* Generated (plan F2.7, ADR 0012): do not edit; regenerate with `pnpm sim oracle regen`. dc seed 20261030 index 210 nodes 28 elements 55
.options sparse gmin=1e-12 noopac
RG1 1 0 1000000000000
RG2 2 0 1000000000000
RG3 3 0 1000000000000
RG4 4 0 1000000000000
RG5 5 0 1000000000000
RG6 6 0 1000000000000
RG7 7 0 1000000000000
RG8 8 0 1000000000000
RG9 9 0 1000000000000
RG10 10 0 1000000000000
RG11 11 0 1000000000000
RG12 12 0 1000000000000
RG13 13 0 1000000000000
RG14 14 0 1000000000000
RG15 15 0 1000000000000
RG16 16 0 1000000000000
RG17 17 0 1000000000000
RG18 18 0 1000000000000
RG19 19 0 1000000000000
RG20 20 0 1000000000000
RG21 21 0 1000000000000
RG22 22 0 1000000000000
RG23 23 0 1000000000000
RG24 24 0 1000000000000
RG25 25 0 1000000000000
RG26 26 0 1000000000000
RG27 27 0 1000000000000
VS0 4 s0 0
I0 s0 3 DC 10e-1
VS1 12 s1 0
R1 s1 18 68e2
VS2 0 s2 0
R2 s2 26 27e1
VS3 0 s3 0
V3 e3 s3 DC 68e1
RI3 e3 6 68e-1
VS4 6 s4 0
R4 s4 10 39e3
VS5 6 s5 0
V5 e5 s5 DC 27e-1
RI5 e5 25 18e-2
VS6 11 s6 0
R6 s6 14 82e3
VS7 5 s7 0
R7 s7 13 15e-1
VS8 24 s8 0
R8 s8 16 15e-2
VS9 9 s9 0
R9 s9 27 27e3
VS10 17 s10 0
I10 s10 6 DC 18e-3
VS11 23 s11 0
V11 e11 s11 DC 39e1
RI11 e11 3 56e-1
VS12 17 s12 0
R12 s12 21 82e0
VS13 16 s13 0
V13 e13 s13 DC 82e-1
RI13 e13 10 68e-3
VS14 2 s14 0
R14 s14 21 15e-1
VS15 0 s15 0
I15 s15 7 DC 47e-1
VS16 20 s16 0
R16 s16 16 18e1
VS17 7 s17 0
R17 s17 23 39e3
VS18 15 s18 0
R18 s18 12 68e2
VS19 5 s19 0
I19 s19 16 DC 27e-2
VS20 8 s20 0
R20 s20 21 56e3
VS21 8 s21 0
R21 s21 23 12e-1
VS22 2 s22 0
R22 s22 8 33e-1
VS23 6 s23 0
R23 s23 17 22e0
VS24 6 s24 0
I24 s24 14 DC 27e-4
VS25 3 s25 0
R25 s25 23 39e1
VS26 17 s26 0
R26 s26 7 56e-2
VS27 10 s27 0
R27 s27 22 22e-2
VS28 14 s28 0
R28 s28 4 82e-2
VS29 7 s29 0
R29 s29 2 47e-1
VS30 22 s30 0
R30 s30 23 47e-1
VS31 19 s31 0
R31 s31 23 33e2
VS32 13 s32 0
R32 s32 4 56e-1
VS33 27 s33 0
V33 e33 s33 DC 39e0
RI33 e33 6 39e-1
VS34 26 s34 0
R34 s34 22 56e2
VS35 27 s35 0
R35 s35 13 39e0
VS36 13 s36 0
R36 s36 7 47e1
VS37 1 s37 0
V37 e37 s37 DC 10e-1
RI37 e37 7 12e-3
VS38 9 s38 0
R38 s38 18 18e3
VS39 7 s39 0
V39 e39 s39 DC 39e0
RI39 e39 9 15e-1
VS40 3 s40 0
I40 s40 20 DC 10e-1
VS41 11 s41 0
R41 s41 9 47e-1
VS42 20 s42 0
R42 s42 7 15e2
VS43 16 s43 0
R43 s43 4 47e-2
VS44 7 s44 0
I44 s44 3 DC 56e-2
VS45 25 s45 0
R45 s45 6 39e0
VS46 18 s46 0
R46 s46 23 15e-1
VS47 24 s47 0
V47 e47 s47 DC 39e0
RI47 e47 7 22e-2
VS48 12 s48 0
R48 s48 7 15e3
VS49 23 s49 0
V49 e49 s49 DC 18e1
RI49 e49 11 47e-2
VS50 20 s50 0
R50 s50 1 10e-1
VS51 15 s51 0
R51 s51 20 12e-1
VS52 1 s52 0
I52 s52 21 DC 47e-1
VS53 23 s53 0
R53 s53 15 12e-1
VS54 5 s54 0
R54 s54 6 12e-1
.control
set numdgt=17
op
print v(1) v(2) v(3) v(4) v(5) v(6) v(7) v(8) v(9) v(10)
print v(11) v(12) v(13) v(14) v(15) v(16) v(17) v(18) v(19) v(20)
print v(21) v(22) v(23) v(24) v(25) v(26) v(27)
print i(vs0) i(vs1) i(vs2) i(vs3) i(vs4) i(vs5) i(vs6) i(vs7) i(vs8) i(vs9)
print i(vs10) i(vs11) i(vs12) i(vs13) i(vs14) i(vs15) i(vs16) i(vs17) i(vs18) i(vs19)
print i(vs20) i(vs21) i(vs22) i(vs23) i(vs24) i(vs25) i(vs26) i(vs27) i(vs28) i(vs29)
print i(vs30) i(vs31) i(vs32) i(vs33) i(vs34) i(vs35) i(vs36) i(vs37) i(vs38) i(vs39)
print i(vs40) i(vs41) i(vs42) i(vs43) i(vs44) i(vs45) i(vs46) i(vs47) i(vs48) i(vs49)
print i(vs50) i(vs51) i(vs52) i(vs53) i(vs54)
.endc
.end
