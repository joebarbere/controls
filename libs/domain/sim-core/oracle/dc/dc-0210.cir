controls oracle dc-0210
* Generated (plan F2.7, ADR 0012): do not edit; regenerate with `pnpm sim oracle regen`. dc seed 20261030 index 210 nodes 28 elements 58
.options sparse gmin=1e-12 noopac
RG1 1 0 1000000000000
RG2 2 0 1000000000000
RG3 3 0 1000000000000
RG4 4 0 1000000000000
RG5 5 0 1000000000000
RG6 6 0 1000000000000
RG7 7 0 1000000000000
RG8 8 0 1000000000000
RG9 9 0 1000000000000
RG10 10 0 1000000000000
RG11 11 0 1000000000000
RG12 12 0 1000000000000
RG13 13 0 1000000000000
RG14 14 0 1000000000000
RG15 15 0 1000000000000
RG16 16 0 1000000000000
RG17 17 0 1000000000000
RG18 18 0 1000000000000
RG19 19 0 1000000000000
RG20 20 0 1000000000000
RG21 21 0 1000000000000
RG22 22 0 1000000000000
RG23 23 0 1000000000000
RG24 24 0 1000000000000
RG25 25 0 1000000000000
RG26 26 0 1000000000000
RG27 27 0 1000000000000
VS0 0 s0 0
R0 s0 17 22e0
VS1 0 s1 0
R1 s1 10 39e3
VS2 6 s2 0
R2 s2 2 47e-1
VS3 0 s3 0
V3 e3 s3 DC 27e-1
RI3 e3 25 18e-2
VS4 1 s4 0
I4 s4 21 DC 47e-1
VS5 17 s5 0
R5 s5 6 56e-2
VS6 17 s6 0
I6 s6 0 DC 18e-3
VS7 3 s7 0
R7 s7 23 39e1
VS8 13 s8 0
R8 s8 4 56e-1
VS9 4 s9 0
I9 s9 3 DC 10e-1
VS10 16 s10 0
V10 e10 s10 DC 82e-1
RI10 e10 10 68e-3
VS11 9 s11 0
R11 s11 27 27e3
VS12 6 s12 0
V12 e12 s12 DC 39e0
RI12 e12 9 15e-1
VS13 1 s13 0
V13 e13 s13 DC 10e-1
RI13 e13 6 12e-3
VS14 3 s14 0
I14 s14 20 DC 10e-1
VS15 2 s15 0
R15 s15 21 15e-1
VS16 12 s16 0
R16 s16 6 15e3
VS17 27 s17 0
V17 e17 s17 DC 39e0
RI17 e17 0 39e-1
VS18 11 s18 0
R18 s18 14 82e3
VS19 19 s19 0
R19 s19 23 33e2
VS20 24 s20 0
V20 e20 s20 DC 39e0
RI20 e20 6 22e-2
VS21 7 s21 0
V21 e21 s21 DC 68e1
RI21 e21 0 68e-1
VS22 5 s22 0
R22 s22 13 15e-1
VS23 14 s23 0
R23 s23 4 82e-2
VS24 10 s24 0
R24 s24 22 22e-2
VS25 9 s25 0
R25 s25 18 18e3
VS26 8 s26 0
R26 s26 21 56e3
VS27 23 s27 0
V27 e27 s27 DC 39e1
RI27 e27 3 56e-1
VS28 19 s28 0
R28 s28 7 12e0
VS29 24 s29 0
R29 s29 16 15e-2
VS30 18 s30 0
R30 s30 23 15e-1
VS31 7 s31 0
R31 s31 26 27e1
VS32 6 s32 0
I32 s32 3 DC 56e-2
VS33 11 s33 0
R33 s33 9 47e-1
VS34 23 s34 0
R34 s34 15 12e-1
VS35 17 s35 0
R35 s35 21 82e0
VS36 6 s36 0
R36 s36 23 39e3
VS37 12 s37 0
R37 s37 18 68e2
VS38 16 s38 0
R38 s38 4 47e-2
VS39 20 s39 0
R39 s39 16 18e1
VS40 22 s40 0
R40 s40 23 47e-1
VS41 23 s41 0
R41 s41 25 18e3
VS42 8 s42 0
R42 s42 3 22e2
VS43 20 s43 0
R43 s43 6 15e2
VS44 26 s44 0
R44 s44 22 56e2
VS45 25 s45 0
R45 s45 0 39e0
VS46 5 s46 0
R46 s46 0 12e-1
VS47 7 s47 0
I47 s47 6 DC 47e-1
VS48 20 s48 0
R48 s48 1 10e-1
VS49 23 s49 0
V49 e49 s49 DC 18e1
RI49 e49 11 47e-2
VS50 27 s50 0
R50 s50 13 39e0
VS51 8 s51 0
R51 s51 23 12e-1
VS52 15 s52 0
R52 s52 12 68e2
VS53 0 s53 0
I53 s53 14 DC 27e-4
VS54 15 s54 0
R54 s54 20 12e-1
VS55 13 s55 0
R55 s55 6 47e1
VS56 2 s56 0
R56 s56 8 33e-1
VS57 5 s57 0
I57 s57 16 DC 27e-2
.control
set numdgt=17
op
print v(1) v(2) v(3) v(4) v(5) v(6) v(7) v(8) v(9) v(10)
print v(11) v(12) v(13) v(14) v(15) v(16) v(17) v(18) v(19) v(20)
print v(21) v(22) v(23) v(24) v(25) v(26) v(27)
print i(vs0) i(vs1) i(vs2) i(vs3) i(vs4) i(vs5) i(vs6) i(vs7) i(vs8) i(vs9)
print i(vs10) i(vs11) i(vs12) i(vs13) i(vs14) i(vs15) i(vs16) i(vs17) i(vs18) i(vs19)
print i(vs20) i(vs21) i(vs22) i(vs23) i(vs24) i(vs25) i(vs26) i(vs27) i(vs28) i(vs29)
print i(vs30) i(vs31) i(vs32) i(vs33) i(vs34) i(vs35) i(vs36) i(vs37) i(vs38) i(vs39)
print i(vs40) i(vs41) i(vs42) i(vs43) i(vs44) i(vs45) i(vs46) i(vs47) i(vs48) i(vs49)
print i(vs50) i(vs51) i(vs52) i(vs53) i(vs54) i(vs55) i(vs56) i(vs57)
.endc
.end
