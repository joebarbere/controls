controls oracle dc-0459
* Generated (plan F2.7, ADR 0012): do not edit; regenerate with `pnpm sim oracle regen`. dc seed 20261030 index 459 nodes 22 elements 46
.options sparse gmin=1e-12 noopac
RG1 1 0 1000000000000
RG2 2 0 1000000000000
RG3 3 0 1000000000000
RG4 4 0 1000000000000
RG5 5 0 1000000000000
RG6 6 0 1000000000000
RG7 7 0 1000000000000
RG8 8 0 1000000000000
RG9 9 0 1000000000000
RG10 10 0 1000000000000
RG11 11 0 1000000000000
RG12 12 0 1000000000000
RG13 13 0 1000000000000
RG14 14 0 1000000000000
RG15 15 0 1000000000000
RG16 16 0 1000000000000
RG17 17 0 1000000000000
RG18 18 0 1000000000000
RG19 19 0 1000000000000
RG20 20 0 1000000000000
RG21 21 0 1000000000000
VS0 17 s0 0
R0 s0 4 82e1
VS1 0 s1 0
R1 s1 19 12e-2
VS2 1 s2 0
I2 s2 21 DC 27e-1
VS3 3 s3 0
R3 s3 7 47e2
VS4 11 s4 0
R4 s4 21 18e0
VS5 11 s5 0
I5 s5 17 DC 82e-1
VS6 11 s6 0
R6 s6 9 27e3
VS7 6 s7 0
R7 s7 5 15e2
VS8 0 s8 0
V8 e8 s8 DC 33e0
RI8 e8 10 33e-3
VS9 18 s9 0
V9 e9 s9 DC 10e-1
RI9 e9 1 22e-3
VS10 8 s10 0
R10 s10 1 68e2
VS11 19 s11 0
R11 s11 21 56e2
VS12 2 s12 0
R12 s12 0 56e3
VS13 14 s13 0
R13 s13 1 82e2
VS14 4 s14 0
R14 s14 3 47e-1
VS15 3 s15 0
R15 s15 10 39e3
VS16 13 s16 0
R16 s16 0 68e1
VS17 10 s17 0
V17 e17 s17 DC 56e0
RI17 e17 20 33e-2
VS18 2 s18 0
R18 s18 9 39e-1
VS19 10 s19 0
V19 e19 s19 DC 10e-1
RI19 e19 3 22e-1
VS20 2 s20 0
R20 s20 12 18e1
VS21 19 s21 0
R21 s21 16 39e3
VS22 15 s22 0
I22 s22 7 DC 18e-3
VS23 17 s23 0
R23 s23 0 68e0
VS24 8 s24 0
R24 s24 12 56e3
VS25 5 s25 0
R25 s25 11 22e2
VS26 18 s26 0
I26 s26 1 DC 27e-3
VS27 0 s27 0
R27 s27 12 18e0
VS28 20 s28 0
R28 s28 19 18e-2
VS29 6 s29 0
R29 s29 4 15e0
VS30 1 s30 0
R30 s30 19 18e3
VS31 2 s31 0
I31 s31 0 DC 22e-1
VS32 5 s32 0
V32 e32 s32 DC 15e-1
RI32 e32 13 33e-3
VS33 11 s33 0
R33 s33 0 33e0
VS34 18 s34 0
R34 s34 5 47e2
VS35 9 s35 0
R35 s35 15 39e3
VS36 17 s36 0
I36 s36 2 DC 47e-2
VS37 10 s37 0
R37 s37 19 10e1
VS38 7 s38 0
R38 s38 5 22e-2
VS39 15 s39 0
V39 e39 s39 DC 15e1
RI39 e39 11 27e-2
VS40 16 s40 0
R40 s40 11 39e3
VS41 8 s41 0
R41 s41 10 10e0
VS42 6 s42 0
R42 s42 12 56e-2
VS43 14 s43 0
R43 s43 15 27e2
VS44 8 s44 0
V44 e44 s44 DC 15e-1
RI44 e44 13 47e-1
VS45 15 s45 0
I45 s45 8 DC 56e-1
.control
set numdgt=17
op
print v(1) v(2) v(3) v(4) v(5) v(6) v(7) v(8) v(9) v(10)
print v(11) v(12) v(13) v(14) v(15) v(16) v(17) v(18) v(19) v(20)
print v(21)
print i(vs0) i(vs1) i(vs2) i(vs3) i(vs4) i(vs5) i(vs6) i(vs7) i(vs8) i(vs9)
print i(vs10) i(vs11) i(vs12) i(vs13) i(vs14) i(vs15) i(vs16) i(vs17) i(vs18) i(vs19)
print i(vs20) i(vs21) i(vs22) i(vs23) i(vs24) i(vs25) i(vs26) i(vs27) i(vs28) i(vs29)
print i(vs30) i(vs31) i(vs32) i(vs33) i(vs34) i(vs35) i(vs36) i(vs37) i(vs38) i(vs39)
print i(vs40) i(vs41) i(vs42) i(vs43) i(vs44) i(vs45)
.endc
.end
