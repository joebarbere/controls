controls oracle dc-0459
* Generated (plan F2.7, ADR 0012): do not edit; regenerate with `pnpm sim oracle regen`. dc seed 20261030 index 459 nodes 22 elements 42
.options sparse gmin=1e-12 noopac
RG1 1 0 1000000000000
RG2 2 0 1000000000000
RG3 3 0 1000000000000
RG4 4 0 1000000000000
RG5 5 0 1000000000000
RG6 6 0 1000000000000
RG7 7 0 1000000000000
RG8 8 0 1000000000000
RG9 9 0 1000000000000
RG10 10 0 1000000000000
RG11 11 0 1000000000000
RG12 12 0 1000000000000
RG13 13 0 1000000000000
RG14 14 0 1000000000000
RG15 15 0 1000000000000
RG16 16 0 1000000000000
RG17 17 0 1000000000000
RG18 18 0 1000000000000
RG19 19 0 1000000000000
RG20 20 0 1000000000000
RG21 21 0 1000000000000
VS0 5 s0 0
R0 s0 19 12e-2
VS1 3 s1 0
R1 s1 10 39e3
VS2 11 s2 0
R2 s2 21 18e0
VS3 3 s3 0
R3 s3 7 47e2
VS4 19 s4 0
R4 s4 21 56e2
VS5 11 s5 0
R5 s5 5 33e0
VS6 6 s6 0
R6 s6 4 15e0
VS7 0 s7 0
V7 e7 s7 DC 15e-1
RI7 e7 13 33e-3
VS8 2 s8 0
R8 s8 5 56e3
VS9 1 s9 0
I9 s9 21 DC 27e-1
VS10 5 s10 0
V10 e10 s10 DC 33e0
RI10 e10 10 33e-3
VS11 10 s11 0
V11 e11 s11 DC 10e-1
RI11 e11 3 22e-1
VS12 2 s12 0
I12 s12 5 DC 22e-1
VS13 17 s13 0
I13 s13 2 DC 47e-2
VS14 9 s14 0
R14 s14 15 39e3
VS15 6 s15 0
R15 s15 0 15e2
VS16 8 s16 0
R16 s16 12 56e3
VS17 11 s17 0
R17 s17 9 27e3
VS18 1 s18 0
R18 s18 19 18e3
VS19 19 s19 0
R19 s19 16 39e3
VS20 0 s20 0
R20 s20 11 22e2
VS21 11 s21 0
I21 s21 17 DC 82e-1
VS22 8 s22 0
R22 s22 10 10e0
VS23 18 s23 0
R23 s23 0 47e2
VS24 17 s24 0
R24 s24 5 68e0
VS25 15 s25 0
I25 s25 7 DC 18e-3
VS26 2 s26 0
R26 s26 12 18e1
VS27 8 s27 0
V27 e27 s27 DC 15e-1
RI27 e27 13 47e-1
VS28 7 s28 0
R28 s28 0 22e-2
VS29 10 s29 0
R29 s29 19 10e1
VS30 8 s30 0
R30 s30 1 68e2
VS31 6 s31 0
R31 s31 12 56e-2
VS32 16 s32 0
R32 s32 11 39e3
VS33 2 s33 0
R33 s33 9 39e-1
VS34 10 s34 0
V34 e34 s34 DC 56e0
RI34 e34 20 33e-2
VS35 5 s35 0
R35 s35 12 18e0
VS36 18 s36 0
V36 e36 s36 DC 10e-1
RI36 e36 1 22e-3
VS37 18 s37 0
I37 s37 1 DC 27e-3
VS38 13 s38 0
R38 s38 5 68e1
VS39 14 s39 0
R39 s39 15 27e2
VS40 15 s40 0
I40 s40 8 DC 56e-1
VS41 15 s41 0
V41 e41 s41 DC 15e1
RI41 e41 11 27e-2
.control
set numdgt=17
op
print v(1) v(2) v(3) v(4) v(5) v(6) v(7) v(8) v(9) v(10)
print v(11) v(12) v(13) v(14) v(15) v(16) v(17) v(18) v(19) v(20)
print v(21)
print i(vs0) i(vs1) i(vs2) i(vs3) i(vs4) i(vs5) i(vs6) i(vs7) i(vs8) i(vs9)
print i(vs10) i(vs11) i(vs12) i(vs13) i(vs14) i(vs15) i(vs16) i(vs17) i(vs18) i(vs19)
print i(vs20) i(vs21) i(vs22) i(vs23) i(vs24) i(vs25) i(vs26) i(vs27) i(vs28) i(vs29)
print i(vs30) i(vs31) i(vs32) i(vs33) i(vs34) i(vs35) i(vs36) i(vs37) i(vs38) i(vs39)
print i(vs40) i(vs41)
.endc
.end
