controls oracle dc-0281
* Generated (plan F2.7, ADR 0012): do not edit; regenerate with `pnpm sim oracle regen`. dc seed 20261030 index 281 nodes 16 elements 27
.options sparse gmin=1e-12 noopac
RG1 1 0 1000000000000
RG2 2 0 1000000000000
RG3 3 0 1000000000000
RG4 4 0 1000000000000
RG5 5 0 1000000000000
RG6 6 0 1000000000000
RG7 7 0 1000000000000
RG8 8 0 1000000000000
RG9 9 0 1000000000000
RG10 10 0 1000000000000
RG11 11 0 1000000000000
RG12 12 0 1000000000000
RG13 13 0 1000000000000
RG14 14 0 1000000000000
RG15 15 0 1000000000000
VS0 3 s0 0
I0 s0 12 DC 15e-3
VS1 13 s1 0
R1 s1 11 15e2
VS2 0 s2 0
V2 e2 s2 DC 10e-1
RI2 e2 15 56e-2
VS3 3 s3 0
R3 s3 8 47e0
VS4 7 s4 0
V4 e4 s4 DC 22e1
RI4 e4 6 47e-1
VS5 6 s5 0
V5 e5 s5 DC 10e1
RI5 e5 4 82e-3
VS6 13 s6 0
V6 e6 s6 DC 47e-1
RI6 e6 5 18e-1
VS7 6 s7 0
R7 s7 8 33e1
VS8 1 s8 0
R8 s8 7 39e3
VS9 13 s9 0
R9 s9 7 68e2
VS10 1 s10 0
R10 s10 14 15e2
VS11 12 s11 0
R11 s11 1 56e-1
VS12 7 s12 0
I12 s12 6 DC 68e-4
VS13 15 s13 0
R13 s13 7 27e0
VS14 14 s14 0
R14 s14 3 10e0
VS15 8 s15 0
R15 s15 1 27e-1
VS16 8 s16 0
R16 s16 4 68e0
VS17 12 s17 0
R17 s17 11 82e2
VS18 12 s18 0
R18 s18 4 10e1
VS19 13 s19 0
I19 s19 3 DC 82e-4
VS20 2 s20 0
R20 s20 8 27e-2
VS21 15 s21 0
R21 s21 5 68e1
VS22 14 s22 0
R22 s22 3 56e0
VS23 11 s23 0
V23 e23 s23 DC 39e-1
RI23 e23 10 56e-2
VS24 13 s24 0
R24 s24 8 12e-2
VS25 7 s25 0
V25 e25 s25 DC 12e1
RI25 e25 9 15e-1
VS26 1 s26 0
R26 s26 11 27e-1
.control
set numdgt=17
op
print v(1) v(2) v(3) v(4) v(5) v(6) v(7) v(8) v(9) v(10)
print v(11) v(12) v(13) v(14) v(15)
print i(vs0) i(vs1) i(vs2) i(vs3) i(vs4) i(vs5) i(vs6) i(vs7) i(vs8) i(vs9)
print i(vs10) i(vs11) i(vs12) i(vs13) i(vs14) i(vs15) i(vs16) i(vs17) i(vs18) i(vs19)
print i(vs20) i(vs21) i(vs22) i(vs23) i(vs24) i(vs25) i(vs26)
.endc
.end
