controls oracle dc-0281
* Generated (plan F2.7, ADR 0012): do not edit; regenerate with `pnpm sim oracle regen`. dc seed 20261030 index 281 nodes 16 elements 31
.options sparse gmin=1e-12 noopac
RG1 1 0 1000000000000
RG2 2 0 1000000000000
RG3 3 0 1000000000000
RG4 4 0 1000000000000
RG5 5 0 1000000000000
RG6 6 0 1000000000000
RG7 7 0 1000000000000
RG8 8 0 1000000000000
RG9 9 0 1000000000000
RG10 10 0 1000000000000
RG11 11 0 1000000000000
RG12 12 0 1000000000000
RG13 13 0 1000000000000
RG14 14 0 1000000000000
RG15 15 0 1000000000000
VS0 0 s0 0
V0 e0 s0 DC 10e-1
RI0 e0 15 56e-2
VS1 13 s1 0
R1 s1 11 15e2
VS2 1 s2 0
R2 s2 14 15e2
VS3 2 s3 0
R3 s3 3 56e-1
VS4 7 s4 0
V4 e4 s4 DC 12e1
RI4 e4 9 15e-1
VS5 14 s5 0
R5 s5 3 10e0
VS6 0 s6 0
R6 s6 14 82e2
VS7 1 s7 0
R7 s7 7 39e3
VS8 7 s8 0
I8 s8 6 DC 68e-4
VS9 8 s9 0
R9 s9 1 27e-1
VS10 1 s10 0
R10 s10 11 27e-1
VS11 13 s11 0
R11 s11 8 12e-2
VS12 14 s12 0
R12 s12 3 56e0
VS13 12 s13 0
R13 s13 11 82e2
VS14 2 s14 0
R14 s14 8 27e-2
VS15 6 s15 0
R15 s15 8 33e1
VS16 12 s16 0
R16 s16 4 10e1
VS17 3 s17 0
I17 s17 12 DC 15e-3
VS18 13 s18 0
R18 s18 7 68e2
VS19 6 s19 0
V19 e19 s19 DC 10e1
RI19 e19 4 82e-3
VS20 12 s20 0
R20 s20 10 22e2
VS21 8 s21 0
R21 s21 4 68e0
VS22 15 s22 0
R22 s22 5 68e1
VS23 3 s23 0
R23 s23 8 47e0
VS24 13 s24 0
I24 s24 3 DC 82e-4
VS25 11 s25 0
V25 e25 s25 DC 39e-1
RI25 e25 10 56e-2
VS26 12 s26 0
R26 s26 1 56e-1
VS27 15 s27 0
R27 s27 7 27e0
VS28 9 s28 0
R28 s28 15 39e0
VS29 7 s29 0
V29 e29 s29 DC 22e1
RI29 e29 6 47e-1
VS30 13 s30 0
V30 e30 s30 DC 47e-1
RI30 e30 5 18e-1
.control
set numdgt=17
op
print v(1) v(2) v(3) v(4) v(5) v(6) v(7) v(8) v(9) v(10)
print v(11) v(12) v(13) v(14) v(15)
print i(vs0) i(vs1) i(vs2) i(vs3) i(vs4) i(vs5) i(vs6) i(vs7) i(vs8) i(vs9)
print i(vs10) i(vs11) i(vs12) i(vs13) i(vs14) i(vs15) i(vs16) i(vs17) i(vs18) i(vs19)
print i(vs20) i(vs21) i(vs22) i(vs23) i(vs24) i(vs25) i(vs26) i(vs27) i(vs28) i(vs29)
print i(vs30)
.endc
.end
