controls oracle dc-0351
* Generated (plan F2.7, ADR 0012): do not edit; regenerate with `pnpm sim oracle regen`. dc seed 20261030 index 351 nodes 3 elements 4
.options sparse gmin=1e-12 noopac
RG1 1 0 1000000000000
RG2 2 0 1000000000000
VS0 2 s0 0
I0 s0 1 DC 33e-1
VS1 1 s1 0
R1 s1 0 27e-2
VS2 2 s2 0
R2 s2 1 82e-1
VS3 0 s3 0
V3 e3 s3 DC 56e0
RI3 e3 2 47e-1
.control
set numdgt=17
op
print v(1) v(2)
print i(vs0) i(vs1) i(vs2) i(vs3)
.endc
.end
