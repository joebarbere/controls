controls oracle dc-0314
* Generated (plan F2.7, ADR 0012): do not edit; regenerate with `pnpm sim oracle regen`. dc seed 20261030 index 314 nodes 8 elements 15
.options sparse gmin=1e-12 noopac
RG1 1 0 1000000000000
RG2 2 0 1000000000000
RG3 3 0 1000000000000
RG4 4 0 1000000000000
RG5 5 0 1000000000000
RG6 6 0 1000000000000
RG7 7 0 1000000000000
VS0 3 s0 0
R0 s0 5 15e2
VS1 0 s1 0
R1 s1 1 68e-2
VS2 0 s2 0
V2 e2 s2 DC 22e1
RI2 e2 7 22e-1
VS3 1 s3 0
R3 s3 0 15e-2
VS4 5 s4 0
I4 s4 0 DC 82e-1
VS5 5 s5 0
R5 s5 6 39e3
VS6 4 s6 0
V6 e6 s6 DC 82e1
RI6 e6 1 27e-2
VS7 2 s7 0
R7 s7 4 12e-2
VS8 5 s8 0
R8 s8 3 56e0
VS9 3 s9 0
R9 s9 4 18e3
VS10 1 s10 0
R10 s10 2 56e3
VS11 1 s11 0
I11 s11 7 DC 15e-3
VS12 1 s12 0
R12 s12 2 39e-1
VS13 1 s13 0
I13 s13 6 DC 15e-1
VS14 3 s14 0
V14 e14 s14 DC 56e1
RI14 e14 7 68e-3
.control
set numdgt=17
op
print v(1) v(2) v(3) v(4) v(5) v(6) v(7)
print i(vs0) i(vs1) i(vs2) i(vs3) i(vs4) i(vs5) i(vs6) i(vs7) i(vs8) i(vs9)
print i(vs10) i(vs11) i(vs12) i(vs13) i(vs14)
.endc
.end
