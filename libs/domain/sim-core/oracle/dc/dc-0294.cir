controls oracle dc-0294
* Generated (plan F2.7, ADR 0012): do not edit; regenerate with `pnpm sim oracle regen`. dc seed 20261030 index 294 nodes 24 elements 38
.options sparse gmin=1e-12 noopac
RG1 1 0 1000000000000
RG2 2 0 1000000000000
RG3 3 0 1000000000000
RG4 4 0 1000000000000
RG5 5 0 1000000000000
RG6 6 0 1000000000000
RG7 7 0 1000000000000
RG8 8 0 1000000000000
RG9 9 0 1000000000000
RG10 10 0 1000000000000
RG11 11 0 1000000000000
RG12 12 0 1000000000000
RG13 13 0 1000000000000
RG14 14 0 1000000000000
RG15 15 0 1000000000000
RG16 16 0 1000000000000
RG17 17 0 1000000000000
RG18 18 0 1000000000000
RG19 19 0 1000000000000
RG20 20 0 1000000000000
RG21 21 0 1000000000000
RG22 22 0 1000000000000
RG23 23 0 1000000000000
VS0 2 s0 0
R0 s0 9 22e3
VS1 1 s1 0
R1 s1 11 56e-1
VS2 23 s2 0
R2 s2 17 18e-1
VS3 16 s3 0
I3 s3 20 DC 68e-2
VS4 8 s4 0
I4 s4 7 DC 68e-3
VS5 6 s5 0
I5 s5 15 DC 15e-4
VS6 6 s6 0
I6 s6 9 DC 56e-2
VS7 16 s7 0
R7 s7 10 33e-1
VS8 18 s8 0
R8 s8 10 18e-2
VS9 17 s9 0
R9 s9 7 22e1
VS10 9 s10 0
R10 s10 14 33e3
VS11 9 s11 0
R11 s11 5 82e2
VS12 4 s12 0
R12 s12 5 27e-2
VS13 15 s13 0
R13 s13 8 18e-1
VS14 12 s14 0
R14 s14 21 56e1
VS15 4 s15 0
R15 s15 9 33e-1
VS16 0 s16 0
V16 e16 s16 DC 47e0
RI16 e16 12 39e-1
VS17 11 s17 0
R17 s17 4 18e2
VS18 5 s18 0
R18 s18 7 56e1
VS19 11 s19 0
R19 s19 9 12e2
VS20 16 s20 0
R20 s20 20 10e3
VS21 12 s21 0
R21 s21 8 47e0
VS22 6 s22 0
R22 s22 4 18e3
VS23 16 s23 0
V23 e23 s23 DC 15e-1
RI23 e23 3 33e-1
VS24 9 s24 0
R24 s24 16 82e-1
VS25 18 s25 0
R25 s25 16 56e-1
VS26 10 s26 0
R26 s26 13 56e1
VS27 17 s27 0
R27 s27 20 18e-1
VS28 19 s28 0
R28 s28 6 15e0
VS29 15 s29 0
R29 s29 18 39e-2
VS30 7 s30 0
R30 s30 22 68e0
VS31 14 s31 0
I31 s31 6 DC 10e-1
VS32 16 s32 0
R32 s32 17 12e-2
VS33 0 s33 0
R33 s33 23 47e3
VS34 6 s34 0
R34 s34 0 33e3
VS35 17 s35 0
R35 s35 15 27e2
VS36 7 s36 0
I36 s36 8 DC 15e-3
VS37 14 s37 0
R37 s37 17 27e-2
.control
set numdgt=17
op
print v(1) v(2) v(3) v(4) v(5) v(6) v(7) v(8) v(9) v(10)
print v(11) v(12) v(13) v(14) v(15) v(16) v(17) v(18) v(19) v(20)
print v(21) v(22) v(23)
print i(vs0) i(vs1) i(vs2) i(vs3) i(vs4) i(vs5) i(vs6) i(vs7) i(vs8) i(vs9)
print i(vs10) i(vs11) i(vs12) i(vs13) i(vs14) i(vs15) i(vs16) i(vs17) i(vs18) i(vs19)
print i(vs20) i(vs21) i(vs22) i(vs23) i(vs24) i(vs25) i(vs26) i(vs27) i(vs28) i(vs29)
print i(vs30) i(vs31) i(vs32) i(vs33) i(vs34) i(vs35) i(vs36) i(vs37)
.endc
.end
