controls oracle dc-0294
* Generated (plan F2.7, ADR 0012): do not edit; regenerate with `pnpm sim oracle regen`. dc seed 20261030 index 294 nodes 24 elements 44
.options sparse gmin=1e-12 noopac
RG1 1 0 1000000000000
RG2 2 0 1000000000000
RG3 3 0 1000000000000
RG4 4 0 1000000000000
RG5 5 0 1000000000000
RG6 6 0 1000000000000
RG7 7 0 1000000000000
RG8 8 0 1000000000000
RG9 9 0 1000000000000
RG10 10 0 1000000000000
RG11 11 0 1000000000000
RG12 12 0 1000000000000
RG13 13 0 1000000000000
RG14 14 0 1000000000000
RG15 15 0 1000000000000
RG16 16 0 1000000000000
RG17 17 0 1000000000000
RG18 18 0 1000000000000
RG19 19 0 1000000000000
RG20 20 0 1000000000000
RG21 21 0 1000000000000
RG22 22 0 1000000000000
RG23 23 0 1000000000000
VS0 13 s0 0
R0 s0 7 33e3
VS1 14 s1 0
R1 s1 17 27e-2
VS2 0 s2 0
V2 e2 s2 DC 47e0
RI2 e2 12 39e-1
VS3 18 s3 0
R3 s3 10 18e-2
VS4 8 s4 0
I4 s4 7 DC 68e-3
VS5 9 s5 0
R5 s5 14 33e3
VS6 1 s6 0
R6 s6 22 56e3
VS7 17 s7 0
R7 s7 7 22e1
VS8 17 s8 0
R8 s8 15 27e2
VS9 7 s9 0
I9 s9 8 DC 15e-3
VS10 16 s10 0
V10 e10 s10 DC 15e-1
RI10 e10 3 33e-1
VS11 6 s11 0
R11 s11 0 33e3
VS12 7 s12 0
R12 s12 22 68e0
VS13 6 s13 0
R13 s13 4 18e3
VS14 10 s14 0
R14 s14 13 56e1
VS15 3 s15 0
R15 s15 21 56e-1
VS16 16 s16 0
R16 s16 10 33e-1
VS17 19 s17 0
V17 e17 s17 DC 18e1
RI17 e17 5 12e-2
VS18 17 s18 0
R18 s18 20 18e-1
VS19 6 s19 0
I19 s19 15 DC 15e-4
VS20 18 s20 0
R20 s20 16 56e-1
VS21 6 s21 0
I21 s21 9 DC 56e-2
VS22 15 s22 0
R22 s22 18 39e-2
VS23 5 s23 0
R23 s23 7 56e1
VS24 21 s24 0
V24 e24 s24 DC 10e-1
RI24 e24 14 47e-3
VS25 12 s25 0
R25 s25 8 47e0
VS26 16 s26 0
R26 s26 17 12e-2
VS27 15 s27 0
R27 s27 8 18e-1
VS28 9 s28 0
R28 s28 5 82e2
VS29 12 s29 0
R29 s29 21 56e1
VS30 0 s30 0
R30 s30 23 47e3
VS31 2 s31 0
R31 s31 10 18e2
VS32 16 s32 0
I32 s32 20 DC 68e-2
VS33 9 s33 0
R33 s33 16 82e-1
VS34 4 s34 0
R34 s34 5 27e-2
VS35 23 s35 0
R35 s35 17 18e-1
VS36 14 s36 0
I36 s36 6 DC 10e-1
VS37 11 s37 0
R37 s37 4 18e2
VS38 2 s38 0
R38 s38 9 22e3
VS39 1 s39 0
R39 s39 11 56e-1
VS40 4 s40 0
R40 s40 9 33e-1
VS41 11 s41 0
R41 s41 9 12e2
VS42 16 s42 0
R42 s42 20 10e3
VS43 19 s43 0
R43 s43 6 15e0
.control
set numdgt=17
op
print v(1) v(2) v(3) v(4) v(5) v(6) v(7) v(8) v(9) v(10)
print v(11) v(12) v(13) v(14) v(15) v(16) v(17) v(18) v(19) v(20)
print v(21) v(22) v(23)
print i(vs0) i(vs1) i(vs2) i(vs3) i(vs4) i(vs5) i(vs6) i(vs7) i(vs8) i(vs9)
print i(vs10) i(vs11) i(vs12) i(vs13) i(vs14) i(vs15) i(vs16) i(vs17) i(vs18) i(vs19)
print i(vs20) i(vs21) i(vs22) i(vs23) i(vs24) i(vs25) i(vs26) i(vs27) i(vs28) i(vs29)
print i(vs30) i(vs31) i(vs32) i(vs33) i(vs34) i(vs35) i(vs36) i(vs37) i(vs38) i(vs39)
print i(vs40) i(vs41) i(vs42) i(vs43)
.endc
.end
