controls oracle dc-0479
* Generated (plan F2.7, ADR 0012): do not edit; regenerate with `pnpm sim oracle regen`. dc seed 20261030 index 479 nodes 29 elements 60
.options sparse gmin=1e-12 noopac
RG1 1 0 1000000000000
RG2 2 0 1000000000000
RG3 3 0 1000000000000
RG4 4 0 1000000000000
RG5 5 0 1000000000000
RG6 6 0 1000000000000
RG7 7 0 1000000000000
RG8 8 0 1000000000000
RG9 9 0 1000000000000
RG10 10 0 1000000000000
RG11 11 0 1000000000000
RG12 12 0 1000000000000
RG13 13 0 1000000000000
RG14 14 0 1000000000000
RG15 15 0 1000000000000
RG16 16 0 1000000000000
RG17 17 0 1000000000000
RG18 18 0 1000000000000
RG19 19 0 1000000000000
RG20 20 0 1000000000000
RG21 21 0 1000000000000
RG22 22 0 1000000000000
RG23 23 0 1000000000000
RG24 24 0 1000000000000
RG25 25 0 1000000000000
RG26 26 0 1000000000000
RG27 27 0 1000000000000
RG28 28 0 1000000000000
VS0 17 s0 0
R0 s0 4 56e3
VS1 16 s1 0
R1 s1 28 10e0
VS2 0 s2 0
V2 e2 s2 DC 18e0
RI2 e2 15 12e-1
VS3 6 s3 0
V3 e3 s3 DC 27e-1
RI3 e3 24 12e-2
VS4 19 s4 0
R4 s4 2 39e0
VS5 28 s5 0
R5 s5 21 12e3
VS6 8 s6 0
V6 e6 s6 DC 82e1
RI6 e6 9 33e-2
VS7 21 s7 0
R7 s7 6 82e0
VS8 12 s8 0
R8 s8 1 33e1
VS9 13 s9 0
I9 s9 28 DC 56e-3
VS10 7 s10 0
R10 s10 4 56e2
VS11 15 s11 0
V11 e11 s11 DC 47e0
RI11 e11 9 33e-2
VS12 25 s12 0
R12 s12 9 10e-1
VS13 6 s13 0
R13 s13 13 33e1
VS14 12 s14 0
R14 s14 19 12e2
VS15 7 s15 0
R15 s15 17 10e1
VS16 11 s16 0
V16 e16 s16 DC 56e0
RI16 e16 27 47e-1
VS17 1 s17 0
R17 s17 16 10e3
VS18 11 s18 0
I18 s18 24 DC 33e-1
VS19 25 s19 0
R19 s19 9 15e-1
VS20 25 s20 0
R20 s20 20 47e0
VS21 11 s21 0
R21 s21 16 15e-2
VS22 22 s22 0
I22 s22 13 DC 68e-3
VS23 9 s23 0
R23 s23 11 12e-1
VS24 28 s24 0
R24 s24 2 27e-1
VS25 10 s25 0
R25 s25 18 18e0
VS26 18 s26 0
I26 s26 2 DC 27e-1
VS27 3 s27 0
V27 e27 s27 DC 18e-1
RI27 e27 18 82e-1
VS28 19 s28 0
R28 s28 10 27e2
VS29 28 s29 0
R29 s29 20 18e3
VS30 28 s30 0
R30 s30 24 15e3
VS31 22 s31 0
V31 e31 s31 DC 18e-1
RI31 e31 3 56e-1
VS32 27 s32 0
R32 s32 5 22e0
VS33 16 s33 0
R33 s33 14 10e-1
VS34 23 s34 0
V34 e34 s34 DC 27e0
RI34 e34 10 39e-2
VS35 22 s35 0
R35 s35 26 56e-1
VS36 9 s36 0
R36 s36 24 12e1
VS37 6 s37 0
I37 s37 13 DC 18e-4
VS38 12 s38 0
V38 e38 s38 DC 33e1
RI38 e38 17 10e-1
VS39 15 s39 0
I39 s39 2 DC 10e-2
VS40 6 s40 0
I40 s40 4 DC 10e-2
VS41 28 s41 0
R41 s41 14 39e-1
VS42 8 s42 0
R42 s42 16 18e-2
VS43 18 s43 0
R43 s43 11 47e-1
VS44 6 s44 0
R44 s44 5 39e3
VS45 9 s45 0
R45 s45 22 12e1
VS46 23 s46 0
R46 s46 9 68e3
VS47 17 s47 0
R47 s47 11 12e-2
VS48 15 s48 0
I48 s48 12 DC 27e-2
VS49 1 s49 0
V49 e49 s49 DC 12e0
RI49 e49 2 33e-2
VS50 21 s50 0
V50 e50 s50 DC 10e1
RI50 e50 16 39e-3
VS51 21 s51 0
R51 s51 26 56e-1
VS52 5 s52 0
R52 s52 12 15e1
VS53 13 s53 0
V53 e53 s53 DC 82e1
RI53 e53 16 10e-1
VS54 1 s54 0
R54 s54 17 18e-1
VS55 22 s55 0
R55 s55 11 15e0
VS56 5 s56 0
R56 s56 0 68e-1
VS57 10 s57 0
R57 s57 28 47e2
VS58 23 s58 0
R58 s58 15 68e1
VS59 7 s59 0
R59 s59 5 82e0
.control
set numdgt=17
op
print v(1) v(2) v(3) v(4) v(5) v(6) v(7) v(8) v(9) v(10)
print v(11) v(12) v(13) v(14) v(15) v(16) v(17) v(18) v(19) v(20)
print v(21) v(22) v(23) v(24) v(25) v(26) v(27) v(28)
print i(vs0) i(vs1) i(vs2) i(vs3) i(vs4) i(vs5) i(vs6) i(vs7) i(vs8) i(vs9)
print i(vs10) i(vs11) i(vs12) i(vs13) i(vs14) i(vs15) i(vs16) i(vs17) i(vs18) i(vs19)
print i(vs20) i(vs21) i(vs22) i(vs23) i(vs24) i(vs25) i(vs26) i(vs27) i(vs28) i(vs29)
print i(vs30) i(vs31) i(vs32) i(vs33) i(vs34) i(vs35) i(vs36) i(vs37) i(vs38) i(vs39)
print i(vs40) i(vs41) i(vs42) i(vs43) i(vs44) i(vs45) i(vs46) i(vs47) i(vs48) i(vs49)
print i(vs50) i(vs51) i(vs52) i(vs53) i(vs54) i(vs55) i(vs56) i(vs57) i(vs58) i(vs59)
.endc
.end
