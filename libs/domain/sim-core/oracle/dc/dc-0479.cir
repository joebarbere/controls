controls oracle dc-0479
* Generated (plan F2.7, ADR 0012): do not edit; regenerate with `pnpm sim oracle regen`. dc seed 20261030 index 479 nodes 29 elements 55
.options sparse gmin=1e-12 noopac
RG1 1 0 1000000000000
RG2 2 0 1000000000000
RG3 3 0 1000000000000
RG4 4 0 1000000000000
RG5 5 0 1000000000000
RG6 6 0 1000000000000
RG7 7 0 1000000000000
RG8 8 0 1000000000000
RG9 9 0 1000000000000
RG10 10 0 1000000000000
RG11 11 0 1000000000000
RG12 12 0 1000000000000
RG13 13 0 1000000000000
RG14 14 0 1000000000000
RG15 15 0 1000000000000
RG16 16 0 1000000000000
RG17 17 0 1000000000000
RG18 18 0 1000000000000
RG19 19 0 1000000000000
RG20 20 0 1000000000000
RG21 21 0 1000000000000
RG22 22 0 1000000000000
RG23 23 0 1000000000000
RG24 24 0 1000000000000
RG25 25 0 1000000000000
RG26 26 0 1000000000000
RG27 27 0 1000000000000
RG28 28 0 1000000000000
VS0 28 s0 0
R0 s0 24 15e3
VS1 10 s1 0
R1 s1 18 18e0
VS2 0 s2 0
V2 e2 s2 DC 18e-1
RI2 e2 18 82e-1
VS3 15 s3 0
I3 s3 2 DC 10e-2
VS4 3 s4 0
R4 s4 5 68e-1
VS5 21 s5 0
R5 s5 26 56e-1
VS6 22 s6 0
R6 s6 26 56e-1
VS7 25 s7 0
R7 s7 9 10e-1
VS8 16 s8 0
R8 s8 28 10e0
VS9 1 s9 0
V9 e9 s9 DC 12e0
RI9 e9 2 33e-2
VS10 19 s10 0
R10 s10 10 27e2
VS11 9 s11 0
R11 s11 22 12e1
VS12 1 s12 0
R12 s12 17 18e-1
VS13 6 s13 0
I13 s13 13 DC 18e-4
VS14 12 s14 0
R14 s14 1 33e1
VS15 16 s15 0
R15 s15 14 10e-1
VS16 28 s16 0
R16 s16 2 27e-1
VS17 7 s17 0
R17 s17 3 82e0
VS18 21 s18 0
V18 e18 s18 DC 10e1
RI18 e18 16 39e-3
VS19 6 s19 0
I19 s19 4 DC 10e-2
VS20 8 s20 0
V20 e20 s20 DC 82e1
RI20 e20 9 33e-2
VS21 7 s21 0
R21 s21 4 56e2
VS22 25 s22 0
R22 s22 20 47e0
VS23 12 s23 0
V23 e23 s23 DC 33e1
RI23 e23 17 10e-1
VS24 1 s24 0
R24 s24 16 10e3
VS25 22 s25 0
R25 s25 11 15e0
VS26 11 s26 0
I26 s26 24 DC 33e-1
VS27 23 s27 0
V27 e27 s27 DC 27e0
RI27 e27 10 39e-2
VS28 6 s28 0
R28 s28 13 33e1
VS29 17 s29 0
R29 s29 4 56e3
VS30 25 s30 0
R30 s30 9 15e-1
VS31 18 s31 0
I31 s31 2 DC 27e-1
VS32 8 s32 0
R32 s32 16 18e-2
VS33 17 s33 0
R33 s33 11 12e-2
VS34 23 s34 0
R34 s34 9 68e3
VS35 6 s35 0
R35 s35 3 39e3
VS36 28 s36 0
R36 s36 21 12e3
VS37 12 s37 0
R37 s37 19 12e2
VS38 13 s38 0
V38 e38 s38 DC 82e1
RI38 e38 16 10e-1
VS39 3 s39 0
R39 s39 12 15e1
VS40 23 s40 0
R40 s40 15 68e1
VS41 11 s41 0
V41 e41 s41 DC 56e0
RI41 e41 27 47e-1
VS42 7 s42 0
R42 s42 17 10e1
VS43 18 s43 0
R43 s43 11 47e-1
VS44 15 s44 0
V44 e44 s44 DC 47e0
RI44 e44 9 33e-2
VS45 13 s45 0
I45 s45 28 DC 56e-3
VS46 9 s46 0
R46 s46 11 12e-1
VS47 10 s47 0
R47 s47 28 47e2
VS48 6 s48 0
V48 e48 s48 DC 27e-1
RI48 e48 24 12e-2
VS49 21 s49 0
R49 s49 6 82e0
VS50 22 s50 0
I50 s50 13 DC 68e-3
VS51 19 s51 0
R51 s51 2 39e0
VS52 9 s52 0
R52 s52 24 12e1
VS53 15 s53 0
I53 s53 12 DC 27e-2
VS54 11 s54 0
R54 s54 16 15e-2
.control
set numdgt=17
op
print v(1) v(2) v(3) v(4) v(5) v(6) v(7) v(8) v(9) v(10)
print v(11) v(12) v(13) v(14) v(15) v(16) v(17) v(18) v(19) v(20)
print v(21) v(22) v(23) v(24) v(25) v(26) v(27) v(28)
print i(vs0) i(vs1) i(vs2) i(vs3) i(vs4) i(vs5) i(vs6) i(vs7) i(vs8) i(vs9)
print i(vs10) i(vs11) i(vs12) i(vs13) i(vs14) i(vs15) i(vs16) i(vs17) i(vs18) i(vs19)
print i(vs20) i(vs21) i(vs22) i(vs23) i(vs24) i(vs25) i(vs26) i(vs27) i(vs28) i(vs29)
print i(vs30) i(vs31) i(vs32) i(vs33) i(vs34) i(vs35) i(vs36) i(vs37) i(vs38) i(vs39)
print i(vs40) i(vs41) i(vs42) i(vs43) i(vs44) i(vs45) i(vs46) i(vs47) i(vs48) i(vs49)
print i(vs50) i(vs51) i(vs52) i(vs53) i(vs54)
.endc
.end
