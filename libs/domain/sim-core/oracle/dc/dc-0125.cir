controls oracle dc-0125
* Generated (plan F2.7, ADR 0012): do not edit; regenerate with `pnpm sim oracle regen`. dc seed 20261030 index 125 nodes 24 elements 40
.options sparse gmin=1e-12 noopac
RG1 1 0 1000000000000
RG2 2 0 1000000000000
RG3 3 0 1000000000000
RG4 4 0 1000000000000
RG5 5 0 1000000000000
RG6 6 0 1000000000000
RG7 7 0 1000000000000
RG8 8 0 1000000000000
RG9 9 0 1000000000000
RG10 10 0 1000000000000
RG11 11 0 1000000000000
RG12 12 0 1000000000000
RG13 13 0 1000000000000
RG14 14 0 1000000000000
RG15 15 0 1000000000000
RG16 16 0 1000000000000
RG17 17 0 1000000000000
RG18 18 0 1000000000000
RG19 19 0 1000000000000
RG20 20 0 1000000000000
RG21 21 0 1000000000000
RG22 22 0 1000000000000
RG23 23 0 1000000000000
VS0 13 s0 0
R0 s0 17 18e-1
VS1 22 s1 0
I1 s1 7 DC 15e-4
VS2 20 s2 0
R2 s2 11 47e3
VS3 11 s3 0
I3 s3 15 DC 82e-2
VS4 15 s4 0
I4 s4 21 DC 56e-3
VS5 13 s5 0
R5 s5 19 27e0
VS6 7 s6 0
R6 s6 8 47e0
VS7 18 s7 0
R7 s7 4 18e0
VS8 5 s8 0
R8 s8 0 27e3
VS9 14 s9 0
R9 s9 21 68e-1
VS10 0 s10 0
V10 e10 s10 DC 10e0
RI10 e10 20 22e-3
VS11 5 s11 0
R11 s11 19 27e-1
VS12 3 s12 0
I12 s12 12 DC 39e-4
VS13 16 s13 0
R13 s13 17 27e0
VS14 13 s14 0
R14 s14 9 22e3
VS15 9 s15 0
R15 s15 1 47e-1
VS16 2 s16 0
R16 s16 22 27e0
VS17 9 s17 0
R17 s17 20 39e-1
VS18 10 s18 0
R18 s18 17 56e-2
VS19 7 s19 0
R19 s19 9 12e-1
VS20 1 s20 0
I20 s20 23 DC 47e-3
VS21 4 s21 0
R21 s21 3 12e2
VS22 22 s22 0
R22 s22 6 68e0
VS23 15 s23 0
R23 s23 6 18e-2
VS24 9 s24 0
R24 s24 22 39e3
VS25 4 s25 0
V25 e25 s25 DC 22e0
RI25 e25 12 12e-1
VS26 22 s26 0
V26 e26 s26 DC 82e1
RI26 e26 18 22e-2
VS27 21 s27 0
R27 s27 8 68e-2
VS28 14 s28 0
R28 s28 3 22e3
VS29 17 s29 0
R29 s29 23 39e3
VS30 11 s30 0
V30 e30 s30 DC 12e-1
RI30 e30 5 68e-3
VS31 5 s31 0
R31 s31 4 18e0
VS32 13 s32 0
V32 e32 s32 DC 15e1
RI32 e32 16 56e-3
VS33 20 s33 0
R33 s33 22 22e0
VS34 12 s34 0
R34 s34 23 15e3
VS35 21 s35 0
V35 e35 s35 DC 22e-1
RI35 e35 10 12e-1
VS36 1 s36 0
R36 s36 15 82e-2
VS37 12 s37 0
V37 e37 s37 DC 56e1
RI37 e37 22 82e-3
VS38 21 s38 0
R38 s38 20 68e2
VS39 17 s39 0
R39 s39 2 82e0
.control
set numdgt=17
op
print v(1) v(2) v(3) v(4) v(5) v(6) v(7) v(8) v(9) v(10)
print v(11) v(12) v(13) v(14) v(15) v(16) v(17) v(18) v(19) v(20)
print v(21) v(22) v(23)
print i(vs0) i(vs1) i(vs2) i(vs3) i(vs4) i(vs5) i(vs6) i(vs7) i(vs8) i(vs9)
print i(vs10) i(vs11) i(vs12) i(vs13) i(vs14) i(vs15) i(vs16) i(vs17) i(vs18) i(vs19)
print i(vs20) i(vs21) i(vs22) i(vs23) i(vs24) i(vs25) i(vs26) i(vs27) i(vs28) i(vs29)
print i(vs30) i(vs31) i(vs32) i(vs33) i(vs34) i(vs35) i(vs36) i(vs37) i(vs38) i(vs39)
.endc
.end
