controls oracle dc-0125
* Generated (plan F2.7, ADR 0012): do not edit; regenerate with `pnpm sim oracle regen`. dc seed 20261030 index 125 nodes 24 elements 28
.options sparse gmin=1e-12 noopac
RG1 1 0 1000000000000
RG2 2 0 1000000000000
RG3 3 0 1000000000000
RG4 4 0 1000000000000
RG5 5 0 1000000000000
RG6 6 0 1000000000000
RG7 7 0 1000000000000
RG8 8 0 1000000000000
RG9 9 0 1000000000000
RG10 10 0 1000000000000
RG11 11 0 1000000000000
RG12 12 0 1000000000000
RG13 13 0 1000000000000
RG14 14 0 1000000000000
RG15 15 0 1000000000000
RG16 16 0 1000000000000
RG17 17 0 1000000000000
RG18 18 0 1000000000000
RG19 19 0 1000000000000
RG20 20 0 1000000000000
RG21 21 0 1000000000000
RG22 22 0 1000000000000
RG23 23 0 1000000000000
VS0 22 s0 0
I0 s0 7 DC 15e-4
VS1 21 s1 0
R1 s1 20 68e2
VS2 20 s2 0
R2 s2 22 22e0
VS3 2 s3 0
R3 s3 22 27e0
VS4 5 s4 0
R4 s4 4 18e0
VS5 3 s5 0
I5 s5 12 DC 39e-4
VS6 15 s6 0
R6 s6 6 18e-2
VS7 22 s7 0
R7 s7 6 68e0
VS8 9 s8 0
R8 s8 1 47e-1
VS9 7 s9 0
R9 s9 8 47e0
VS10 1 s10 0
I10 s10 23 DC 47e-3
VS11 13 s11 0
R11 s11 17 18e-1
VS12 17 s12 0
R12 s12 23 39e3
VS13 16 s13 0
R13 s13 17 27e0
VS14 20 s14 0
R14 s14 11 47e3
VS15 13 s15 0
R15 s15 9 22e3
VS16 9 s16 0
R16 s16 22 39e3
VS17 10 s17 0
R17 s17 17 56e-2
VS18 11 s18 0
I18 s18 15 DC 82e-2
VS19 4 s19 0
R19 s19 3 12e2
VS20 14 s20 0
R20 s20 3 22e3
VS21 0 s21 0
V21 e21 s21 DC 10e0
RI21 e21 20 22e-3
VS22 12 s22 0
V22 e22 s22 DC 56e1
RI22 e22 22 82e-3
VS23 15 s23 0
I23 s23 21 DC 56e-3
VS24 7 s24 0
R24 s24 9 12e-1
VS25 4 s25 0
V25 e25 s25 DC 22e0
RI25 e25 12 12e-1
VS26 13 s26 0
R26 s26 19 27e0
VS27 18 s27 0
R27 s27 4 18e0
.control
set numdgt=17
op
print v(1) v(2) v(3) v(4) v(5) v(6) v(7) v(8) v(9) v(10)
print v(11) v(12) v(13) v(14) v(15) v(16) v(17) v(18) v(19) v(20)
print v(21) v(22) v(23)
print i(vs0) i(vs1) i(vs2) i(vs3) i(vs4) i(vs5) i(vs6) i(vs7) i(vs8) i(vs9)
print i(vs10) i(vs11) i(vs12) i(vs13) i(vs14) i(vs15) i(vs16) i(vs17) i(vs18) i(vs19)
print i(vs20) i(vs21) i(vs22) i(vs23) i(vs24) i(vs25) i(vs26) i(vs27)
.endc
.end
