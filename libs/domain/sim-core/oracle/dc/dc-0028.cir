controls oracle dc-0028
* Generated (plan F2.7, ADR 0012): do not edit; regenerate with `pnpm sim oracle regen`. dc seed 20261030 index 28 nodes 12 elements 12
.options sparse gmin=1e-12 noopac
RG1 1 0 1000000000000
RG2 2 0 1000000000000
RG3 3 0 1000000000000
RG4 4 0 1000000000000
RG5 5 0 1000000000000
RG6 6 0 1000000000000
RG7 7 0 1000000000000
RG8 8 0 1000000000000
RG9 9 0 1000000000000
RG10 10 0 1000000000000
RG11 11 0 1000000000000
VS0 10 s0 0
R0 s0 3 10e2
VS1 0 s1 0
V1 e1 s1 DC 10e0
RI1 e1 8 39e-2
VS2 6 s2 0
R2 s2 9 56e0
VS3 6 s3 0
R3 s3 1 56e-1
VS4 6 s4 0
V4 e4 s4 DC 27e1
RI4 e4 11 12e-1
VS5 8 s5 0
R5 s5 2 27e3
VS6 11 s6 0
R6 s6 2 22e-1
VS7 8 s7 0
V7 e7 s7 DC 10e-1
RI7 e7 3 18e-2
VS8 7 s8 0
V8 e8 s8 DC 12e0
RI8 e8 11 39e-2
VS9 0 s9 0
R9 s9 4 56e3
VS10 7 s10 0
R10 s10 0 22e2
VS11 5 s11 0
R11 s11 11 18e-1
.control
set numdgt=17
op
print v(1) v(2) v(3) v(4) v(5) v(6) v(7) v(8) v(9) v(10)
print v(11)
print i(vs0) i(vs1) i(vs2) i(vs3) i(vs4) i(vs5) i(vs6) i(vs7) i(vs8) i(vs9)
print i(vs10) i(vs11)
.endc
.end
