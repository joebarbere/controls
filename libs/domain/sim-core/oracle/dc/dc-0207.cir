controls oracle dc-0207
* Generated (plan F2.7, ADR 0012): do not edit; regenerate with `pnpm sim oracle regen`. dc seed 20261030 index 207 nodes 26 elements 39
.options sparse gmin=1e-12 noopac
RG1 1 0 1000000000000
RG2 2 0 1000000000000
RG3 3 0 1000000000000
RG4 4 0 1000000000000
RG5 5 0 1000000000000
RG6 6 0 1000000000000
RG7 7 0 1000000000000
RG8 8 0 1000000000000
RG9 9 0 1000000000000
RG10 10 0 1000000000000
RG11 11 0 1000000000000
RG12 12 0 1000000000000
RG13 13 0 1000000000000
RG14 14 0 1000000000000
RG15 15 0 1000000000000
RG16 16 0 1000000000000
RG17 17 0 1000000000000
RG18 18 0 1000000000000
RG19 19 0 1000000000000
RG20 20 0 1000000000000
RG21 21 0 1000000000000
RG22 22 0 1000000000000
RG23 23 0 1000000000000
RG24 24 0 1000000000000
RG25 25 0 1000000000000
VS0 21 s0 0
R0 s0 22 12e2
VS1 1 s1 0
R1 s1 3 10e-2
VS2 7 s2 0
R2 s2 12 56e0
VS3 7 s3 0
R3 s3 15 39e3
VS4 8 s4 0
R4 s4 2 10e1
VS5 11 s5 0
I5 s5 21 DC 18e-4
VS6 4 s6 0
R6 s6 3 27e3
VS7 16 s7 0
R7 s7 23 10e2
VS8 1 s8 0
R8 s8 2 22e-1
VS9 24 s9 0
R9 s9 5 18e1
VS10 19 s10 0
R10 s10 13 27e-2
VS11 2 s11 0
R11 s11 21 56e-2
VS12 20 s12 0
R12 s12 11 33e1
VS13 25 s13 0
R13 s13 16 68e-2
VS14 25 s14 0
R14 s14 9 82e2
VS15 24 s15 0
R15 s15 20 33e0
VS16 9 s16 0
R16 s16 4 68e3
VS17 16 s17 0
R17 s17 0 27e-1
VS18 10 s18 0
R18 s18 6 27e-2
VS19 14 s19 0
R19 s19 6 15e2
VS20 13 s20 0
I20 s20 8 DC 68e-4
VS21 16 s21 0
R21 s21 13 18e3
VS22 17 s22 0
R22 s22 18 22e1
VS23 3 s23 0
R23 s23 1 56e1
VS24 9 s24 0
R24 s24 17 68e-1
VS25 0 s25 0
V25 e25 s25 DC 47e1
RI25 e25 6 18e-2
VS26 9 s26 0
R26 s26 5 12e-1
VS27 19 s27 0
R27 s27 18 12e3
VS28 11 s28 0
R28 s28 13 27e3
VS29 8 s29 0
R29 s29 18 68e0
VS30 13 s30 0
R30 s30 8 27e0
VS31 17 s31 0
R31 s31 2 56e2
VS32 20 s32 0
R32 s32 0 47e2
VS33 16 s33 0
R33 s33 14 39e0
VS34 7 s34 0
R34 s34 0 22e1
VS35 17 s35 0
I35 s35 20 DC 68e-3
VS36 1 s36 0
R36 s36 7 82e0
VS37 8 s37 0
V37 e37 s37 DC 39e0
RI37 e37 0 56e-2
VS38 22 s38 0
V38 e38 s38 DC 10e-1
RI38 e38 3 82e-2
.control
set numdgt=17
op
print v(1) v(2) v(3) v(4) v(5) v(6) v(7) v(8) v(9) v(10)
print v(11) v(12) v(13) v(14) v(15) v(16) v(17) v(18) v(19) v(20)
print v(21) v(22) v(23) v(24) v(25)
print i(vs0) i(vs1) i(vs2) i(vs3) i(vs4) i(vs5) i(vs6) i(vs7) i(vs8) i(vs9)
print i(vs10) i(vs11) i(vs12) i(vs13) i(vs14) i(vs15) i(vs16) i(vs17) i(vs18) i(vs19)
print i(vs20) i(vs21) i(vs22) i(vs23) i(vs24) i(vs25) i(vs26) i(vs27) i(vs28) i(vs29)
print i(vs30) i(vs31) i(vs32) i(vs33) i(vs34) i(vs35) i(vs36) i(vs37) i(vs38)
.endc
.end
