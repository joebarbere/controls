controls oracle dc-0207
* Generated (plan F2.7, ADR 0012): do not edit; regenerate with `pnpm sim oracle regen`. dc seed 20261030 index 207 nodes 26 elements 43
.options sparse gmin=1e-12 noopac
RG1 1 0 1000000000000
RG2 2 0 1000000000000
RG3 3 0 1000000000000
RG4 4 0 1000000000000
RG5 5 0 1000000000000
RG6 6 0 1000000000000
RG7 7 0 1000000000000
RG8 8 0 1000000000000
RG9 9 0 1000000000000
RG10 10 0 1000000000000
RG11 11 0 1000000000000
RG12 12 0 1000000000000
RG13 13 0 1000000000000
RG14 14 0 1000000000000
RG15 15 0 1000000000000
RG16 16 0 1000000000000
RG17 17 0 1000000000000
RG18 18 0 1000000000000
RG19 19 0 1000000000000
RG20 20 0 1000000000000
RG21 21 0 1000000000000
RG22 22 0 1000000000000
RG23 23 0 1000000000000
RG24 24 0 1000000000000
RG25 25 0 1000000000000
VS0 9 s0 0
R0 s0 5 12e-1
VS1 0 s1 0
V1 e1 s1 DC 39e0
RI1 e1 2 56e-2
VS2 16 s2 0
R2 s2 2 27e-1
VS3 7 s3 0
R3 s3 15 39e3
VS4 17 s4 0
R4 s4 18 22e1
VS5 17 s5 0
R5 s5 8 56e2
VS6 11 s6 0
R6 s6 13 27e3
VS7 24 s7 0
R7 s7 5 18e1
VS8 9 s8 0
R8 s8 4 68e3
VS9 3 s9 0
R9 s9 1 56e1
VS10 16 s10 0
R10 s10 14 39e0
VS11 16 s11 0
R11 s11 13 18e3
VS12 8 s12 0
R12 s12 21 56e-2
VS13 24 s13 0
R13 s13 20 33e0
VS14 9 s14 0
R14 s14 17 68e-1
VS15 16 s15 0
R15 s15 23 10e2
VS16 19 s16 0
R16 s16 18 12e3
VS17 25 s17 0
R17 s17 16 68e-2
VS18 1 s18 0
R18 s18 8 22e-1
VS19 17 s19 0
I19 s19 20 DC 68e-3
VS20 7 s20 0
R20 s20 12 56e0
VS21 1 s21 0
R21 s21 3 10e-2
VS22 25 s22 0
R22 s22 9 82e2
VS23 19 s23 0
R23 s23 13 27e-2
VS24 22 s24 0
V24 e24 s24 DC 10e-1
RI24 e24 3 82e-2
VS25 20 s25 0
R25 s25 11 33e1
VS26 2 s26 0
V26 e26 s26 DC 47e1
RI26 e26 6 18e-2
VS27 0 s27 0
R27 s27 18 68e0
VS28 19 s28 0
R28 s28 12 12e-1
VS29 21 s29 0
R29 s29 22 12e2
VS30 10 s30 0
R30 s30 6 27e-2
VS31 1 s31 0
R31 s31 7 82e0
VS32 15 s32 0
R32 s32 10 82e-1
VS33 14 s33 0
R33 s33 6 15e2
VS34 20 s34 0
R34 s34 2 47e2
VS35 4 s35 0
R35 s35 3 27e3
VS36 13 s36 0
R36 s36 0 27e0
VS37 0 s37 0
R37 s37 8 10e1
VS38 13 s38 0
I38 s38 0 DC 68e-4
VS39 7 s39 0
R39 s39 2 22e1
VS40 11 s40 0
I40 s40 21 DC 18e-4
VS41 23 s41 0
V41 e41 s41 DC 12e-1
RI41 e41 24 22e-3
VS42 10 s42 0
R42 s42 17 22e0
.control
set numdgt=17
op
print v(1) v(2) v(3) v(4) v(5) v(6) v(7) v(8) v(9) v(10)
print v(11) v(12) v(13) v(14) v(15) v(16) v(17) v(18) v(19) v(20)
print v(21) v(22) v(23) v(24) v(25)
print i(vs0) i(vs1) i(vs2) i(vs3) i(vs4) i(vs5) i(vs6) i(vs7) i(vs8) i(vs9)
print i(vs10) i(vs11) i(vs12) i(vs13) i(vs14) i(vs15) i(vs16) i(vs17) i(vs18) i(vs19)
print i(vs20) i(vs21) i(vs22) i(vs23) i(vs24) i(vs25) i(vs26) i(vs27) i(vs28) i(vs29)
print i(vs30) i(vs31) i(vs32) i(vs33) i(vs34) i(vs35) i(vs36) i(vs37) i(vs38) i(vs39)
print i(vs40) i(vs41) i(vs42)
.endc
.end
