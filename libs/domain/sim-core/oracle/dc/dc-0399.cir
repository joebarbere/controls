controls oracle dc-0399
* Generated (plan F2.7, ADR 0012): do not edit; regenerate with `pnpm sim oracle regen`. dc seed 20261030 index 399 nodes 5 elements 9
.options sparse gmin=1e-12 noopac
RG1 1 0 1000000000000
RG2 2 0 1000000000000
RG3 3 0 1000000000000
RG4 4 0 1000000000000
VS0 0 s0 0
R0 s0 3 56e0
VS1 0 s1 0
V1 e1 s1 DC 22e-1
RI1 e1 2 56e-1
VS2 0 s2 0
R2 s2 1 12e2
VS3 3 s3 0
R3 s3 2 15e1
VS4 4 s4 0
R4 s4 2 39e-1
VS5 3 s5 0
R5 s5 1 39e-1
VS6 1 s6 0
R6 s6 2 15e2
VS7 3 s7 0
R7 s7 0 33e-1
VS8 4 s8 0
R8 s8 2 82e3
.control
set numdgt=17
op
print v(1) v(2) v(3) v(4)
print i(vs0) i(vs1) i(vs2) i(vs3) i(vs4) i(vs5) i(vs6) i(vs7) i(vs8)
.endc
.end
