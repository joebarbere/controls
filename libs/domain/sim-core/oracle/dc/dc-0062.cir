controls oracle dc-0062
* Generated (plan F2.7, ADR 0012): do not edit; regenerate with `pnpm sim oracle regen`. dc seed 20261030 index 62 nodes 14 elements 18
.options sparse gmin=1e-12 noopac
RG1 1 0 1000000000000
RG2 2 0 1000000000000
RG3 3 0 1000000000000
RG4 4 0 1000000000000
RG5 5 0 1000000000000
RG6 6 0 1000000000000
RG7 7 0 1000000000000
RG8 8 0 1000000000000
RG9 9 0 1000000000000
RG10 10 0 1000000000000
RG11 11 0 1000000000000
RG12 12 0 1000000000000
RG13 13 0 1000000000000
VS0 0 s0 0
V0 e0 s0 DC 22e0
RI0 e0 11 27e-1
VS1 12 s1 0
R1 s1 10 47e0
VS2 10 s2 0
R2 s2 6 33e0
VS3 1 s3 0
R3 s3 3 10e0
VS4 0 s4 0
R4 s4 1 47e1
VS5 8 s5 0
R5 s5 5 22e1
VS6 8 s6 0
V6 e6 s6 DC 33e1
RI6 e6 7 56e-3
VS7 10 s7 0
V7 e7 s7 DC 47e1
RI7 e7 4 33e-1
VS8 1 s8 0
I8 s8 13 DC 12e-1
VS9 6 s9 0
R9 s9 0 10e0
VS10 0 s10 0
R10 s10 8 15e0
VS11 6 s11 0
R11 s11 12 18e3
VS12 2 s12 0
R12 s12 9 56e2
VS13 2 s13 0
R13 s13 8 39e2
VS14 9 s14 0
R14 s14 11 47e1
VS15 10 s15 0
I15 s15 7 DC 27e-2
VS16 2 s16 0
R16 s16 3 56e2
VS17 13 s17 0
R17 s17 8 33e1
.control
set numdgt=17
op
print v(1) v(2) v(3) v(4) v(5) v(6) v(7) v(8) v(9) v(10)
print v(11) v(12) v(13)
print i(vs0) i(vs1) i(vs2) i(vs3) i(vs4) i(vs5) i(vs6) i(vs7) i(vs8) i(vs9)
print i(vs10) i(vs11) i(vs12) i(vs13) i(vs14) i(vs15) i(vs16) i(vs17)
.endc
.end
