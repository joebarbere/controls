controls oracle dc-0061
* Generated (plan F2.7, ADR 0012): do not edit; regenerate with `pnpm sim oracle regen`. dc seed 20261030 index 61 nodes 23 elements 33
.options sparse gmin=1e-12 noopac
RG1 1 0 1000000000000
RG2 2 0 1000000000000
RG3 3 0 1000000000000
RG4 4 0 1000000000000
RG5 5 0 1000000000000
RG6 6 0 1000000000000
RG7 7 0 1000000000000
RG8 8 0 1000000000000
RG9 9 0 1000000000000
RG10 10 0 1000000000000
RG11 11 0 1000000000000
RG12 12 0 1000000000000
RG13 13 0 1000000000000
RG14 14 0 1000000000000
RG15 15 0 1000000000000
RG16 16 0 1000000000000
RG17 17 0 1000000000000
RG18 18 0 1000000000000
RG19 19 0 1000000000000
RG20 20 0 1000000000000
RG21 21 0 1000000000000
RG22 22 0 1000000000000
VS0 4 s0 0
I0 s0 8 DC 10e-4
VS1 2 s1 0
R1 s1 20 82e-1
VS2 0 s2 0
V2 e2 s2 DC 18e-1
RI2 e2 17 56e-3
VS3 17 s3 0
V3 e3 s3 DC 18e0
RI3 e3 13 82e-3
VS4 12 s4 0
R4 s4 1 22e-1
VS5 14 s5 0
R5 s5 22 10e-1
VS6 15 s6 0
V6 e6 s6 DC 56e0
RI6 e6 9 39e-2
VS7 22 s7 0
R7 s7 21 12e1
VS8 20 s8 0
R8 s8 10 22e1
VS9 19 s9 0
R9 s9 13 22e-1
VS10 16 s10 0
R10 s10 7 18e0
VS11 18 s11 0
R11 s11 4 10e3
VS12 5 s12 0
R12 s12 1 27e-1
VS13 14 s13 0
R13 s13 17 22e1
VS14 7 s14 0
R14 s14 10 10e0
VS15 10 s15 0
R15 s15 19 56e-2
VS16 4 s16 0
V16 e16 s16 DC 33e-1
RI16 e16 10 82e-1
VS17 21 s17 0
R17 s17 3 39e1
VS18 8 s18 0
R18 s18 11 68e-1
VS19 11 s19 0
R19 s19 19 68e0
VS20 7 s20 0
R20 s20 17 22e-1
VS21 19 s21 0
R21 s21 6 39e3
VS22 17 s22 0
R22 s22 14 47e-1
VS23 13 s23 0
R23 s23 21 15e0
VS24 16 s24 0
I24 s24 8 DC 10e-4
VS25 11 s25 0
V25 e25 s25 DC 15e1
RI25 e25 1 12e-2
VS26 16 s26 0
R26 s26 3 12e2
VS27 17 s27 0
R27 s27 15 22e-2
VS28 21 s28 0
R28 s28 2 47e1
VS29 7 s29 0
R29 s29 6 10e1
VS30 14 s30 0
V30 e30 s30 DC 27e1
RI30 e30 17 22e-3
VS31 14 s31 0
I31 s31 20 DC 15e-3
VS32 18 s32 0
R32 s32 10 27e0
.control
set numdgt=17
op
print v(1) v(2) v(3) v(4) v(5) v(6) v(7) v(8) v(9) v(10)
print v(11) v(12) v(13) v(14) v(15) v(16) v(17) v(18) v(19) v(20)
print v(21) v(22)
print i(vs0) i(vs1) i(vs2) i(vs3) i(vs4) i(vs5) i(vs6) i(vs7) i(vs8) i(vs9)
print i(vs10) i(vs11) i(vs12) i(vs13) i(vs14) i(vs15) i(vs16) i(vs17) i(vs18) i(vs19)
print i(vs20) i(vs21) i(vs22) i(vs23) i(vs24) i(vs25) i(vs26) i(vs27) i(vs28) i(vs29)
print i(vs30) i(vs31) i(vs32)
.endc
.end
