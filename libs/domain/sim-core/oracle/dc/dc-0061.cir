controls oracle dc-0061
* Generated (plan F2.7, ADR 0012): do not edit; regenerate with `pnpm sim oracle regen`. dc seed 20261030 index 61 nodes 23 elements 39
.options sparse gmin=1e-12 noopac
RG1 1 0 1000000000000
RG2 2 0 1000000000000
RG3 3 0 1000000000000
RG4 4 0 1000000000000
RG5 5 0 1000000000000
RG6 6 0 1000000000000
RG7 7 0 1000000000000
RG8 8 0 1000000000000
RG9 9 0 1000000000000
RG10 10 0 1000000000000
RG11 11 0 1000000000000
RG12 12 0 1000000000000
RG13 13 0 1000000000000
RG14 14 0 1000000000000
RG15 15 0 1000000000000
RG16 16 0 1000000000000
RG17 17 0 1000000000000
RG18 18 0 1000000000000
RG19 19 0 1000000000000
RG20 20 0 1000000000000
RG21 21 0 1000000000000
RG22 22 0 1000000000000
VS0 16 s0 0
R0 s0 7 18e0
VS1 10 s1 0
R1 s1 19 56e-2
VS2 18 s2 0
R2 s2 10 27e0
VS3 0 s3 0
R3 s3 14 47e-1
VS4 12 s4 0
R4 s4 10 33e0
VS5 8 s5 0
R5 s5 7 18e2
VS6 14 s6 0
R6 s6 22 10e-1
VS7 20 s7 0
R7 s7 10 22e1
VS8 0 s8 0
V8 e8 s8 DC 18e0
RI8 e8 17 82e-3
VS9 14 s9 0
R9 s9 0 22e1
VS10 11 s10 0
R10 s10 19 68e0
VS11 19 s11 0
R11 s11 6 39e3
VS12 22 s12 0
R12 s12 21 12e1
VS13 16 s13 0
I13 s13 8 DC 10e-4
VS14 14 s14 0
I14 s14 20 DC 15e-3
VS15 21 s15 0
R15 s15 2 47e1
VS16 4 s16 0
I16 s16 8 DC 10e-4
VS17 11 s17 0
V17 e17 s17 DC 15e1
RI17 e17 1 12e-2
VS18 16 s18 0
R18 s18 3 12e2
VS19 2 s19 0
R19 s19 9 33e3
VS20 4 s20 0
R20 s20 9 39e3
VS21 0 s21 0
R21 s21 15 22e-2
VS22 4 s22 0
V22 e22 s22 DC 33e-1
RI22 e22 10 82e-1
VS23 12 s23 0
R23 s23 1 22e-1
VS24 17 s24 0
R24 s24 21 15e0
VS25 19 s25 0
R25 s25 17 22e-1
VS26 8 s26 0
R26 s26 11 68e-1
VS27 15 s27 0
V27 e27 s27 DC 56e0
RI27 e27 9 39e-2
VS28 7 s28 0
R28 s28 0 22e-1
VS29 5 s29 0
R29 s29 1 27e-1
VS30 15 s30 0
V30 e30 s30 DC 33e-1
RI30 e30 13 18e-2
VS31 7 s31 0
R31 s31 6 10e1
VS32 18 s32 0
R32 s32 4 10e3
VS33 13 s33 0
V33 e33 s33 DC 18e-1
RI33 e33 0 56e-3
VS34 14 s34 0
V34 e34 s34 DC 27e1
RI34 e34 0 22e-3
VS35 21 s35 0
R35 s35 3 39e1
VS36 7 s36 0
R36 s36 10 10e0
VS37 2 s37 0
R37 s37 20 82e-1
VS38 12 s38 0
R38 s38 5 22e2
.control
set numdgt=17
op
print v(1) v(2) v(3) v(4) v(5) v(6) v(7) v(8) v(9) v(10)
print v(11) v(12) v(13) v(14) v(15) v(16) v(17) v(18) v(19) v(20)
print v(21) v(22)
print i(vs0) i(vs1) i(vs2) i(vs3) i(vs4) i(vs5) i(vs6) i(vs7) i(vs8) i(vs9)
print i(vs10) i(vs11) i(vs12) i(vs13) i(vs14) i(vs15) i(vs16) i(vs17) i(vs18) i(vs19)
print i(vs20) i(vs21) i(vs22) i(vs23) i(vs24) i(vs25) i(vs26) i(vs27) i(vs28) i(vs29)
print i(vs30) i(vs31) i(vs32) i(vs33) i(vs34) i(vs35) i(vs36) i(vs37) i(vs38)
.endc
.end
