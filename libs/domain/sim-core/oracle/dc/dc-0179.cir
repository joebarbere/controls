controls oracle dc-0179
* Generated (plan F2.7, ADR 0012): do not edit; regenerate with `pnpm sim oracle regen`. dc seed 20261030 index 179 nodes 20 elements 33
.options sparse gmin=1e-12 noopac
RG1 1 0 1000000000000
RG2 2 0 1000000000000
RG3 3 0 1000000000000
RG4 4 0 1000000000000
RG5 5 0 1000000000000
RG6 6 0 1000000000000
RG7 7 0 1000000000000
RG8 8 0 1000000000000
RG9 9 0 1000000000000
RG10 10 0 1000000000000
RG11 11 0 1000000000000
RG12 12 0 1000000000000
RG13 13 0 1000000000000
RG14 14 0 1000000000000
RG15 15 0 1000000000000
RG16 16 0 1000000000000
RG17 17 0 1000000000000
RG18 18 0 1000000000000
RG19 19 0 1000000000000
VS0 12 s0 0
R0 s0 6 56e-1
VS1 6 s1 0
R1 s1 3 47e1
VS2 12 s2 0
R2 s2 5 18e2
VS3 4 s3 0
R3 s3 1 22e-1
VS4 8 s4 0
R4 s4 18 82e-1
VS5 13 s5 0
R5 s5 11 33e-1
VS6 18 s6 0
R6 s6 10 39e1
VS7 16 s7 0
R7 s7 13 27e0
VS8 11 s8 0
I8 s8 18 DC 68e-1
VS9 0 s9 0
V9 e9 s9 DC 22e1
RI9 e9 7 56e-1
VS10 16 s10 0
R10 s10 1 27e3
VS11 9 s11 0
R11 s11 7 12e0
VS12 10 s12 0
R12 s12 19 15e0
VS13 2 s13 0
R13 s13 4 18e-2
VS14 19 s14 0
R14 s14 15 56e2
VS15 2 s15 0
V15 e15 s15 DC 47e1
RI15 e15 0 39e-2
VS16 0 s16 0
R16 s16 17 82e1
VS17 19 s17 0
I17 s17 11 DC 33e-3
VS18 15 s18 0
V18 e18 s18 DC 15e-1
RI18 e18 12 27e-3
VS19 2 s19 0
V19 e19 s19 DC 22e1
RI19 e19 13 22e-1
VS20 18 s20 0
R20 s20 9 12e-2
VS21 9 s21 0
R21 s21 8 12e-1
VS22 11 s22 0
R22 s22 8 10e1
VS23 9 s23 0
R23 s23 17 39e-1
VS24 9 s24 0
R24 s24 12 22e3
VS25 3 s25 0
R25 s25 9 47e0
VS26 18 s26 0
I26 s26 7 DC 22e-4
VS27 16 s27 0
R27 s27 5 56e2
VS28 7 s28 0
V28 e28 s28 DC 27e-1
RI28 e28 11 68e-2
VS29 19 s29 0
V29 e29 s29 DC 10e0
RI29 e29 0 15e-2
VS30 14 s30 0
R30 s30 8 27e2
VS31 10 s31 0
I31 s31 12 DC 27e-3
VS32 0 s32 0
R32 s32 18 18e3
.control
set numdgt=17
op
print v(1) v(2) v(3) v(4) v(5) v(6) v(7) v(8) v(9) v(10)
print v(11) v(12) v(13) v(14) v(15) v(16) v(17) v(18) v(19)
print i(vs0) i(vs1) i(vs2) i(vs3) i(vs4) i(vs5) i(vs6) i(vs7) i(vs8) i(vs9)
print i(vs10) i(vs11) i(vs12) i(vs13) i(vs14) i(vs15) i(vs16) i(vs17) i(vs18) i(vs19)
print i(vs20) i(vs21) i(vs22) i(vs23) i(vs24) i(vs25) i(vs26) i(vs27) i(vs28) i(vs29)
print i(vs30) i(vs31) i(vs32)
.endc
.end
