controls oracle dc-0179
* Generated (plan F2.7, ADR 0012): do not edit; regenerate with `pnpm sim oracle regen`. dc seed 20261030 index 179 nodes 20 elements 34
.options sparse gmin=1e-12 noopac
RG1 1 0 1000000000000
RG2 2 0 1000000000000
RG3 3 0 1000000000000
RG4 4 0 1000000000000
RG5 5 0 1000000000000
RG6 6 0 1000000000000
RG7 7 0 1000000000000
RG8 8 0 1000000000000
RG9 9 0 1000000000000
RG10 10 0 1000000000000
RG11 11 0 1000000000000
RG12 12 0 1000000000000
RG13 13 0 1000000000000
RG14 14 0 1000000000000
RG15 15 0 1000000000000
RG16 16 0 1000000000000
RG17 17 0 1000000000000
RG18 18 0 1000000000000
RG19 19 0 1000000000000
VS0 16 s0 0
R0 s0 13 27e0
VS1 19 s1 0
R1 s1 0 56e2
VS2 16 s2 0
R2 s2 5 56e2
VS3 12 s3 0
R3 s3 6 56e-1
VS4 0 s4 0
V4 e4 s4 DC 15e-1
RI4 e4 12 27e-3
VS5 11 s5 0
I5 s5 15 DC 68e-1
VS6 3 s6 0
R6 s6 9 47e0
VS7 8 s7 0
R7 s7 15 82e-1
VS8 15 s8 0
R8 s8 9 12e-2
VS9 12 s9 0
R9 s9 5 18e2
VS10 9 s10 0
R10 s10 17 39e-1
VS11 9 s11 0
R11 s11 7 12e0
VS12 18 s12 0
V12 e12 s12 DC 22e1
RI12 e12 7 56e-1
VS13 18 s13 0
R13 s13 17 82e1
VS14 15 s14 0
R14 s14 10 39e1
VS15 19 s15 0
I15 s15 11 DC 33e-3
VS16 15 s16 0
R16 s16 14 12e3
VS17 9 s17 0
R17 s17 8 12e-1
VS18 9 s18 0
R18 s18 12 22e3
VS19 2 s19 0
V19 e19 s19 DC 22e1
RI19 e19 13 22e-1
VS20 19 s20 0
V20 e20 s20 DC 10e0
RI20 e20 18 15e-2
VS21 4 s21 0
R21 s21 1 22e-1
VS22 13 s22 0
R22 s22 11 33e-1
VS23 18 s23 0
R23 s23 15 18e3
VS24 6 s24 0
R24 s24 3 47e1
VS25 10 s25 0
I25 s25 12 DC 27e-3
VS26 11 s26 0
R26 s26 8 10e1
VS27 2 s27 0
R27 s27 4 18e-2
VS28 16 s28 0
R28 s28 1 27e3
VS29 2 s29 0
V29 e29 s29 DC 47e1
RI29 e29 18 39e-2
VS30 10 s30 0
R30 s30 19 15e0
VS31 7 s31 0
V31 e31 s31 DC 27e-1
RI31 e31 11 68e-2
VS32 15 s32 0
I32 s32 7 DC 22e-4
VS33 14 s33 0
R33 s33 8 27e2
.control
set numdgt=17
op
print v(1) v(2) v(3) v(4) v(5) v(6) v(7) v(8) v(9) v(10)
print v(11) v(12) v(13) v(14) v(15) v(16) v(17) v(18) v(19)
print i(vs0) i(vs1) i(vs2) i(vs3) i(vs4) i(vs5) i(vs6) i(vs7) i(vs8) i(vs9)
print i(vs10) i(vs11) i(vs12) i(vs13) i(vs14) i(vs15) i(vs16) i(vs17) i(vs18) i(vs19)
print i(vs20) i(vs21) i(vs22) i(vs23) i(vs24) i(vs25) i(vs26) i(vs27) i(vs28) i(vs29)
print i(vs30) i(vs31) i(vs32) i(vs33)
.endc
.end
