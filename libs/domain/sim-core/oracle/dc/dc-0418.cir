controls oracle dc-0418
* Generated (plan F2.7, ADR 0012): do not edit; regenerate with `pnpm sim oracle regen`. dc seed 20261030 index 418 nodes 14 elements 27
.options sparse gmin=1e-12 noopac
RG1 1 0 1000000000000
RG2 2 0 1000000000000
RG3 3 0 1000000000000
RG4 4 0 1000000000000
RG5 5 0 1000000000000
RG6 6 0 1000000000000
RG7 7 0 1000000000000
RG8 8 0 1000000000000
RG9 9 0 1000000000000
RG10 10 0 1000000000000
RG11 11 0 1000000000000
RG12 12 0 1000000000000
RG13 13 0 1000000000000
VS0 3 s0 0
R0 s0 5 39e-2
VS1 7 s1 0
R1 s1 5 39e1
VS2 7 s2 0
R2 s2 10 15e3
VS3 2 s3 0
R3 s3 3 12e2
VS4 10 s4 0
R4 s4 8 10e0
VS5 5 s5 0
R5 s5 1 39e1
VS6 0 s6 0
V6 e6 s6 DC 27e1
RI6 e6 10 15e-3
VS7 13 s7 0
R7 s7 5 39e-1
VS8 8 s8 0
R8 s8 6 39e-1
VS9 3 s9 0
I9 s9 12 DC 82e-3
VS10 4 s10 0
V10 e10 s10 DC 68e1
RI10 e10 3 82e-2
VS11 2 s11 0
R11 s11 11 15e-1
VS12 13 s12 0
R12 s12 3 39e0
VS13 13 s13 0
V13 e13 s13 DC 56e-1
RI13 e13 3 68e-2
VS14 2 s14 0
I14 s14 10 DC 27e-4
VS15 6 s15 0
R15 s15 4 39e3
VS16 12 s16 0
R16 s16 13 82e0
VS17 3 s17 0
V17 e17 s17 DC 39e1
RI17 e17 1 18e-2
VS18 11 s18 0
R18 s18 3 56e0
VS19 4 s19 0
R19 s19 10 15e3
VS20 4 s20 0
R20 s20 12 82e3
VS21 9 s21 0
R21 s21 3 56e-1
VS22 13 s22 0
R22 s22 11 56e3
VS23 11 s23 0
R23 s23 8 82e3
VS24 0 s24 0
R24 s24 2 68e3
VS25 10 s25 0
R25 s25 4 12e0
VS26 5 s26 0
R26 s26 9 15e2
.control
set numdgt=17
op
print v(1) v(2) v(3) v(4) v(5) v(6) v(7) v(8) v(9) v(10)
print v(11) v(12) v(13)
print i(vs0) i(vs1) i(vs2) i(vs3) i(vs4) i(vs5) i(vs6) i(vs7) i(vs8) i(vs9)
print i(vs10) i(vs11) i(vs12) i(vs13) i(vs14) i(vs15) i(vs16) i(vs17) i(vs18) i(vs19)
print i(vs20) i(vs21) i(vs22) i(vs23) i(vs24) i(vs25) i(vs26)
.endc
.end
