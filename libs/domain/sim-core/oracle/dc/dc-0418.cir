controls oracle dc-0418
* Generated (plan F2.7, ADR 0012): do not edit; regenerate with `pnpm sim oracle regen`. dc seed 20261030 index 418 nodes 14 elements 23
.options sparse gmin=1e-12 noopac
RG1 1 0 1000000000000
RG2 2 0 1000000000000
RG3 3 0 1000000000000
RG4 4 0 1000000000000
RG5 5 0 1000000000000
RG6 6 0 1000000000000
RG7 7 0 1000000000000
RG8 8 0 1000000000000
RG9 9 0 1000000000000
RG10 10 0 1000000000000
RG11 11 0 1000000000000
RG12 12 0 1000000000000
RG13 13 0 1000000000000
VS0 3 s0 0
R0 s0 5 39e-2
VS1 0 s1 0
R1 s1 12 82e3
VS2 3 s2 0
I2 s2 12 DC 82e-3
VS3 10 s3 0
R3 s3 0 12e0
VS4 2 s4 0
R4 s4 11 15e-1
VS5 10 s5 0
R5 s5 8 10e0
VS6 9 s6 0
R6 s6 3 56e-1
VS7 12 s7 0
R7 s7 4 82e0
VS8 11 s8 0
R8 s8 3 56e0
VS9 7 s9 0
R9 s9 10 15e3
VS10 2 s10 0
I10 s10 10 DC 27e-4
VS11 6 s11 0
R11 s11 0 39e3
VS12 0 s12 0
V12 e12 s12 DC 68e1
RI12 e12 3 82e-2
VS13 7 s13 0
R13 s13 5 39e1
VS14 11 s14 0
R14 s14 8 82e3
VS15 4 s15 0
R15 s15 3 39e0
VS16 2 s16 0
R16 s16 3 12e2
VS17 4 s17 0
R17 s17 11 56e3
VS18 4 s18 0
V18 e18 s18 DC 56e-1
RI18 e18 3 68e-2
VS19 4 s19 0
R19 s19 5 39e-1
VS20 0 s20 0
R20 s20 10 15e3
VS21 3 s21 0
V21 e21 s21 DC 39e1
RI21 e21 1 18e-2
VS22 13 s22 0
R22 s22 2 68e3
.control
set numdgt=17
op
print v(1) v(2) v(3) v(4) v(5) v(6) v(7) v(8) v(9) v(10)
print v(11) v(12) v(13)
print i(vs0) i(vs1) i(vs2) i(vs3) i(vs4) i(vs5) i(vs6) i(vs7) i(vs8) i(vs9)
print i(vs10) i(vs11) i(vs12) i(vs13) i(vs14) i(vs15) i(vs16) i(vs17) i(vs18) i(vs19)
print i(vs20) i(vs21) i(vs22)
.endc
.end
