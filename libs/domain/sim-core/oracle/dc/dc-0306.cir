controls oracle dc-0306
* Generated (plan F2.7, ADR 0012): do not edit; regenerate with `pnpm sim oracle regen`. dc seed 20261030 index 306 nodes 22 elements 40
.options sparse gmin=1e-12 noopac
RG1 1 0 1000000000000
RG2 2 0 1000000000000
RG3 3 0 1000000000000
RG4 4 0 1000000000000
RG5 5 0 1000000000000
RG6 6 0 1000000000000
RG7 7 0 1000000000000
RG8 8 0 1000000000000
RG9 9 0 1000000000000
RG10 10 0 1000000000000
RG11 11 0 1000000000000
RG12 12 0 1000000000000
RG13 13 0 1000000000000
RG14 14 0 1000000000000
RG15 15 0 1000000000000
RG16 16 0 1000000000000
RG17 17 0 1000000000000
RG18 18 0 1000000000000
RG19 19 0 1000000000000
RG20 20 0 1000000000000
RG21 21 0 1000000000000
VS0 21 s0 0
R0 s0 6 12e-2
VS1 13 s1 0
R1 s1 16 12e3
VS2 12 s2 0
R2 s2 0 56e1
VS3 20 s3 0
R3 s3 18 10e-2
VS4 0 s4 0
V4 e4 s4 DC 15e0
RI4 e4 16 39e-1
VS5 20 s5 0
R5 s5 19 68e1
VS6 5 s6 0
R6 s6 8 33e-2
VS7 15 s7 0
R7 s7 3 33e2
VS8 3 s8 0
I8 s8 11 DC 39e-3
VS9 10 s9 0
R9 s9 11 39e3
VS10 18 s10 0
I10 s10 10 DC 27e-1
VS11 14 s11 0
R11 s11 8 12e2
VS12 9 s12 0
R12 s12 13 47e-2
VS13 21 s13 0
R13 s13 3 15e-1
VS14 4 s14 0
R14 s14 19 56e-1
VS15 9 s15 0
R15 s15 11 12e1
VS16 3 s16 0
I16 s16 9 DC 47e-2
VS17 1 s17 0
R17 s17 14 33e0
VS18 1 s18 0
R18 s18 6 12e3
VS19 3 s19 0
V19 e19 s19 DC 12e1
RI19 e19 5 22e-1
VS20 2 s20 0
R20 s20 13 22e2
VS21 12 s21 0
R21 s21 15 10e-2
VS22 13 s22 0
R22 s22 17 22e2
VS23 6 s23 0
R23 s23 10 18e3
VS24 2 s24 0
R24 s24 13 47e-1
VS25 7 s25 0
R25 s25 4 56e-2
VS26 20 s26 0
R26 s26 2 10e0
VS27 10 s27 0
I27 s27 7 DC 47e-1
VS28 3 s28 0
R28 s28 19 22e2
VS29 19 s29 0
R29 s29 0 10e1
VS30 3 s30 0
I30 s30 8 DC 47e-4
VS31 14 s31 0
R31 s31 9 33e0
VS32 6 s32 0
R32 s32 7 22e1
VS33 13 s33 0
R33 s33 21 47e1
VS34 16 s34 0
R34 s34 13 15e3
VS35 17 s35 0
R35 s35 12 39e-2
VS36 18 s36 0
R36 s36 6 82e2
VS37 18 s37 0
I37 s37 17 DC 15e-2
VS38 13 s38 0
R38 s38 9 33e3
VS39 9 s39 0
R39 s39 6 12e-1
.control
set numdgt=17
op
print v(1) v(2) v(3) v(4) v(5) v(6) v(7) v(8) v(9) v(10)
print v(11) v(12) v(13) v(14) v(15) v(16) v(17) v(18) v(19) v(20)
print v(21)
print i(vs0) i(vs1) i(vs2) i(vs3) i(vs4) i(vs5) i(vs6) i(vs7) i(vs8) i(vs9)
print i(vs10) i(vs11) i(vs12) i(vs13) i(vs14) i(vs15) i(vs16) i(vs17) i(vs18) i(vs19)
print i(vs20) i(vs21) i(vs22) i(vs23) i(vs24) i(vs25) i(vs26) i(vs27) i(vs28) i(vs29)
print i(vs30) i(vs31) i(vs32) i(vs33) i(vs34) i(vs35) i(vs36) i(vs37) i(vs38) i(vs39)
.endc
.end
