controls oracle dc-0306
* Generated (plan F2.7, ADR 0012): do not edit; regenerate with `pnpm sim oracle regen`. dc seed 20261030 index 306 nodes 22 elements 38
.options sparse gmin=1e-12 noopac
RG1 1 0 1000000000000
RG2 2 0 1000000000000
RG3 3 0 1000000000000
RG4 4 0 1000000000000
RG5 5 0 1000000000000
RG6 6 0 1000000000000
RG7 7 0 1000000000000
RG8 8 0 1000000000000
RG9 9 0 1000000000000
RG10 10 0 1000000000000
RG11 11 0 1000000000000
RG12 12 0 1000000000000
RG13 13 0 1000000000000
RG14 14 0 1000000000000
RG15 15 0 1000000000000
RG16 16 0 1000000000000
RG17 17 0 1000000000000
RG18 18 0 1000000000000
RG19 19 0 1000000000000
RG20 20 0 1000000000000
RG21 21 0 1000000000000
VS0 9 s0 0
R0 s0 13 47e-2
VS1 19 s1 0
R1 s1 0 10e1
VS2 14 s2 0
R2 s2 9 33e0
VS3 12 s3 0
R3 s3 15 10e-2
VS4 17 s4 0
R4 s4 12 39e-2
VS5 10 s5 0
I5 s5 7 DC 47e-1
VS6 3 s6 0
I6 s6 8 DC 47e-4
VS7 1 s7 0
R7 s7 14 33e0
VS8 20 s8 0
R8 s8 19 68e1
VS9 13 s9 0
R9 s9 21 47e1
VS10 3 s10 0
R10 s10 19 22e2
VS11 9 s11 0
R11 s11 11 12e1
VS12 15 s12 0
R12 s12 3 33e2
VS13 20 s13 0
R13 s13 2 10e0
VS14 3 s14 0
I14 s14 9 DC 47e-2
VS15 0 s15 0
V15 e15 s15 DC 15e0
RI15 e15 16 39e-1
VS16 13 s16 0
R16 s16 9 33e3
VS17 16 s17 0
R17 s17 13 15e3
VS18 6 s18 0
R18 s18 10 18e3
VS19 21 s19 0
R19 s19 6 12e-2
VS20 21 s20 0
R20 s20 3 15e-1
VS21 4 s21 0
R21 s21 19 56e-1
VS22 12 s22 0
R22 s22 0 56e1
VS23 5 s23 0
R23 s23 8 33e-2
VS24 7 s24 0
R24 s24 4 56e-2
VS25 2 s25 0
R25 s25 13 22e2
VS26 13 s26 0
R26 s26 16 12e3
VS27 18 s27 0
R27 s27 6 82e2
VS28 13 s28 0
R28 s28 17 22e2
VS29 14 s29 0
R29 s29 8 12e2
VS30 1 s30 0
R30 s30 6 12e3
VS31 18 s31 0
I31 s31 17 DC 15e-2
VS32 6 s32 0
R32 s32 7 22e1
VS33 2 s33 0
R33 s33 13 47e-1
VS34 9 s34 0
R34 s34 6 12e-1
VS35 3 s35 0
V35 e35 s35 DC 12e1
RI35 e35 5 22e-1
VS36 3 s36 0
I36 s36 11 DC 39e-3
VS37 18 s37 0
I37 s37 10 DC 27e-1
.control
set numdgt=17
op
print v(1) v(2) v(3) v(4) v(5) v(6) v(7) v(8) v(9) v(10)
print v(11) v(12) v(13) v(14) v(15) v(16) v(17) v(18) v(19) v(20)
print v(21)
print i(vs0) i(vs1) i(vs2) i(vs3) i(vs4) i(vs5) i(vs6) i(vs7) i(vs8) i(vs9)
print i(vs10) i(vs11) i(vs12) i(vs13) i(vs14) i(vs15) i(vs16) i(vs17) i(vs18) i(vs19)
print i(vs20) i(vs21) i(vs22) i(vs23) i(vs24) i(vs25) i(vs26) i(vs27) i(vs28) i(vs29)
print i(vs30) i(vs31) i(vs32) i(vs33) i(vs34) i(vs35) i(vs36) i(vs37)
.endc
.end
