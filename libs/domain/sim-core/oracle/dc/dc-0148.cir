controls oracle dc-0148
* Generated (plan F2.7, ADR 0012): do not edit; regenerate with `pnpm sim oracle regen`. dc seed 20261030 index 148 nodes 23 elements 23
.options sparse gmin=1e-12 noopac
RG1 1 0 1000000000000
RG2 2 0 1000000000000
RG3 3 0 1000000000000
RG4 4 0 1000000000000
RG5 5 0 1000000000000
RG6 6 0 1000000000000
RG7 7 0 1000000000000
RG8 8 0 1000000000000
RG9 9 0 1000000000000
RG10 10 0 1000000000000
RG11 11 0 1000000000000
RG12 12 0 1000000000000
RG13 13 0 1000000000000
RG14 14 0 1000000000000
RG15 15 0 1000000000000
RG16 16 0 1000000000000
RG17 17 0 1000000000000
RG18 18 0 1000000000000
RG19 19 0 1000000000000
RG20 20 0 1000000000000
RG21 21 0 1000000000000
RG22 22 0 1000000000000
VS0 17 s0 0
R0 s0 19 27e-2
VS1 4 s1 0
R1 s1 10 33e2
VS2 6 s2 0
R2 s2 17 22e1
VS3 8 s3 0
R3 s3 15 68e0
VS4 7 s4 0
R4 s4 14 68e2
VS5 8 s5 0
R5 s5 16 22e0
VS6 13 s6 0
R6 s6 14 15e0
VS7 19 s7 0
R7 s7 20 12e-1
VS8 0 s8 0
V8 e8 s8 DC 56e0
RI8 e8 14 12e-2
VS9 12 s9 0
V9 e9 s9 DC 10e1
RI9 e9 11 18e-2
VS10 1 s10 0
R10 s10 5 10e0
VS11 8 s11 0
R11 s11 18 82e2
VS12 7 s12 0
I12 s12 8 DC 12e-2
VS13 19 s13 0
R13 s13 13 12e3
VS14 3 s14 0
R14 s14 21 47e0
VS15 2 s15 0
R15 s15 19 10e2
VS16 8 s16 0
R16 s16 17 27e1
VS17 13 s17 0
R17 s17 21 39e-2
VS18 12 s18 0
R18 s18 4 12e2
VS19 9 s19 0
R19 s19 4 15e-2
VS20 5 s20 0
R20 s20 14 82e-1
VS21 14 s21 0
R21 s21 22 12e-2
VS22 17 s22 0
V22 e22 s22 DC 82e1
RI22 e22 4 68e-3
.control
set numdgt=17
op
print v(1) v(2) v(3) v(4) v(5) v(6) v(7) v(8) v(9) v(10)
print v(11) v(12) v(13) v(14) v(15) v(16) v(17) v(18) v(19) v(20)
print v(21) v(22)
print i(vs0) i(vs1) i(vs2) i(vs3) i(vs4) i(vs5) i(vs6) i(vs7) i(vs8) i(vs9)
print i(vs10) i(vs11) i(vs12) i(vs13) i(vs14) i(vs15) i(vs16) i(vs17) i(vs18) i(vs19)
print i(vs20) i(vs21) i(vs22)
.endc
.end
