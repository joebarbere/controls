controls oracle dc-0233
* Generated (plan F2.7, ADR 0012): do not edit; regenerate with `pnpm sim oracle regen`. dc seed 20261030 index 233 nodes 9 elements 12
.options sparse gmin=1e-12 noopac
RG1 1 0 1000000000000
RG2 2 0 1000000000000
RG3 3 0 1000000000000
RG4 4 0 1000000000000
RG5 5 0 1000000000000
RG6 6 0 1000000000000
RG7 7 0 1000000000000
RG8 8 0 1000000000000
VS0 6 s0 0
R0 s0 2 68e-2
VS1 3 s1 0
R1 s1 7 47e0
VS2 0 s2 0
V2 e2 s2 DC 39e1
RI2 e2 5 10e-3
VS3 4 s3 0
V3 e3 s3 DC 22e0
RI3 e3 7 68e-3
VS4 4 s4 0
R4 s4 6 15e-2
VS5 1 s5 0
R5 s5 4 18e3
VS6 1 s6 0
R6 s6 8 47e1
VS7 7 s7 0
V7 e7 s7 DC 39e-1
RI7 e7 5 68e-1
VS8 0 s8 0
R8 s8 1 12e3
VS9 2 s9 0
V9 e9 s9 DC 12e0
RI9 e9 5 56e-2
VS10 3 s10 0
R10 s10 0 47e-2
VS11 3 s11 0
R11 s11 8 27e2
.control
set numdgt=17
op
print v(1) v(2) v(3) v(4) v(5) v(6) v(7) v(8)
print i(vs0) i(vs1) i(vs2) i(vs3) i(vs4) i(vs5) i(vs6) i(vs7) i(vs8) i(vs9)
print i(vs10) i(vs11)
.endc
.end
