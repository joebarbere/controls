controls oracle dc-0233
* Generated (plan F2.7, ADR 0012): do not edit; regenerate with `pnpm sim oracle regen`. dc seed 20261030 index 233 nodes 9 elements 9
.options sparse gmin=1e-12 noopac
RG1 1 0 1000000000000
RG2 2 0 1000000000000
RG3 3 0 1000000000000
RG4 4 0 1000000000000
RG5 5 0 1000000000000
RG6 6 0 1000000000000
RG7 7 0 1000000000000
RG8 8 0 1000000000000
VS0 6 s0 0
R0 s0 2 68e-2
VS1 0 s1 0
V1 e1 s1 DC 22e0
RI1 e1 7 68e-3
VS2 0 s2 0
R2 s2 6 15e-2
VS3 4 s3 0
R3 s3 1 12e3
VS4 1 s4 0
R4 s4 0 18e3
VS5 3 s5 0
R5 s5 4 47e-2
VS6 3 s6 0
R6 s6 7 47e0
VS7 1 s7 0
R7 s7 8 47e1
VS8 4 s8 0
V8 e8 s8 DC 39e1
RI8 e8 5 10e-3
.control
set numdgt=17
op
print v(1) v(2) v(3) v(4) v(5) v(6) v(7) v(8)
print i(vs0) i(vs1) i(vs2) i(vs3) i(vs4) i(vs5) i(vs6) i(vs7) i(vs8)
.endc
.end
