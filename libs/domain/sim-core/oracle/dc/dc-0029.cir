controls oracle dc-0029
* Generated (plan F2.7, ADR 0012): do not edit; regenerate with `pnpm sim oracle regen`. dc seed 20261030 index 29 nodes 14 elements 21
.options sparse gmin=1e-12 noopac
RG1 1 0 1000000000000
RG2 2 0 1000000000000
RG3 3 0 1000000000000
RG4 4 0 1000000000000
RG5 5 0 1000000000000
RG6 6 0 1000000000000
RG7 7 0 1000000000000
RG8 8 0 1000000000000
RG9 9 0 1000000000000
RG10 10 0 1000000000000
RG11 11 0 1000000000000
RG12 12 0 1000000000000
RG13 13 0 1000000000000
VS0 0 s0 0
V0 e0 s0 DC 10e0
RI0 e0 10 82e-1
VS1 12 s1 0
R1 s1 6 22e-2
VS2 4 s2 0
R2 s2 7 56e-1
VS3 6 s3 0
I3 s3 10 DC 39e-1
VS4 13 s4 0
V4 e4 s4 DC 27e0
RI4 e4 5 82e-3
VS5 0 s5 0
R5 s5 3 33e0
VS6 5 s6 0
R6 s6 4 18e-1
VS7 2 s7 0
R7 s7 10 33e2
VS8 10 s8 0
R8 s8 5 27e0
VS9 11 s9 0
R9 s9 8 82e1
VS10 1 s10 0
R10 s10 12 12e0
VS11 5 s11 0
R11 s11 3 39e-1
VS12 7 s12 0
R12 s12 2 33e3
VS13 13 s13 0
R13 s13 6 68e-1
VS14 7 s14 0
R14 s14 9 27e-1
VS15 12 s15 0
V15 e15 s15 DC 33e1
RI15 e15 13 18e-1
VS16 1 s16 0
R16 s16 8 22e3
VS17 11 s17 0
R17 s17 10 68e3
VS18 9 s18 0
V18 e18 s18 DC 15e0
RI18 e18 13 15e-3
VS19 11 s19 0
R19 s19 7 22e2
VS20 3 s20 0
R20 s20 2 33e-1
.control
set numdgt=17
op
print v(1) v(2) v(3) v(4) v(5) v(6) v(7) v(8) v(9) v(10)
print v(11) v(12) v(13)
print i(vs0) i(vs1) i(vs2) i(vs3) i(vs4) i(vs5) i(vs6) i(vs7) i(vs8) i(vs9)
print i(vs10) i(vs11) i(vs12) i(vs13) i(vs14) i(vs15) i(vs16) i(vs17) i(vs18) i(vs19)
print i(vs20)
.endc
.end
