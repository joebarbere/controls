controls oracle dc-0029
* Generated (plan F2.7, ADR 0012): do not edit; regenerate with `pnpm sim oracle regen`. dc seed 20261030 index 29 nodes 14 elements 15
.options sparse gmin=1e-12 noopac
RG1 1 0 1000000000000
RG2 2 0 1000000000000
RG3 3 0 1000000000000
RG4 4 0 1000000000000
RG5 5 0 1000000000000
RG6 6 0 1000000000000
RG7 7 0 1000000000000
RG8 8 0 1000000000000
RG9 9 0 1000000000000
RG10 10 0 1000000000000
RG11 11 0 1000000000000
RG12 12 0 1000000000000
RG13 13 0 1000000000000
VS0 11 s0 0
R0 s0 8 82e1
VS1 13 s1 0
R1 s1 6 68e-1
VS2 11 s2 0
R2 s2 12 68e3
VS3 12 s3 0
R3 s3 5 27e0
VS4 4 s4 0
R4 s4 7 56e-1
VS5 5 s5 0
R5 s5 3 39e-1
VS6 7 s6 0
R6 s6 2 33e3
VS7 0 s7 0
V7 e7 s7 DC 33e1
RI7 e7 13 18e-1
VS8 10 s8 0
V8 e8 s8 DC 10e0
RI8 e8 12 82e-1
VS9 5 s9 0
R9 s9 4 18e-1
VS10 9 s10 0
V10 e10 s10 DC 15e0
RI10 e10 13 15e-3
VS11 13 s11 0
V11 e11 s11 DC 27e0
RI11 e11 5 82e-3
VS12 1 s12 0
R12 s12 0 12e0
VS13 6 s13 0
I13 s13 12 DC 39e-1
VS14 11 s14 0
R14 s14 7 22e2
.control
set numdgt=17
op
print v(1) v(2) v(3) v(4) v(5) v(6) v(7) v(8) v(9) v(10)
print v(11) v(12) v(13)
print i(vs0) i(vs1) i(vs2) i(vs3) i(vs4) i(vs5) i(vs6) i(vs7) i(vs8) i(vs9)
print i(vs10) i(vs11) i(vs12) i(vs13) i(vs14)
.endc
.end
