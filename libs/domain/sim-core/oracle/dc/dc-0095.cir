controls oracle dc-0095
* Generated (plan F2.7, ADR 0012): do not edit; regenerate with `pnpm sim oracle regen`. dc seed 20261030 index 95 nodes 15 elements 30
.options sparse gmin=1e-12 noopac
RG1 1 0 1000000000000
RG2 2 0 1000000000000
RG3 3 0 1000000000000
RG4 4 0 1000000000000
RG5 5 0 1000000000000
RG6 6 0 1000000000000
RG7 7 0 1000000000000
RG8 8 0 1000000000000
RG9 9 0 1000000000000
RG10 10 0 1000000000000
RG11 11 0 1000000000000
RG12 12 0 1000000000000
RG13 13 0 1000000000000
RG14 14 0 1000000000000
VS0 2 s0 0
R0 s0 5 68e1
VS1 10 s1 0
R1 s1 12 47e0
VS2 1 s2 0
R2 s2 12 12e-2
VS3 9 s3 0
R3 s3 4 27e-1
VS4 8 s4 0
R4 s4 10 10e0
VS5 1 s5 0
R5 s5 4 56e3
VS6 0 s6 0
V6 e6 s6 DC 12e1
RI6 e6 1 27e-2
VS7 8 s7 0
R7 s7 12 56e0
VS8 8 s8 0
R8 s8 3 39e-2
VS9 9 s9 0
R9 s9 12 15e-2
VS10 5 s10 0
R10 s10 7 27e1
VS11 4 s11 0
R11 s11 3 82e-2
VS12 13 s12 0
R12 s12 14 33e-2
VS13 7 s13 0
I13 s13 6 DC 15e-3
VS14 3 s14 0
R14 s14 1 10e1
VS15 11 s15 0
V15 e15 s15 DC 22e1
RI15 e15 0 27e-3
VS16 14 s16 0
R16 s16 3 33e3
VS17 4 s17 0
I17 s17 12 DC 27e-3
VS18 8 s18 0
R18 s18 2 56e2
VS19 7 s19 0
R19 s19 11 47e0
VS20 9 s20 0
V20 e20 s20 DC 47e0
RI20 e20 0 68e-3
VS21 3 s21 0
V21 e21 s21 DC 22e-1
RI21 e21 8 82e-3
VS22 9 s22 0
V22 e22 s22 DC 56e-1
RI22 e22 6 10e-3
VS23 3 s23 0
V23 e23 s23 DC 12e-1
RI23 e23 11 12e-3
VS24 4 s24 0
R24 s24 5 10e0
VS25 5 s25 0
I25 s25 8 DC 12e-2
VS26 11 s26 0
R26 s26 6 10e0
VS27 9 s27 0
R27 s27 5 47e3
VS28 13 s28 0
R28 s28 6 68e3
VS29 5 s29 0
R29 s29 9 68e3
.control
set numdgt=17
op
print v(1) v(2) v(3) v(4) v(5) v(6) v(7) v(8) v(9) v(10)
print v(11) v(12) v(13) v(14)
print i(vs0) i(vs1) i(vs2) i(vs3) i(vs4) i(vs5) i(vs6) i(vs7) i(vs8) i(vs9)
print i(vs10) i(vs11) i(vs12) i(vs13) i(vs14) i(vs15) i(vs16) i(vs17) i(vs18) i(vs19)
print i(vs20) i(vs21) i(vs22) i(vs23) i(vs24) i(vs25) i(vs26) i(vs27) i(vs28) i(vs29)
.endc
.end
