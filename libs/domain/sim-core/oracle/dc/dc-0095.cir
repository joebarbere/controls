controls oracle dc-0095
* Generated (plan F2.7, ADR 0012): do not edit; regenerate with `pnpm sim oracle regen`. dc seed 20261030 index 95 nodes 15 elements 28
.options sparse gmin=1e-12 noopac
RG1 1 0 1000000000000
RG2 2 0 1000000000000
RG3 3 0 1000000000000
RG4 4 0 1000000000000
RG5 5 0 1000000000000
RG6 6 0 1000000000000
RG7 7 0 1000000000000
RG8 8 0 1000000000000
RG9 9 0 1000000000000
RG10 10 0 1000000000000
RG11 11 0 1000000000000
RG12 12 0 1000000000000
RG13 13 0 1000000000000
RG14 14 0 1000000000000
VS0 5 s0 0
R0 s0 7 27e1
VS1 0 s1 0
V1 e1 s1 DC 22e-1
RI1 e1 8 82e-3
VS2 1 s2 0
R2 s2 12 12e-2
VS3 3 s3 0
V3 e3 s3 DC 47e0
RI3 e3 9 68e-3
VS4 8 s4 0
R4 s4 2 56e2
VS5 4 s5 0
I5 s5 12 DC 27e-3
VS6 7 s6 0
R6 s6 11 47e0
VS7 3 s7 0
R7 s7 4 27e-1
VS8 1 s8 0
R8 s8 4 56e3
VS9 9 s9 0
V9 e9 s9 DC 12e1
RI9 e9 1 27e-2
VS10 2 s10 0
R10 s10 5 68e1
VS11 8 s11 0
R11 s11 10 10e0
VS12 8 s12 0
R12 s12 12 56e0
VS13 11 s13 0
R13 s13 6 10e0
VS14 5 s14 0
I14 s14 8 DC 12e-2
VS15 0 s15 0
V15 e15 s15 DC 12e-1
RI15 e15 11 12e-3
VS16 10 s16 0
R16 s16 12 47e0
VS17 4 s17 0
R17 s17 0 82e-2
VS18 3 s18 0
R18 s18 12 15e-2
VS19 11 s19 0
V19 e19 s19 DC 22e1
RI19 e19 9 27e-3
VS20 8 s20 0
R20 s20 0 39e-2
VS21 3 s21 0
R21 s21 5 47e3
VS22 0 s22 0
R22 s22 1 10e1
VS23 7 s23 0
I23 s23 6 DC 15e-3
VS24 13 s24 0
R24 s24 14 33e-2
VS25 14 s25 0
R25 s25 0 33e3
VS26 5 s26 0
R26 s26 3 68e3
VS27 4 s27 0
R27 s27 5 10e0
.control
set numdgt=17
op
print v(1) v(2) v(3) v(4) v(5) v(6) v(7) v(8) v(9) v(10)
print v(11) v(12) v(13) v(14)
print i(vs0) i(vs1) i(vs2) i(vs3) i(vs4) i(vs5) i(vs6) i(vs7) i(vs8) i(vs9)
print i(vs10) i(vs11) i(vs12) i(vs13) i(vs14) i(vs15) i(vs16) i(vs17) i(vs18) i(vs19)
print i(vs20) i(vs21) i(vs22) i(vs23) i(vs24) i(vs25) i(vs26) i(vs27)
.endc
.end
