controls oracle dc-0360
* Generated (plan F2.7, ADR 0012): do not edit; regenerate with `pnpm sim oracle regen`. dc seed 20261030 index 360 nodes 19 elements 33
.options sparse gmin=1e-12 noopac
RG1 1 0 1000000000000
RG2 2 0 1000000000000
RG3 3 0 1000000000000
RG4 4 0 1000000000000
RG5 5 0 1000000000000
RG6 6 0 1000000000000
RG7 7 0 1000000000000
RG8 8 0 1000000000000
RG9 9 0 1000000000000
RG10 10 0 1000000000000
RG11 11 0 1000000000000
RG12 12 0 1000000000000
RG13 13 0 1000000000000
RG14 14 0 1000000000000
RG15 15 0 1000000000000
RG16 16 0 1000000000000
RG17 17 0 1000000000000
RG18 18 0 1000000000000
VS0 1 s0 0
I0 s0 8 DC 18e-4
VS1 9 s1 0
R1 s1 5 22e1
VS2 0 s2 0
V2 e2 s2 DC 39e0
RI2 e2 7 39e-3
VS3 15 s3 0
R3 s3 7 22e1
VS4 17 s4 0
R4 s4 10 68e2
VS5 13 s5 0
R5 s5 5 22e3
VS6 11 s6 0
R6 s6 14 39e-1
VS7 8 s7 0
R7 s7 4 47e0
VS8 13 s8 0
R8 s8 7 56e2
VS9 15 s9 0
R9 s9 1 18e-2
VS10 3 s10 0
V10 e10 s10 DC 39e-1
RI10 e10 8 68e-1
VS11 7 s11 0
R11 s11 12 39e3
VS12 2 s12 0
R12 s12 7 15e-2
VS13 0 s13 0
R13 s13 6 47e1
VS14 11 s14 0
R14 s14 8 15e-2
VS15 16 s15 0
R15 s15 7 10e-2
VS16 4 s16 0
V16 e16 s16 DC 15e1
RI16 e16 0 22e-1
VS17 4 s17 0
I17 s17 9 DC 39e-4
VS18 5 s18 0
R18 s18 18 10e1
VS19 10 s19 0
V19 e19 s19 DC 47e0
RI19 e19 17 22e-2
VS20 15 s20 0
R20 s20 10 39e0
VS21 12 s21 0
I21 s21 1 DC 47e-2
VS22 2 s22 0
R22 s22 7 18e-1
VS23 13 s23 0
R23 s23 8 56e1
VS24 3 s24 0
R24 s24 10 27e-2
VS25 15 s25 0
R25 s25 10 56e1
VS26 2 s26 0
R26 s26 16 82e0
VS27 16 s27 0
R27 s27 6 10e3
VS28 9 s28 0
R28 s28 10 47e0
VS29 8 s29 0
R29 s29 15 82e2
VS30 3 s30 0
R30 s30 17 39e-2
VS31 3 s31 0
V31 e31 s31 DC 39e1
RI31 e31 6 10e-3
VS32 15 s32 0
I32 s32 13 DC 12e-1
.control
set numdgt=17
op
print v(1) v(2) v(3) v(4) v(5) v(6) v(7) v(8) v(9) v(10)
print v(11) v(12) v(13) v(14) v(15) v(16) v(17) v(18)
print i(vs0) i(vs1) i(vs2) i(vs3) i(vs4) i(vs5) i(vs6) i(vs7) i(vs8) i(vs9)
print i(vs10) i(vs11) i(vs12) i(vs13) i(vs14) i(vs15) i(vs16) i(vs17) i(vs18) i(vs19)
print i(vs20) i(vs21) i(vs22) i(vs23) i(vs24) i(vs25) i(vs26) i(vs27) i(vs28) i(vs29)
print i(vs30) i(vs31) i(vs32)
.endc
.end
