controls oracle dc-0360
* Generated (plan F2.7, ADR 0012): do not edit; regenerate with `pnpm sim oracle regen`. dc seed 20261030 index 360 nodes 19 elements 37
.options sparse gmin=1e-12 noopac
RG1 1 0 1000000000000
RG2 2 0 1000000000000
RG3 3 0 1000000000000
RG4 4 0 1000000000000
RG5 5 0 1000000000000
RG6 6 0 1000000000000
RG7 7 0 1000000000000
RG8 8 0 1000000000000
RG9 9 0 1000000000000
RG10 10 0 1000000000000
RG11 11 0 1000000000000
RG12 12 0 1000000000000
RG13 13 0 1000000000000
RG14 14 0 1000000000000
RG15 15 0 1000000000000
RG16 16 0 1000000000000
RG17 17 0 1000000000000
RG18 18 0 1000000000000
VS0 5 s0 0
R0 s0 18 10e1
VS1 3 s1 0
R1 s1 17 39e-2
VS2 0 s2 0
V2 e2 s2 DC 39e0
RI2 e2 7 39e-3
VS3 12 s3 0
I3 s3 1 DC 47e-2
VS4 3 s4 0
V4 e4 s4 DC 39e1
RI4 e4 6 10e-3
VS5 10 s5 0
V5 e5 s5 DC 47e0
RI5 e5 17 22e-2
VS6 8 s6 0
R6 s6 12 10e1
VS7 15 s7 0
R7 s7 10 56e1
VS8 4 s8 0
V8 e8 s8 DC 15e1
RI8 e8 0 22e-1
VS9 18 s9 0
R9 s9 7 18e-1
VS10 10 s10 0
R10 s10 14 27e2
VS11 3 s11 0
V11 e11 s11 DC 39e-1
RI11 e11 8 68e-1
VS12 8 s12 0
R12 s12 15 82e2
VS13 13 s13 0
R13 s13 7 56e2
VS14 11 s14 0
R14 s14 14 39e-1
VS15 11 s15 0
R15 s15 8 15e-2
VS16 9 s16 0
R16 s16 10 47e0
VS17 3 s17 0
R17 s17 10 27e-2
VS18 15 s18 0
R18 s18 1 18e-2
VS19 17 s19 0
R19 s19 10 68e2
VS20 0 s20 0
R20 s20 6 47e1
VS21 16 s21 0
R21 s21 6 10e3
VS22 15 s22 0
I22 s22 13 DC 12e-1
VS23 9 s23 0
R23 s23 5 22e1
VS24 4 s24 0
I24 s24 9 DC 39e-4
VS25 1 s25 0
I25 s25 8 DC 18e-4
VS26 2 s26 0
R26 s26 7 18e-1
VS27 13 s27 0
R27 s27 5 22e3
VS28 15 s28 0
R28 s28 7 22e1
VS29 2 s29 0
R29 s29 16 82e0
VS30 14 s30 0
R30 s30 1 22e2
VS31 15 s31 0
R31 s31 10 39e0
VS32 2 s32 0
R32 s32 7 15e-2
VS33 8 s33 0
R33 s33 4 47e0
VS34 16 s34 0
R34 s34 7 10e-2
VS35 7 s35 0
R35 s35 12 39e3
VS36 13 s36 0
R36 s36 8 56e1
.control
set numdgt=17
op
print v(1) v(2) v(3) v(4) v(5) v(6) v(7) v(8) v(9) v(10)
print v(11) v(12) v(13) v(14) v(15) v(16) v(17) v(18)
print i(vs0) i(vs1) i(vs2) i(vs3) i(vs4) i(vs5) i(vs6) i(vs7) i(vs8) i(vs9)
print i(vs10) i(vs11) i(vs12) i(vs13) i(vs14) i(vs15) i(vs16) i(vs17) i(vs18) i(vs19)
print i(vs20) i(vs21) i(vs22) i(vs23) i(vs24) i(vs25) i(vs26) i(vs27) i(vs28) i(vs29)
print i(vs30) i(vs31) i(vs32) i(vs33) i(vs34) i(vs35) i(vs36)
.endc
.end
