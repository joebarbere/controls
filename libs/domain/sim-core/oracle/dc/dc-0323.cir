controls oracle dc-0323
* Generated (plan F2.7, ADR 0012): do not edit; regenerate with `pnpm sim oracle regen`. dc seed 20261030 index 323 nodes 16 elements 23
.options sparse gmin=1e-12 noopac
RG1 1 0 1000000000000
RG2 2 0 1000000000000
RG3 3 0 1000000000000
RG4 4 0 1000000000000
RG5 5 0 1000000000000
RG6 6 0 1000000000000
RG7 7 0 1000000000000
RG8 8 0 1000000000000
RG9 9 0 1000000000000
RG10 10 0 1000000000000
RG11 11 0 1000000000000
RG12 12 0 1000000000000
RG13 13 0 1000000000000
RG14 14 0 1000000000000
RG15 15 0 1000000000000
VS0 0 s0 0
V0 e0 s0 DC 56e1
RI0 e0 1 12e-2
VS1 3 s1 0
R1 s1 9 82e2
VS2 15 s2 0
R2 s2 11 12e-1
VS3 8 s3 0
R3 s3 3 39e-1
VS4 11 s4 0
R4 s4 14 68e-2
VS5 15 s5 0
R5 s5 6 15e0
VS6 1 s6 0
R6 s6 0 10e0
VS7 0 s7 0
R7 s7 12 82e-1
VS8 13 s8 0
V8 e8 s8 DC 27e-1
RI8 e8 8 82e-2
VS9 10 s9 0
R9 s9 12 39e-1
VS10 11 s10 0
R10 s10 10 33e-2
VS11 7 s11 0
R11 s11 5 56e-1
VS12 3 s12 0
R12 s12 15 82e-1
VS13 12 s13 0
V13 e13 s13 DC 82e-1
RI13 e13 5 47e-3
VS14 10 s14 0
R14 s14 5 12e2
VS15 13 s15 0
V15 e15 s15 DC 39e-1
RI15 e15 3 27e-3
VS16 9 s16 0
R16 s16 4 47e1
VS17 15 s17 0
R17 s17 10 47e0
VS18 7 s18 0
R18 s18 3 18e1
VS19 2 s19 0
R19 s19 11 82e-1
VS20 12 s20 0
V20 e20 s20 DC 33e1
RI20 e20 4 47e-2
VS21 7 s21 0
R21 s21 14 15e0
VS22 11 s22 0
V22 e22 s22 DC 18e-1
RI22 e22 0 27e-2
.control
set numdgt=17
op
print v(1) v(2) v(3) v(4) v(5) v(6) v(7) v(8) v(9) v(10)
print v(11) v(12) v(13) v(14) v(15)
print i(vs0) i(vs1) i(vs2) i(vs3) i(vs4) i(vs5) i(vs6) i(vs7) i(vs8) i(vs9)
print i(vs10) i(vs11) i(vs12) i(vs13) i(vs14) i(vs15) i(vs16) i(vs17) i(vs18) i(vs19)
print i(vs20) i(vs21) i(vs22)
.endc
.end
