controls oracle dc-0401
* Generated (plan F2.7, ADR 0012): do not edit; regenerate with `pnpm sim oracle regen`. dc seed 20261030 index 401 nodes 4 elements 5
.options sparse gmin=1e-12 noopac
RG1 1 0 1000000000000
RG2 2 0 1000000000000
RG3 3 0 1000000000000
VS0 2 s0 0
R0 s0 0 27e-1
VS1 3 s1 0
I1 s1 0 DC 22e-1
VS2 1 s2 0
R2 s2 0 18e0
VS3 0 s3 0
R3 s3 1 33e1
VS4 3 s4 0
R4 s4 2 22e2
.control
set numdgt=17
op
print v(1) v(2) v(3)
print i(vs0) i(vs1) i(vs2) i(vs3) i(vs4)
.endc
.end
