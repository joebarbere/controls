controls oracle dc-0088
* Generated (plan F2.7, ADR 0012): do not edit; regenerate with `pnpm sim oracle regen`. dc seed 20261030 index 88 nodes 28 elements 42
.options sparse gmin=1e-12 noopac
RG1 1 0 1000000000000
RG2 2 0 1000000000000
RG3 3 0 1000000000000
RG4 4 0 1000000000000
RG5 5 0 1000000000000
RG6 6 0 1000000000000
RG7 7 0 1000000000000
RG8 8 0 1000000000000
RG9 9 0 1000000000000
RG10 10 0 1000000000000
RG11 11 0 1000000000000
RG12 12 0 1000000000000
RG13 13 0 1000000000000
RG14 14 0 1000000000000
RG15 15 0 1000000000000
RG16 16 0 1000000000000
RG17 17 0 1000000000000
RG18 18 0 1000000000000
RG19 19 0 1000000000000
RG20 20 0 1000000000000
RG21 21 0 1000000000000
RG22 22 0 1000000000000
RG23 23 0 1000000000000
RG24 24 0 1000000000000
RG25 25 0 1000000000000
RG26 26 0 1000000000000
RG27 27 0 1000000000000
VS0 8 s0 0
R0 s0 11 82e-1
VS1 0 s1 0
R1 s1 7 56e1
VS2 21 s2 0
R2 s2 2 10e0
VS3 5 s3 0
R3 s3 9 68e1
VS4 1 s4 0
R4 s4 23 39e0
VS5 4 s5 0
R5 s5 0 10e1
VS6 12 s6 0
R6 s6 27 82e-1
VS7 0 s7 0
V7 e7 s7 DC 82e-1
RI7 e7 21 22e-2
VS8 3 s8 0
I8 s8 22 DC 27e-1
VS9 14 s9 0
V9 e9 s9 DC 33e0
RI9 e9 3 18e-3
VS10 16 s10 0
R10 s10 2 12e2
VS11 10 s11 0
R11 s11 5 22e2
VS12 2 s12 0
R12 s12 22 18e0
VS13 15 s13 0
R13 s13 20 12e1
VS14 13 s14 0
R14 s14 16 15e1
VS15 24 s15 0
V15 e15 s15 DC 10e1
RI15 e15 2 33e-3
VS16 19 s16 0
R16 s16 5 10e0
VS17 19 s17 0
I17 s17 6 DC 33e-1
VS18 15 s18 0
R18 s18 17 82e3
VS19 24 s19 0
R19 s19 10 56e-2
VS20 14 s20 0
R20 s20 5 27e1
VS21 12 s21 0
R21 s21 17 22e1
VS22 21 s22 0
V22 e22 s22 DC 68e1
RI22 e22 25 12e-2
VS23 3 s23 0
R23 s23 17 82e3
VS24 15 s24 0
V24 e24 s24 DC 18e-1
RI24 e24 18 47e-1
VS25 9 s25 0
R25 s25 19 82e-2
VS26 26 s26 0
I26 s26 13 DC 82e-3
VS27 13 s27 0
R27 s27 25 47e-2
VS28 4 s28 0
I28 s28 24 DC 68e-2
VS29 22 s29 0
R29 s29 11 39e3
VS30 7 s30 0
R30 s30 2 15e0
VS31 8 s31 0
V31 e31 s31 DC 10e1
RI31 e31 5 82e-1
VS32 13 s32 0
R32 s32 18 68e0
VS33 27 s33 0
R33 s33 5 56e-1
VS34 8 s34 0
R34 s34 26 39e1
VS35 8 s35 0
R35 s35 1 10e-1
VS36 21 s36 0
R36 s36 6 39e-2
VS37 23 s37 0
V37 e37 s37 DC 33e0
RI37 e37 17 56e-3
VS38 26 s38 0
R38 s38 15 82e-1
VS39 4 s39 0
R39 s39 5 68e1
VS40 6 s40 0
R40 s40 20 68e3
VS41 19 s41 0
V41 e41 s41 DC 82e0
RI41 e41 21 15e-3
.control
set numdgt=17
op
print v(1) v(2) v(3) v(4) v(5) v(6) v(7) v(8) v(9) v(10)
print v(11) v(12) v(13) v(14) v(15) v(16) v(17) v(18) v(19) v(20)
print v(21) v(22) v(23) v(24) v(25) v(26) v(27)
print i(vs0) i(vs1) i(vs2) i(vs3) i(vs4) i(vs5) i(vs6) i(vs7) i(vs8) i(vs9)
print i(vs10) i(vs11) i(vs12) i(vs13) i(vs14) i(vs15) i(vs16) i(vs17) i(vs18) i(vs19)
print i(vs20) i(vs21) i(vs22) i(vs23) i(vs24) i(vs25) i(vs26) i(vs27) i(vs28) i(vs29)
print i(vs30) i(vs31) i(vs32) i(vs33) i(vs34) i(vs35) i(vs36) i(vs37) i(vs38) i(vs39)
print i(vs40) i(vs41)
.endc
.end
