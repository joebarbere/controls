controls oracle dc-0088
* Generated (plan F2.7, ADR 0012): do not edit; regenerate with `pnpm sim oracle regen`. dc seed 20261030 index 88 nodes 28 elements 33
.options sparse gmin=1e-12 noopac
RG1 1 0 1000000000000
RG2 2 0 1000000000000
RG3 3 0 1000000000000
RG4 4 0 1000000000000
RG5 5 0 1000000000000
RG6 6 0 1000000000000
RG7 7 0 1000000000000
RG8 8 0 1000000000000
RG9 9 0 1000000000000
RG10 10 0 1000000000000
RG11 11 0 1000000000000
RG12 12 0 1000000000000
RG13 13 0 1000000000000
RG14 14 0 1000000000000
RG15 15 0 1000000000000
RG16 16 0 1000000000000
RG17 17 0 1000000000000
RG18 18 0 1000000000000
RG19 19 0 1000000000000
RG20 20 0 1000000000000
RG21 21 0 1000000000000
RG22 22 0 1000000000000
RG23 23 0 1000000000000
RG24 24 0 1000000000000
RG25 25 0 1000000000000
RG26 26 0 1000000000000
RG27 27 0 1000000000000
VS0 27 s0 0
R0 s0 5 56e-1
VS1 4 s1 0
I1 s1 24 DC 68e-2
VS2 26 s2 0
R2 s2 15 82e-1
VS3 13 s3 0
R3 s3 18 68e0
VS4 24 s4 0
R4 s4 10 56e-2
VS5 0 s5 0
R5 s5 7 56e1
VS6 15 s6 0
R6 s6 17 82e3
VS7 3 s7 0
R7 s7 17 82e3
VS8 0 s8 0
V8 e8 s8 DC 82e-1
RI8 e8 21 22e-2
VS9 21 s9 0
V9 e9 s9 DC 68e1
RI9 e9 25 12e-2
VS10 21 s10 0
R10 s10 6 39e-2
VS11 14 s11 0
R11 s11 5 27e1
VS12 7 s12 0
R12 s12 2 15e0
VS13 3 s13 0
I13 s13 22 DC 27e-1
VS14 10 s14 0
R14 s14 5 22e2
VS15 22 s15 0
R15 s15 11 39e3
VS16 19 s16 0
I16 s16 6 DC 33e-1
VS17 13 s17 0
R17 s17 25 47e-2
VS18 8 s18 0
V18 e18 s18 DC 10e1
RI18 e18 5 82e-1
VS19 23 s19 0
V19 e19 s19 DC 33e0
RI19 e19 17 56e-3
VS20 5 s20 0
R20 s20 9 68e1
VS21 2 s21 0
R21 s21 22 18e0
VS22 15 s22 0
R22 s22 20 12e1
VS23 21 s23 0
R23 s23 2 10e0
VS24 26 s24 0
I24 s24 13 DC 82e-3
VS25 12 s25 0
R25 s25 17 22e1
VS26 13 s26 0
R26 s26 16 15e1
VS27 8 s27 0
R27 s27 26 39e1
VS28 1 s28 0
R28 s28 23 39e0
VS29 16 s29 0
R29 s29 2 12e2
VS30 19 s30 0
V30 e30 s30 DC 82e0
RI30 e30 21 15e-3
VS31 19 s31 0
R31 s31 5 10e0
VS32 4 s32 0
R32 s32 0 10e1
.control
set numdgt=17
op
print v(1) v(2) v(3) v(4) v(5) v(6) v(7) v(8) v(9) v(10)
print v(11) v(12) v(13) v(14) v(15) v(16) v(17) v(18) v(19) v(20)
print v(21) v(22) v(23) v(24) v(25) v(26) v(27)
print i(vs0) i(vs1) i(vs2) i(vs3) i(vs4) i(vs5) i(vs6) i(vs7) i(vs8) i(vs9)
print i(vs10) i(vs11) i(vs12) i(vs13) i(vs14) i(vs15) i(vs16) i(vs17) i(vs18) i(vs19)
print i(vs20) i(vs21) i(vs22) i(vs23) i(vs24) i(vs25) i(vs26) i(vs27) i(vs28) i(vs29)
print i(vs30) i(vs31) i(vs32)
.endc
.end
