controls oracle dc-0304
* Generated (plan F2.7, ADR 0012): do not edit; regenerate with `pnpm sim oracle regen`. dc seed 20261030 index 304 nodes 9 elements 13
.options sparse gmin=1e-12 noopac
RG1 1 0 1000000000000
RG2 2 0 1000000000000
RG3 3 0 1000000000000
RG4 4 0 1000000000000
RG5 5 0 1000000000000
RG6 6 0 1000000000000
RG7 7 0 1000000000000
RG8 8 0 1000000000000
VS0 8 s0 0
R0 s0 1 47e1
VS1 0 s1 0
R1 s1 3 68e1
VS2 2 s2 0
R2 s2 1 15e1
VS3 8 s3 0
I3 s3 7 DC 47e-4
VS4 6 s4 0
R4 s4 3 18e2
VS5 6 s5 0
R5 s5 4 33e3
VS6 5 s6 0
R6 s6 0 39e2
VS7 4 s7 0
R7 s7 5 12e1
VS8 7 s8 0
R8 s8 5 10e2
VS9 4 s9 0
I9 s9 8 DC 22e-2
VS10 7 s10 0
R10 s10 2 27e0
VS11 1 s11 0
R11 s11 3 82e-1
VS12 8 s12 0
R12 s12 3 56e0
.control
set numdgt=17
op
print v(1) v(2) v(3) v(4) v(5) v(6) v(7) v(8)
print i(vs0) i(vs1) i(vs2) i(vs3) i(vs4) i(vs5) i(vs6) i(vs7) i(vs8) i(vs9)
print i(vs10) i(vs11) i(vs12)
.endc
.end
