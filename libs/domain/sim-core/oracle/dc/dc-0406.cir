controls oracle dc-0406
* Generated (plan F2.7, ADR 0012): do not edit; regenerate with `pnpm sim oracle regen`. dc seed 20261030 index 406 nodes 27 elements 27
.options sparse gmin=1e-12 noopac
RG1 1 0 1000000000000
RG2 2 0 1000000000000
RG3 3 0 1000000000000
RG4 4 0 1000000000000
RG5 5 0 1000000000000
RG6 6 0 1000000000000
RG7 7 0 1000000000000
RG8 8 0 1000000000000
RG9 9 0 1000000000000
RG10 10 0 1000000000000
RG11 11 0 1000000000000
RG12 12 0 1000000000000
RG13 13 0 1000000000000
RG14 14 0 1000000000000
RG15 15 0 1000000000000
RG16 16 0 1000000000000
RG17 17 0 1000000000000
RG18 18 0 1000000000000
RG19 19 0 1000000000000
RG20 20 0 1000000000000
RG21 21 0 1000000000000
RG22 22 0 1000000000000
RG23 23 0 1000000000000
RG24 24 0 1000000000000
RG25 25 0 1000000000000
RG26 26 0 1000000000000
VS0 9 s0 0
R0 s0 25 82e-2
VS1 16 s1 0
R1 s1 14 18e-1
VS2 0 s2 0
V2 e2 s2 DC 68e1
RI2 e2 25 39e-1
VS3 19 s3 0
R3 s3 24 47e3
VS4 4 s4 0
R4 s4 8 22e2
VS5 1 s5 0
R5 s5 18 39e-2
VS6 9 s6 0
R6 s6 22 47e-1
VS7 10 s7 0
R7 s7 2 15e-2
VS8 19 s8 0
R8 s8 11 39e0
VS9 6 s9 0
R9 s9 10 33e1
VS10 15 s10 0
R10 s10 20 82e1
VS11 17 s11 0
V11 e11 s11 DC 27e1
RI11 e11 10 18e-1
VS12 5 s12 0
V12 e12 s12 DC 12e1
RI12 e12 17 18e-1
VS13 13 s13 0
R13 s13 17 33e0
VS14 22 s14 0
V14 e14 s14 DC 27e-1
RI14 e14 23 15e-1
VS15 4 s15 0
R15 s15 25 39e3
VS16 13 s16 0
R16 s16 21 82e3
VS17 19 s17 0
R17 s17 18 39e1
VS18 14 s18 0
V18 e18 s18 DC 18e-1
RI18 e18 3 27e-1
VS19 17 s19 0
R19 s19 1 12e0
VS20 16 s20 0
R20 s20 15 82e-1
VS21 4 s21 0
V21 e21 s21 DC 22e1
RI21 e21 7 56e-1
VS22 26 s22 0
R22 s22 13 22e0
VS23 12 s23 0
R23 s23 10 33e1
VS24 20 s24 0
R24 s24 25 18e1
VS25 1 s25 0
R25 s25 20 27e-2
VS26 15 s26 0
V26 e26 s26 DC 15e0
RI26 e26 20 33e-1
.control
set numdgt=17
op
print v(1) v(2) v(3) v(4) v(5) v(6) v(7) v(8) v(9) v(10)
print v(11) v(12) v(13) v(14) v(15) v(16) v(17) v(18) v(19) v(20)
print v(21) v(22) v(23) v(24) v(25) v(26)
print i(vs0) i(vs1) i(vs2) i(vs3) i(vs4) i(vs5) i(vs6) i(vs7) i(vs8) i(vs9)
print i(vs10) i(vs11) i(vs12) i(vs13) i(vs14) i(vs15) i(vs16) i(vs17) i(vs18) i(vs19)
print i(vs20) i(vs21) i(vs22) i(vs23) i(vs24) i(vs25) i(vs26)
.endc
.end
