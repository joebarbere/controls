controls oracle dc-0406
* Generated (plan F2.7, ADR 0012): do not edit; regenerate with `pnpm sim oracle regen`. dc seed 20261030 index 406 nodes 27 elements 35
.options sparse gmin=1e-12 noopac
RG1 1 0 1000000000000
RG2 2 0 1000000000000
RG3 3 0 1000000000000
RG4 4 0 1000000000000
RG5 5 0 1000000000000
RG6 6 0 1000000000000
RG7 7 0 1000000000000
RG8 8 0 1000000000000
RG9 9 0 1000000000000
RG10 10 0 1000000000000
RG11 11 0 1000000000000
RG12 12 0 1000000000000
RG13 13 0 1000000000000
RG14 14 0 1000000000000
RG15 15 0 1000000000000
RG16 16 0 1000000000000
RG17 17 0 1000000000000
RG18 18 0 1000000000000
RG19 19 0 1000000000000
RG20 20 0 1000000000000
RG21 21 0 1000000000000
RG22 22 0 1000000000000
RG23 23 0 1000000000000
RG24 24 0 1000000000000
RG25 25 0 1000000000000
RG26 26 0 1000000000000
VS0 12 s0 0
R0 s0 7 82e1
VS1 0 s1 0
V1 e1 s1 DC 22e1
RI1 e1 7 56e-1
VS2 14 s2 0
V2 e2 s2 DC 18e-1
RI2 e2 3 27e-1
VS3 13 s3 0
R3 s3 17 33e0
VS4 16 s4 0
R4 s4 15 82e-1
VS5 3 s5 0
V5 e5 s5 DC 68e0
RI5 e5 4 33e-1
VS6 2 s6 0
V6 e6 s6 DC 82e0
RI6 e6 5 18e-1
VS7 13 s7 0
R7 s7 21 82e3
VS8 12 s8 0
R8 s8 10 33e1
VS9 0 s9 0
R9 s9 8 22e2
VS10 12 s10 0
R10 s10 24 47e1
VS11 23 s11 0
R11 s11 12 10e3
VS12 17 s12 0
R12 s12 4 12e0
VS13 19 s13 0
R13 s13 11 39e0
VS14 14 s14 0
R14 s14 8 18e1
VS15 22 s15 0
V15 e15 s15 DC 27e-1
RI15 e15 23 15e-1
VS16 0 s16 0
R16 s16 25 39e3
VS17 4 s17 0
R17 s17 20 27e-2
VS18 17 s18 0
V18 e18 s18 DC 27e1
RI18 e18 10 18e-1
VS19 6 s19 0
R19 s19 10 33e1
VS20 5 s20 0
V20 e20 s20 DC 12e1
RI20 e20 17 18e-1
VS21 6 s21 0
R21 s21 26 12e1
VS22 9 s22 0
R22 s22 22 47e-1
VS23 4 s23 0
R23 s23 18 39e-2
VS24 9 s24 0
R24 s24 25 82e-2
VS25 19 s25 0
R25 s25 18 39e1
VS26 26 s26 0
R26 s26 13 22e0
VS27 16 s27 0
R27 s27 14 18e-1
VS28 20 s28 0
R28 s28 25 18e1
VS29 15 s29 0
V29 e29 s29 DC 15e0
RI29 e29 20 33e-1
VS30 19 s30 0
R30 s30 24 47e3
VS31 17 s31 0
R31 s31 11 39e0
VS32 21 s32 0
R32 s32 1 39e-1
VS33 1 s33 0
V33 e33 s33 DC 68e1
RI33 e33 25 39e-1
VS34 10 s34 0
R34 s34 2 15e-2
.control
set numdgt=17
op
print v(1) v(2) v(3) v(4) v(5) v(6) v(7) v(8) v(9) v(10)
print v(11) v(12) v(13) v(14) v(15) v(16) v(17) v(18) v(19) v(20)
print v(21) v(22) v(23) v(24) v(25) v(26)
print i(vs0) i(vs1) i(vs2) i(vs3) i(vs4) i(vs5) i(vs6) i(vs7) i(vs8) i(vs9)
print i(vs10) i(vs11) i(vs12) i(vs13) i(vs14) i(vs15) i(vs16) i(vs17) i(vs18) i(vs19)
print i(vs20) i(vs21) i(vs22) i(vs23) i(vs24) i(vs25) i(vs26) i(vs27) i(vs28) i(vs29)
print i(vs30) i(vs31) i(vs32) i(vs33) i(vs34)
.endc
.end
