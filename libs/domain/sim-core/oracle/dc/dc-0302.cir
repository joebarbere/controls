controls oracle dc-0302
* Generated (plan F2.7, ADR 0012): do not edit; regenerate with `pnpm sim oracle regen`. dc seed 20261030 index 302 nodes 23 elements 42
.options sparse gmin=1e-12 noopac
RG1 1 0 1000000000000
RG2 2 0 1000000000000
RG3 3 0 1000000000000
RG4 4 0 1000000000000
RG5 5 0 1000000000000
RG6 6 0 1000000000000
RG7 7 0 1000000000000
RG8 8 0 1000000000000
RG9 9 0 1000000000000
RG10 10 0 1000000000000
RG11 11 0 1000000000000
RG12 12 0 1000000000000
RG13 13 0 1000000000000
RG14 14 0 1000000000000
RG15 15 0 1000000000000
RG16 16 0 1000000000000
RG17 17 0 1000000000000
RG18 18 0 1000000000000
RG19 19 0 1000000000000
RG20 20 0 1000000000000
RG21 21 0 1000000000000
RG22 22 0 1000000000000
VS0 4 s0 0
R0 s0 17 22e0
VS1 2 s1 0
R1 s1 15 82e-1
VS2 8 s2 0
R2 s2 9 18e3
VS3 11 s3 0
R3 s3 4 39e3
VS4 0 s4 0
V4 e4 s4 DC 47e1
RI4 e4 20 10e-3
VS5 15 s5 0
R5 s5 14 33e1
VS6 22 s6 0
V6 e6 s6 DC 39e0
RI6 e6 6 68e-3
VS7 7 s7 0
V7 e7 s7 DC 47e0
RI7 e7 17 27e-1
VS8 14 s8 0
R8 s8 3 27e-2
VS9 18 s9 0
R9 s9 4 33e3
VS10 15 s10 0
I10 s10 3 DC 18e-1
VS11 13 s11 0
R11 s11 7 82e2
VS12 19 s12 0
R12 s12 18 10e0
VS13 20 s13 0
R13 s13 4 68e0
VS14 13 s14 0
V14 e14 s14 DC 68e0
RI14 e14 0 39e-1
VS15 21 s15 0
R15 s15 9 39e1
VS16 22 s16 0
R16 s16 1 10e2
VS17 5 s17 0
R17 s17 16 39e-2
VS18 5 s18 0
R18 s18 4 12e1
VS19 5 s19 0
R19 s19 1 12e3
VS20 15 s20 0
R20 s20 1 22e2
VS21 1 s21 0
R21 s21 9 12e0
VS22 20 s22 0
R22 s22 10 56e1
VS23 6 s23 0
I23 s23 21 DC 27e-4
VS24 22 s24 0
R24 s24 4 68e-2
VS25 8 s25 0
R25 s25 21 15e3
VS26 11 s26 0
I26 s26 19 DC 27e-2
VS27 6 s27 0
V27 e27 s27 DC 12e1
RI27 e27 1 82e-1
VS28 1 s28 0
R28 s28 19 22e3
VS29 15 s29 0
R29 s29 7 15e-1
VS30 12 s30 0
R30 s30 16 18e-1
VS31 7 s31 0
R31 s31 14 39e2
VS32 17 s32 0
R32 s32 3 22e0
VS33 4 s33 0
V33 e33 s33 DC 68e0
RI33 e33 0 68e-3
VS34 16 s34 0
I34 s34 8 DC 39e-4
VS35 6 s35 0
I35 s35 4 DC 56e-2
VS36 17 s36 0
R36 s36 8 10e2
VS37 7 s37 0
R37 s37 11 47e1
VS38 0 s38 0
R38 s38 12 56e3
VS39 17 s39 0
R39 s39 2 39e-1
VS40 16 s40 0
R40 s40 15 68e3
VS41 11 s41 0
R41 s41 10 10e-2
.control
set numdgt=17
op
print v(1) v(2) v(3) v(4) v(5) v(6) v(7) v(8) v(9) v(10)
print v(11) v(12) v(13) v(14) v(15) v(16) v(17) v(18) v(19) v(20)
print v(21) v(22)
print i(vs0) i(vs1) i(vs2) i(vs3) i(vs4) i(vs5) i(vs6) i(vs7) i(vs8) i(vs9)
print i(vs10) i(vs11) i(vs12) i(vs13) i(vs14) i(vs15) i(vs16) i(vs17) i(vs18) i(vs19)
print i(vs20) i(vs21) i(vs22) i(vs23) i(vs24) i(vs25) i(vs26) i(vs27) i(vs28) i(vs29)
print i(vs30) i(vs31) i(vs32) i(vs33) i(vs34) i(vs35) i(vs36) i(vs37) i(vs38) i(vs39)
print i(vs40) i(vs41)
.endc
.end
