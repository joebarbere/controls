controls oracle dc-0302
* Generated (plan F2.7, ADR 0012): do not edit; regenerate with `pnpm sim oracle regen`. dc seed 20261030 index 302 nodes 23 elements 36
.options sparse gmin=1e-12 noopac
RG1 1 0 1000000000000
RG2 2 0 1000000000000
RG3 3 0 1000000000000
RG4 4 0 1000000000000
RG5 5 0 1000000000000
RG6 6 0 1000000000000
RG7 7 0 1000000000000
RG8 8 0 1000000000000
RG9 9 0 1000000000000
RG10 10 0 1000000000000
RG11 11 0 1000000000000
RG12 12 0 1000000000000
RG13 13 0 1000000000000
RG14 14 0 1000000000000
RG15 15 0 1000000000000
RG16 16 0 1000000000000
RG17 17 0 1000000000000
RG18 18 0 1000000000000
RG19 19 0 1000000000000
RG20 20 0 1000000000000
RG21 21 0 1000000000000
RG22 22 0 1000000000000
VS0 13 s0 0
R0 s0 0 82e2
VS1 5 s1 0
R1 s1 4 12e1
VS2 4 s2 0
R2 s2 17 22e0
VS3 0 s3 0
V3 e3 s3 DC 47e0
RI3 e3 17 27e-1
VS4 8 s4 0
R4 s4 9 18e3
VS5 5 s5 0
R5 s5 7 12e3
VS6 1 s6 0
V6 e6 s6 DC 47e1
RI6 e6 20 10e-3
VS7 22 s7 0
R7 s7 7 10e2
VS8 11 s8 0
R8 s8 10 10e-2
VS9 15 s9 0
R9 s9 14 33e1
VS10 7 s10 0
R10 s10 19 22e3
VS11 1 s11 0
R11 s11 12 56e3
VS12 0 s12 0
R12 s12 14 39e2
VS13 21 s13 0
R13 s13 9 39e1
VS14 16 s14 0
R14 s14 15 68e3
VS15 17 s15 0
R15 s15 2 39e-1
VS16 7 s16 0
R16 s16 9 12e0
VS17 17 s17 0
R17 s17 3 22e0
VS18 0 s18 0
R18 s18 11 47e1
VS19 17 s19 0
R19 s19 8 10e2
VS20 22 s20 0
R20 s20 4 68e-2
VS21 16 s21 0
I21 s21 8 DC 39e-4
VS22 6 s22 0
I22 s22 4 DC 56e-2
VS23 13 s23 0
V23 e23 s23 DC 68e0
RI23 e23 1 39e-1
VS24 6 s24 0
V24 e24 s24 DC 12e1
RI24 e24 7 82e-1
VS25 2 s25 0
R25 s25 15 82e-1
VS26 15 s26 0
R26 s26 7 22e2
VS27 15 s27 0
I27 s27 3 DC 18e-1
VS28 20 s28 0
R28 s28 4 68e0
VS29 18 s29 0
R29 s29 4 33e3
VS30 11 s30 0
R30 s30 4 39e3
VS31 6 s31 0
I31 s31 21 DC 27e-4
VS32 4 s32 0
V32 e32 s32 DC 68e0
RI32 e32 1 68e-3
VS33 11 s33 0
I33 s33 19 DC 27e-2
VS34 15 s34 0
R34 s34 0 15e-1
VS35 19 s35 0
R35 s35 18 10e0
.control
set numdgt=17
op
print v(1) v(2) v(3) v(4) v(5) v(6) v(7) v(8) v(9) v(10)
print v(11) v(12) v(13) v(14) v(15) v(16) v(17) v(18) v(19) v(20)
print v(21) v(22)
print i(vs0) i(vs1) i(vs2) i(vs3) i(vs4) i(vs5) i(vs6) i(vs7) i(vs8) i(vs9)
print i(vs10) i(vs11) i(vs12) i(vs13) i(vs14) i(vs15) i(vs16) i(vs17) i(vs18) i(vs19)
print i(vs20) i(vs21) i(vs22) i(vs23) i(vs24) i(vs25) i(vs26) i(vs27) i(vs28) i(vs29)
print i(vs30) i(vs31) i(vs32) i(vs33) i(vs34) i(vs35)
.endc
.end
