controls oracle dc-0332
* Generated (plan F2.7, ADR 0012): do not edit; regenerate with `pnpm sim oracle regen`. dc seed 20261030 index 332 nodes 18 elements 32
.options sparse gmin=1e-12 noopac
RG1 1 0 1000000000000
RG2 2 0 1000000000000
RG3 3 0 1000000000000
RG4 4 0 1000000000000
RG5 5 0 1000000000000
RG6 6 0 1000000000000
RG7 7 0 1000000000000
RG8 8 0 1000000000000
RG9 9 0 1000000000000
RG10 10 0 1000000000000
RG11 11 0 1000000000000
RG12 12 0 1000000000000
RG13 13 0 1000000000000
RG14 14 0 1000000000000
RG15 15 0 1000000000000
RG16 16 0 1000000000000
RG17 17 0 1000000000000
VS0 2 s0 0
R0 s0 11 10e3
VS1 6 s1 0
I1 s1 14 DC 22e-4
VS2 13 s2 0
R2 s2 5 39e0
VS3 9 s3 0
R3 s3 17 27e1
VS4 13 s4 0
R4 s4 3 12e-2
VS5 8 s5 0
R5 s5 11 47e-1
VS6 14 s6 0
R6 s6 12 10e2
VS7 10 s7 0
R7 s7 3 10e1
VS8 0 s8 0
R8 s8 12 15e3
VS9 0 s9 0
V9 e9 s9 DC 12e1
RI9 e9 1 10e-3
VS10 0 s10 0
R10 s10 4 39e-2
VS11 13 s11 0
V11 e11 s11 DC 18e-1
RI11 e11 14 15e-2
VS12 15 s12 0
R12 s12 8 68e0
VS13 14 s13 0
R13 s13 15 27e0
VS14 16 s14 0
R14 s14 9 82e2
VS15 13 s15 0
R15 s15 1 15e1
VS16 14 s16 0
R16 s16 10 18e-1
VS17 11 s17 0
R17 s17 7 12e0
VS18 14 s18 0
R18 s18 16 56e3
VS19 4 s19 0
R19 s19 8 82e2
VS20 13 s20 0
R20 s20 9 27e-2
VS21 6 s21 0
V21 e21 s21 DC 33e0
RI21 e21 14 47e-1
VS22 10 s22 0
R22 s22 0 47e-1
VS23 6 s23 0
R23 s23 17 12e0
VS24 8 s24 0
R24 s24 5 27e-1
VS25 1 s25 0
V25 e25 s25 DC 68e0
RI25 e25 9 18e-1
VS26 2 s26 0
I26 s26 1 DC 47e-2
VS27 6 s27 0
R27 s27 8 47e-2
VS28 13 s28 0
R28 s28 2 39e-1
VS29 17 s29 0
R29 s29 16 10e0
VS30 7 s30 0
R30 s30 0 15e0
VS31 15 s31 0
I31 s31 3 DC 10e-2
.control
set numdgt=17
op
print v(1) v(2) v(3) v(4) v(5) v(6) v(7) v(8) v(9) v(10)
print v(11) v(12) v(13) v(14) v(15) v(16) v(17)
print i(vs0) i(vs1) i(vs2) i(vs3) i(vs4) i(vs5) i(vs6) i(vs7) i(vs8) i(vs9)
print i(vs10) i(vs11) i(vs12) i(vs13) i(vs14) i(vs15) i(vs16) i(vs17) i(vs18) i(vs19)
print i(vs20) i(vs21) i(vs22) i(vs23) i(vs24) i(vs25) i(vs26) i(vs27) i(vs28) i(vs29)
print i(vs30) i(vs31)
.endc
.end
