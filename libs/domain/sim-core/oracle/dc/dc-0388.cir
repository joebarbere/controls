controls oracle dc-0388
* Generated (plan F2.7, ADR 0012): do not edit; regenerate with `pnpm sim oracle regen`. dc seed 20261030 index 388 nodes 23 elements 35
.options sparse gmin=1e-12 noopac
RG1 1 0 1000000000000
RG2 2 0 1000000000000
RG3 3 0 1000000000000
RG4 4 0 1000000000000
RG5 5 0 1000000000000
RG6 6 0 1000000000000
RG7 7 0 1000000000000
RG8 8 0 1000000000000
RG9 9 0 1000000000000
RG10 10 0 1000000000000
RG11 11 0 1000000000000
RG12 12 0 1000000000000
RG13 13 0 1000000000000
RG14 14 0 1000000000000
RG15 15 0 1000000000000
RG16 16 0 1000000000000
RG17 17 0 1000000000000
RG18 18 0 1000000000000
RG19 19 0 1000000000000
RG20 20 0 1000000000000
RG21 21 0 1000000000000
RG22 22 0 1000000000000
VS0 19 s0 0
R0 s0 14 22e1
VS1 8 s1 0
I1 s1 14 DC 18e-4
VS2 15 s2 0
R2 s2 8 82e-1
VS3 21 s3 0
R3 s3 8 68e0
VS4 1 s4 0
R4 s4 14 15e-1
VS5 22 s5 0
R5 s5 7 12e-2
VS6 8 s6 0
R6 s6 22 82e1
VS7 6 s7 0
R7 s7 16 10e-1
VS8 14 s8 0
R8 s8 15 10e-2
VS9 8 s9 0
R9 s9 20 47e1
VS10 15 s10 0
I10 s10 8 DC 33e-3
VS11 5 s11 0
R11 s11 14 68e1
VS12 15 s12 0
R12 s12 6 39e3
VS13 17 s13 0
R13 s13 7 47e-1
VS14 0 s14 0
V14 e14 s14 DC 56e-1
RI14 e14 19 33e-3
VS15 5 s15 0
V15 e15 s15 DC 33e1
RI15 e15 10 12e-3
VS16 10 s16 0
R16 s16 17 22e3
VS17 19 s17 0
V17 e17 s17 DC 12e1
RI17 e17 3 56e-2
VS18 5 s18 0
R18 s18 22 47e-1
VS19 21 s19 0
V19 e19 s19 DC 82e0
RI19 e19 15 33e-1
VS20 16 s20 0
V20 e20 s20 DC 22e-1
RI20 e20 13 82e-3
VS21 6 s21 0
V21 e21 s21 DC 15e1
RI21 e21 11 56e-1
VS22 16 s22 0
V22 e22 s22 DC 10e0
RI22 e22 4 27e-2
VS23 1 s23 0
R23 s23 17 22e-2
VS24 12 s24 0
R24 s24 9 82e1
VS25 19 s25 0
R25 s25 18 47e2
VS26 2 s26 0
R26 s26 1 56e3
VS27 0 s27 0
R27 s27 11 56e1
VS28 14 s28 0
R28 s28 12 15e-1
VS29 3 s29 0
I29 s29 9 DC 68e-2
VS30 9 s30 0
R30 s30 10 56e-1
VS31 21 s31 0
R31 s31 18 27e3
VS32 1 s32 0
R32 s32 14 10e-2
VS33 9 s33 0
V33 e33 s33 DC 82e0
RI33 e33 17 82e-2
VS34 8 s34 0
R34 s34 0 68e0
.control
set numdgt=17
op
print v(1) v(2) v(3) v(4) v(5) v(6) v(7) v(8) v(9) v(10)
print v(11) v(12) v(13) v(14) v(15) v(16) v(17) v(18) v(19) v(20)
print v(21) v(22)
print i(vs0) i(vs1) i(vs2) i(vs3) i(vs4) i(vs5) i(vs6) i(vs7) i(vs8) i(vs9)
print i(vs10) i(vs11) i(vs12) i(vs13) i(vs14) i(vs15) i(vs16) i(vs17) i(vs18) i(vs19)
print i(vs20) i(vs21) i(vs22) i(vs23) i(vs24) i(vs25) i(vs26) i(vs27) i(vs28) i(vs29)
print i(vs30) i(vs31) i(vs32) i(vs33) i(vs34)
.endc
.end
