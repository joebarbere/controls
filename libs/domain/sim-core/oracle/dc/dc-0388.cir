controls oracle dc-0388
* Generated (plan F2.7, ADR 0012): do not edit; regenerate with `pnpm sim oracle regen`. dc seed 20261030 index 388 nodes 23 elements 40
.options sparse gmin=1e-12 noopac
RG1 1 0 1000000000000
RG2 2 0 1000000000000
RG3 3 0 1000000000000
RG4 4 0 1000000000000
RG5 5 0 1000000000000
RG6 6 0 1000000000000
RG7 7 0 1000000000000
RG8 8 0 1000000000000
RG9 9 0 1000000000000
RG10 10 0 1000000000000
RG11 11 0 1000000000000
RG12 12 0 1000000000000
RG13 13 0 1000000000000
RG14 14 0 1000000000000
RG15 15 0 1000000000000
RG16 16 0 1000000000000
RG17 17 0 1000000000000
RG18 18 0 1000000000000
RG19 19 0 1000000000000
RG20 20 0 1000000000000
RG21 21 0 1000000000000
RG22 22 0 1000000000000
VS0 19 s0 0
R0 s0 18 47e2
VS1 21 s1 0
R1 s1 2 15e-1
VS2 0 s2 0
V2 e2 s2 DC 15e1
RI2 e2 11 56e-1
VS3 14 s3 0
R3 s3 12 15e-1
VS4 19 s4 0
R4 s4 14 22e1
VS5 0 s5 0
R5 s5 16 10e-1
VS6 16 s6 0
V6 e6 s6 DC 22e-1
RI6 e6 13 82e-3
VS7 4 s7 0
R7 s7 22 15e1
VS8 22 s8 0
R8 s8 7 12e-2
VS9 8 s9 0
R9 s9 9 68e0
VS10 19 s10 0
V10 e10 s10 DC 12e1
RI10 e10 3 56e-2
VS11 8 s11 0
R11 s11 20 47e1
VS12 8 s12 0
R12 s12 22 82e1
VS13 15 s13 0
I13 s13 8 DC 33e-3
VS14 0 s14 0
R14 s14 13 82e2
VS15 16 s15 0
V15 e15 s15 DC 10e0
RI15 e15 4 27e-2
VS16 5 s16 0
R16 s16 14 68e1
VS17 21 s17 0
R17 s17 8 68e0
VS18 6 s18 0
V18 e18 s18 DC 82e0
RI18 e18 17 82e-2
VS19 3 s19 0
I19 s19 6 DC 68e-2
VS20 5 s20 0
R20 s20 22 47e-1
VS21 15 s21 0
R21 s21 0 39e3
VS22 15 s22 0
R22 s22 8 82e-1
VS23 17 s23 0
R23 s23 7 47e-1
VS24 1 s24 0
R24 s24 14 15e-1
VS25 2 s25 0
R25 s25 1 56e3
VS26 14 s26 0
R26 s26 15 10e-2
VS27 21 s27 0
R27 s27 18 27e3
VS28 10 s28 0
R28 s28 17 22e3
VS29 1 s29 0
R29 s29 14 10e-2
VS30 19 s30 0
R30 s30 20 15e0
VS31 9 s31 0
R31 s31 11 56e1
VS32 6 s32 0
R32 s32 10 56e-1
VS33 1 s33 0
R33 s33 17 22e-2
VS34 5 s34 0
V34 e34 s34 DC 33e1
RI34 e34 10 12e-3
VS35 21 s35 0
V35 e35 s35 DC 82e0
RI35 e35 15 33e-1
VS36 5 s36 0
R36 s36 3 33e2
VS37 8 s37 0
I37 s37 14 DC 18e-4
VS38 12 s38 0
R38 s38 6 82e1
VS39 9 s39 0
V39 e39 s39 DC 56e-1
RI39 e39 19 33e-3
.control
set numdgt=17
op
print v(1) v(2) v(3) v(4) v(5) v(6) v(7) v(8) v(9) v(10)
print v(11) v(12) v(13) v(14) v(15) v(16) v(17) v(18) v(19) v(20)
print v(21) v(22)
print i(vs0) i(vs1) i(vs2) i(vs3) i(vs4) i(vs5) i(vs6) i(vs7) i(vs8) i(vs9)
print i(vs10) i(vs11) i(vs12) i(vs13) i(vs14) i(vs15) i(vs16) i(vs17) i(vs18) i(vs19)
print i(vs20) i(vs21) i(vs22) i(vs23) i(vs24) i(vs25) i(vs26) i(vs27) i(vs28) i(vs29)
print i(vs30) i(vs31) i(vs32) i(vs33) i(vs34) i(vs35) i(vs36) i(vs37) i(vs38) i(vs39)
.endc
.end
