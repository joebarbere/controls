controls oracle dc-0167
* Generated (plan F2.7, ADR 0012): do not edit; regenerate with `pnpm sim oracle regen`. dc seed 20261030 index 167 nodes 12 elements 16
.options sparse gmin=1e-12 noopac
RG1 1 0 1000000000000
RG2 2 0 1000000000000
RG3 3 0 1000000000000
RG4 4 0 1000000000000
RG5 5 0 1000000000000
RG6 6 0 1000000000000
RG7 7 0 1000000000000
RG8 8 0 1000000000000
RG9 9 0 1000000000000
RG10 10 0 1000000000000
RG11 11 0 1000000000000
VS0 9 s0 0
R0 s0 8 82e0
VS1 9 s1 0
R1 s1 3 68e0
VS2 3 s2 0
R2 s2 2 18e-1
VS3 6 s3 0
R3 s3 10 15e-1
VS4 0 s4 0
V4 e4 s4 DC 33e-1
RI4 e4 5 47e-2
VS5 0 s5 0
R5 s5 8 39e1
VS6 11 s6 0
R6 s6 0 18e2
VS7 7 s7 0
V7 e7 s7 DC 10e0
RI7 e7 0 39e-1
VS8 2 s8 0
R8 s8 11 56e2
VS9 7 s9 0
R9 s9 3 82e1
VS10 4 s10 0
R10 s10 5 33e0
VS11 10 s11 0
R11 s11 4 33e3
VS12 1 s12 0
R12 s12 10 27e0
VS13 9 s13 0
V13 e13 s13 DC 68e-1
RI13 e13 0 82e-3
VS14 1 s14 0
R14 s14 3 68e0
VS15 0 s15 0
R15 s15 6 47e2
.control
set numdgt=17
op
print v(1) v(2) v(3) v(4) v(5) v(6) v(7) v(8) v(9) v(10)
print v(11)
print i(vs0) i(vs1) i(vs2) i(vs3) i(vs4) i(vs5) i(vs6) i(vs7) i(vs8) i(vs9)
print i(vs10) i(vs11) i(vs12) i(vs13) i(vs14) i(vs15)
.endc
.end
