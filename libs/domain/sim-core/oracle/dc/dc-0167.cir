controls oracle dc-0167
* Generated (plan F2.7, ADR 0012): do not edit; regenerate with `pnpm sim oracle regen`. dc seed 20261030 index 167 nodes 12 elements 12
.options sparse gmin=1e-12 noopac
RG1 1 0 1000000000000
RG2 2 0 1000000000000
RG3 3 0 1000000000000
RG4 4 0 1000000000000
RG5 5 0 1000000000000
RG6 6 0 1000000000000
RG7 7 0 1000000000000
RG8 8 0 1000000000000
RG9 9 0 1000000000000
RG10 10 0 1000000000000
RG11 11 0 1000000000000
VS0 0 s0 0
V0 e0 s0 DC 68e-1
RI0 e0 9 82e-3
VS1 4 s1 0
R1 s1 5 33e0
VS2 2 s2 0
R2 s2 11 56e2
VS3 6 s3 0
R3 s3 10 15e-1
VS4 7 s4 0
V4 e4 s4 DC 10e0
RI4 e4 9 39e-1
VS5 9 s5 0
R5 s5 6 47e2
VS6 1 s6 0
R6 s6 3 68e0
VS7 9 s7 0
R7 s7 8 39e1
VS8 0 s8 0
R8 s8 3 68e0
VS9 9 s9 0
R9 s9 5 56e-2
VS10 9 s10 0
V10 e10 s10 DC 33e-1
RI10 e10 5 47e-2
VS11 3 s11 0
R11 s11 2 18e-1
.control
set numdgt=17
op
print v(1) v(2) v(3) v(4) v(5) v(6) v(7) v(8) v(9) v(10)
print v(11)
print i(vs0) i(vs1) i(vs2) i(vs3) i(vs4) i(vs5) i(vs6) i(vs7) i(vs8) i(vs9)
print i(vs10) i(vs11)
.endc
.end
