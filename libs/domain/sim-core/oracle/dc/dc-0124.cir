controls oracle dc-0124
* Generated (plan F2.7, ADR 0012): do not edit; regenerate with `pnpm sim oracle regen`. dc seed 20261030 index 124 nodes 8 elements 8
.options sparse gmin=1e-12 noopac
RG1 1 0 1000000000000
RG2 2 0 1000000000000
RG3 3 0 1000000000000
RG4 4 0 1000000000000
RG5 5 0 1000000000000
RG6 6 0 1000000000000
RG7 7 0 1000000000000
VS0 0 s0 0
R0 s0 1 22e0
VS1 4 s1 0
R1 s1 5 68e0
VS2 3 s2 0
R2 s2 7 27e-1
VS3 4 s3 0
R3 s3 0 10e-2
VS4 0 s4 0
V4 e4 s4 DC 47e1
RI4 e4 4 15e-2
VS5 0 s5 0
R5 s5 7 18e0
VS6 7 s6 0
R6 s6 6 39e0
VS7 2 s7 0
R7 s7 7 33e2
.control
set numdgt=17
op
print v(1) v(2) v(3) v(4) v(5) v(6) v(7)
print i(vs0) i(vs1) i(vs2) i(vs3) i(vs4) i(vs5) i(vs6) i(vs7)
.endc
.end
