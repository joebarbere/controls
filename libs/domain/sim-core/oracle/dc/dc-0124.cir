controls oracle dc-0124
* Generated (plan F2.7, ADR 0012): do not edit; regenerate with `pnpm sim oracle regen`. dc seed 20261030 index 124 nodes 8 elements 11
.options sparse gmin=1e-12 noopac
RG1 1 0 1000000000000
RG2 2 0 1000000000000
RG3 3 0 1000000000000
RG4 4 0 1000000000000
RG5 5 0 1000000000000
RG6 6 0 1000000000000
RG7 7 0 1000000000000
VS0 3 s0 0
R0 s0 7 27e-1
VS1 2 s1 0
R1 s1 7 33e2
VS2 6 s2 0
R2 s2 3 15e3
VS3 7 s3 0
R3 s3 6 39e0
VS4 3 s4 0
R4 s4 1 12e3
VS5 0 s5 0
R5 s5 1 22e0
VS6 4 s6 0
R6 s6 5 68e0
VS7 5 s7 0
R7 s7 2 33e-1
VS8 0 s8 0
R8 s8 7 18e0
VS9 0 s9 0
V9 e9 s9 DC 47e1
RI9 e9 4 15e-2
VS10 1 s10 0
R10 s10 5 18e0
.control
set numdgt=17
op
print v(1) v(2) v(3) v(4) v(5) v(6) v(7)
print i(vs0) i(vs1) i(vs2) i(vs3) i(vs4) i(vs5) i(vs6) i(vs7) i(vs8) i(vs9)
print i(vs10)
.endc
.end
