controls oracle dc-0318
* Generated (plan F2.7, ADR 0012): do not edit; regenerate with `pnpm sim oracle regen`. dc seed 20261030 index 318 nodes 11 elements 22
.options sparse gmin=1e-12 noopac
RG1 1 0 1000000000000
RG2 2 0 1000000000000
RG3 3 0 1000000000000
RG4 4 0 1000000000000
RG5 5 0 1000000000000
RG6 6 0 1000000000000
RG7 7 0 1000000000000
RG8 8 0 1000000000000
RG9 9 0 1000000000000
RG10 10 0 1000000000000
VS0 0 s0 0
V0 e0 s0 DC 15e-1
RI0 e0 6 10e-1
VS1 6 s1 0
R1 s1 0 56e3
VS2 7 s2 0
R2 s2 4 39e-2
VS3 6 s3 0
R3 s3 8 18e3
VS4 2 s4 0
R4 s4 10 33e2
VS5 3 s5 0
V5 e5 s5 DC 22e1
RI5 e5 9 68e-1
VS6 8 s6 0
R6 s6 10 15e-2
VS7 1 s7 0
I7 s7 3 DC 68e-2
VS8 5 s8 0
I8 s8 0 DC 22e-2
VS9 2 s9 0
R9 s9 7 12e-2
VS10 3 s10 0
R10 s10 9 15e-1
VS11 1 s11 0
R11 s11 0 15e2
VS12 1 s12 0
R12 s12 8 22e-2
VS13 4 s13 0
R13 s13 3 33e1
VS14 1 s14 0
R14 s14 10 47e1
VS15 8 s15 0
R15 s15 1 22e1
VS16 9 s16 0
R16 s16 6 15e-2
VS17 1 s17 0
V17 e17 s17 DC 33e-1
RI17 e17 3 47e-1
VS18 6 s18 0
R18 s18 3 47e2
VS19 5 s19 0
R19 s19 0 33e3
VS20 5 s20 0
R20 s20 4 39e1
VS21 8 s21 0
R21 s21 7 82e-2
.control
set numdgt=17
op
print v(1) v(2) v(3) v(4) v(5) v(6) v(7) v(8) v(9) v(10)
print i(vs0) i(vs1) i(vs2) i(vs3) i(vs4) i(vs5) i(vs6) i(vs7) i(vs8) i(vs9)
print i(vs10) i(vs11) i(vs12) i(vs13) i(vs14) i(vs15) i(vs16) i(vs17) i(vs18) i(vs19)
print i(vs20) i(vs21)
.endc
.end
