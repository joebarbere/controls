controls oracle dc-0318
* Generated (plan F2.7, ADR 0012): do not edit; regenerate with `pnpm sim oracle regen`. dc seed 20261030 index 318 nodes 11 elements 21
.options sparse gmin=1e-12 noopac
RG1 1 0 1000000000000
RG2 2 0 1000000000000
RG3 3 0 1000000000000
RG4 4 0 1000000000000
RG5 5 0 1000000000000
RG6 6 0 1000000000000
RG7 7 0 1000000000000
RG8 8 0 1000000000000
RG9 9 0 1000000000000
RG10 10 0 1000000000000
VS0 3 s0 0
R0 s0 9 15e-1
VS1 6 s1 0
R1 s1 8 18e3
VS2 0 s2 0
R2 s2 8 22e-2
VS3 0 s3 0
V3 e3 s3 DC 33e-1
RI3 e3 3 47e-1
VS4 6 s4 0
R4 s4 3 47e2
VS5 8 s5 0
R5 s5 7 82e-2
VS6 0 s6 0
I6 s6 3 DC 68e-2
VS7 5 s7 0
I7 s7 4 DC 22e-2
VS8 0 s8 0
R8 s8 10 47e1
VS9 7 s9 0
R9 s9 1 39e-2
VS10 3 s10 0
V10 e10 s10 DC 22e1
RI10 e10 9 68e-1
VS11 4 s11 0
V11 e11 s11 DC 15e-1
RI11 e11 6 10e-1
VS12 9 s12 0
R12 s12 6 15e-2
VS13 8 s13 0
R13 s13 0 22e1
VS14 5 s14 0
R14 s14 4 33e3
VS15 1 s15 0
R15 s15 3 33e1
VS16 0 s16 0
R16 s16 4 15e2
VS17 5 s17 0
R17 s17 1 39e1
VS18 6 s18 0
R18 s18 4 56e3
VS19 8 s19 0
R19 s19 10 15e-2
VS20 2 s20 0
R20 s20 7 12e-2
.control
set numdgt=17
op
print v(1) v(2) v(3) v(4) v(5) v(6) v(7) v(8) v(9) v(10)
print i(vs0) i(vs1) i(vs2) i(vs3) i(vs4) i(vs5) i(vs6) i(vs7) i(vs8) i(vs9)
print i(vs10) i(vs11) i(vs12) i(vs13) i(vs14) i(vs15) i(vs16) i(vs17) i(vs18) i(vs19)
print i(vs20)
.endc
.end
