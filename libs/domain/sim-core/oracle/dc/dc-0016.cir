controls oracle dc-0016
* Generated (plan F2.7, ADR 0012): do not edit; regenerate with `pnpm sim oracle regen`. dc seed 20261030 index 16 nodes 23 elements 42
.options sparse gmin=1e-12 noopac
RG1 1 0 1000000000000
RG2 2 0 1000000000000
RG3 3 0 1000000000000
RG4 4 0 1000000000000
RG5 5 0 1000000000000
RG6 6 0 1000000000000
RG7 7 0 1000000000000
RG8 8 0 1000000000000
RG9 9 0 1000000000000
RG10 10 0 1000000000000
RG11 11 0 1000000000000
RG12 12 0 1000000000000
RG13 13 0 1000000000000
RG14 14 0 1000000000000
RG15 15 0 1000000000000
RG16 16 0 1000000000000
RG17 17 0 1000000000000
RG18 18 0 1000000000000
RG19 19 0 1000000000000
RG20 20 0 1000000000000
RG21 21 0 1000000000000
RG22 22 0 1000000000000
VS0 3 s0 0
R0 s0 16 39e3
VS1 12 s1 0
R1 s1 20 27e3
VS2 0 s2 0
V2 e2 s2 DC 18e-1
RI2 e2 9 56e-3
VS3 10 s3 0
I3 s3 6 DC 33e-4
VS4 9 s4 0
R4 s4 7 47e1
VS5 4 s5 0
V5 e5 s5 DC 33e-1
RI5 e5 12 22e-3
VS6 0 s6 0
V6 e6 s6 DC 56e-1
RI6 e6 16 22e-3
VS7 10 s7 0
R7 s7 1 15e-2
VS8 6 s8 0
R8 s8 11 27e-1
VS9 13 s9 0
R9 s9 18 39e2
VS10 11 s10 0
R10 s10 2 22e1
VS11 11 s11 0
R11 s11 3 10e3
VS12 8 s12 0
R12 s12 1 56e-2
VS13 22 s13 0
R13 s13 18 10e3
VS14 2 s14 0
V14 e14 s14 DC 18e1
RI14 e14 19 47e-1
VS15 4 s15 0
R15 s15 8 33e-2
VS16 9 s16 0
R16 s16 11 12e2
VS17 17 s17 0
R17 s17 4 12e2
VS18 11 s18 0
R18 s18 4 10e-1
VS19 11 s19 0
R19 s19 7 82e3
VS20 15 s20 0
R20 s20 11 33e-2
VS21 16 s21 0
R21 s21 2 15e-2
VS22 6 s22 0
I22 s22 4 DC 22e-4
VS23 11 s23 0
I23 s23 13 DC 18e-2
VS24 0 s24 0
R24 s24 2 33e1
VS25 10 s25 0
R25 s25 19 68e3
VS26 6 s26 0
R26 s26 17 10e3
VS27 1 s27 0
R27 s27 0 33e2
VS28 4 s28 0
R28 s28 21 15e0
VS29 4 s29 0
R29 s29 5 27e-2
VS30 11 s30 0
R30 s30 5 33e-2
VS31 3 s31 0
R31 s31 13 56e1
VS32 4 s32 0
V32 e32 s32 DC 33e0
RI32 e32 22 33e-3
VS33 7 s33 0
R33 s33 12 22e3
VS34 9 s34 0
R34 s34 14 47e3
VS35 10 s35 0
R35 s35 17 12e0
VS36 9 s36 0
R36 s36 3 12e-2
VS37 12 s37 0
I37 s37 13 DC 47e-3
VS38 18 s38 0
R38 s38 8 27e-2
VS39 22 s39 0
R39 s39 9 68e-2
VS40 14 s40 0
R40 s40 22 12e-2
VS41 17 s41 0
R41 s41 22 39e1
.control
set numdgt=17
op
print v(1) v(2) v(3) v(4) v(5) v(6) v(7) v(8) v(9) v(10)
print v(11) v(12) v(13) v(14) v(15) v(16) v(17) v(18) v(19) v(20)
print v(21) v(22)
print i(vs0) i(vs1) i(vs2) i(vs3) i(vs4) i(vs5) i(vs6) i(vs7) i(vs8) i(vs9)
print i(vs10) i(vs11) i(vs12) i(vs13) i(vs14) i(vs15) i(vs16) i(vs17) i(vs18) i(vs19)
print i(vs20) i(vs21) i(vs22) i(vs23) i(vs24) i(vs25) i(vs26) i(vs27) i(vs28) i(vs29)
print i(vs30) i(vs31) i(vs32) i(vs33) i(vs34) i(vs35) i(vs36) i(vs37) i(vs38) i(vs39)
print i(vs40) i(vs41)
.endc
.end
