controls oracle dc-0016
* Generated (plan F2.7, ADR 0012): do not edit; regenerate with `pnpm sim oracle regen`. dc seed 20261030 index 16 nodes 23 elements 45
.options sparse gmin=1e-12 noopac
RG1 1 0 1000000000000
RG2 2 0 1000000000000
RG3 3 0 1000000000000
RG4 4 0 1000000000000
RG5 5 0 1000000000000
RG6 6 0 1000000000000
RG7 7 0 1000000000000
RG8 8 0 1000000000000
RG9 9 0 1000000000000
RG10 10 0 1000000000000
RG11 11 0 1000000000000
RG12 12 0 1000000000000
RG13 13 0 1000000000000
RG14 14 0 1000000000000
RG15 15 0 1000000000000
RG16 16 0 1000000000000
RG17 17 0 1000000000000
RG18 18 0 1000000000000
RG19 19 0 1000000000000
RG20 20 0 1000000000000
RG21 21 0 1000000000000
RG22 22 0 1000000000000
VS0 4 s0 0
R0 s0 20 39e1
VS1 16 s1 0
R1 s1 2 15e-2
VS2 6 s2 0
R2 s2 17 10e3
VS3 6 s3 0
I3 s3 0 DC 22e-4
VS4 3 s4 0
R4 s4 16 39e3
VS5 0 s5 0
V5 e5 s5 DC 33e0
RI5 e5 22 33e-3
VS6 18 s6 0
R6 s6 8 27e-2
VS7 17 s7 0
R7 s7 0 12e2
VS8 4 s8 0
I8 s8 13 DC 18e-2
VS9 9 s9 0
R9 s9 7 47e1
VS10 14 s10 0
R10 s10 22 12e-2
VS11 14 s11 0
R11 s11 21 39e-2
VS12 0 s12 0
R12 s12 5 27e-2
VS13 11 s13 0
V13 e13 s13 DC 56e-1
RI13 e13 16 22e-3
VS14 15 s14 0
R14 s14 4 33e-2
VS15 0 s15 0
R15 s15 8 33e-2
VS16 17 s16 0
R16 s16 22 39e1
VS17 3 s17 0
R17 s17 13 56e1
VS18 4 s18 0
R18 s18 7 82e3
VS19 9 s19 0
R19 s19 4 12e2
VS20 9 s20 0
R20 s20 14 47e3
VS21 4 s21 0
R21 s21 5 33e-2
VS22 7 s22 0
R22 s22 12 22e3
VS23 4 s23 0
R23 s23 0 10e-1
VS24 1 s24 0
R24 s24 11 33e2
VS25 9 s25 0
R25 s25 3 12e-2
VS26 0 s26 0
R26 s26 21 15e0
VS27 11 s27 0
V27 e27 s27 DC 18e-1
RI27 e27 9 56e-3
VS28 8 s28 0
R28 s28 1 56e-2
VS29 5 s29 0
R29 s29 15 15e-1
VS30 6 s30 0
R30 s30 4 27e-1
VS31 10 s31 0
R31 s31 1 15e-2
VS32 0 s32 0
V32 e32 s32 DC 33e-1
RI32 e32 12 22e-3
VS33 13 s33 0
R33 s33 18 39e2
VS34 22 s34 0
R34 s34 18 10e3
VS35 12 s35 0
I35 s35 13 DC 47e-3
VS36 11 s36 0
R36 s36 2 33e1
VS37 4 s37 0
R37 s37 3 10e3
VS38 10 s38 0
R38 s38 19 68e3
VS39 12 s39 0
R39 s39 20 27e3
VS40 2 s40 0
V40 e40 s40 DC 18e1
RI40 e40 19 47e-1
VS41 22 s41 0
R41 s41 9 68e-2
VS42 10 s42 0
R42 s42 17 12e0
VS43 10 s43 0
I43 s43 6 DC 33e-4
VS44 4 s44 0
R44 s44 2 22e1
.control
set numdgt=17
op
print v(1) v(2) v(3) v(4) v(5) v(6) v(7) v(8) v(9) v(10)
print v(11) v(12) v(13) v(14) v(15) v(16) v(17) v(18) v(19) v(20)
print v(21) v(22)
print i(vs0) i(vs1) i(vs2) i(vs3) i(vs4) i(vs5) i(vs6) i(vs7) i(vs8) i(vs9)
print i(vs10) i(vs11) i(vs12) i(vs13) i(vs14) i(vs15) i(vs16) i(vs17) i(vs18) i(vs19)
print i(vs20) i(vs21) i(vs22) i(vs23) i(vs24) i(vs25) i(vs26) i(vs27) i(vs28) i(vs29)
print i(vs30) i(vs31) i(vs32) i(vs33) i(vs34) i(vs35) i(vs36) i(vs37) i(vs38) i(vs39)
print i(vs40) i(vs41) i(vs42) i(vs43) i(vs44)
.endc
.end
