controls oracle dc-0013
* Generated (plan F2.7, ADR 0012): do not edit; regenerate with `pnpm sim oracle regen`. dc seed 20261030 index 13 nodes 26 elements 40
.options sparse gmin=1e-12 noopac
RG1 1 0 1000000000000
RG2 2 0 1000000000000
RG3 3 0 1000000000000
RG4 4 0 1000000000000
RG5 5 0 1000000000000
RG6 6 0 1000000000000
RG7 7 0 1000000000000
RG8 8 0 1000000000000
RG9 9 0 1000000000000
RG10 10 0 1000000000000
RG11 11 0 1000000000000
RG12 12 0 1000000000000
RG13 13 0 1000000000000
RG14 14 0 1000000000000
RG15 15 0 1000000000000
RG16 16 0 1000000000000
RG17 17 0 1000000000000
RG18 18 0 1000000000000
RG19 19 0 1000000000000
RG20 20 0 1000000000000
RG21 21 0 1000000000000
RG22 22 0 1000000000000
RG23 23 0 1000000000000
RG24 24 0 1000000000000
RG25 25 0 1000000000000
VS0 10 s0 0
I0 s0 7 DC 10e-4
VS1 11 s1 0
R1 s1 5 18e2
VS2 0 s2 0
R2 s2 10 22e2
VS3 21 s3 0
R3 s3 9 33e3
VS4 5 s4 0
R4 s4 21 12e0
VS5 23 s5 0
R5 s5 8 33e-1
VS6 25 s6 0
R6 s6 10 39e3
VS7 3 s7 0
R7 s7 12 56e0
VS8 17 s8 0
R8 s8 12 18e2
VS9 19 s9 0
R9 s9 3 56e-1
VS10 3 s10 0
R10 s10 6 47e2
VS11 4 s11 0
R11 s11 21 56e-2
VS12 16 s12 0
R12 s12 24 10e-1
VS13 20 s13 0
R13 s13 12 15e0
VS14 23 s14 0
R14 s14 18 82e3
VS15 25 s15 0
R15 s15 15 82e3
VS16 22 s16 0
R16 s16 1 33e2
VS17 16 s17 0
R17 s17 21 56e-2
VS18 0 s18 0
V18 e18 s18 DC 56e1
RI18 e18 14 27e-2
VS19 23 s19 0
R19 s19 6 39e3
VS20 5 s20 0
R20 s20 10 39e3
VS21 7 s21 0
R21 s21 22 10e2
VS22 4 s22 0
V22 e22 s22 DC 56e-1
RI22 e22 7 18e-1
VS23 17 s23 0
V23 e23 s23 DC 18e0
RI23 e23 13 33e-3
VS24 2 s24 0
R24 s24 18 56e-1
VS25 20 s25 0
R25 s25 8 68e-2
VS26 14 s26 0
R26 s26 15 47e0
VS27 23 s27 0
R27 s27 9 39e3
VS28 14 s28 0
R28 s28 13 12e2
VS29 13 s29 0
R29 s29 24 68e3
VS30 19 s30 0
R30 s30 12 22e-1
VS31 1 s31 0
R31 s31 5 12e-2
VS32 15 s32 0
V32 e32 s32 DC 18e-1
RI32 e32 21 18e-2
VS33 0 s33 0
R33 s33 20 56e0
VS34 16 s34 0
R34 s34 2 12e0
VS35 0 s35 0
I35 s35 4 DC 68e-3
VS36 2 s36 0
R36 s36 20 18e-2
VS37 2 s37 0
R37 s37 22 12e-1
VS38 21 s38 0
R38 s38 17 10e-1
VS39 11 s39 0
R39 s39 9 12e-1
.control
set numdgt=17
op
print v(1) v(2) v(3) v(4) v(5) v(6) v(7) v(8) v(9) v(10)
print v(11) v(12) v(13) v(14) v(15) v(16) v(17) v(18) v(19) v(20)
print v(21) v(22) v(23) v(24) v(25)
print i(vs0) i(vs1) i(vs2) i(vs3) i(vs4) i(vs5) i(vs6) i(vs7) i(vs8) i(vs9)
print i(vs10) i(vs11) i(vs12) i(vs13) i(vs14) i(vs15) i(vs16) i(vs17) i(vs18) i(vs19)
print i(vs20) i(vs21) i(vs22) i(vs23) i(vs24) i(vs25) i(vs26) i(vs27) i(vs28) i(vs29)
print i(vs30) i(vs31) i(vs32) i(vs33) i(vs34) i(vs35) i(vs36) i(vs37) i(vs38) i(vs39)
.endc
.end
