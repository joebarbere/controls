controls oracle dc-0013
* Generated (plan F2.7, ADR 0012): do not edit; regenerate with `pnpm sim oracle regen`. dc seed 20261030 index 13 nodes 26 elements 34
.options sparse gmin=1e-12 noopac
RG1 1 0 1000000000000
RG2 2 0 1000000000000
RG3 3 0 1000000000000
RG4 4 0 1000000000000
RG5 5 0 1000000000000
RG6 6 0 1000000000000
RG7 7 0 1000000000000
RG8 8 0 1000000000000
RG9 9 0 1000000000000
RG10 10 0 1000000000000
RG11 11 0 1000000000000
RG12 12 0 1000000000000
RG13 13 0 1000000000000
RG14 14 0 1000000000000
RG15 15 0 1000000000000
RG16 16 0 1000000000000
RG17 17 0 1000000000000
RG18 18 0 1000000000000
RG19 19 0 1000000000000
RG20 20 0 1000000000000
RG21 21 0 1000000000000
RG22 22 0 1000000000000
RG23 23 0 1000000000000
RG24 24 0 1000000000000
RG25 25 0 1000000000000
VS0 23 s0 0
R0 s0 6 39e3
VS1 23 s1 0
R1 s1 9 39e3
VS2 11 s2 0
R2 s2 9 12e-1
VS3 16 s3 0
R3 s3 21 56e-2
VS4 13 s4 0
R4 s4 24 68e3
VS5 5 s5 0
R5 s5 10 22e2
VS6 0 s6 0
V6 e6 s6 DC 18e0
RI6 e6 13 33e-3
VS7 19 s7 0
R7 s7 12 22e-1
VS8 14 s8 0
R8 s8 13 12e2
VS9 25 s9 0
R9 s9 15 82e3
VS10 20 s10 0
R10 s10 8 68e-2
VS11 17 s11 0
R11 s11 10 39e3
VS12 2 s12 0
R12 s12 20 18e-2
VS13 22 s13 0
R13 s13 1 33e2
VS14 5 s14 0
I14 s14 4 DC 68e-3
VS15 2 s15 0
R15 s15 22 12e-1
VS16 23 s16 0
R16 s16 18 82e3
VS17 21 s17 0
R17 s17 9 33e3
VS18 2 s18 0
R18 s18 18 56e-1
VS19 15 s19 0
V19 e19 s19 DC 18e-1
RI19 e19 21 18e-2
VS20 14 s20 0
R20 s20 15 47e0
VS21 23 s21 0
R21 s21 8 33e-1
VS22 5 s22 0
R22 s22 20 56e0
VS23 3 s23 0
R23 s23 6 47e2
VS24 1 s24 0
R24 s24 17 12e-2
VS25 17 s25 0
R25 s25 21 12e0
VS26 0 s26 0
R26 s26 12 18e2
VS27 21 s27 0
R27 s27 0 10e-1
VS28 5 s28 0
V28 e28 s28 DC 56e1
RI28 e28 14 27e-2
VS29 16 s29 0
R29 s29 2 12e0
VS30 20 s30 0
R30 s30 12 15e0
VS31 7 s31 0
R31 s31 22 10e2
VS32 10 s32 0
I32 s32 7 DC 10e-4
VS33 4 s33 0
R33 s33 21 56e-2
.control
set numdgt=17
op
print v(1) v(2) v(3) v(4) v(5) v(6) v(7) v(8) v(9) v(10)
print v(11) v(12) v(13) v(14) v(15) v(16) v(17) v(18) v(19) v(20)
print v(21) v(22) v(23) v(24) v(25)
print i(vs0) i(vs1) i(vs2) i(vs3) i(vs4) i(vs5) i(vs6) i(vs7) i(vs8) i(vs9)
print i(vs10) i(vs11) i(vs12) i(vs13) i(vs14) i(vs15) i(vs16) i(vs17) i(vs18) i(vs19)
print i(vs20) i(vs21) i(vs22) i(vs23) i(vs24) i(vs25) i(vs26) i(vs27) i(vs28) i(vs29)
print i(vs30) i(vs31) i(vs32) i(vs33)
.endc
.end
