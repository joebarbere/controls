controls oracle dc-0090
* Generated (plan F2.7, ADR 0012): do not edit; regenerate with `pnpm sim oracle regen`. dc seed 20261030 index 90 nodes 4 elements 7
.options sparse gmin=1e-12 noopac
RG1 1 0 1000000000000
RG2 2 0 1000000000000
RG3 3 0 1000000000000
VS0 1 s0 0
R0 s0 2 33e3
VS1 3 s1 0
R1 s1 1 47e2
VS2 0 s2 0
V2 e2 s2 DC 47e-1
RI2 e2 2 22e-2
VS3 0 s3 0
R3 s3 1 10e1
VS4 3 s4 0
R4 s4 2 82e0
VS5 2 s5 0
V5 e5 s5 DC 15e1
RI5 e5 0 33e-2
VS6 1 s6 0
I6 s6 3 DC 27e-2
.control
set numdgt=17
op
print v(1) v(2) v(3)
print i(vs0) i(vs1) i(vs2) i(vs3) i(vs4) i(vs5) i(vs6)
.endc
.end
