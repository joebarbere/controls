controls oracle dc-0098
* Generated (plan F2.7, ADR 0012): do not edit; regenerate with `pnpm sim oracle regen`. dc seed 20261030 index 98 nodes 14 elements 18
.options sparse gmin=1e-12 noopac
RG1 1 0 1000000000000
RG2 2 0 1000000000000
RG3 3 0 1000000000000
RG4 4 0 1000000000000
RG5 5 0 1000000000000
RG6 6 0 1000000000000
RG7 7 0 1000000000000
RG8 8 0 1000000000000
RG9 9 0 1000000000000
RG10 10 0 1000000000000
RG11 11 0 1000000000000
RG12 12 0 1000000000000
RG13 13 0 1000000000000
VS0 9 s0 0
R0 s0 7 15e1
VS1 9 s1 0
R1 s1 3 56e-1
VS2 4 s2 0
R2 s2 8 68e-1
VS3 13 s3 0
R3 s3 9 39e-1
VS4 0 s4 0
R4 s4 8 22e1
VS5 0 s5 0
R5 s5 12 33e2
VS6 8 s6 0
I6 s6 9 DC 39e-3
VS7 7 s7 0
R7 s7 10 12e1
VS8 11 s8 0
R8 s8 8 22e-2
VS9 2 s9 0
R9 s9 12 47e3
VS10 4 s10 0
R10 s10 7 33e3
VS11 13 s11 0
R11 s11 1 18e-2
VS12 13 s12 0
R12 s12 11 18e0
VS13 0 s13 0
I13 s13 4 DC 33e-3
VS14 5 s14 0
R14 s14 8 39e-2
VS15 13 s15 0
R15 s15 5 68e3
VS16 13 s16 0
R16 s16 6 56e1
VS17 5 s17 0
R17 s17 9 15e0
.control
set numdgt=17
op
print v(1) v(2) v(3) v(4) v(5) v(6) v(7) v(8) v(9) v(10)
print v(11) v(12) v(13)
print i(vs0) i(vs1) i(vs2) i(vs3) i(vs4) i(vs5) i(vs6) i(vs7) i(vs8) i(vs9)
print i(vs10) i(vs11) i(vs12) i(vs13) i(vs14) i(vs15) i(vs16) i(vs17)
.endc
.end
