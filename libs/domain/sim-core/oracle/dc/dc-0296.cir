controls oracle dc-0296
* Generated (plan F2.7, ADR 0012): do not edit; regenerate with `pnpm sim oracle regen`. dc seed 20261030 index 296 nodes 6 elements 7
.options sparse gmin=1e-12 noopac
RG1 1 0 1000000000000
RG2 2 0 1000000000000
RG3 3 0 1000000000000
RG4 4 0 1000000000000
RG5 5 0 1000000000000
VS0 0 s0 0
R0 s0 5 47e3
VS1 4 s1 0
R1 s1 1 10e-2
VS2 5 s2 0
R2 s2 1 22e1
VS3 2 s3 0
R3 s3 5 10e0
VS4 0 s4 0
V4 e4 s4 DC 10e-1
RI4 e4 5 82e-1
VS5 5 s5 0
V5 e5 s5 DC 10e0
RI5 e5 2 56e-2
VS6 1 s6 0
V6 e6 s6 DC 10e1
RI6 e6 3 22e-2
.control
set numdgt=17
op
print v(1) v(2) v(3) v(4) v(5)
print i(vs0) i(vs1) i(vs2) i(vs3) i(vs4) i(vs5) i(vs6)
.endc
.end
