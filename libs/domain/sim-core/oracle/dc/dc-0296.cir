controls oracle dc-0296
* Generated (plan F2.7, ADR 0012): do not edit; regenerate with `pnpm sim oracle regen`. dc seed 20261030 index 296 nodes 6 elements 10
.options sparse gmin=1e-12 noopac
RG1 1 0 1000000000000
RG2 2 0 1000000000000
RG3 3 0 1000000000000
RG4 4 0 1000000000000
RG5 5 0 1000000000000
VS0 2 s0 0
R0 s0 5 10e0
VS1 5 s1 0
R1 s1 0 22e1
VS2 1 s2 0
R2 s2 0 68e0
VS3 0 s3 0
V3 e3 s3 DC 10e1
RI3 e3 3 22e-2
VS4 5 s4 0
V4 e4 s4 DC 10e0
RI4 e4 2 56e-2
VS5 4 s5 0
R5 s5 0 10e-2
VS6 4 s6 0
R6 s6 3 39e-2
VS7 2 s7 0
R7 s7 3 10e2
VS8 1 s8 0
V8 e8 s8 DC 10e-1
RI8 e8 5 82e-1
VS9 1 s9 0
R9 s9 5 47e3
.control
set numdgt=17
op
print v(1) v(2) v(3) v(4) v(5)
print i(vs0) i(vs1) i(vs2) i(vs3) i(vs4) i(vs5) i(vs6) i(vs7) i(vs8) i(vs9)
.endc
.end
