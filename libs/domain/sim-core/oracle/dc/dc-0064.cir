controls oracle dc-0064
* Generated (plan F2.7, ADR 0012): do not edit; regenerate with `pnpm sim oracle regen`. dc seed 20261030 index 64 nodes 4 elements 5
.options sparse gmin=1e-12 noopac
RG1 1 0 1000000000000
RG2 2 0 1000000000000
RG3 3 0 1000000000000
VS0 2 s0 0
R0 s0 1 82e2
VS1 0 s1 0
R1 s1 3 10e-1
VS2 3 s2 0
R2 s2 2 39e2
VS3 0 s3 0
V3 e3 s3 DC 10e1
RI3 e3 1 47e-2
VS4 1 s4 0
R4 s4 3 22e2
.control
set numdgt=17
op
print v(1) v(2) v(3)
print i(vs0) i(vs1) i(vs2) i(vs3) i(vs4)
.endc
.end
