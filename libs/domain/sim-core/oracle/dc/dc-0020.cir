controls oracle dc-0020
* Generated (plan F2.7, ADR 0012): do not edit; regenerate with `pnpm sim oracle regen`. dc seed 20261030 index 20 nodes 14 elements 27
.options sparse gmin=1e-12 noopac
RG1 1 0 1000000000000
RG2 2 0 1000000000000
RG3 3 0 1000000000000
RG4 4 0 1000000000000
RG5 5 0 1000000000000
RG6 6 0 1000000000000
RG7 7 0 1000000000000
RG8 8 0 1000000000000
RG9 9 0 1000000000000
RG10 10 0 1000000000000
RG11 11 0 1000000000000
RG12 12 0 1000000000000
RG13 13 0 1000000000000
VS0 12 s0 0
R0 s0 8 39e0
VS1 4 s1 0
R1 s1 5 18e-1
VS2 0 s2 0
R2 s2 5 10e0
VS3 7 s3 0
R3 s3 6 22e2
VS4 2 s4 0
R4 s4 9 12e3
VS5 0 s5 0
R5 s5 10 47e0
VS6 0 s6 0
V6 e6 s6 DC 56e0
RI6 e6 12 18e-3
VS7 2 s7 0
I7 s7 8 DC 18e-1
VS8 7 s8 0
R8 s8 4 27e-1
VS9 9 s9 0
R9 s9 2 39e2
VS10 8 s10 0
V10 e10 s10 DC 12e-1
RI10 e10 5 10e-2
VS11 1 s11 0
R11 s11 4 56e-1
VS12 13 s12 0
R12 s12 12 15e1
VS13 6 s13 0
R13 s13 11 56e3
VS14 11 s14 0
R14 s14 2 47e2
VS15 11 s15 0
R15 s15 7 68e0
VS16 9 s16 0
R16 s16 7 68e-1
VS17 0 s17 0
R17 s17 1 39e-1
VS18 5 s18 0
R18 s18 3 39e2
VS19 3 s19 0
R19 s19 7 33e2
VS20 1 s20 0
I20 s20 13 DC 33e-1
VS21 10 s21 0
V21 e21 s21 DC 33e0
RI21 e21 11 39e-3
VS22 9 s22 0
V22 e22 s22 DC 12e-1
RI22 e22 12 12e-1
VS23 13 s23 0
I23 s23 0 DC 47e-2
VS24 8 s24 0
R24 s24 12 27e0
VS25 13 s25 0
V25 e25 s25 DC 10e-1
RI25 e25 1 33e-1
VS26 11 s26 0
I26 s26 8 DC 47e-3
.control
set numdgt=17
op
print v(1) v(2) v(3) v(4) v(5) v(6) v(7) v(8) v(9) v(10)
print v(11) v(12) v(13)
print i(vs0) i(vs1) i(vs2) i(vs3) i(vs4) i(vs5) i(vs6) i(vs7) i(vs8) i(vs9)
print i(vs10) i(vs11) i(vs12) i(vs13) i(vs14) i(vs15) i(vs16) i(vs17) i(vs18) i(vs19)
print i(vs20) i(vs21) i(vs22) i(vs23) i(vs24) i(vs25) i(vs26)
.endc
.end
