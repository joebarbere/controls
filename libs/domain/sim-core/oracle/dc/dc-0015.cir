controls oracle dc-0015
* Generated (plan F2.7, ADR 0012): do not edit; regenerate with `pnpm sim oracle regen`. dc seed 20261030 index 15 nodes 26 elements 55
.options sparse gmin=1e-12 noopac
RG1 1 0 1000000000000
RG2 2 0 1000000000000
RG3 3 0 1000000000000
RG4 4 0 1000000000000
RG5 5 0 1000000000000
RG6 6 0 1000000000000
RG7 7 0 1000000000000
RG8 8 0 1000000000000
RG9 9 0 1000000000000
RG10 10 0 1000000000000
RG11 11 0 1000000000000
RG12 12 0 1000000000000
RG13 13 0 1000000000000
RG14 14 0 1000000000000
RG15 15 0 1000000000000
RG16 16 0 1000000000000
RG17 17 0 1000000000000
RG18 18 0 1000000000000
RG19 19 0 1000000000000
RG20 20 0 1000000000000
RG21 21 0 1000000000000
RG22 22 0 1000000000000
RG23 23 0 1000000000000
RG24 24 0 1000000000000
RG25 25 0 1000000000000
VS0 7 s0 0
R0 s0 11 15e3
VS1 2 s1 0
R1 s1 11 33e0
VS2 0 s2 0
V2 e2 s2 DC 68e-1
RI2 e2 8 47e-3
VS3 13 s3 0
I3 s3 5 DC 68e-4
VS4 15 s4 0
R4 s4 10 10e-1
VS5 17 s5 0
R5 s5 3 18e-2
VS6 7 s6 0
R6 s6 8 15e-1
VS7 25 s7 0
I7 s7 4 DC 15e-3
VS8 11 s8 0
R8 s8 7 27e3
VS9 22 s9 0
R9 s9 0 47e3
VS10 20 s10 0
V10 e10 s10 DC 47e0
RI10 e10 21 12e-3
VS11 24 s11 0
R11 s11 8 39e-1
VS12 11 s12 0
R12 s12 5 12e3
VS13 4 s13 0
R13 s13 12 39e0
VS14 18 s14 0
V14 e14 s14 DC 33e1
RI14 e14 20 47e-1
VS15 5 s15 0
R15 s15 15 12e1
VS16 1 s16 0
R16 s16 9 68e0
VS17 8 s17 0
R17 s17 11 82e0
VS18 20 s18 0
V18 e18 s18 DC 33e1
RI18 e18 13 15e-3
VS19 10 s19 0
R19 s19 14 22e0
VS20 25 s20 0
R20 s20 10 18e-2
VS21 16 s21 0
R21 s21 20 39e1
VS22 22 s22 0
V22 e22 s22 DC 22e0
RI22 e22 19 47e-1
VS23 15 s23 0
V23 e23 s23 DC 27e-1
RI23 e23 8 12e-1
VS24 12 s24 0
R24 s24 13 27e3
VS25 22 s25 0
I25 s25 12 DC 68e-4
VS26 22 s26 0
R26 s26 18 12e0
VS27 2 s27 0
R27 s27 25 22e1
VS28 12 s28 0
R28 s28 11 18e-1
VS29 3 s29 0
R29 s29 23 15e-1
VS30 10 s30 0
R30 s30 8 22e2
VS31 20 s31 0
R31 s31 18 39e1
VS32 15 s32 0
R32 s32 8 68e0
VS33 4 s33 0
V33 e33 s33 DC 22e-1
RI33 e33 24 47e-1
VS34 1 s34 0
R34 s34 12 33e1
VS35 20 s35 0
R35 s35 7 10e-2
VS36 11 s36 0
R36 s36 23 33e0
VS37 7 s37 0
R37 s37 21 47e-2
VS38 23 s38 0
R38 s38 14 56e1
VS39 22 s39 0
R39 s39 3 33e-1
VS40 0 s40 0
R40 s40 22 27e0
VS41 2 s41 0
I41 s41 23 DC 12e-2
VS42 22 s42 0
V42 e42 s42 DC 22e1
RI42 e42 9 47e-2
VS43 6 s43 0
R43 s43 20 10e3
VS44 10 s44 0
R44 s44 8 39e-2
VS45 10 s45 0
V45 e45 s45 DC 27e-1
RI45 e45 1 10e-3
VS46 4 s46 0
R46 s46 14 18e2
VS47 19 s47 0
R47 s47 0 39e0
VS48 7 s48 0
R48 s48 9 27e1
VS49 5 s49 0
R49 s49 22 15e2
VS50 17 s50 0
R50 s50 3 12e3
VS51 16 s51 0
R51 s51 23 18e3
VS52 8 s52 0
R52 s52 9 33e-1
VS53 11 s53 0
V53 e53 s53 DC 22e1
RI53 e53 17 12e-1
VS54 6 s54 0
R54 s54 14 10e2
.control
set numdgt=17
op
print v(1) v(2) v(3) v(4) v(5) v(6) v(7) v(8) v(9) v(10)
print v(11) v(12) v(13) v(14) v(15) v(16) v(17) v(18) v(19) v(20)
print v(21) v(22) v(23) v(24) v(25)
print i(vs0) i(vs1) i(vs2) i(vs3) i(vs4) i(vs5) i(vs6) i(vs7) i(vs8) i(vs9)
print i(vs10) i(vs11) i(vs12) i(vs13) i(vs14) i(vs15) i(vs16) i(vs17) i(vs18) i(vs19)
print i(vs20) i(vs21) i(vs22) i(vs23) i(vs24) i(vs25) i(vs26) i(vs27) i(vs28) i(vs29)
print i(vs30) i(vs31) i(vs32) i(vs33) i(vs34) i(vs35) i(vs36) i(vs37) i(vs38) i(vs39)
print i(vs40) i(vs41) i(vs42) i(vs43) i(vs44) i(vs45) i(vs46) i(vs47) i(vs48) i(vs49)
print i(vs50) i(vs51) i(vs52) i(vs53) i(vs54)
.endc
.end
