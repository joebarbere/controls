controls oracle dc-0015
* Generated (plan F2.7, ADR 0012): do not edit; regenerate with `pnpm sim oracle regen`. dc seed 20261030 index 15 nodes 26 elements 51
.options sparse gmin=1e-12 noopac
RG1 1 0 1000000000000
RG2 2 0 1000000000000
RG3 3 0 1000000000000
RG4 4 0 1000000000000
RG5 5 0 1000000000000
RG6 6 0 1000000000000
RG7 7 0 1000000000000
RG8 8 0 1000000000000
RG9 9 0 1000000000000
RG10 10 0 1000000000000
RG11 11 0 1000000000000
RG12 12 0 1000000000000
RG13 13 0 1000000000000
RG14 14 0 1000000000000
RG15 15 0 1000000000000
RG16 16 0 1000000000000
RG17 17 0 1000000000000
RG18 18 0 1000000000000
RG19 19 0 1000000000000
RG20 20 0 1000000000000
RG21 21 0 1000000000000
RG22 22 0 1000000000000
RG23 23 0 1000000000000
RG24 24 0 1000000000000
RG25 25 0 1000000000000
VS0 11 s0 0
R0 s0 7 27e3
VS1 9 s1 0
R1 s1 22 27e0
VS2 1 s2 0
R2 s2 20 68e0
VS3 17 s3 0
R3 s3 3 18e-2
VS4 10 s4 0
R4 s4 8 22e2
VS5 0 s5 0
R5 s5 18 39e1
VS6 10 s6 0
R6 s6 8 39e-2
VS7 12 s7 0
R7 s7 13 27e3
VS8 25 s8 0
I8 s8 4 DC 15e-3
VS9 8 s9 0
R9 s9 11 82e0
VS10 4 s10 0
R10 s10 12 39e0
VS11 10 s11 0
R11 s11 14 22e0
VS12 0 s12 0
V12 e12 s12 DC 33e1
RI12 e12 13 15e-3
VS13 8 s13 0
R13 s13 20 33e-1
VS14 11 s14 0
V14 e14 s14 DC 22e1
RI14 e14 17 12e-1
VS15 5 s15 0
R15 s15 15 12e1
VS16 16 s16 0
R16 s16 0 39e1
VS17 2 s17 0
R17 s17 11 33e0
VS18 22 s18 0
V18 e18 s18 DC 22e0
RI18 e18 19 47e-1
VS19 9 s19 0
V19 e19 s19 DC 68e-1
RI19 e19 8 47e-3
VS20 15 s20 0
V20 e20 s20 DC 27e-1
RI20 e20 8 12e-1
VS21 12 s21 0
R21 s21 11 18e-1
VS22 2 s22 0
R22 s22 25 22e1
VS23 6 s23 0
R23 s23 0 10e3
VS24 1 s24 0
R24 s24 12 33e1
VS25 22 s25 0
V25 e25 s25 DC 22e1
RI25 e25 20 47e-2
VS26 7 s26 0
R26 s26 11 15e3
VS27 23 s27 0
R27 s27 14 56e1
VS28 3 s28 0
R28 s28 23 15e-1
VS29 10 s29 0
V29 e29 s29 DC 27e-1
RI29 e29 1 10e-3
VS30 15 s30 0
R30 s30 10 10e-1
VS31 15 s31 0
R31 s31 8 68e0
VS32 25 s32 0
R32 s32 10 18e-2
VS33 0 s33 0
R33 s33 7 10e-2
VS34 2 s34 0
I34 s34 23 DC 12e-2
VS35 17 s35 0
R35 s35 3 12e3
VS36 11 s36 0
R36 s36 5 12e3
VS37 7 s37 0
R37 s37 21 47e-2
VS38 22 s38 0
R38 s38 18 12e0
VS39 22 s39 0
I39 s39 12 DC 68e-4
VS40 4 s40 0
R40 s40 14 18e2
VS41 5 s41 0
R41 s41 22 15e2
VS42 13 s42 0
I42 s42 5 DC 68e-4
VS43 22 s43 0
R43 s43 9 47e3
VS44 18 s44 0
V44 e44 s44 DC 33e1
RI44 e44 0 47e-1
VS45 7 s45 0
R45 s45 20 27e1
VS46 11 s46 0
R46 s46 23 33e0
VS47 4 s47 0
V47 e47 s47 DC 22e-1
RI47 e47 24 47e-1
VS48 24 s48 0
R48 s48 8 39e-1
VS49 7 s49 0
R49 s49 8 15e-1
VS50 22 s50 0
R50 s50 3 33e-1
.control
set numdgt=17
op
print v(1) v(2) v(3) v(4) v(5) v(6) v(7) v(8) v(9) v(10)
print v(11) v(12) v(13) v(14) v(15) v(16) v(17) v(18) v(19) v(20)
print v(21) v(22) v(23) v(24) v(25)
print i(vs0) i(vs1) i(vs2) i(vs3) i(vs4) i(vs5) i(vs6) i(vs7) i(vs8) i(vs9)
print i(vs10) i(vs11) i(vs12) i(vs13) i(vs14) i(vs15) i(vs16) i(vs17) i(vs18) i(vs19)
print i(vs20) i(vs21) i(vs22) i(vs23) i(vs24) i(vs25) i(vs26) i(vs27) i(vs28) i(vs29)
print i(vs30) i(vs31) i(vs32) i(vs33) i(vs34) i(vs35) i(vs36) i(vs37) i(vs38) i(vs39)
print i(vs40) i(vs41) i(vs42) i(vs43) i(vs44) i(vs45) i(vs46) i(vs47) i(vs48) i(vs49)
print i(vs50)
.endc
.end
