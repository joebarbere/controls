controls oracle dc-0415
* Generated (plan F2.7, ADR 0012): do not edit; regenerate with `pnpm sim oracle regen`. dc seed 20261030 index 415 nodes 12 elements 23
.options sparse gmin=1e-12 noopac
RG1 1 0 1000000000000
RG2 2 0 1000000000000
RG3 3 0 1000000000000
RG4 4 0 1000000000000
RG5 5 0 1000000000000
RG6 6 0 1000000000000
RG7 7 0 1000000000000
RG8 8 0 1000000000000
RG9 9 0 1000000000000
RG10 10 0 1000000000000
RG11 11 0 1000000000000
VS0 8 s0 0
R0 s0 10 47e-1
VS1 11 s1 0
R1 s1 2 56e0
VS2 9 s2 0
I2 s2 10 DC 12e-2
VS3 3 s3 0
R3 s3 1 18e-2
VS4 5 s4 0
I4 s4 1 DC 22e-1
VS5 10 s5 0
R5 s5 8 68e1
VS6 2 s6 0
R6 s6 4 22e2
VS7 5 s7 0
R7 s7 2 18e0
VS8 0 s8 0
V8 e8 s8 DC 12e1
RI8 e8 7 10e-3
VS9 7 s9 0
V9 e9 s9 DC 39e1
RI9 e9 4 39e-3
VS10 0 s10 0
R10 s10 6 27e2
VS11 10 s11 0
V11 e11 s11 DC 12e0
RI11 e11 1 15e-1
VS12 10 s12 0
V12 e12 s12 DC 10e0
RI12 e12 7 12e-1
VS13 6 s13 0
R13 s13 10 27e1
VS14 5 s14 0
R14 s14 10 47e2
VS15 3 s15 0
R15 s15 7 33e-1
VS16 0 s16 0
R16 s16 11 12e2
VS17 5 s17 0
R17 s17 8 82e-1
VS18 8 s18 0
I18 s18 1 DC 15e-4
VS19 8 s19 0
R19 s19 11 82e2
VS20 10 s20 0
R20 s20 9 39e1
VS21 1 s21 0
I21 s21 11 DC 68e-4
VS22 6 s22 0
R22 s22 3 47e2
.control
set numdgt=17
op
print v(1) v(2) v(3) v(4) v(5) v(6) v(7) v(8) v(9) v(10)
print v(11)
print i(vs0) i(vs1) i(vs2) i(vs3) i(vs4) i(vs5) i(vs6) i(vs7) i(vs8) i(vs9)
print i(vs10) i(vs11) i(vs12) i(vs13) i(vs14) i(vs15) i(vs16) i(vs17) i(vs18) i(vs19)
print i(vs20) i(vs21) i(vs22)
.endc
.end
