controls oracle dc-0415
* Generated (plan F2.7, ADR 0012): do not edit; regenerate with `pnpm sim oracle regen`. dc seed 20261030 index 415 nodes 12 elements 24
.options sparse gmin=1e-12 noopac
RG1 1 0 1000000000000
RG2 2 0 1000000000000
RG3 3 0 1000000000000
RG4 4 0 1000000000000
RG5 5 0 1000000000000
RG6 6 0 1000000000000
RG7 7 0 1000000000000
RG8 8 0 1000000000000
RG9 9 0 1000000000000
RG10 10 0 1000000000000
RG11 11 0 1000000000000
VS0 0 s0 0
V0 e0 s0 DC 10e0
RI0 e0 10 12e-1
VS1 8 s1 0
R1 s1 11 82e2
VS2 0 s2 0
R2 s2 9 39e1
VS3 7 s3 0
V3 e3 s3 DC 18e-1
RI3 e3 9 68e-1
VS4 5 s4 0
R4 s4 2 18e0
VS5 7 s5 0
R5 s5 6 27e2
VS6 3 s6 0
R6 s6 1 18e-2
VS7 5 s7 0
I7 s7 1 DC 22e-1
VS8 1 s8 0
I8 s8 11 DC 68e-4
VS9 8 s9 0
I9 s9 1 DC 15e-4
VS10 8 s10 0
R10 s10 0 47e-1
VS11 9 s11 0
I11 s11 0 DC 12e-2
VS12 5 s12 0
R12 s12 8 82e-1
VS13 5 s13 0
R13 s13 0 47e2
VS14 10 s14 0
V14 e14 s14 DC 39e1
RI14 e14 4 39e-3
VS15 11 s15 0
R15 s15 2 56e0
VS16 2 s16 0
R16 s16 4 22e2
VS17 7 s17 0
V17 e17 s17 DC 12e1
RI17 e17 10 10e-3
VS18 0 s18 0
V18 e18 s18 DC 12e0
RI18 e18 1 15e-1
VS19 6 s19 0
R19 s19 0 27e1
VS20 6 s20 0
R20 s20 3 47e2
VS21 0 s21 0
R21 s21 8 68e1
VS22 7 s22 0
R22 s22 11 12e2
VS23 3 s23 0
R23 s23 10 33e-1
.control
set numdgt=17
op
print v(1) v(2) v(3) v(4) v(5) v(6) v(7) v(8) v(9) v(10)
print v(11)
print i(vs0) i(vs1) i(vs2) i(vs3) i(vs4) i(vs5) i(vs6) i(vs7) i(vs8) i(vs9)
print i(vs10) i(vs11) i(vs12) i(vs13) i(vs14) i(vs15) i(vs16) i(vs17) i(vs18) i(vs19)
print i(vs20) i(vs21) i(vs22) i(vs23)
.endc
.end
