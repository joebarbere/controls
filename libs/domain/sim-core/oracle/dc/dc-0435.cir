controls oracle dc-0435
* Generated (plan F2.7, ADR 0012): do not edit; regenerate with `pnpm sim oracle regen`. dc seed 20261030 index 435 nodes 4 elements 6
.options sparse gmin=1e-12 noopac
RG1 1 0 1000000000000
RG2 2 0 1000000000000
RG3 3 0 1000000000000
VS0 0 s0 0
V0 e0 s0 DC 12e1
RI0 e0 1 12e-3
VS1 0 s1 0
I1 s1 3 DC 22e-3
VS2 0 s2 0
R2 s2 2 10e2
VS3 2 s3 0
R3 s3 0 10e1
VS4 2 s4 0
R4 s4 3 10e3
VS5 3 s5 0
R5 s5 0 12e0
.control
set numdgt=17
op
print v(1) v(2) v(3)
print i(vs0) i(vs1) i(vs2) i(vs3) i(vs4) i(vs5)
.endc
.end
