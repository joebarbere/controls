controls oracle dc-0247
* Generated (plan F2.7, ADR 0012): do not edit; regenerate with `pnpm sim oracle regen`. dc seed 20261030 index 247 nodes 24 elements 24
.options sparse gmin=1e-12 noopac
RG1 1 0 1000000000000
RG2 2 0 1000000000000
RG3 3 0 1000000000000
RG4 4 0 1000000000000
RG5 5 0 1000000000000
RG6 6 0 1000000000000
RG7 7 0 1000000000000
RG8 8 0 1000000000000
RG9 9 0 1000000000000
RG10 10 0 1000000000000
RG11 11 0 1000000000000
RG12 12 0 1000000000000
RG13 13 0 1000000000000
RG14 14 0 1000000000000
RG15 15 0 1000000000000
RG16 16 0 1000000000000
RG17 17 0 1000000000000
RG18 18 0 1000000000000
RG19 19 0 1000000000000
RG20 20 0 1000000000000
RG21 21 0 1000000000000
RG22 22 0 1000000000000
RG23 23 0 1000000000000
VS0 3 s0 0
R0 s0 4 82e-1
VS1 22 s1 0
R1 s1 8 68e-2
VS2 0 s2 0
V2 e2 s2 DC 82e0
RI2 e2 19 12e-2
VS3 22 s3 0
R3 s3 2 27e-1
VS4 17 s4 0
R4 s4 18 22e1
VS5 11 s5 0
R5 s5 5 39e2
VS6 5 s6 0
V6 e6 s6 DC 27e1
RI6 e6 12 33e-2
VS7 15 s7 0
R7 s7 0 22e-1
VS8 9 s8 0
V8 e8 s8 DC 15e1
RI8 e8 19 10e-1
VS9 13 s9 0
R9 s9 8 56e2
VS10 10 s10 0
V10 e10 s10 DC 82e-1
RI10 e10 16 33e-1
VS11 6 s11 0
R11 s11 16 18e-2
VS12 13 s12 0
R12 s12 16 56e-2
VS13 14 s13 0
R13 s13 16 10e3
VS14 14 s14 0
R14 s14 15 56e1
VS15 20 s15 0
R15 s15 13 22e1
VS16 0 s16 0
R16 s16 17 82e3
VS17 1 s17 0
R17 s17 16 56e-1
VS18 14 s18 0
V18 e18 s18 DC 82e-1
RI18 e18 23 68e-1
VS19 21 s19 0
R19 s19 15 10e2
VS20 15 s20 0
V20 e20 s20 DC 15e0
RI20 e20 14 68e-2
VS21 3 s21 0
R21 s21 17 18e2
VS22 7 s22 0
R22 s22 15 82e-1
VS23 7 s23 0
R23 s23 12 39e3
.control
set numdgt=17
op
print v(1) v(2) v(3) v(4) v(5) v(6) v(7) v(8) v(9) v(10)
print v(11) v(12) v(13) v(14) v(15) v(16) v(17) v(18) v(19) v(20)
print v(21) v(22) v(23)
print i(vs0) i(vs1) i(vs2) i(vs3) i(vs4) i(vs5) i(vs6) i(vs7) i(vs8) i(vs9)
print i(vs10) i(vs11) i(vs12) i(vs13) i(vs14) i(vs15) i(vs16) i(vs17) i(vs18) i(vs19)
print i(vs20) i(vs21) i(vs22) i(vs23)
.endc
.end
