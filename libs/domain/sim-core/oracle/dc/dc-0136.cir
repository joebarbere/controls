controls oracle dc-0136
* Generated (plan F2.7, ADR 0012): do not edit; regenerate with `pnpm sim oracle regen`. dc seed 20261030 index 136 nodes 11 elements 19
.options sparse gmin=1e-12 noopac
RG1 1 0 1000000000000
RG2 2 0 1000000000000
RG3 3 0 1000000000000
RG4 4 0 1000000000000
RG5 5 0 1000000000000
RG6 6 0 1000000000000
RG7 7 0 1000000000000
RG8 8 0 1000000000000
RG9 9 0 1000000000000
RG10 10 0 1000000000000
VS0 0 s0 0
V0 e0 s0 DC 39e-1
RI0 e0 9 22e-1
VS1 8 s1 0
R1 s1 6 33e3
VS2 9 s2 0
I2 s2 8 DC 15e-4
VS3 3 s3 0
R3 s3 7 33e3
VS4 1 s4 0
V4 e4 s4 DC 82e-1
RI4 e4 0 10e-3
VS5 8 s5 0
R5 s5 7 82e-2
VS6 10 s6 0
I6 s6 7 DC 39e-3
VS7 0 s7 0
I7 s7 5 DC 12e-3
VS8 4 s8 0
I8 s8 9 DC 27e-3
VS9 1 s9 0
R9 s9 10 68e-1
VS10 5 s10 0
R10 s10 2 12e0
VS11 5 s11 0
R11 s11 4 56e3
VS12 9 s12 0
V12 e12 s12 DC 10e1
RI12 e12 8 18e-3
VS13 2 s13 0
R13 s13 8 82e2
VS14 3 s14 0
R14 s14 2 33e1
VS15 4 s15 0
R15 s15 0 18e3
VS16 6 s16 0
R16 s16 10 22e0
VS17 6 s17 0
R17 s17 3 12e0
VS18 10 s18 0
R18 s18 1 22e-2
.control
set numdgt=17
op
print v(1) v(2) v(3) v(4) v(5) v(6) v(7) v(8) v(9) v(10)
print i(vs0) i(vs1) i(vs2) i(vs3) i(vs4) i(vs5) i(vs6) i(vs7) i(vs8) i(vs9)
print i(vs10) i(vs11) i(vs12) i(vs13) i(vs14) i(vs15) i(vs16) i(vs17) i(vs18)
.endc
.end
