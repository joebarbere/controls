controls oracle dc-0031
* Generated (plan F2.7, ADR 0012): do not edit; regenerate with `pnpm sim oracle regen`. dc seed 20261030 index 31 nodes 2 elements 3
.options sparse gmin=1e-12 noopac
RG1 1 0 1000000000000
VS0 0 s0 0
V0 e0 s0 DC 56e-1
RI0 e0 1 15e-2
VS1 0 s1 0
I1 s1 1 DC 15e-1
VS2 0 s2 0
R2 s2 1 15e1
.control
set numdgt=17
op
print v(1)
print i(vs0) i(vs1) i(vs2)
.endc
.end
