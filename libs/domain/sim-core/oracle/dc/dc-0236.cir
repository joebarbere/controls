controls oracle dc-0236
* Generated (plan F2.7, ADR 0012): do not edit; regenerate with `pnpm sim oracle regen`. dc seed 20261030 index 236 nodes 19 elements 38
.options sparse gmin=1e-12 noopac
RG1 1 0 1000000000000
RG2 2 0 1000000000000
RG3 3 0 1000000000000
RG4 4 0 1000000000000
RG5 5 0 1000000000000
RG6 6 0 1000000000000
RG7 7 0 1000000000000
RG8 8 0 1000000000000
RG9 9 0 1000000000000
RG10 10 0 1000000000000
RG11 11 0 1000000000000
RG12 12 0 1000000000000
RG13 13 0 1000000000000
RG14 14 0 1000000000000
RG15 15 0 1000000000000
RG16 16 0 1000000000000
RG17 17 0 1000000000000
RG18 18 0 1000000000000
VS0 1 s0 0
R0 s0 11 12e1
VS1 1 s1 0
R1 s1 7 12e-1
VS2 13 s2 0
R2 s2 10 82e2
VS3 11 s3 0
R3 s3 18 18e2
VS4 0 s4 0
V4 e4 s4 DC 12e0
RI4 e4 15 22e-3
VS5 9 s5 0
R5 s5 14 39e3
VS6 5 s6 0
R6 s6 8 12e-2
VS7 18 s7 0
R7 s7 17 10e-2
VS8 5 s8 0
R8 s8 7 82e2
VS9 18 s9 0
R9 s9 11 56e-2
VS10 15 s10 0
R10 s10 16 47e-1
VS11 4 s11 0
R11 s11 17 15e3
VS12 11 s12 0
I12 s12 5 DC 47e-4
VS13 14 s13 0
R13 s13 18 12e-1
VS14 7 s14 0
I14 s14 9 DC 82e-3
VS15 5 s15 0
V15 e15 s15 DC 33e-1
RI15 e15 13 27e-3
VS16 10 s16 0
R16 s16 5 22e1
VS17 7 s17 0
R17 s17 3 10e2
VS18 14 s18 0
V18 e18 s18 DC 33e1
RI18 e18 0 68e-3
VS19 9 s19 0
V19 e19 s19 DC 15e1
RI19 e19 2 39e-1
VS20 3 s20 0
R20 s20 1 47e-2
VS21 12 s21 0
R21 s21 13 68e1
VS22 4 s22 0
R22 s22 5 47e-2
VS23 5 s23 0
R23 s23 18 39e3
VS24 8 s24 0
R24 s24 13 56e-1
VS25 10 s25 0
I25 s25 5 DC 12e-3
VS26 0 s26 0
R26 s26 18 68e1
VS27 2 s27 0
R27 s27 1 15e0
VS28 5 s28 0
R28 s28 0 68e1
VS29 8 s29 0
I29 s29 9 DC 33e-1
VS30 6 s30 0
V30 e30 s30 DC 33e0
RI30 e30 16 47e-3
VS31 11 s31 0
I31 s31 5 DC 12e-4
VS32 17 s32 0
R32 s32 18 47e0
VS33 8 s33 0
R33 s33 9 10e2
VS34 3 s34 0
R34 s34 12 68e0
VS35 18 s35 0
R35 s35 6 10e2
VS36 2 s36 0
R36 s36 0 27e1
VS37 5 s37 0
R37 s37 6 10e-2
.control
set numdgt=17
op
print v(1) v(2) v(3) v(4) v(5) v(6) v(7) v(8) v(9) v(10)
print v(11) v(12) v(13) v(14) v(15) v(16) v(17) v(18)
print i(vs0) i(vs1) i(vs2) i(vs3) i(vs4) i(vs5) i(vs6) i(vs7) i(vs8) i(vs9)
print i(vs10) i(vs11) i(vs12) i(vs13) i(vs14) i(vs15) i(vs16) i(vs17) i(vs18) i(vs19)
print i(vs20) i(vs21) i(vs22) i(vs23) i(vs24) i(vs25) i(vs26) i(vs27) i(vs28) i(vs29)
print i(vs30) i(vs31) i(vs32) i(vs33) i(vs34) i(vs35) i(vs36) i(vs37)
.endc
.end
