controls oracle dc-0236
* Generated (plan F2.7, ADR 0012): do not edit; regenerate with `pnpm sim oracle regen`. dc seed 20261030 index 236 nodes 19 elements 35
.options sparse gmin=1e-12 noopac
RG1 1 0 1000000000000
RG2 2 0 1000000000000
RG3 3 0 1000000000000
RG4 4 0 1000000000000
RG5 5 0 1000000000000
RG6 6 0 1000000000000
RG7 7 0 1000000000000
RG8 8 0 1000000000000
RG9 9 0 1000000000000
RG10 10 0 1000000000000
RG11 11 0 1000000000000
RG12 12 0 1000000000000
RG13 13 0 1000000000000
RG14 14 0 1000000000000
RG15 15 0 1000000000000
RG16 16 0 1000000000000
RG17 17 0 1000000000000
RG18 18 0 1000000000000
VS0 2 s0 0
R0 s0 5 27e1
VS1 10 s1 0
I1 s1 14 DC 12e-3
VS2 2 s2 0
R2 s2 1 15e0
VS3 5 s3 0
R3 s3 18 68e1
VS4 14 s4 0
R4 s4 18 39e3
VS5 14 s5 0
R5 s5 8 12e-2
VS6 7 s6 0
I6 s6 9 DC 82e-3
VS7 8 s7 0
R7 s7 9 10e2
VS8 3 s8 0
R8 s8 12 68e0
VS9 14 s9 0
R9 s9 7 82e2
VS10 0 s10 0
V10 e10 s10 DC 33e1
RI10 e10 5 68e-3
VS11 18 s11 0
R11 s11 17 10e-2
VS12 17 s12 0
R12 s12 18 47e0
VS13 15 s13 0
R13 s13 16 47e-1
VS14 5 s14 0
V14 e14 s14 DC 12e0
RI14 e14 15 22e-3
VS15 14 s15 0
V15 e15 s15 DC 33e-1
RI15 e15 13 27e-3
VS16 6 s16 0
V16 e16 s16 DC 33e0
RI16 e16 16 47e-3
VS17 11 s17 0
R17 s17 18 18e2
VS18 11 s18 0
I18 s18 14 DC 12e-4
VS19 8 s19 0
I19 s19 9 DC 33e-1
VS20 4 s20 0
R20 s20 14 47e-2
VS21 14 s21 0
R21 s21 5 68e1
VS22 7 s22 0
R22 s22 3 10e2
VS23 9 s23 0
V23 e23 s23 DC 15e1
RI23 e23 2 39e-1
VS24 12 s24 0
R24 s24 13 68e1
VS25 14 s25 0
R25 s25 6 10e-2
VS26 11 s26 0
I26 s26 14 DC 47e-4
VS27 18 s27 0
R27 s27 6 10e2
VS28 3 s28 0
R28 s28 1 47e-2
VS29 18 s29 0
R29 s29 11 56e-2
VS30 1 s30 0
R30 s30 7 12e-1
VS31 10 s31 0
R31 s31 14 22e1
VS32 0 s32 0
R32 s32 18 12e-1
VS33 8 s33 0
R33 s33 13 56e-1
VS34 9 s34 0
R34 s34 0 39e3
.control
set numdgt=17
op
print v(1) v(2) v(3) v(4) v(5) v(6) v(7) v(8) v(9) v(10)
print v(11) v(12) v(13) v(14) v(15) v(16) v(17) v(18)
print i(vs0) i(vs1) i(vs2) i(vs3) i(vs4) i(vs5) i(vs6) i(vs7) i(vs8) i(vs9)
print i(vs10) i(vs11) i(vs12) i(vs13) i(vs14) i(vs15) i(vs16) i(vs17) i(vs18) i(vs19)
print i(vs20) i(vs21) i(vs22) i(vs23) i(vs24) i(vs25) i(vs26) i(vs27) i(vs28) i(vs29)
print i(vs30) i(vs31) i(vs32) i(vs33) i(vs34)
.endc
.end
