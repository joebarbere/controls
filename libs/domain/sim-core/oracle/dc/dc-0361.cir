controls oracle dc-0361
* Generated (plan F2.7, ADR 0012): do not edit; regenerate with `pnpm sim oracle regen`. dc seed 20261030 index 361 nodes 20 elements 27
.options sparse gmin=1e-12 noopac
RG1 1 0 1000000000000
RG2 2 0 1000000000000
RG3 3 0 1000000000000
RG4 4 0 1000000000000
RG5 5 0 1000000000000
RG6 6 0 1000000000000
RG7 7 0 1000000000000
RG8 8 0 1000000000000
RG9 9 0 1000000000000
RG10 10 0 1000000000000
RG11 11 0 1000000000000
RG12 12 0 1000000000000
RG13 13 0 1000000000000
RG14 14 0 1000000000000
RG15 15 0 1000000000000
RG16 16 0 1000000000000
RG17 17 0 1000000000000
RG18 18 0 1000000000000
RG19 19 0 1000000000000
VS0 1 s0 0
R0 s0 2 39e-2
VS1 16 s1 0
R1 s1 4 15e2
VS2 9 s2 0
R2 s2 7 33e-2
VS3 19 s3 0
R3 s3 1 33e3
VS4 13 s4 0
R4 s4 2 22e-2
VS5 18 s5 0
R5 s5 16 56e-1
VS6 4 s6 0
R6 s6 14 68e-2
VS7 10 s7 0
R7 s7 14 39e1
VS8 0 s8 0
V8 e8 s8 DC 15e1
RI8 e8 8 56e-1
VS9 13 s9 0
V9 e9 s9 DC 12e-1
RI9 e9 5 22e-3
VS10 5 s10 0
V10 e10 s10 DC 10e1
RI10 e10 10 39e-1
VS11 12 s11 0
V11 e11 s11 DC 15e1
RI11 e11 1 39e-1
VS12 7 s12 0
R12 s12 17 47e2
VS13 3 s13 0
R13 s13 15 39e1
VS14 6 s14 0
R14 s14 16 33e1
VS15 19 s15 0
R15 s15 15 33e-1
VS16 12 s16 0
R16 s16 0 15e3
VS17 2 s17 0
R17 s17 7 68e0
VS18 6 s18 0
R18 s18 18 68e-2
VS19 1 s19 0
R19 s19 11 82e1
VS20 16 s20 0
R20 s20 19 39e1
VS21 9 s21 0
R21 s21 16 82e-2
VS22 17 s22 0
R22 s22 8 12e3
VS23 11 s23 0
R23 s23 12 18e0
VS24 3 s24 0
R24 s24 5 12e-1
VS25 18 s25 0
R25 s25 8 68e1
VS26 19 s26 0
R26 s26 5 27e3
.control
set numdgt=17
op
print v(1) v(2) v(3) v(4) v(5) v(6) v(7) v(8) v(9) v(10)
print v(11) v(12) v(13) v(14) v(15) v(16) v(17) v(18) v(19)
print i(vs0) i(vs1) i(vs2) i(vs3) i(vs4) i(vs5) i(vs6) i(vs7) i(vs8) i(vs9)
print i(vs10) i(vs11) i(vs12) i(vs13) i(vs14) i(vs15) i(vs16) i(vs17) i(vs18) i(vs19)
print i(vs20) i(vs21) i(vs22) i(vs23) i(vs24) i(vs25) i(vs26)
.endc
.end
