controls oracle dc-0361
* Generated (plan F2.7, ADR 0012): do not edit; regenerate with `pnpm sim oracle regen`. dc seed 20261030 index 361 nodes 20 elements 21
.options sparse gmin=1e-12 noopac
RG1 1 0 1000000000000
RG2 2 0 1000000000000
RG3 3 0 1000000000000
RG4 4 0 1000000000000
RG5 5 0 1000000000000
RG6 6 0 1000000000000
RG7 7 0 1000000000000
RG8 8 0 1000000000000
RG9 9 0 1000000000000
RG10 10 0 1000000000000
RG11 11 0 1000000000000
RG12 12 0 1000000000000
RG13 13 0 1000000000000
RG14 14 0 1000000000000
RG15 15 0 1000000000000
RG16 16 0 1000000000000
RG17 17 0 1000000000000
RG18 18 0 1000000000000
RG19 19 0 1000000000000
VS0 0 s0 0
V0 e0 s0 DC 10e1
RI0 e0 10 39e-1
VS1 19 s1 0
R1 s1 15 33e-1
VS2 11 s2 0
R2 s2 12 18e0
VS3 1 s3 0
R3 s3 2 39e-2
VS4 6 s4 0
R4 s4 18 68e-2
VS5 5 s5 0
V5 e5 s5 DC 15e1
RI5 e5 8 56e-1
VS6 1 s6 0
R6 s6 11 82e1
VS7 3 s7 0
R7 s7 15 39e1
VS8 12 s8 0
V8 e8 s8 DC 15e1
RI8 e8 1 39e-1
VS9 9 s9 0
R9 s9 7 33e-2
VS10 13 s10 0
V10 e10 s10 DC 12e-1
RI10 e10 0 22e-3
VS11 19 s11 0
R11 s11 0 27e3
VS12 18 s12 0
R12 s12 8 68e1
VS13 7 s13 0
R13 s13 17 47e2
VS14 2 s14 0
R14 s14 7 68e0
VS15 10 s15 0
R15 s15 14 39e1
VS16 16 s16 0
R16 s16 19 39e1
VS17 19 s17 0
R17 s17 1 33e3
VS18 18 s18 0
R18 s18 16 56e-1
VS19 4 s19 0
R19 s19 14 68e-2
VS20 13 s20 0
R20 s20 2 22e-2
.control
set numdgt=17
op
print v(1) v(2) v(3) v(4) v(5) v(6) v(7) v(8) v(9) v(10)
print v(11) v(12) v(13) v(14) v(15) v(16) v(17) v(18) v(19)
print i(vs0) i(vs1) i(vs2) i(vs3) i(vs4) i(vs5) i(vs6) i(vs7) i(vs8) i(vs9)
print i(vs10) i(vs11) i(vs12) i(vs13) i(vs14) i(vs15) i(vs16) i(vs17) i(vs18) i(vs19)
print i(vs20)
.endc
.end
