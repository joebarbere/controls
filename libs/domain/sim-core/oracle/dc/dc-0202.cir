controls oracle dc-0202
* Generated (plan F2.7, ADR 0012): do not edit; regenerate with `pnpm sim oracle regen`. dc seed 20261030 index 202 nodes 9 elements 12
.options sparse gmin=1e-12 noopac
RG1 1 0 1000000000000
RG2 2 0 1000000000000
RG3 3 0 1000000000000
RG4 4 0 1000000000000
RG5 5 0 1000000000000
RG6 6 0 1000000000000
RG7 7 0 1000000000000
RG8 8 0 1000000000000
VS0 7 s0 0
I0 s0 0 DC 12e-1
VS1 0 s1 0
V1 e1 s1 DC 27e-1
RI1 e1 2 12e-3
VS2 8 s2 0
R2 s2 6 27e-2
VS3 4 s3 0
R3 s3 8 68e0
VS4 8 s4 0
R4 s4 3 18e2
VS5 3 s5 0
R5 s5 2 39e-2
VS6 1 s6 0
R6 s6 8 56e-2
VS7 5 s7 0
R7 s7 2 82e-2
VS8 6 s8 0
R8 s8 7 47e1
VS9 0 s9 0
R9 s9 7 18e0
VS10 8 s10 0
R10 s10 5 56e0
VS11 1 s11 0
R11 s11 5 18e-1
.control
set numdgt=17
op
print v(1) v(2) v(3) v(4) v(5) v(6) v(7) v(8)
print i(vs0) i(vs1) i(vs2) i(vs3) i(vs4) i(vs5) i(vs6) i(vs7) i(vs8) i(vs9)
print i(vs10) i(vs11)
.endc
.end
