controls oracle dc-0068
* Generated (plan F2.7, ADR 0012): do not edit; regenerate with `pnpm sim oracle regen`. dc seed 20261030 index 68 nodes 29 elements 62
.options sparse gmin=1e-12 noopac
RG1 1 0 1000000000000
RG2 2 0 1000000000000
RG3 3 0 1000000000000
RG4 4 0 1000000000000
RG5 5 0 1000000000000
RG6 6 0 1000000000000
RG7 7 0 1000000000000
RG8 8 0 1000000000000
RG9 9 0 1000000000000
RG10 10 0 1000000000000
RG11 11 0 1000000000000
RG12 12 0 1000000000000
RG13 13 0 1000000000000
RG14 14 0 1000000000000
RG15 15 0 1000000000000
RG16 16 0 1000000000000
RG17 17 0 1000000000000
RG18 18 0 1000000000000
RG19 19 0 1000000000000
RG20 20 0 1000000000000
RG21 21 0 1000000000000
RG22 22 0 1000000000000
RG23 23 0 1000000000000
RG24 24 0 1000000000000
RG25 25 0 1000000000000
RG26 26 0 1000000000000
RG27 27 0 1000000000000
RG28 28 0 1000000000000
VS0 8 s0 0
R0 s0 23 47e2
VS1 22 s1 0
R1 s1 5 12e0
VS2 0 s2 0
V2 e2 s2 DC 82e1
RI2 e2 1 22e-1
VS3 19 s3 0
V3 e3 s3 DC 27e-1
RI3 e3 23 10e-3
VS4 16 s4 0
R4 s4 9 27e2
VS5 15 s5 0
R5 s5 6 15e0
VS6 22 s6 0
R6 s6 25 15e1
VS7 24 s7 0
I7 s7 8 DC 22e-1
VS8 1 s8 0
R8 s8 14 39e1
VS9 14 s9 0
R9 s9 22 33e3
VS10 7 s10 0
V10 e10 s10 DC 33e1
RI10 e10 16 18e-1
VS11 26 s11 0
R11 s11 24 33e2
VS12 3 s12 0
R12 s12 0 82e-1
VS13 22 s13 0
R13 s13 0 12e3
VS14 21 s14 0
I14 s14 19 DC 15e-1
VS15 17 s15 0
R15 s15 3 10e2
VS16 28 s16 0
R16 s16 23 82e3
VS17 21 s17 0
R17 s17 2 68e2
VS18 4 s18 0
R18 s18 27 18e1
VS19 21 s19 0
V19 e19 s19 DC 33e-1
RI19 e19 14 15e-2
VS20 16 s20 0
R20 s20 25 33e0
VS21 0 s21 0
R21 s21 28 47e1
VS22 4 s22 0
R22 s22 18 56e0
VS23 27 s23 0
I23 s23 19 DC 15e-1
VS24 7 s24 0
I24 s24 26 DC 82e-2
VS25 23 s25 0
R25 s25 5 56e-1
VS26 6 s26 0
I26 s26 11 DC 15e-4
VS27 9 s27 0
R27 s27 2 39e-2
VS28 12 s28 0
R28 s28 9 15e2
VS29 18 s29 0
I29 s29 5 DC 56e-4
VS30 10 s30 0
V30 e30 s30 DC 10e1
RI30 e30 2 22e-2
VS31 8 s31 0
R31 s31 25 15e3
VS32 14 s32 0
V32 e32 s32 DC 56e0
RI32 e32 6 39e-3
VS33 1 s33 0
I33 s33 23 DC 15e-2
VS34 28 s34 0
I34 s34 7 DC 68e-4
VS35 17 s35 0
R35 s35 14 15e1
VS36 6 s36 0
R36 s36 10 18e1
VS37 27 s37 0
R37 s37 8 47e-2
VS38 19 s38 0
V38 e38 s38 DC 18e-1
RI38 e38 11 12e-1
VS39 7 s39 0
R39 s39 4 27e-2
VS40 20 s40 0
R40 s40 15 27e3
VS41 27 s41 0
R41 s41 11 18e2
VS42 24 s42 0
R42 s42 7 10e1
VS43 7 s43 0
R43 s43 12 18e3
VS44 3 s44 0
I44 s44 16 DC 15e-3
VS45 22 s45 0
R45 s45 6 47e3
VS46 12 s46 0
V46 e46 s46 DC 82e-1
RI46 e46 7 56e-2
VS47 14 s47 0
V47 e47 s47 DC 12e1
RI47 e47 20 18e-3
VS48 21 s48 0
R48 s48 11 68e2
VS49 16 s49 0
R49 s49 25 15e0
VS50 13 s50 0
V50 e50 s50 DC 15e0
RI50 e50 2 56e-2
VS51 4 s51 0
I51 s51 12 DC 18e-2
VS52 7 s52 0
R52 s52 3 68e3
VS53 26 s53 0
R53 s53 13 22e0
VS54 6 s54 0
V54 e54 s54 DC 56e1
RI54 e54 8 39e-3
VS55 18 s55 0
V55 e55 s55 DC 56e-1
RI55 e55 8 10e-2
VS56 10 s56 0
I56 s56 22 DC 47e-1
VS57 25 s57 0
R57 s57 27 56e2
VS58 3 s58 0
R58 s58 23 10e-2
VS59 20 s59 0
I59 s59 9 DC 27e-4
VS60 0 s60 0
R60 s60 6 12e-1
VS61 9 s61 0
I61 s61 25 DC 27e-1
.control
set numdgt=17
op
print v(1) v(2) v(3) v(4) v(5) v(6) v(7) v(8) v(9) v(10)
print v(11) v(12) v(13) v(14) v(15) v(16) v(17) v(18) v(19) v(20)
print v(21) v(22) v(23) v(24) v(25) v(26) v(27) v(28)
print i(vs0) i(vs1) i(vs2) i(vs3) i(vs4) i(vs5) i(vs6) i(vs7) i(vs8) i(vs9)
print i(vs10) i(vs11) i(vs12) i(vs13) i(vs14) i(vs15) i(vs16) i(vs17) i(vs18) i(vs19)
print i(vs20) i(vs21) i(vs22) i(vs23) i(vs24) i(vs25) i(vs26) i(vs27) i(vs28) i(vs29)
print i(vs30) i(vs31) i(vs32) i(vs33) i(vs34) i(vs35) i(vs36) i(vs37) i(vs38) i(vs39)
print i(vs40) i(vs41) i(vs42) i(vs43) i(vs44) i(vs45) i(vs46) i(vs47) i(vs48) i(vs49)
print i(vs50) i(vs51) i(vs52) i(vs53) i(vs54) i(vs55) i(vs56) i(vs57) i(vs58) i(vs59)
print i(vs60) i(vs61)
.endc
.end
