controls oracle dc-0068
* Generated (plan F2.7, ADR 0012): do not edit; regenerate with `pnpm sim oracle regen`. dc seed 20261030 index 68 nodes 29 elements 55
.options sparse gmin=1e-12 noopac
RG1 1 0 1000000000000
RG2 2 0 1000000000000
RG3 3 0 1000000000000
RG4 4 0 1000000000000
RG5 5 0 1000000000000
RG6 6 0 1000000000000
RG7 7 0 1000000000000
RG8 8 0 1000000000000
RG9 9 0 1000000000000
RG10 10 0 1000000000000
RG11 11 0 1000000000000
RG12 12 0 1000000000000
RG13 13 0 1000000000000
RG14 14 0 1000000000000
RG15 15 0 1000000000000
RG16 16 0 1000000000000
RG17 17 0 1000000000000
RG18 18 0 1000000000000
RG19 19 0 1000000000000
RG20 20 0 1000000000000
RG21 21 0 1000000000000
RG22 22 0 1000000000000
RG23 23 0 1000000000000
RG24 24 0 1000000000000
RG25 25 0 1000000000000
RG26 26 0 1000000000000
RG27 27 0 1000000000000
RG28 28 0 1000000000000
VS0 27 s0 0
R0 s0 11 18e2
VS1 9 s1 0
R1 s1 2 39e-2
VS2 6 s2 0
R2 s2 0 12e-1
VS3 22 s3 0
R3 s3 0 47e3
VS4 7 s4 0
R4 s4 12 18e3
VS5 20 s5 0
R5 s5 15 27e3
VS6 10 s6 0
I6 s6 22 DC 47e-1
VS7 9 s7 0
I7 s7 25 DC 27e-1
VS8 21 s8 0
R8 s8 2 68e2
VS9 24 s9 0
I9 s9 8 DC 22e-1
VS10 18 s10 0
I10 s10 5 DC 56e-4
VS11 8 s11 0
R11 s11 23 47e2
VS12 7 s12 0
I12 s12 26 DC 82e-2
VS13 3 s13 0
R13 s13 23 10e-2
VS14 0 s14 0
V14 e14 s14 DC 56e1
RI14 e14 8 39e-3
VS15 19 s15 0
V15 e15 s15 DC 27e-1
RI15 e15 23 10e-3
VS16 7 s16 0
V16 e16 s16 DC 33e1
RI16 e16 16 18e-1
VS17 12 s17 0
V17 e17 s17 DC 82e-1
RI17 e17 7 56e-2
VS18 7 s18 0
R18 s18 3 68e3
VS19 22 s19 0
R19 s19 25 15e1
VS20 27 s20 0
R20 s20 8 47e-2
VS21 21 s21 0
R21 s21 11 68e2
VS22 6 s22 0
V22 e22 s22 DC 82e1
RI22 e22 1 22e-1
VS23 25 s23 0
R23 s23 27 56e2
VS24 10 s24 0
V24 e24 s24 DC 10e1
RI24 e24 2 22e-2
VS25 21 s25 0
V25 e25 s25 DC 33e-1
RI25 e25 14 15e-2
VS26 3 s26 0
R26 s26 6 82e-1
VS27 21 s27 0
I27 s27 19 DC 15e-1
VS28 27 s28 0
I28 s28 19 DC 15e-1
VS29 4 s29 0
R29 s29 18 56e0
VS30 16 s30 0
R30 s30 25 33e0
VS31 24 s31 0
R31 s31 7 10e1
VS32 26 s32 0
R32 s32 13 22e0
VS33 16 s33 0
R33 s33 25 15e0
VS34 14 s34 0
R34 s34 22 33e3
VS35 28 s35 0
I35 s35 7 DC 68e-4
VS36 23 s36 0
R36 s36 5 56e-1
VS37 6 s37 0
R37 s37 28 47e1
VS38 14 s38 0
V38 e38 s38 DC 56e0
RI38 e38 0 39e-3
VS39 8 s39 0
R39 s39 25 15e3
VS40 4 s40 0
I40 s40 12 DC 18e-2
VS41 3 s41 0
I41 s41 16 DC 15e-3
VS42 0 s42 0
I42 s42 11 DC 15e-4
VS43 20 s43 0
I43 s43 9 DC 27e-4
VS44 1 s44 0
I44 s44 23 DC 15e-2
VS45 28 s45 0
R45 s45 23 82e3
VS46 14 s46 0
V46 e46 s46 DC 12e1
RI46 e46 20 18e-3
VS47 18 s47 0
V47 e47 s47 DC 56e-1
RI47 e47 8 10e-2
VS48 16 s48 0
R48 s48 9 27e2
VS49 13 s49 0
V49 e49 s49 DC 15e0
RI49 e49 2 56e-2
VS50 17 s50 0
R50 s50 3 10e2
VS51 4 s51 0
R51 s51 27 18e1
VS52 22 s52 0
R52 s52 6 12e3
VS53 17 s53 0
R53 s53 14 15e1
VS54 7 s54 0
R54 s54 4 27e-2
.control
set numdgt=17
op
print v(1) v(2) v(3) v(4) v(5) v(6) v(7) v(8) v(9) v(10)
print v(11) v(12) v(13) v(14) v(15) v(16) v(17) v(18) v(19) v(20)
print v(21) v(22) v(23) v(24) v(25) v(26) v(27) v(28)
print i(vs0) i(vs1) i(vs2) i(vs3) i(vs4) i(vs5) i(vs6) i(vs7) i(vs8) i(vs9)
print i(vs10) i(vs11) i(vs12) i(vs13) i(vs14) i(vs15) i(vs16) i(vs17) i(vs18) i(vs19)
print i(vs20) i(vs21) i(vs22) i(vs23) i(vs24) i(vs25) i(vs26) i(vs27) i(vs28) i(vs29)
print i(vs30) i(vs31) i(vs32) i(vs33) i(vs34) i(vs35) i(vs36) i(vs37) i(vs38) i(vs39)
print i(vs40) i(vs41) i(vs42) i(vs43) i(vs44) i(vs45) i(vs46) i(vs47) i(vs48) i(vs49)
print i(vs50) i(vs51) i(vs52) i(vs53) i(vs54)
.endc
.end
