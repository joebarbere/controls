controls oracle dc-0005
* Generated (plan F2.7, ADR 0012): do not edit; regenerate with `pnpm sim oracle regen`. dc seed 20261030 index 5 nodes 20 elements 33
.options sparse gmin=1e-12 noopac
RG1 1 0 1000000000000
RG2 2 0 1000000000000
RG3 3 0 1000000000000
RG4 4 0 1000000000000
RG5 5 0 1000000000000
RG6 6 0 1000000000000
RG7 7 0 1000000000000
RG8 8 0 1000000000000
RG9 9 0 1000000000000
RG10 10 0 1000000000000
RG11 11 0 1000000000000
RG12 12 0 1000000000000
RG13 13 0 1000000000000
RG14 14 0 1000000000000
RG15 15 0 1000000000000
RG16 16 0 1000000000000
RG17 17 0 1000000000000
RG18 18 0 1000000000000
RG19 19 0 1000000000000
VS0 0 s0 0
V0 e0 s0 DC 56e0
RI0 e0 5 47e-3
VS1 18 s1 0
R1 s1 3 39e3
VS2 1 s2 0
R2 s2 10 27e0
VS3 15 s3 0
R3 s3 13 68e-2
VS4 6 s4 0
R4 s4 5 56e-2
VS5 16 s5 0
R5 s5 19 68e1
VS6 17 s6 0
R6 s6 5 15e3
VS7 11 s7 0
R7 s7 10 22e0
VS8 3 s8 0
R8 s8 16 33e-2
VS9 7 s9 0
R9 s9 8 39e3
VS10 3 s10 0
R10 s10 8 56e-1
VS11 6 s11 0
R11 s11 9 82e2
VS12 18 s12 0
R12 s12 1 68e-2
VS13 5 s13 0
R13 s13 7 82e2
VS14 14 s14 0
R14 s14 19 18e1
VS15 19 s15 0
R15 s15 7 33e2
VS16 15 s16 0
I16 s16 4 DC 68e-4
VS17 18 s17 0
I17 s17 5 DC 27e-1
VS18 16 s18 0
R18 s18 2 15e-2
VS19 6 s19 0
V19 e19 s19 DC 18e-1
RI19 e19 0 56e-2
VS20 18 s20 0
R20 s20 6 47e2
VS21 13 s21 0
R21 s21 6 22e0
VS22 5 s22 0
V22 e22 s22 DC 22e-1
RI22 e22 9 82e-1
VS23 15 s23 0
R23 s23 19 56e1
VS24 4 s24 0
R24 s24 5 47e-2
VS25 11 s25 0
R25 s25 17 18e-2
VS26 18 s26 0
R26 s26 4 12e-1
VS27 10 s27 0
R27 s27 13 10e-1
VS28 2 s28 0
I28 s28 18 DC 15e-1
VS29 12 s29 0
V29 e29 s29 DC 18e0
RI29 e29 10 27e-1
VS30 1 s30 0
V30 e30 s30 DC 68e0
RI30 e30 18 18e-3
VS31 2 s31 0
R31 s31 6 10e-1
VS32 12 s32 0
R32 s32 14 39e2
.control
set numdgt=17
op
print v(1) v(2) v(3) v(4) v(5) v(6) v(7) v(8) v(9) v(10)
print v(11) v(12) v(13) v(14) v(15) v(16) v(17) v(18) v(19)
print i(vs0) i(vs1) i(vs2) i(vs3) i(vs4) i(vs5) i(vs6) i(vs7) i(vs8) i(vs9)
print i(vs10) i(vs11) i(vs12) i(vs13) i(vs14) i(vs15) i(vs16) i(vs17) i(vs18) i(vs19)
print i(vs20) i(vs21) i(vs22) i(vs23) i(vs24) i(vs25) i(vs26) i(vs27) i(vs28) i(vs29)
print i(vs30) i(vs31) i(vs32)
.endc
.end
