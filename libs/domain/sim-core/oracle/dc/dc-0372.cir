controls oracle dc-0372
* Generated (plan F2.7, ADR 0012): do not edit; regenerate with `pnpm sim oracle regen`. dc seed 20261030 index 372 nodes 20 elements 35
.options sparse gmin=1e-12 noopac
RG1 1 0 1000000000000
RG2 2 0 1000000000000
RG3 3 0 1000000000000
RG4 4 0 1000000000000
RG5 5 0 1000000000000
RG6 6 0 1000000000000
RG7 7 0 1000000000000
RG8 8 0 1000000000000
RG9 9 0 1000000000000
RG10 10 0 1000000000000
RG11 11 0 1000000000000
RG12 12 0 1000000000000
RG13 13 0 1000000000000
RG14 14 0 1000000000000
RG15 15 0 1000000000000
RG16 16 0 1000000000000
RG17 17 0 1000000000000
RG18 18 0 1000000000000
RG19 19 0 1000000000000
VS0 12 s0 0
R0 s0 15 10e0
VS1 8 s1 0
R1 s1 13 12e-2
VS2 9 s2 0
R2 s2 7 68e3
VS3 5 s3 0
R3 s3 2 47e1
VS4 0 s4 0
R4 s4 4 39e0
VS5 10 s5 0
R5 s5 9 22e0
VS6 5 s6 0
R6 s6 8 47e1
VS7 0 s7 0
V7 e7 s7 DC 27e-1
RI7 e7 8 27e-1
VS8 19 s8 0
R8 s8 13 68e0
VS9 3 s9 0
I9 s9 19 DC 68e-1
VS10 12 s10 0
V10 e10 s10 DC 22e-1
RI10 e10 17 68e-2
VS11 10 s11 0
R11 s11 8 22e1
VS12 5 s12 0
R12 s12 6 22e0
VS13 0 s13 0
R13 s13 16 22e1
VS14 14 s14 0
V14 e14 s14 DC 22e-1
RI14 e14 8 39e-1
VS15 11 s15 0
R15 s15 15 18e0
VS16 12 s16 0
R16 s16 18 10e-1
VS17 7 s17 0
R17 s17 5 47e3
VS18 3 s18 0
R18 s18 9 18e2
VS19 17 s19 0
R19 s19 19 82e1
VS20 6 s20 0
R20 s20 8 10e1
VS21 14 s21 0
R21 s21 13 68e0
VS22 8 s22 0
R22 s22 1 18e1
VS23 3 s23 0
V23 e23 s23 DC 27e-1
RI23 e23 8 39e-2
VS24 10 s24 0
I24 s24 4 DC 27e-3
VS25 14 s25 0
R25 s25 2 18e-2
VS26 4 s26 0
R26 s26 5 56e2
VS27 18 s27 0
R27 s27 8 68e3
VS28 11 s28 0
V28 e28 s28 DC 82e0
RI28 e28 8 18e-2
VS29 16 s29 0
I29 s29 12 DC 15e-3
VS30 12 s30 0
R30 s30 1 39e-1
VS31 14 s31 0
V31 e31 s31 DC 22e0
RI31 e31 17 18e-2
VS32 13 s32 0
R32 s32 17 27e3
VS33 11 s33 0
I33 s33 4 DC 22e-3
VS34 16 s34 0
R34 s34 13 10e2
.control
set numdgt=17
op
print v(1) v(2) v(3) v(4) v(5) v(6) v(7) v(8) v(9) v(10)
print v(11) v(12) v(13) v(14) v(15) v(16) v(17) v(18) v(19)
print i(vs0) i(vs1) i(vs2) i(vs3) i(vs4) i(vs5) i(vs6) i(vs7) i(vs8) i(vs9)
print i(vs10) i(vs11) i(vs12) i(vs13) i(vs14) i(vs15) i(vs16) i(vs17) i(vs18) i(vs19)
print i(vs20) i(vs21) i(vs22) i(vs23) i(vs24) i(vs25) i(vs26) i(vs27) i(vs28) i(vs29)
print i(vs30) i(vs31) i(vs32) i(vs33) i(vs34)
.endc
.end
