controls oracle dc-0372
* Generated (plan F2.7, ADR 0012): do not edit; regenerate with `pnpm sim oracle regen`. dc seed 20261030 index 372 nodes 20 elements 29
.options sparse gmin=1e-12 noopac
RG1 1 0 1000000000000
RG2 2 0 1000000000000
RG3 3 0 1000000000000
RG4 4 0 1000000000000
RG5 5 0 1000000000000
RG6 6 0 1000000000000
RG7 7 0 1000000000000
RG8 8 0 1000000000000
RG9 9 0 1000000000000
RG10 10 0 1000000000000
RG11 11 0 1000000000000
RG12 12 0 1000000000000
RG13 13 0 1000000000000
RG14 14 0 1000000000000
RG15 15 0 1000000000000
RG16 16 0 1000000000000
RG17 17 0 1000000000000
RG18 18 0 1000000000000
RG19 19 0 1000000000000
VS0 13 s0 0
R0 s0 14 27e3
VS1 8 s1 0
R1 s1 13 12e-2
VS2 7 s2 0
R2 s2 5 47e3
VS3 11 s3 0
R3 s3 15 18e0
VS4 12 s4 0
R4 s4 15 10e0
VS5 4 s5 0
R5 s5 5 56e2
VS6 0 s6 0
V6 e6 s6 DC 22e-1
RI6 e6 8 39e-1
VS7 17 s7 0
R7 s7 16 22e1
VS8 16 s8 0
I8 s8 12 DC 15e-3
VS9 5 s9 0
R9 s9 6 22e0
VS10 3 s10 0
R10 s10 9 18e2
VS11 10 s11 0
R11 s11 8 22e1
VS12 16 s12 0
R12 s12 13 10e2
VS13 5 s13 0
R13 s13 2 47e1
VS14 3 s14 0
I14 s14 19 DC 68e-1
VS15 12 s15 0
V15 e15 s15 DC 22e-1
RI15 e15 14 68e-2
VS16 18 s16 0
R16 s16 8 68e3
VS17 0 s17 0
R17 s17 13 68e0
VS18 17 s18 0
V18 e18 s18 DC 27e-1
RI18 e18 8 27e-1
VS19 3 s19 0
V19 e19 s19 DC 27e-1
RI19 e19 8 39e-2
VS20 10 s20 0
R20 s20 9 22e0
VS21 6 s21 0
R21 s21 8 10e1
VS22 12 s22 0
R22 s22 1 39e-1
VS23 11 s23 0
I23 s23 4 DC 22e-3
VS24 10 s24 0
I24 s24 4 DC 27e-3
VS25 19 s25 0
R25 s25 13 68e0
VS26 5 s26 0
R26 s26 8 47e1
VS27 14 s27 0
R27 s27 19 82e1
VS28 0 s28 0
V28 e28 s28 DC 22e0
RI28 e28 14 18e-2
.control
set numdgt=17
op
print v(1) v(2) v(3) v(4) v(5) v(6) v(7) v(8) v(9) v(10)
print v(11) v(12) v(13) v(14) v(15) v(16) v(17) v(18) v(19)
print i(vs0) i(vs1) i(vs2) i(vs3) i(vs4) i(vs5) i(vs6) i(vs7) i(vs8) i(vs9)
print i(vs10) i(vs11) i(vs12) i(vs13) i(vs14) i(vs15) i(vs16) i(vs17) i(vs18) i(vs19)
print i(vs20) i(vs21) i(vs22) i(vs23) i(vs24) i(vs25) i(vs26) i(vs27) i(vs28)
.endc
.end
