controls oracle dc-0447
* Generated (plan F2.7, ADR 0012): do not edit; regenerate with `pnpm sim oracle regen`. dc seed 20261030 index 447 nodes 15 elements 24
.options sparse gmin=1e-12 noopac
RG1 1 0 1000000000000
RG2 2 0 1000000000000
RG3 3 0 1000000000000
RG4 4 0 1000000000000
RG5 5 0 1000000000000
RG6 6 0 1000000000000
RG7 7 0 1000000000000
RG8 8 0 1000000000000
RG9 9 0 1000000000000
RG10 10 0 1000000000000
RG11 11 0 1000000000000
RG12 12 0 1000000000000
RG13 13 0 1000000000000
RG14 14 0 1000000000000
VS0 12 s0 0
R0 s0 3 18e3
VS1 5 s1 0
I1 s1 11 DC 56e-4
VS2 5 s2 0
R2 s2 7 47e2
VS3 4 s3 0
R3 s3 3 56e2
VS4 11 s4 0
R4 s4 7 18e2
VS5 4 s5 0
R5 s5 7 18e0
VS6 0 s6 0
V6 e6 s6 DC 15e1
RI6 e6 1 27e-3
VS7 0 s7 0
R7 s7 7 10e2
VS8 14 s8 0
R8 s8 5 39e3
VS9 14 s9 0
R9 s9 11 39e0
VS10 2 s10 0
R10 s10 8 47e0
VS11 12 s11 0
V11 e11 s11 DC 33e0
RI11 e11 0 10e-3
VS12 6 s12 0
I12 s12 9 DC 15e-1
VS13 8 s13 0
R13 s13 5 82e0
VS14 3 s14 0
V14 e14 s14 DC 12e0
RI14 e14 0 47e-1
VS15 5 s15 0
R15 s15 9 22e3
VS16 10 s16 0
R16 s16 7 27e3
VS17 2 s17 0
R17 s17 0 18e0
VS18 13 s18 0
R18 s18 10 33e3
VS19 6 s19 0
R19 s19 1 18e-1
VS20 7 s20 0
R20 s20 9 68e0
VS21 6 s21 0
R21 s21 14 82e-1
VS22 13 s22 0
V22 e22 s22 DC 18e-1
RI22 e22 6 10e-2
VS23 1 s23 0
R23 s23 3 33e3
.control
set numdgt=17
op
print v(1) v(2) v(3) v(4) v(5) v(6) v(7) v(8) v(9) v(10)
print v(11) v(12) v(13) v(14)
print i(vs0) i(vs1) i(vs2) i(vs3) i(vs4) i(vs5) i(vs6) i(vs7) i(vs8) i(vs9)
print i(vs10) i(vs11) i(vs12) i(vs13) i(vs14) i(vs15) i(vs16) i(vs17) i(vs18) i(vs19)
print i(vs20) i(vs21) i(vs22) i(vs23)
.endc
.end
