controls oracle dc-0301
* Generated (plan F2.7, ADR 0012): do not edit; regenerate with `pnpm sim oracle regen`. dc seed 20261030 index 301 nodes 5 elements 9
.options sparse gmin=1e-12 noopac
RG1 1 0 1000000000000
RG2 2 0 1000000000000
RG3 3 0 1000000000000
RG4 4 0 1000000000000
VS0 0 s0 0
V0 e0 s0 DC 15e-1
RI0 e0 1 15e-2
VS1 4 s1 0
R1 s1 1 10e-2
VS2 2 s2 0
I2 s2 3 DC 27e-3
VS3 4 s3 0
R3 s3 0 15e3
VS4 0 s4 0
V4 e4 s4 DC 47e-1
RI4 e4 3 82e-2
VS5 1 s5 0
R5 s5 0 27e0
VS6 2 s6 0
R6 s6 3 33e3
VS7 1 s7 0
R7 s7 2 27e1
VS8 0 s8 0
R8 s8 2 82e3
.control
set numdgt=17
op
print v(1) v(2) v(3) v(4)
print i(vs0) i(vs1) i(vs2) i(vs3) i(vs4) i(vs5) i(vs6) i(vs7) i(vs8)
.endc
.end
