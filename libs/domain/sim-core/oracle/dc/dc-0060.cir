controls oracle dc-0060
* Generated (plan F2.7, ADR 0012): do not edit; regenerate with `pnpm sim oracle regen`. dc seed 20261030 index 60 nodes 25 elements 36
.options sparse gmin=1e-12 noopac
RG1 1 0 1000000000000
RG2 2 0 1000000000000
RG3 3 0 1000000000000
RG4 4 0 1000000000000
RG5 5 0 1000000000000
RG6 6 0 1000000000000
RG7 7 0 1000000000000
RG8 8 0 1000000000000
RG9 9 0 1000000000000
RG10 10 0 1000000000000
RG11 11 0 1000000000000
RG12 12 0 1000000000000
RG13 13 0 1000000000000
RG14 14 0 1000000000000
RG15 15 0 1000000000000
RG16 16 0 1000000000000
RG17 17 0 1000000000000
RG18 18 0 1000000000000
RG19 19 0 1000000000000
RG20 20 0 1000000000000
RG21 21 0 1000000000000
RG22 22 0 1000000000000
RG23 23 0 1000000000000
RG24 24 0 1000000000000
VS0 16 s0 0
R0 s0 4 18e-1
VS1 9 s1 0
R1 s1 4 22e2
VS2 17 s2 0
R2 s2 8 33e1
VS3 17 s3 0
R3 s3 19 47e1
VS4 19 s4 0
R4 s4 18 68e1
VS5 4 s5 0
R5 s5 13 39e1
VS6 0 s6 0
V6 e6 s6 DC 27e0
RI6 e6 2 27e-2
VS7 12 s7 0
V7 e7 s7 DC 18e1
RI7 e7 13 22e-1
VS8 4 s8 0
R8 s8 11 12e0
VS9 23 s9 0
V9 e9 s9 DC 39e0
RI9 e9 13 33e-1
VS10 4 s10 0
R10 s10 5 27e0
VS11 16 s11 0
R11 s11 21 56e-1
VS12 14 s12 0
R12 s12 13 12e-2
VS13 0 s13 0
R13 s13 12 22e0
VS14 19 s14 0
V14 e14 s14 DC 68e0
RI14 e14 1 82e-3
VS15 6 s15 0
R15 s15 4 10e1
VS16 23 s16 0
R16 s16 0 56e-1
VS17 0 s17 0
I17 s17 20 DC 27e-4
VS18 4 s18 0
I18 s18 3 DC 56e-1
VS19 17 s19 0
V19 e19 s19 DC 27e-1
RI19 e19 0 68e-1
VS20 15 s20 0
R20 s20 24 10e1
VS21 11 s21 0
V21 e21 s21 DC 82e-1
RI21 e21 17 47e-1
VS22 0 s22 0
V22 e22 s22 DC 12e0
RI22 e22 9 56e-1
VS23 13 s23 0
R23 s23 10 12e0
VS24 3 s24 0
V24 e24 s24 DC 22e-1
RI24 e24 0 82e-3
VS25 8 s25 0
R25 s25 13 47e1
VS26 4 s26 0
R26 s26 24 10e1
VS27 20 s27 0
R27 s27 7 33e3
VS28 9 s28 0
R28 s28 13 47e-2
VS29 17 s29 0
R29 s29 20 12e1
VS30 13 s30 0
R30 s30 5 10e-2
VS31 6 s31 0
R31 s31 2 15e0
VS32 2 s32 0
R32 s32 24 56e1
VS33 2 s33 0
I33 s33 15 DC 47e-3
VS34 24 s34 0
V34 e34 s34 DC 18e0
RI34 e34 10 47e-3
VS35 0 s35 0
V35 e35 s35 DC 39e-1
RI35 e35 22 18e-1
.control
set numdgt=17
op
print v(1) v(2) v(3) v(4) v(5) v(6) v(7) v(8) v(9) v(10)
print v(11) v(12) v(13) v(14) v(15) v(16) v(17) v(18) v(19) v(20)
print v(21) v(22) v(23) v(24)
print i(vs0) i(vs1) i(vs2) i(vs3) i(vs4) i(vs5) i(vs6) i(vs7) i(vs8) i(vs9)
print i(vs10) i(vs11) i(vs12) i(vs13) i(vs14) i(vs15) i(vs16) i(vs17) i(vs18) i(vs19)
print i(vs20) i(vs21) i(vs22) i(vs23) i(vs24) i(vs25) i(vs26) i(vs27) i(vs28) i(vs29)
print i(vs30) i(vs31) i(vs32) i(vs33) i(vs34) i(vs35)
.endc
.end
