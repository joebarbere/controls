controls oracle dc-0060
* Generated (plan F2.7, ADR 0012): do not edit; regenerate with `pnpm sim oracle regen`. dc seed 20261030 index 60 nodes 25 elements 42
.options sparse gmin=1e-12 noopac
RG1 1 0 1000000000000
RG2 2 0 1000000000000
RG3 3 0 1000000000000
RG4 4 0 1000000000000
RG5 5 0 1000000000000
RG6 6 0 1000000000000
RG7 7 0 1000000000000
RG8 8 0 1000000000000
RG9 9 0 1000000000000
RG10 10 0 1000000000000
RG11 11 0 1000000000000
RG12 12 0 1000000000000
RG13 13 0 1000000000000
RG14 14 0 1000000000000
RG15 15 0 1000000000000
RG16 16 0 1000000000000
RG17 17 0 1000000000000
RG18 18 0 1000000000000
RG19 19 0 1000000000000
RG20 20 0 1000000000000
RG21 21 0 1000000000000
RG22 22 0 1000000000000
RG23 23 0 1000000000000
RG24 24 0 1000000000000
VS0 6 s0 0
R0 s0 2 15e0
VS1 0 s1 0
V1 e1 s1 DC 82e-1
RI1 e1 17 47e-1
VS2 2 s2 0
R2 s2 24 56e1
VS3 17 s3 0
R3 s3 8 33e1
VS4 11 s4 0
V4 e4 s4 DC 39e0
RI4 e4 13 33e-1
VS5 15 s5 0
R5 s5 24 10e1
VS6 23 s6 0
V6 e6 s6 DC 27e0
RI6 e6 2 27e-2
VS7 9 s7 0
V7 e7 s7 DC 82e1
RI7 e7 22 47e-1
VS8 6 s8 0
R8 s8 4 10e1
VS9 4 s9 0
R9 s9 0 12e0
VS10 3 s10 0
R10 s10 0 27e0
VS11 9 s11 0
R11 s11 13 47e-2
VS12 23 s12 0
I12 s12 20 DC 27e-4
VS13 4 s13 0
R13 s13 5 27e0
VS14 17 s14 0
R14 s14 20 12e1
VS15 17 s15 0
R15 s15 19 47e1
VS16 16 s16 0
R16 s16 4 18e-1
VS17 8 s17 0
R17 s17 13 47e1
VS18 3 s18 0
V18 e18 s18 DC 22e-1
RI18 e18 23 82e-3
VS19 4 s19 0
R19 s19 13 39e1
VS20 14 s20 0
R20 s20 1 82e-2
VS21 23 s21 0
R21 s21 12 22e0
VS22 13 s22 0
R22 s22 5 10e-2
VS23 5 s23 0
R23 s23 7 56e2
VS24 18 s24 0
R24 s24 21 39e-1
VS25 4 s25 0
I25 s25 3 DC 56e-1
VS26 14 s26 0
R26 s26 13 12e-2
VS27 13 s27 0
R27 s27 10 12e0
VS28 19 s28 0
V28 e28 s28 DC 68e0
RI28 e28 1 82e-3
VS29 20 s29 0
R29 s29 7 33e3
VS30 19 s30 0
R30 s30 18 68e1
VS31 23 s31 0
V31 e31 s31 DC 12e0
RI31 e31 9 56e-1
VS32 2 s32 0
I32 s32 15 DC 47e-3
VS33 17 s33 0
V33 e33 s33 DC 27e-1
RI33 e33 23 68e-1
VS34 4 s34 0
R34 s34 24 10e1
VS35 9 s35 0
R35 s35 4 22e2
VS36 23 s36 0
R36 s36 15 39e3
VS37 23 s37 0
V37 e37 s37 DC 39e-1
RI37 e37 22 18e-1
VS38 24 s38 0
V38 e38 s38 DC 18e0
RI38 e38 10 47e-3
VS39 12 s39 0
V39 e39 s39 DC 18e1
RI39 e39 13 22e-1
VS40 11 s40 0
R40 s40 23 56e-1
VS41 16 s41 0
R41 s41 21 56e-1
.control
set numdgt=17
op
print v(1) v(2) v(3) v(4) v(5) v(6) v(7) v(8) v(9) v(10)
print v(11) v(12) v(13) v(14) v(15) v(16) v(17) v(18) v(19) v(20)
print v(21) v(22) v(23) v(24)
print i(vs0) i(vs1) i(vs2) i(vs3) i(vs4) i(vs5) i(vs6) i(vs7) i(vs8) i(vs9)
print i(vs10) i(vs11) i(vs12) i(vs13) i(vs14) i(vs15) i(vs16) i(vs17) i(vs18) i(vs19)
print i(vs20) i(vs21) i(vs22) i(vs23) i(vs24) i(vs25) i(vs26) i(vs27) i(vs28) i(vs29)
print i(vs30) i(vs31) i(vs32) i(vs33) i(vs34) i(vs35) i(vs36) i(vs37) i(vs38) i(vs39)
print i(vs40) i(vs41)
.endc
.end
