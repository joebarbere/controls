controls oracle dc-0218
* Generated (plan F2.7, ADR 0012): do not edit; regenerate with `pnpm sim oracle regen`. dc seed 20261030 index 218 nodes 23 elements 42
.options sparse gmin=1e-12 noopac
RG1 1 0 1000000000000
RG2 2 0 1000000000000
RG3 3 0 1000000000000
RG4 4 0 1000000000000
RG5 5 0 1000000000000
RG6 6 0 1000000000000
RG7 7 0 1000000000000
RG8 8 0 1000000000000
RG9 9 0 1000000000000
RG10 10 0 1000000000000
RG11 11 0 1000000000000
RG12 12 0 1000000000000
RG13 13 0 1000000000000
RG14 14 0 1000000000000
RG15 15 0 1000000000000
RG16 16 0 1000000000000
RG17 17 0 1000000000000
RG18 18 0 1000000000000
RG19 19 0 1000000000000
RG20 20 0 1000000000000
RG21 21 0 1000000000000
RG22 22 0 1000000000000
VS0 16 s0 0
R0 s0 18 27e3
VS1 3 s1 0
R1 s1 19 39e-1
VS2 8 s2 0
R2 s2 6 39e1
VS3 13 s3 0
R3 s3 18 56e1
VS4 20 s4 0
R4 s4 1 47e1
VS5 2 s5 0
I5 s5 18 DC 56e-2
VS6 14 s6 0
R6 s6 22 22e0
VS7 0 s7 0
V7 e7 s7 DC 22e0
RI7 e7 2 47e-1
VS8 15 s8 0
R8 s8 0 15e-2
VS9 13 s9 0
R9 s9 17 82e2
VS10 8 s10 0
R10 s10 9 82e2
VS11 19 s11 0
R11 s11 2 82e2
VS12 10 s12 0
R12 s12 19 82e-2
VS13 6 s13 0
V13 e13 s13 DC 68e-1
RI13 e13 5 22e-2
VS14 9 s14 0
I14 s14 0 DC 10e-4
VS15 10 s15 0
I15 s15 20 DC 10e-2
VS16 13 s16 0
R16 s16 0 12e1
VS17 1 s17 0
R17 s17 19 56e1
VS18 2 s18 0
R18 s18 18 68e2
VS19 15 s19 0
R19 s19 22 33e-1
VS20 14 s20 0
R20 s20 9 56e3
VS21 15 s21 0
R21 s21 9 56e3
VS22 21 s22 0
R22 s22 16 33e0
VS23 5 s23 0
V23 e23 s23 DC 10e-1
RI23 e23 19 10e-2
VS24 12 s24 0
R24 s24 7 18e-2
VS25 3 s25 0
I25 s25 22 DC 15e-2
VS26 18 s26 0
R26 s26 8 33e1
VS27 5 s27 0
R27 s27 10 10e3
VS28 17 s28 0
V28 e28 s28 DC 82e-1
RI28 e28 19 47e-2
VS29 0 s29 0
R29 s29 16 12e2
VS30 4 s30 0
R30 s30 3 10e2
VS31 19 s31 0
R31 s31 9 12e0
VS32 11 s32 0
R32 s32 1 47e0
VS33 9 s33 0
R33 s33 6 10e-2
VS34 13 s34 0
R34 s34 21 22e-1
VS35 4 s35 0
R35 s35 19 27e2
VS36 13 s36 0
I36 s36 14 DC 33e-3
VS37 15 s37 0
R37 s37 7 39e0
VS38 12 s38 0
R38 s38 20 18e3
VS39 20 s39 0
V39 e39 s39 DC 10e-1
RI39 e39 3 68e-2
VS40 2 s40 0
I40 s40 15 DC 47e-3
VS41 11 s41 0
R41 s41 3 22e-2
.control
set numdgt=17
op
print v(1) v(2) v(3) v(4) v(5) v(6) v(7) v(8) v(9) v(10)
print v(11) v(12) v(13) v(14) v(15) v(16) v(17) v(18) v(19) v(20)
print v(21) v(22)
print i(vs0) i(vs1) i(vs2) i(vs3) i(vs4) i(vs5) i(vs6) i(vs7) i(vs8) i(vs9)
print i(vs10) i(vs11) i(vs12) i(vs13) i(vs14) i(vs15) i(vs16) i(vs17) i(vs18) i(vs19)
print i(vs20) i(vs21) i(vs22) i(vs23) i(vs24) i(vs25) i(vs26) i(vs27) i(vs28) i(vs29)
print i(vs30) i(vs31) i(vs32) i(vs33) i(vs34) i(vs35) i(vs36) i(vs37) i(vs38) i(vs39)
print i(vs40) i(vs41)
.endc
.end
