controls oracle dc-0218
* Generated (plan F2.7, ADR 0012): do not edit; regenerate with `pnpm sim oracle regen`. dc seed 20261030 index 218 nodes 23 elements 38
.options sparse gmin=1e-12 noopac
RG1 1 0 1000000000000
RG2 2 0 1000000000000
RG3 3 0 1000000000000
RG4 4 0 1000000000000
RG5 5 0 1000000000000
RG6 6 0 1000000000000
RG7 7 0 1000000000000
RG8 8 0 1000000000000
RG9 9 0 1000000000000
RG10 10 0 1000000000000
RG11 11 0 1000000000000
RG12 12 0 1000000000000
RG13 13 0 1000000000000
RG14 14 0 1000000000000
RG15 15 0 1000000000000
RG16 16 0 1000000000000
RG17 17 0 1000000000000
RG18 18 0 1000000000000
RG19 19 0 1000000000000
RG20 20 0 1000000000000
RG21 21 0 1000000000000
RG22 22 0 1000000000000
VS0 19 s0 0
R0 s0 2 82e2
VS1 0 s1 0
R1 s1 10 10e3
VS2 9 s2 0
I2 s2 14 DC 10e-4
VS3 11 s3 0
R3 s3 1 47e0
VS4 9 s4 0
R4 s4 6 10e-2
VS5 15 s5 0
R5 s5 9 56e3
VS6 5 s6 0
R6 s6 22 22e0
VS7 19 s7 0
R7 s7 9 12e0
VS8 2 s8 0
R8 s8 18 68e2
VS9 4 s9 0
R9 s9 19 27e2
VS10 10 s10 0
I10 s10 20 DC 10e-2
VS11 12 s11 0
R11 s11 20 18e3
VS12 13 s12 0
R12 s12 17 82e2
VS13 13 s13 0
I13 s13 5 DC 33e-3
VS14 13 s14 0
R14 s14 21 22e-1
VS15 8 s15 0
R15 s15 9 82e2
VS16 11 s16 0
R16 s16 3 22e-2
VS17 16 s17 0
R17 s17 18 27e3
VS18 3 s18 0
I18 s18 22 DC 15e-2
VS19 8 s19 0
R19 s19 6 39e1
VS20 20 s20 0
R20 s20 1 47e1
VS21 15 s21 0
R21 s21 7 39e0
VS22 5 s22 0
R22 s22 9 56e3
VS23 15 s23 0
R23 s23 14 15e-2
VS24 14 s24 0
R24 s24 16 12e2
VS25 0 s25 0
V25 e25 s25 DC 10e-1
RI25 e25 19 10e-2
VS26 2 s26 0
I26 s26 15 DC 47e-3
VS27 18 s27 0
R27 s27 8 33e1
VS28 13 s28 0
R28 s28 14 12e1
VS29 2 s29 0
I29 s29 18 DC 56e-2
VS30 14 s30 0
V30 e30 s30 DC 22e0
RI30 e30 2 47e-1
VS31 13 s31 0
R31 s31 18 56e1
VS32 17 s32 0
V32 e32 s32 DC 82e-1
RI32 e32 19 47e-2
VS33 1 s33 0
R33 s33 19 56e1
VS34 3 s34 0
R34 s34 19 39e-1
VS35 15 s35 0
R35 s35 22 33e-1
VS36 20 s36 0
V36 e36 s36 DC 10e-1
RI36 e36 3 68e-2
VS37 12 s37 0
R37 s37 7 18e-2
.control
set numdgt=17
op
print v(1) v(2) v(3) v(4) v(5) v(6) v(7) v(8) v(9) v(10)
print v(11) v(12) v(13) v(14) v(15) v(16) v(17) v(18) v(19) v(20)
print v(21) v(22)
print i(vs0) i(vs1) i(vs2) i(vs3) i(vs4) i(vs5) i(vs6) i(vs7) i(vs8) i(vs9)
print i(vs10) i(vs11) i(vs12) i(vs13) i(vs14) i(vs15) i(vs16) i(vs17) i(vs18) i(vs19)
print i(vs20) i(vs21) i(vs22) i(vs23) i(vs24) i(vs25) i(vs26) i(vs27) i(vs28) i(vs29)
print i(vs30) i(vs31) i(vs32) i(vs33) i(vs34) i(vs35) i(vs36) i(vs37)
.endc
.end
