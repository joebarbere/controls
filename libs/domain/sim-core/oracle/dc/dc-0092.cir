controls oracle dc-0092
* Generated (plan F2.7, ADR 0012): do not edit; regenerate with `pnpm sim oracle regen`. dc seed 20261030 index 92 nodes 2 elements 2
.options sparse gmin=1e-12 noopac
RG1 1 0 1000000000000
VS0 0 s0 0
V0 e0 s0 DC 10e0
RI0 e0 1 22e-3
VS1 0 s1 0
V1 e1 s1 DC 10e1
RI1 e1 1 47e-1
.control
set numdgt=17
op
print v(1)
print i(vs0) i(vs1)
.endc
.end
