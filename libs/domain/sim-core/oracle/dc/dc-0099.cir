controls oracle dc-0099
* Generated (plan F2.7, ADR 0012): do not edit; regenerate with `pnpm sim oracle regen`. dc seed 20261030 index 99 nodes 24 elements 36
.options sparse gmin=1e-12 noopac
RG1 1 0 1000000000000
RG2 2 0 1000000000000
RG3 3 0 1000000000000
RG4 4 0 1000000000000
RG5 5 0 1000000000000
RG6 6 0 1000000000000
RG7 7 0 1000000000000
RG8 8 0 1000000000000
RG9 9 0 1000000000000
RG10 10 0 1000000000000
RG11 11 0 1000000000000
RG12 12 0 1000000000000
RG13 13 0 1000000000000
RG14 14 0 1000000000000
RG15 15 0 1000000000000
RG16 16 0 1000000000000
RG17 17 0 1000000000000
RG18 18 0 1000000000000
RG19 19 0 1000000000000
RG20 20 0 1000000000000
RG21 21 0 1000000000000
RG22 22 0 1000000000000
RG23 23 0 1000000000000
VS0 0 s0 0
V0 e0 s0 DC 12e-1
RI0 e0 22 68e-2
VS1 8 s1 0
R1 s1 10 15e-2
VS2 16 s2 0
V2 e2 s2 DC 68e0
RI2 e2 23 22e-3
VS3 22 s3 0
R3 s3 16 27e3
VS4 14 s4 0
V4 e4 s4 DC 47e0
RI4 e4 12 82e-3
VS5 6 s5 0
R5 s5 10 10e-2
VS6 15 s6 0
R6 s6 7 39e0
VS7 19 s7 0
R7 s7 5 10e1
VS8 13 s8 0
R8 s8 21 12e1
VS9 5 s9 0
R9 s9 14 22e2
VS10 1 s10 0
V10 e10 s10 DC 33e-1
RI10 e10 7 22e-2
VS11 10 s11 0
V11 e11 s11 DC 68e-1
RI11 e11 4 15e-2
VS12 11 s12 0
R12 s12 4 56e2
VS13 18 s13 0
R13 s13 14 56e-2
VS14 12 s14 0
R14 s14 21 12e2
VS15 3 s15 0
R15 s15 19 10e3
VS16 20 s16 0
R16 s16 10 39e3
VS17 20 s17 0
R17 s17 22 47e-2
VS18 10 s18 0
R18 s18 22 33e-1
VS19 0 s19 0
R19 s19 1 82e-1
VS20 19 s20 0
R20 s20 9 33e-1
VS21 6 s21 0
V21 e21 s21 DC 10e0
RI21 e21 17 82e-1
VS22 14 s22 0
R22 s22 12 15e0
VS23 11 s23 0
V23 e23 s23 DC 33e1
RI23 e23 2 18e-3
VS24 14 s24 0
R24 s24 22 56e0
VS25 8 s25 0
R25 s25 14 47e-1
VS26 13 s26 0
I26 s26 19 DC 27e-1
VS27 21 s27 0
R27 s27 9 10e-2
VS28 1 s28 0
R28 s28 6 47e-2
VS29 10 s29 0
V29 e29 s29 DC 18e-1
RI29 e29 2 39e-3
VS30 13 s30 0
R30 s30 6 68e3
VS31 18 s31 0
R31 s31 7 68e3
VS32 17 s32 0
R32 s32 23 33e3
VS33 2 s33 0
R33 s33 15 68e3
VS34 12 s34 0
R34 s34 3 68e0
VS35 14 s35 0
V35 e35 s35 DC 47e-1
RI35 e35 19 22e-1
.control
set numdgt=17
op
print v(1) v(2) v(3) v(4) v(5) v(6) v(7) v(8) v(9) v(10)
print v(11) v(12) v(13) v(14) v(15) v(16) v(17) v(18) v(19) v(20)
print v(21) v(22) v(23)
print i(vs0) i(vs1) i(vs2) i(vs3) i(vs4) i(vs5) i(vs6) i(vs7) i(vs8) i(vs9)
print i(vs10) i(vs11) i(vs12) i(vs13) i(vs14) i(vs15) i(vs16) i(vs17) i(vs18) i(vs19)
print i(vs20) i(vs21) i(vs22) i(vs23) i(vs24) i(vs25) i(vs26) i(vs27) i(vs28) i(vs29)
print i(vs30) i(vs31) i(vs32) i(vs33) i(vs34) i(vs35)
.endc
.end
