controls oracle dc-0099
* Generated (plan F2.7, ADR 0012): do not edit; regenerate with `pnpm sim oracle regen`. dc seed 20261030 index 99 nodes 24 elements 25
.options sparse gmin=1e-12 noopac
RG1 1 0 1000000000000
RG2 2 0 1000000000000
RG3 3 0 1000000000000
RG4 4 0 1000000000000
RG5 5 0 1000000000000
RG6 6 0 1000000000000
RG7 7 0 1000000000000
RG8 8 0 1000000000000
RG9 9 0 1000000000000
RG10 10 0 1000000000000
RG11 11 0 1000000000000
RG12 12 0 1000000000000
RG13 13 0 1000000000000
RG14 14 0 1000000000000
RG15 15 0 1000000000000
RG16 16 0 1000000000000
RG17 17 0 1000000000000
RG18 18 0 1000000000000
RG19 19 0 1000000000000
RG20 20 0 1000000000000
RG21 21 0 1000000000000
RG22 22 0 1000000000000
RG23 23 0 1000000000000
VS0 0 s0 0
V0 e0 s0 DC 12e-1
RI0 e0 22 68e-2
VS1 13 s1 0
R1 s1 21 12e1
VS2 6 s2 0
R2 s2 10 10e-2
VS3 3 s3 0
R3 s3 19 10e3
VS4 5 s4 0
R4 s4 14 22e2
VS5 14 s5 0
V5 e5 s5 DC 47e0
RI5 e5 12 82e-3
VS6 10 s6 0
R6 s6 22 33e-1
VS7 6 s7 0
V7 e7 s7 DC 10e0
RI7 e7 17 82e-1
VS8 22 s8 0
R8 s8 16 27e3
VS9 2 s9 0
R9 s9 15 68e3
VS10 18 s10 0
R10 s10 14 56e-2
VS11 10 s11 0
V11 e11 s11 DC 68e-1
RI11 e11 4 15e-2
VS12 13 s12 0
I12 s12 19 DC 27e-1
VS13 1 s13 0
V13 e13 s13 DC 33e-1
RI13 e13 7 22e-2
VS14 14 s14 0
R14 s14 12 15e0
VS15 16 s15 0
V15 e15 s15 DC 68e0
RI15 e15 23 22e-3
VS16 11 s16 0
R16 s16 4 56e2
VS17 14 s17 0
R17 s17 22 56e0
VS18 10 s18 0
V18 e18 s18 DC 18e-1
RI18 e18 2 39e-3
VS19 21 s19 0
R19 s19 9 10e-2
VS20 8 s20 0
R20 s20 10 15e-2
VS21 20 s21 0
R21 s21 22 47e-2
VS22 1 s22 0
R22 s22 6 47e-2
VS23 14 s23 0
V23 e23 s23 DC 47e-1
RI23 e23 19 22e-1
VS24 13 s24 0
R24 s24 6 68e3
.control
set numdgt=17
op
print v(1) v(2) v(3) v(4) v(5) v(6) v(7) v(8) v(9) v(10)
print v(11) v(12) v(13) v(14) v(15) v(16) v(17) v(18) v(19) v(20)
print v(21) v(22) v(23)
print i(vs0) i(vs1) i(vs2) i(vs3) i(vs4) i(vs5) i(vs6) i(vs7) i(vs8) i(vs9)
print i(vs10) i(vs11) i(vs12) i(vs13) i(vs14) i(vs15) i(vs16) i(vs17) i(vs18) i(vs19)
print i(vs20) i(vs21) i(vs22) i(vs23) i(vs24)
.endc
.end
