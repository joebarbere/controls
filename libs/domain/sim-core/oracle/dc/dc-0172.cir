controls oracle dc-0172
* Generated (plan F2.7, ADR 0012): do not edit; regenerate with `pnpm sim oracle regen`. dc seed 20261030 index 172 nodes 20 elements 35
.options sparse gmin=1e-12 noopac
RG1 1 0 1000000000000
RG2 2 0 1000000000000
RG3 3 0 1000000000000
RG4 4 0 1000000000000
RG5 5 0 1000000000000
RG6 6 0 1000000000000
RG7 7 0 1000000000000
RG8 8 0 1000000000000
RG9 9 0 1000000000000
RG10 10 0 1000000000000
RG11 11 0 1000000000000
RG12 12 0 1000000000000
RG13 13 0 1000000000000
RG14 14 0 1000000000000
RG15 15 0 1000000000000
RG16 16 0 1000000000000
RG17 17 0 1000000000000
RG18 18 0 1000000000000
RG19 19 0 1000000000000
VS0 14 s0 0
R0 s0 19 10e-2
VS1 13 s1 0
R1 s1 1 22e-1
VS2 0 s2 0
V2 e2 s2 DC 18e1
RI2 e2 4 39e-3
VS3 13 s3 0
V3 e3 s3 DC 10e-1
RI3 e3 9 22e-2
VS4 5 s4 0
R4 s4 3 39e1
VS5 18 s5 0
R5 s5 7 15e-2
VS6 14 s6 0
R6 s6 17 33e3
VS7 6 s7 0
R7 s7 4 82e2
VS8 0 s8 0
I8 s8 19 DC 82e-4
VS9 18 s9 0
I9 s9 9 DC 10e-2
VS10 12 s10 0
V10 e10 s10 DC 10e-1
RI10 e10 10 82e-3
VS11 14 s11 0
V11 e11 s11 DC 18e-1
RI11 e11 10 56e-3
VS12 15 s12 0
R12 s12 2 39e2
VS13 19 s13 0
R13 s13 1 56e1
VS14 6 s14 0
R14 s14 3 27e2
VS15 3 s15 0
R15 s15 8 10e1
VS16 7 s16 0
R16 s16 14 15e-2
VS17 9 s17 0
R17 s17 4 12e-2
VS18 12 s18 0
V18 e18 s18 DC 12e1
RI18 e18 11 68e-2
VS19 0 s19 0
V19 e19 s19 DC 22e-1
RI19 e19 11 10e-3
VS20 2 s20 0
R20 s20 6 39e1
VS21 15 s21 0
V21 e21 s21 DC 22e1
RI21 e21 0 47e-2
VS22 16 s22 0
R22 s22 0 33e0
VS23 6 s23 0
I23 s23 4 DC 56e-3
VS24 18 s24 0
V24 e24 s24 DC 82e0
RI24 e24 11 56e-2
VS25 16 s25 0
V25 e25 s25 DC 15e0
RI25 e25 12 10e-1
VS26 5 s26 0
R26 s26 12 39e0
VS27 19 s27 0
R27 s27 8 56e-1
VS28 13 s28 0
R28 s28 0 10e0
VS29 11 s29 0
R29 s29 8 10e0
VS30 15 s30 0
R30 s30 13 82e-1
VS31 2 s31 0
R31 s31 0 27e-2
VS32 8 s32 0
R32 s32 0 18e1
VS33 1 s33 0
R33 s33 9 39e3
VS34 11 s34 0
R34 s34 17 56e3
.control
set numdgt=17
op
print v(1) v(2) v(3) v(4) v(5) v(6) v(7) v(8) v(9) v(10)
print v(11) v(12) v(13) v(14) v(15) v(16) v(17) v(18) v(19)
print i(vs0) i(vs1) i(vs2) i(vs3) i(vs4) i(vs5) i(vs6) i(vs7) i(vs8) i(vs9)
print i(vs10) i(vs11) i(vs12) i(vs13) i(vs14) i(vs15) i(vs16) i(vs17) i(vs18) i(vs19)
print i(vs20) i(vs21) i(vs22) i(vs23) i(vs24) i(vs25) i(vs26) i(vs27) i(vs28) i(vs29)
print i(vs30) i(vs31) i(vs32) i(vs33) i(vs34)
.endc
.end
