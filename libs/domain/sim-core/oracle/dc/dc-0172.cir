controls oracle dc-0172
* Generated (plan F2.7, ADR 0012): do not edit; regenerate with `pnpm sim oracle regen`. dc seed 20261030 index 172 nodes 20 elements 32
.options sparse gmin=1e-12 noopac
RG1 1 0 1000000000000
RG2 2 0 1000000000000
RG3 3 0 1000000000000
RG4 4 0 1000000000000
RG5 5 0 1000000000000
RG6 6 0 1000000000000
RG7 7 0 1000000000000
RG8 8 0 1000000000000
RG9 9 0 1000000000000
RG10 10 0 1000000000000
RG11 11 0 1000000000000
RG12 12 0 1000000000000
RG13 13 0 1000000000000
RG14 14 0 1000000000000
RG15 15 0 1000000000000
RG16 16 0 1000000000000
RG17 17 0 1000000000000
RG18 18 0 1000000000000
RG19 19 0 1000000000000
VS0 0 s0 0
V0 e0 s0 DC 10e-1
RI0 e0 9 22e-2
VS1 7 s1 0
R1 s1 14 15e-2
VS2 6 s2 0
R2 s2 3 27e2
VS3 6 s3 0
R3 s3 4 82e2
VS4 13 s4 0
V4 e4 s4 DC 22e-1
RI4 e4 11 10e-3
VS5 2 s5 0
R5 s5 13 27e-2
VS6 18 s6 0
I6 s6 9 DC 10e-2
VS7 15 s7 0
V7 e7 s7 DC 22e1
RI7 e7 13 47e-2
VS8 18 s8 0
R8 s8 7 15e-2
VS9 11 s9 0
R9 s9 8 10e0
VS10 16 s10 0
V10 e10 s10 DC 15e0
RI10 e10 12 10e-1
VS11 13 s11 0
I11 s11 19 DC 82e-4
VS12 13 s12 0
V12 e12 s12 DC 18e1
RI12 e12 4 39e-3
VS13 8 s13 0
R13 s13 13 18e1
VS14 9 s14 0
R14 s14 4 12e-2
VS15 14 s15 0
R15 s15 19 10e-2
VS16 2 s16 0
R16 s16 6 39e1
VS17 19 s17 0
R17 s17 1 56e1
VS18 0 s18 0
R18 s18 1 22e-1
VS19 5 s19 0
R19 s19 12 39e0
VS20 19 s20 0
R20 s20 8 56e-1
VS21 1 s21 0
R21 s21 9 39e3
VS22 18 s22 0
V22 e22 s22 DC 82e0
RI22 e22 11 56e-2
VS23 0 s23 0
R23 s23 13 10e0
VS24 12 s24 0
V24 e24 s24 DC 12e1
RI24 e24 11 68e-2
VS25 16 s25 0
R25 s25 13 33e0
VS26 6 s26 0
I26 s26 4 DC 56e-3
VS27 15 s27 0
R27 s27 0 82e-1
VS28 15 s28 0
R28 s28 2 39e2
VS29 11 s29 0
R29 s29 17 56e3
VS30 14 s30 0
R30 s30 17 33e3
VS31 14 s31 0
V31 e31 s31 DC 18e-1
RI31 e31 10 56e-3
.control
set numdgt=17
op
print v(1) v(2) v(3) v(4) v(5) v(6) v(7) v(8) v(9) v(10)
print v(11) v(12) v(13) v(14) v(15) v(16) v(17) v(18) v(19)
print i(vs0) i(vs1) i(vs2) i(vs3) i(vs4) i(vs5) i(vs6) i(vs7) i(vs8) i(vs9)
print i(vs10) i(vs11) i(vs12) i(vs13) i(vs14) i(vs15) i(vs16) i(vs17) i(vs18) i(vs19)
print i(vs20) i(vs21) i(vs22) i(vs23) i(vs24) i(vs25) i(vs26) i(vs27) i(vs28) i(vs29)
print i(vs30) i(vs31)
.endc
.end
