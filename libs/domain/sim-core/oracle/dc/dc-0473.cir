controls oracle dc-0473
* Generated (plan F2.7, ADR 0012): do not edit; regenerate with `pnpm sim oracle regen`. dc seed 20261030 index 473 nodes 28 elements 50
.options sparse gmin=1e-12 noopac
RG1 1 0 1000000000000
RG2 2 0 1000000000000
RG3 3 0 1000000000000
RG4 4 0 1000000000000
RG5 5 0 1000000000000
RG6 6 0 1000000000000
RG7 7 0 1000000000000
RG8 8 0 1000000000000
RG9 9 0 1000000000000
RG10 10 0 1000000000000
RG11 11 0 1000000000000
RG12 12 0 1000000000000
RG13 13 0 1000000000000
RG14 14 0 1000000000000
RG15 15 0 1000000000000
RG16 16 0 1000000000000
RG17 17 0 1000000000000
RG18 18 0 1000000000000
RG19 19 0 1000000000000
RG20 20 0 1000000000000
RG21 21 0 1000000000000
RG22 22 0 1000000000000
RG23 23 0 1000000000000
RG24 24 0 1000000000000
RG25 25 0 1000000000000
RG26 26 0 1000000000000
RG27 27 0 1000000000000
VS0 14 s0 0
R0 s0 25 47e-1
VS1 0 s1 0
I1 s1 4 DC 33e-1
VS2 0 s2 0
V2 e2 s2 DC 18e0
RI2 e2 10 33e-1
VS3 21 s3 0
R3 s3 8 12e-1
VS4 2 s4 0
I4 s4 16 DC 33e-1
VS5 10 s5 0
R5 s5 13 18e-2
VS6 6 s6 0
R6 s6 3 33e-1
VS7 13 s7 0
R7 s7 25 10e1
VS8 2 s8 0
V8 e8 s8 DC 68e0
RI8 e8 22 68e-1
VS9 21 s9 0
R9 s9 20 10e3
VS10 26 s10 0
R10 s10 14 33e3
VS11 26 s11 0
R11 s11 5 33e2
VS12 11 s12 0
R12 s12 16 33e2
VS13 5 s13 0
R13 s13 26 68e-1
VS14 25 s14 0
R14 s14 1 82e1
VS15 3 s15 0
R15 s15 15 15e2
VS16 4 s16 0
V16 e16 s16 DC 82e0
RI16 e16 0 12e-2
VS17 22 s17 0
R17 s17 24 15e-1
VS18 21 s18 0
R18 s18 23 12e2
VS19 2 s19 0
R19 s19 20 82e3
VS20 27 s20 0
R20 s20 21 10e3
VS21 22 s21 0
R21 s21 16 47e3
VS22 22 s22 0
R22 s22 12 68e2
VS23 8 s23 0
R23 s23 6 12e0
VS24 23 s24 0
R24 s24 22 39e0
VS25 26 s25 0
R25 s25 1 39e0
VS26 8 s26 0
V26 e26 s26 DC 39e0
RI26 e26 1 47e-1
VS27 1 s27 0
I27 s27 9 DC 56e-4
VS28 12 s28 0
V28 e28 s28 DC 12e-1
RI28 e28 19 18e-2
VS29 21 s29 0
R29 s29 18 22e2
VS30 27 s30 0
V30 e30 s30 DC 82e0
RI30 e30 13 12e-3
VS31 20 s31 0
I31 s31 6 DC 12e-2
VS32 19 s32 0
I32 s32 1 DC 18e-2
VS33 0 s33 0
R33 s33 4 27e2
VS34 15 s34 0
I34 s34 10 DC 47e-2
VS35 7 s35 0
I35 s35 21 DC 82e-4
VS36 2 s36 0
R36 s36 10 56e0
VS37 7 s37 0
R37 s37 25 82e0
VS38 26 s38 0
R38 s38 10 10e3
VS39 13 s39 0
I39 s39 22 DC 47e-4
VS40 3 s40 0
R40 s40 7 12e2
VS41 17 s41 0
R41 s41 5 82e2
VS42 26 s42 0
V42 e42 s42 DC 10e1
RI42 e42 21 22e-3
VS43 18 s43 0
R43 s43 13 68e1
VS44 19 s44 0
R44 s44 1 18e2
VS45 9 s45 0
R45 s45 7 33e-1
VS46 21 s46 0
R46 s46 16 22e-1
VS47 3 s47 0
R47 s47 2 39e0
VS48 4 s48 0
I48 s48 23 DC 10e-2
VS49 2 s49 0
R49 s49 18 56e0
.control
set numdgt=17
op
print v(1) v(2) v(3) v(4) v(5) v(6) v(7) v(8) v(9) v(10)
print v(11) v(12) v(13) v(14) v(15) v(16) v(17) v(18) v(19) v(20)
print v(21) v(22) v(23) v(24) v(25) v(26) v(27)
print i(vs0) i(vs1) i(vs2) i(vs3) i(vs4) i(vs5) i(vs6) i(vs7) i(vs8) i(vs9)
print i(vs10) i(vs11) i(vs12) i(vs13) i(vs14) i(vs15) i(vs16) i(vs17) i(vs18) i(vs19)
print i(vs20) i(vs21) i(vs22) i(vs23) i(vs24) i(vs25) i(vs26) i(vs27) i(vs28) i(vs29)
print i(vs30) i(vs31) i(vs32) i(vs33) i(vs34) i(vs35) i(vs36) i(vs37) i(vs38) i(vs39)
print i(vs40) i(vs41) i(vs42) i(vs43) i(vs44) i(vs45) i(vs46) i(vs47) i(vs48) i(vs49)
.endc
.end
