controls oracle dc-0473
* Generated (plan F2.7, ADR 0012): do not edit; regenerate with `pnpm sim oracle regen`. dc seed 20261030 index 473 nodes 28 elements 55
.options sparse gmin=1e-12 noopac
RG1 1 0 1000000000000
RG2 2 0 1000000000000
RG3 3 0 1000000000000
RG4 4 0 1000000000000
RG5 5 0 1000000000000
RG6 6 0 1000000000000
RG7 7 0 1000000000000
RG8 8 0 1000000000000
RG9 9 0 1000000000000
RG10 10 0 1000000000000
RG11 11 0 1000000000000
RG12 12 0 1000000000000
RG13 13 0 1000000000000
RG14 14 0 1000000000000
RG15 15 0 1000000000000
RG16 16 0 1000000000000
RG17 17 0 1000000000000
RG18 18 0 1000000000000
RG19 19 0 1000000000000
RG20 20 0 1000000000000
RG21 21 0 1000000000000
RG22 22 0 1000000000000
RG23 23 0 1000000000000
RG24 24 0 1000000000000
RG25 25 0 1000000000000
RG26 26 0 1000000000000
RG27 27 0 1000000000000
VS0 25 s0 0
R0 s0 1 82e1
VS1 13 s1 0
R1 s1 25 10e1
VS2 26 s2 0
R2 s2 1 39e0
VS3 19 s3 0
R3 s3 1 18e2
VS4 0 s4 0
R4 s4 4 27e2
VS5 4 s5 0
R5 s5 22 68e0
VS6 0 s6 0
V6 e6 s6 DC 18e0
RI6 e6 10 33e-1
VS7 26 s7 0
R7 s7 5 33e2
VS8 21 s8 0
R8 s8 8 12e-1
VS9 13 s9 0
I9 s9 22 DC 47e-4
VS10 21 s10 0
R10 s10 23 12e2
VS11 21 s11 0
R11 s11 16 22e-1
VS12 2 s12 0
R12 s12 18 56e0
VS13 4 s13 0
I13 s13 23 DC 10e-2
VS14 19 s14 0
I14 s14 1 DC 18e-2
VS15 10 s15 0
R15 s15 13 18e-2
VS16 3 s16 0
R16 s16 7 12e2
VS17 9 s17 0
R17 s17 25 12e-2
VS18 3 s18 0
R18 s18 2 39e0
VS19 4 s19 0
V19 e19 s19 DC 82e0
RI19 e19 0 12e-2
VS20 6 s20 0
R20 s20 3 33e-1
VS21 27 s21 0
V21 e21 s21 DC 82e0
RI21 e21 13 12e-3
VS22 7 s22 0
I22 s22 21 DC 82e-4
VS23 2 s23 0
R23 s23 20 82e3
VS24 7 s24 0
R24 s24 25 82e0
VS25 17 s25 0
R25 s25 9 18e3
VS26 11 s26 0
R26 s26 16 33e2
VS27 2 s27 0
V27 e27 s27 DC 68e0
RI27 e27 22 68e-1
VS28 27 s28 0
V28 e28 s28 DC 27e-1
RI28 e28 11 12e-2
VS29 8 s29 0
R29 s29 6 12e0
VS30 17 s30 0
R30 s30 5 82e2
VS31 26 s31 0
V31 e31 s31 DC 10e1
RI31 e31 21 22e-3
VS32 3 s32 0
R32 s32 15 15e2
VS33 0 s33 0
I33 s33 4 DC 33e-1
VS34 8 s34 0
V34 e34 s34 DC 39e0
RI34 e34 1 47e-1
VS35 14 s35 0
R35 s35 25 47e-1
VS36 22 s36 0
R36 s36 16 47e3
VS37 27 s37 0
R37 s37 21 10e3
VS38 12 s38 0
V38 e38 s38 DC 12e-1
RI38 e38 19 18e-2
VS39 22 s39 0
R39 s39 24 15e-1
VS40 21 s40 0
R40 s40 20 10e3
VS41 20 s41 0
I41 s41 6 DC 12e-2
VS42 1 s42 0
I42 s42 9 DC 56e-4
VS43 26 s43 0
R43 s43 10 10e3
VS44 15 s44 0
I44 s44 10 DC 47e-2
VS45 26 s45 0
R45 s45 14 33e3
VS46 2 s46 0
R46 s46 10 56e0
VS47 23 s47 0
R47 s47 22 39e0
VS48 2 s48 0
I48 s48 16 DC 33e-1
VS49 22 s49 0
R49 s49 12 68e2
VS50 21 s50 0
R50 s50 18 22e2
VS51 5 s51 0
R51 s51 26 68e-1
VS52 18 s52 0
R52 s52 13 68e1
VS53 15 s53 0
R53 s53 24 10e0
VS54 9 s54 0
R54 s54 7 33e-1
.control
set numdgt=17
op
print v(1) v(2) v(3) v(4) v(5) v(6) v(7) v(8) v(9) v(10)
print v(11) v(12) v(13) v(14) v(15) v(16) v(17) v(18) v(19) v(20)
print v(21) v(22) v(23) v(24) v(25) v(26) v(27)
print i(vs0) i(vs1) i(vs2) i(vs3) i(vs4) i(vs5) i(vs6) i(vs7) i(vs8) i(vs9)
print i(vs10) i(vs11) i(vs12) i(vs13) i(vs14) i(vs15) i(vs16) i(vs17) i(vs18) i(vs19)
print i(vs20) i(vs21) i(vs22) i(vs23) i(vs24) i(vs25) i(vs26) i(vs27) i(vs28) i(vs29)
print i(vs30) i(vs31) i(vs32) i(vs33) i(vs34) i(vs35) i(vs36) i(vs37) i(vs38) i(vs39)
print i(vs40) i(vs41) i(vs42) i(vs43) i(vs44) i(vs45) i(vs46) i(vs47) i(vs48) i(vs49)
print i(vs50) i(vs51) i(vs52) i(vs53) i(vs54)
.endc
.end
