controls oracle dc-0425
* Generated (plan F2.7, ADR 0012): do not edit; regenerate with `pnpm sim oracle regen`. dc seed 20261030 index 425 nodes 4 elements 7
.options sparse gmin=1e-12 noopac
RG1 1 0 1000000000000
RG2 2 0 1000000000000
RG3 3 0 1000000000000
VS0 3 s0 0
R0 s0 0 47e-1
VS1 1 s1 0
R1 s1 3 56e0
VS2 0 s2 0
V2 e2 s2 DC 39e1
RI2 e2 3 10e-1
VS3 0 s3 0
V3 e3 s3 DC 22e1
RI3 e3 1 47e-3
VS4 2 s4 0
R4 s4 0 12e2
VS5 2 s5 0
R5 s5 3 18e2
VS6 1 s6 0
I6 s6 3 DC 39e-1
.control
set numdgt=17
op
print v(1) v(2) v(3)
print i(vs0) i(vs1) i(vs2) i(vs3) i(vs4) i(vs5) i(vs6)
.endc
.end
