controls oracle dc-0425
* Generated (plan F2.7, ADR 0012): do not edit; regenerate with `pnpm sim oracle regen`. dc seed 20261030 index 425 nodes 4 elements 5
.options sparse gmin=1e-12 noopac
RG1 1 0 1000000000000
RG2 2 0 1000000000000
RG3 3 0 1000000000000
VS0 0 s0 0
V0 e0 s0 DC 39e1
RI0 e0 3 10e-1
VS1 0 s1 0
V1 e1 s1 DC 22e1
RI1 e1 1 47e-3
VS2 1 s2 0
I2 s2 3 DC 39e-1
VS3 2 s3 0
R3 s3 3 18e2
VS4 3 s4 0
R4 s4 0 47e-1
.control
set numdgt=17
op
print v(1) v(2) v(3)
print i(vs0) i(vs1) i(vs2) i(vs3) i(vs4)
.endc
.end
