controls oracle dc-0481
* Generated (plan F2.7, ADR 0012): do not edit; regenerate with `pnpm sim oracle regen`. dc seed 20261030 index 481 nodes 6 elements 9
.options sparse gmin=1e-12 noopac
RG1 1 0 1000000000000
RG2 2 0 1000000000000
RG3 3 0 1000000000000
RG4 4 0 1000000000000
RG5 5 0 1000000000000
VS0 4 s0 0
R0 s0 0 27e-2
VS1 3 s1 0
R1 s1 0 22e1
VS2 4 s2 0
R2 s2 5 15e3
VS3 2 s3 0
R3 s3 4 33e0
VS4 5 s4 0
R4 s4 2 18e1
VS5 0 s5 0
V5 e5 s5 DC 33e1
RI5 e5 1 33e-3
VS6 1 s6 0
R6 s6 2 12e-1
VS7 3 s7 0
R7 s7 1 33e1
VS8 4 s8 0
R8 s8 1 18e2
.control
set numdgt=17
op
print v(1) v(2) v(3) v(4) v(5)
print i(vs0) i(vs1) i(vs2) i(vs3) i(vs4) i(vs5) i(vs6) i(vs7) i(vs8)
.endc
.end
