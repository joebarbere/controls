controls oracle dc-0270
* Generated (plan F2.7, ADR 0012): do not edit; regenerate with `pnpm sim oracle regen`. dc seed 20261030 index 270 nodes 24 elements 40
.options sparse gmin=1e-12 noopac
RG1 1 0 1000000000000
RG2 2 0 1000000000000
RG3 3 0 1000000000000
RG4 4 0 1000000000000
RG5 5 0 1000000000000
RG6 6 0 1000000000000
RG7 7 0 1000000000000
RG8 8 0 1000000000000
RG9 9 0 1000000000000
RG10 10 0 1000000000000
RG11 11 0 1000000000000
RG12 12 0 1000000000000
RG13 13 0 1000000000000
RG14 14 0 1000000000000
RG15 15 0 1000000000000
RG16 16 0 1000000000000
RG17 17 0 1000000000000
RG18 18 0 1000000000000
RG19 19 0 1000000000000
RG20 20 0 1000000000000
RG21 21 0 1000000000000
RG22 22 0 1000000000000
RG23 23 0 1000000000000
VS0 10 s0 0
R0 s0 3 22e0
VS1 18 s1 0
R1 s1 19 33e3
VS2 0 s2 0
V2 e2 s2 DC 10e0
RI2 e2 16 56e-2
VS3 6 s3 0
R3 s3 2 68e-1
VS4 7 s4 0
R4 s4 14 18e-2
VS5 9 s5 0
V5 e5 s5 DC 15e1
RI5 e5 14 47e-3
VS6 18 s6 0
R6 s6 22 68e2
VS7 19 s7 0
I7 s7 22 DC 56e-1
VS8 16 s8 0
R8 s8 23 39e-2
VS9 21 s9 0
I9 s9 20 DC 12e-2
VS10 5 s10 0
R10 s10 1 47e1
VS11 3 s11 0
R11 s11 20 33e3
VS12 8 s12 0
R12 s12 2 10e-1
VS13 6 s13 0
R13 s13 4 68e-1
VS14 2 s14 0
R14 s14 5 10e2
VS15 1 s15 0
I15 s15 15 DC 27e-2
VS16 8 s16 0
R16 s16 10 22e2
VS17 20 s17 0
R17 s17 15 47e-1
VS18 23 s18 0
R18 s18 12 10e2
VS19 3 s19 0
V19 e19 s19 DC 22e0
RI19 e19 1 82e-1
VS20 5 s20 0
R20 s20 7 12e0
VS21 23 s21 0
R21 s21 2 56e-2
VS22 13 s22 0
R22 s22 11 39e3
VS23 7 s23 0
R23 s23 9 82e1
VS24 17 s24 0
R24 s24 12 33e0
VS25 21 s25 0
R25 s25 6 15e0
VS26 15 s26 0
V26 e26 s26 DC 39e1
RI26 e26 13 82e-2
VS27 20 s27 0
I27 s27 7 DC 18e-4
VS28 18 s28 0
R28 s28 8 18e-2
VS29 23 s29 0
R29 s29 3 39e-2
VS30 21 s30 0
R30 s30 12 33e-2
VS31 18 s31 0
R31 s31 7 22e-1
VS32 4 s32 0
I32 s32 20 DC 56e-2
VS33 6 s33 0
R33 s33 20 39e3
VS34 15 s34 0
R34 s34 18 27e1
VS35 13 s35 0
R35 s35 17 82e1
VS36 4 s36 0
R36 s36 16 22e3
VS37 2 s37 0
R37 s37 12 33e2
VS38 22 s38 0
R38 s38 21 10e1
VS39 5 s39 0
R39 s39 22 68e0
.control
set numdgt=17
op
print v(1) v(2) v(3) v(4) v(5) v(6) v(7) v(8) v(9) v(10)
print v(11) v(12) v(13) v(14) v(15) v(16) v(17) v(18) v(19) v(20)
print v(21) v(22) v(23)
print i(vs0) i(vs1) i(vs2) i(vs3) i(vs4) i(vs5) i(vs6) i(vs7) i(vs8) i(vs9)
print i(vs10) i(vs11) i(vs12) i(vs13) i(vs14) i(vs15) i(vs16) i(vs17) i(vs18) i(vs19)
print i(vs20) i(vs21) i(vs22) i(vs23) i(vs24) i(vs25) i(vs26) i(vs27) i(vs28) i(vs29)
print i(vs30) i(vs31) i(vs32) i(vs33) i(vs34) i(vs35) i(vs36) i(vs37) i(vs38) i(vs39)
.endc
.end
