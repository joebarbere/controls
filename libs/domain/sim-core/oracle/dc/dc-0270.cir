controls oracle dc-0270
* Generated (plan F2.7, ADR 0012): do not edit; regenerate with `pnpm sim oracle regen`. dc seed 20261030 index 270 nodes 24 elements 44
.options sparse gmin=1e-12 noopac
RG1 1 0 1000000000000
RG2 2 0 1000000000000
RG3 3 0 1000000000000
RG4 4 0 1000000000000
RG5 5 0 1000000000000
RG6 6 0 1000000000000
RG7 7 0 1000000000000
RG8 8 0 1000000000000
RG9 9 0 1000000000000
RG10 10 0 1000000000000
RG11 11 0 1000000000000
RG12 12 0 1000000000000
RG13 13 0 1000000000000
RG14 14 0 1000000000000
RG15 15 0 1000000000000
RG16 16 0 1000000000000
RG17 17 0 1000000000000
RG18 18 0 1000000000000
RG19 19 0 1000000000000
RG20 20 0 1000000000000
RG21 21 0 1000000000000
RG22 22 0 1000000000000
RG23 23 0 1000000000000
VS0 23 s0 0
R0 s0 12 10e2
VS1 5 s1 0
R1 s1 22 68e0
VS2 6 s2 0
R2 s2 4 68e-1
VS3 17 s3 0
R3 s3 12 33e0
VS4 8 s4 0
R4 s4 10 22e2
VS5 19 s5 0
I5 s5 7 DC 18e-4
VS6 19 s6 0
R6 s6 15 47e-1
VS7 0 s7 0
V7 e7 s7 DC 56e0
RI7 e7 6 27e-3
VS8 18 s8 0
R8 s8 0 33e3
VS9 4 s9 0
R9 s9 16 22e3
VS10 5 s10 0
R10 s10 7 12e0
VS11 20 s11 0
R11 s11 7 10e0
VS12 5 s12 0
R12 s12 9 12e0
VS13 3 s13 0
V13 e13 s13 DC 22e0
RI13 e13 1 82e-1
VS14 15 s14 0
R14 s14 18 27e1
VS15 21 s15 0
R15 s15 12 33e-2
VS16 7 s16 0
R16 s16 14 18e-2
VS17 1 s17 0
I17 s17 15 DC 27e-2
VS18 18 s18 0
R18 s18 8 18e-2
VS19 23 s19 0
R19 s19 3 39e-2
VS20 0 s20 0
I20 s20 22 DC 56e-1
VS21 13 s21 0
R21 s21 11 39e3
VS22 2 s22 0
R22 s22 12 33e2
VS23 18 s23 0
R23 s23 22 68e2
VS24 13 s24 0
R24 s24 17 82e1
VS25 21 s25 0
I25 s25 19 DC 12e-2
VS26 20 s26 0
V26 e26 s26 DC 10e0
RI26 e26 16 56e-2
VS27 6 s27 0
R27 s27 19 39e3
VS28 11 s28 0
R28 s28 23 56e3
VS29 15 s29 0
V29 e29 s29 DC 39e1
RI29 e29 13 82e-2
VS30 18 s30 0
R30 s30 7 22e-1
VS31 7 s31 0
R31 s31 9 82e1
VS32 5 s32 0
R32 s32 1 47e1
VS33 4 s33 0
I33 s33 19 DC 56e-2
VS34 22 s34 0
R34 s34 21 10e1
VS35 3 s35 0
R35 s35 19 33e3
VS36 16 s36 0
R36 s36 23 39e-2
VS37 9 s37 0
V37 e37 s37 DC 15e1
RI37 e37 14 47e-3
VS38 8 s38 0
R38 s38 2 10e-1
VS39 21 s39 0
R39 s39 6 15e0
VS40 10 s40 0
R40 s40 3 22e0
VS41 2 s41 0
R41 s41 5 10e2
VS42 6 s42 0
R42 s42 2 68e-1
VS43 23 s43 0
R43 s43 2 56e-2
.control
set numdgt=17
op
print v(1) v(2) v(3) v(4) v(5) v(6) v(7) v(8) v(9) v(10)
print v(11) v(12) v(13) v(14) v(15) v(16) v(17) v(18) v(19) v(20)
print v(21) v(22) v(23)
print i(vs0) i(vs1) i(vs2) i(vs3) i(vs4) i(vs5) i(vs6) i(vs7) i(vs8) i(vs9)
print i(vs10) i(vs11) i(vs12) i(vs13) i(vs14) i(vs15) i(vs16) i(vs17) i(vs18) i(vs19)
print i(vs20) i(vs21) i(vs22) i(vs23) i(vs24) i(vs25) i(vs26) i(vs27) i(vs28) i(vs29)
print i(vs30) i(vs31) i(vs32) i(vs33) i(vs34) i(vs35) i(vs36) i(vs37) i(vs38) i(vs39)
print i(vs40) i(vs41) i(vs42) i(vs43)
.endc
.end
