controls oracle dc-0181
* Generated (plan F2.7, ADR 0012): do not edit; regenerate with `pnpm sim oracle regen`. dc seed 20261030 index 181 nodes 5 elements 7
.options sparse gmin=1e-12 noopac
RG1 1 0 1000000000000
RG2 2 0 1000000000000
RG3 3 0 1000000000000
RG4 4 0 1000000000000
VS0 3 s0 0
R0 s0 4 15e3
VS1 3 s1 0
R1 s1 1 33e3
VS2 4 s2 0
R2 s2 3 18e1
VS3 0 s3 0
V3 e3 s3 DC 12e1
RI3 e3 1 39e-1
VS4 1 s4 0
R4 s4 0 56e0
VS5 1 s5 0
R5 s5 2 22e0
VS6 2 s6 0
R6 s6 4 15e3
.control
set numdgt=17
op
print v(1) v(2) v(3) v(4)
print i(vs0) i(vs1) i(vs2) i(vs3) i(vs4) i(vs5) i(vs6)
.endc
.end
