controls oracle dc-0181
* Generated (plan F2.7, ADR 0012): do not edit; regenerate with `pnpm sim oracle regen`. dc seed 20261030 index 181 nodes 5 elements 7
.options sparse gmin=1e-12 noopac
RG1 1 0 1000000000000
RG2 2 0 1000000000000
RG3 3 0 1000000000000
RG4 4 0 1000000000000
VS0 0 s0 0
V0 e0 s0 DC 27e0
RI0 e0 3 22e-3
VS1 1 s1 0
R1 s1 2 22e0
VS2 3 s2 0
V2 e2 s2 DC 12e1
RI2 e2 1 39e-1
VS3 0 s3 0
R3 s3 4 18e1
VS4 4 s4 0
R4 s4 1 33e3
VS5 2 s5 0
R5 s5 0 15e3
VS6 4 s6 0
R6 s6 0 15e3
.control
set numdgt=17
op
print v(1) v(2) v(3) v(4)
print i(vs0) i(vs1) i(vs2) i(vs3) i(vs4) i(vs5) i(vs6)
.endc
.end
