controls oracle dc-0022
* Generated (plan F2.7, ADR 0012): do not edit; regenerate with `pnpm sim oracle regen`. dc seed 20261030 index 22 nodes 6 elements 11
.options sparse gmin=1e-12 noopac
RG1 1 0 1000000000000
RG2 2 0 1000000000000
RG3 3 0 1000000000000
RG4 4 0 1000000000000
RG5 5 0 1000000000000
VS0 5 s0 0
R0 s0 0 68e-2
VS1 4 s1 0
R1 s1 1 12e-2
VS2 5 s2 0
R2 s2 1 18e-2
VS3 0 s3 0
V3 e3 s3 DC 12e-1
RI3 e3 2 33e-3
VS4 3 s4 0
R4 s4 4 27e1
VS5 4 s5 0
R5 s5 3 10e-1
VS6 0 s6 0
R6 s6 2 47e-2
VS7 3 s7 0
I7 s7 1 DC 22e-2
VS8 3 s8 0
V8 e8 s8 DC 15e0
RI8 e8 1 82e-3
VS9 3 s9 0
R9 s9 2 10e1
VS10 4 s10 0
R10 s10 0 39e-2
.control
set numdgt=17
op
print v(1) v(2) v(3) v(4) v(5)
print i(vs0) i(vs1) i(vs2) i(vs3) i(vs4) i(vs5) i(vs6) i(vs7) i(vs8) i(vs9)
print i(vs10)
.endc
.end
