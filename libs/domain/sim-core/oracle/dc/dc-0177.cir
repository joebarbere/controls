controls oracle dc-0177
* Generated (plan F2.7, ADR 0012): do not edit; regenerate with `pnpm sim oracle regen`. dc seed 20261030 index 177 nodes 21 elements 31
.options sparse gmin=1e-12 noopac
RG1 1 0 1000000000000
RG2 2 0 1000000000000
RG3 3 0 1000000000000
RG4 4 0 1000000000000
RG5 5 0 1000000000000
RG6 6 0 1000000000000
RG7 7 0 1000000000000
RG8 8 0 1000000000000
RG9 9 0 1000000000000
RG10 10 0 1000000000000
RG11 11 0 1000000000000
RG12 12 0 1000000000000
RG13 13 0 1000000000000
RG14 14 0 1000000000000
RG15 15 0 1000000000000
RG16 16 0 1000000000000
RG17 17 0 1000000000000
RG18 18 0 1000000000000
RG19 19 0 1000000000000
RG20 20 0 1000000000000
VS0 9 s0 0
R0 s0 6 15e-2
VS1 20 s1 0
R1 s1 4 18e-2
VS2 18 s2 0
R2 s2 15 10e-1
VS3 1 s3 0
R3 s3 13 47e2
VS4 3 s4 0
R4 s4 19 47e3
VS5 7 s5 0
R5 s5 4 68e1
VS6 15 s6 0
R6 s6 10 82e0
VS7 1 s7 0
R7 s7 0 47e2
VS8 8 s8 0
R8 s8 5 10e3
VS9 19 s9 0
R9 s9 13 22e3
VS10 12 s10 0
R10 s10 3 18e-1
VS11 3 s11 0
R11 s11 1 10e-1
VS12 20 s12 0
R12 s12 13 27e0
VS13 15 s13 0
R13 s13 16 22e0
VS14 16 s14 0
R14 s14 18 27e-2
VS15 0 s15 0
V15 e15 s15 DC 68e0
RI15 e15 10 39e-3
VS16 9 s16 0
V16 e16 s16 DC 39e1
RI16 e16 5 10e-2
VS17 12 s17 0
R17 s17 1 68e1
VS18 11 s18 0
R18 s18 18 33e-1
VS19 8 s19 0
V19 e19 s19 DC 12e-1
RI19 e19 11 22e-1
VS20 3 s20 0
R20 s20 18 15e0
VS21 6 s21 0
R21 s21 16 56e2
VS22 9 s22 0
R22 s22 8 82e-2
VS23 9 s23 0
R23 s23 7 22e0
VS24 14 s24 0
R24 s24 17 12e-2
VS25 16 s25 0
R25 s25 2 18e-1
VS26 9 s26 0
R26 s26 3 68e-2
VS27 3 s27 0
R27 s27 11 15e2
VS28 18 s28 0
R28 s28 17 22e0
VS29 0 s29 0
V29 e29 s29 DC 33e1
RI29 e29 2 68e-2
VS30 3 s30 0
R30 s30 14 82e0
.control
set numdgt=17
op
print v(1) v(2) v(3) v(4) v(5) v(6) v(7) v(8) v(9) v(10)
print v(11) v(12) v(13) v(14) v(15) v(16) v(17) v(18) v(19) v(20)
print i(vs0) i(vs1) i(vs2) i(vs3) i(vs4) i(vs5) i(vs6) i(vs7) i(vs8) i(vs9)
print i(vs10) i(vs11) i(vs12) i(vs13) i(vs14) i(vs15) i(vs16) i(vs17) i(vs18) i(vs19)
print i(vs20) i(vs21) i(vs22) i(vs23) i(vs24) i(vs25) i(vs26) i(vs27) i(vs28) i(vs29)
print i(vs30)
.endc
.end
