controls oracle dc-0177
* Generated (plan F2.7, ADR 0012): do not edit; regenerate with `pnpm sim oracle regen`. dc seed 20261030 index 177 nodes 21 elements 23
.options sparse gmin=1e-12 noopac
RG1 1 0 1000000000000
RG2 2 0 1000000000000
RG3 3 0 1000000000000
RG4 4 0 1000000000000
RG5 5 0 1000000000000
RG6 6 0 1000000000000
RG7 7 0 1000000000000
RG8 8 0 1000000000000
RG9 9 0 1000000000000
RG10 10 0 1000000000000
RG11 11 0 1000000000000
RG12 12 0 1000000000000
RG13 13 0 1000000000000
RG14 14 0 1000000000000
RG15 15 0 1000000000000
RG16 16 0 1000000000000
RG17 17 0 1000000000000
RG18 18 0 1000000000000
RG19 19 0 1000000000000
RG20 20 0 1000000000000
VS0 12 s0 0
R0 s0 3 18e-1
VS1 3 s1 0
R1 s1 14 82e0
VS2 20 s2 0
R2 s2 13 27e0
VS3 11 s3 0
R3 s3 18 33e-1
VS4 14 s4 0
R4 s4 17 12e-2
VS5 0 s5 0
V5 e5 s5 DC 68e0
RI5 e5 10 39e-3
VS6 2 s6 0
R6 s6 0 22e0
VS7 1 s7 0
R7 s7 0 47e2
VS8 9 s8 0
R8 s8 3 68e-2
VS9 20 s9 0
R9 s9 4 18e-2
VS10 9 s10 0
V10 e10 s10 DC 39e1
RI10 e10 5 10e-2
VS11 6 s11 0
R11 s11 16 56e2
VS12 0 s12 0
V12 e12 s12 DC 33e1
RI12 e12 2 68e-2
VS13 7 s13 0
R13 s13 4 68e1
VS14 3 s14 0
R14 s14 1 10e-1
VS15 1 s15 0
R15 s15 13 47e2
VS16 19 s16 0
R16 s16 13 22e3
VS17 9 s17 0
R17 s17 7 22e0
VS18 16 s18 0
R18 s18 18 27e-2
VS19 3 s19 0
R19 s19 19 47e3
VS20 9 s20 0
R20 s20 8 82e-2
VS21 3 s21 0
R21 s21 18 15e0
VS22 15 s22 0
R22 s22 16 22e0
.control
set numdgt=17
op
print v(1) v(2) v(3) v(4) v(5) v(6) v(7) v(8) v(9) v(10)
print v(11) v(12) v(13) v(14) v(15) v(16) v(17) v(18) v(19) v(20)
print i(vs0) i(vs1) i(vs2) i(vs3) i(vs4) i(vs5) i(vs6) i(vs7) i(vs8) i(vs9)
print i(vs10) i(vs11) i(vs12) i(vs13) i(vs14) i(vs15) i(vs16) i(vs17) i(vs18) i(vs19)
print i(vs20) i(vs21) i(vs22)
.endc
.end
