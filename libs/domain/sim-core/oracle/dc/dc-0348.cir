controls oracle dc-0348
* Generated (plan F2.7, ADR 0012): do not edit; regenerate with `pnpm sim oracle regen`. dc seed 20261030 index 348 nodes 14 elements 24
.options sparse gmin=1e-12 noopac
RG1 1 0 1000000000000
RG2 2 0 1000000000000
RG3 3 0 1000000000000
RG4 4 0 1000000000000
RG5 5 0 1000000000000
RG6 6 0 1000000000000
RG7 7 0 1000000000000
RG8 8 0 1000000000000
RG9 9 0 1000000000000
RG10 10 0 1000000000000
RG11 11 0 1000000000000
RG12 12 0 1000000000000
RG13 13 0 1000000000000
VS0 10 s0 0
R0 s0 7 56e2
VS1 1 s1 0
R1 s1 10 22e1
VS2 10 s2 0
R2 s2 3 33e0
VS3 6 s3 0
R3 s3 4 18e2
VS4 4 s4 0
R4 s4 13 33e-2
VS5 3 s5 0
R5 s5 6 15e-1
VS6 10 s6 0
R6 s6 5 27e2
VS7 9 s7 0
R7 s7 8 10e-1
VS8 0 s8 0
V8 e8 s8 DC 12e0
RI8 e8 11 68e-2
VS9 11 s9 0
R9 s9 10 39e3
VS10 8 s10 0
I10 s10 9 DC 15e-4
VS11 0 s11 0
R11 s11 2 33e-2
VS12 9 s12 0
R12 s12 3 18e-2
VS13 5 s13 0
I13 s13 3 DC 18e-4
VS14 5 s14 0
R14 s14 13 68e0
VS15 1 s15 0
R15 s15 8 68e1
VS16 6 s16 0
I16 s16 8 DC 56e-3
VS17 12 s17 0
R17 s17 6 68e2
VS18 13 s18 0
R18 s18 10 12e-2
VS19 13 s19 0
R19 s19 0 33e1
VS20 13 s20 0
R20 s20 7 18e2
VS21 13 s21 0
R21 s21 12 12e3
VS22 8 s22 0
I22 s22 11 DC 10e-4
VS23 11 s23 0
R23 s23 2 68e3
.control
set numdgt=17
op
print v(1) v(2) v(3) v(4) v(5) v(6) v(7) v(8) v(9) v(10)
print v(11) v(12) v(13)
print i(vs0) i(vs1) i(vs2) i(vs3) i(vs4) i(vs5) i(vs6) i(vs7) i(vs8) i(vs9)
print i(vs10) i(vs11) i(vs12) i(vs13) i(vs14) i(vs15) i(vs16) i(vs17) i(vs18) i(vs19)
print i(vs20) i(vs21) i(vs22) i(vs23)
.endc
.end
