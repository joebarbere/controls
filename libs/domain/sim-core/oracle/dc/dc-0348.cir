controls oracle dc-0348
* Generated (plan F2.7, ADR 0012): do not edit; regenerate with `pnpm sim oracle regen`. dc seed 20261030 index 348 nodes 14 elements 19
.options sparse gmin=1e-12 noopac
RG1 1 0 1000000000000
RG2 2 0 1000000000000
RG3 3 0 1000000000000
RG4 4 0 1000000000000
RG5 5 0 1000000000000
RG6 6 0 1000000000000
RG7 7 0 1000000000000
RG8 8 0 1000000000000
RG9 9 0 1000000000000
RG10 10 0 1000000000000
RG11 11 0 1000000000000
RG12 12 0 1000000000000
RG13 13 0 1000000000000
VS0 13 s0 0
R0 s0 7 18e2
VS1 13 s1 0
R1 s1 12 12e3
VS2 5 s2 0
R2 s2 13 68e0
VS3 1 s3 0
R3 s3 0 22e1
VS4 6 s4 0
I4 s4 8 DC 56e-3
VS5 0 s5 0
R5 s5 7 56e2
VS6 11 s6 0
R6 s6 2 68e3
VS7 9 s7 0
R7 s7 8 10e-1
VS8 9 s8 0
R8 s8 3 18e-2
VS9 5 s9 0
I9 s9 3 DC 18e-4
VS10 6 s10 0
R10 s10 4 18e2
VS11 4 s11 0
R11 s11 13 33e-2
VS12 3 s12 0
R12 s12 6 15e-1
VS13 10 s13 0
R13 s13 2 33e-2
VS14 8 s14 0
I14 s14 9 DC 15e-4
VS15 13 s15 0
R15 s15 10 33e1
VS16 13 s16 0
R16 s16 0 12e-2
VS17 0 s17 0
R17 s17 3 33e0
VS18 8 s18 0
I18 s18 11 DC 10e-4
.control
set numdgt=17
op
print v(1) v(2) v(3) v(4) v(5) v(6) v(7) v(8) v(9) v(10)
print v(11) v(12) v(13)
print i(vs0) i(vs1) i(vs2) i(vs3) i(vs4) i(vs5) i(vs6) i(vs7) i(vs8) i(vs9)
print i(vs10) i(vs11) i(vs12) i(vs13) i(vs14) i(vs15) i(vs16) i(vs17) i(vs18)
.endc
.end
