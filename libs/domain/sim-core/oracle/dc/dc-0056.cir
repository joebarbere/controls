controls oracle dc-0056
* Generated (plan F2.7, ADR 0012): do not edit; regenerate with `pnpm sim oracle regen`. dc seed 20261030 index 56 nodes 4 elements 5
.options sparse gmin=1e-12 noopac
RG1 1 0 1000000000000
RG2 2 0 1000000000000
RG3 3 0 1000000000000
VS0 3 s0 0
R0 s0 2 39e0
VS1 0 s1 0
V1 e1 s1 DC 12e0
RI1 e1 2 27e-3
VS2 0 s2 0
R2 s2 2 47e0
VS3 3 s3 0
R3 s3 0 68e-2
VS4 1 s4 0
V4 e4 s4 DC 47e1
RI4 e4 3 22e-1
.control
set numdgt=17
op
print v(1) v(2) v(3)
print i(vs0) i(vs1) i(vs2) i(vs3) i(vs4)
.endc
.end
