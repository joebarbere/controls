controls oracle dc-0214
* Generated (plan F2.7, ADR 0012): do not edit; regenerate with `pnpm sim oracle regen`. dc seed 20261030 index 214 nodes 15 elements 17
.options sparse gmin=1e-12 noopac
RG1 1 0 1000000000000
RG2 2 0 1000000000000
RG3 3 0 1000000000000
RG4 4 0 1000000000000
RG5 5 0 1000000000000
RG6 6 0 1000000000000
RG7 7 0 1000000000000
RG8 8 0 1000000000000
RG9 9 0 1000000000000
RG10 10 0 1000000000000
RG11 11 0 1000000000000
RG12 12 0 1000000000000
RG13 13 0 1000000000000
RG14 14 0 1000000000000
VS0 0 s0 0
V0 e0 s0 DC 10e0
RI0 e0 10 82e-2
VS1 14 s1 0
R1 s1 1 15e2
VS2 6 s2 0
R2 s2 8 39e2
VS3 13 s3 0
R3 s3 11 10e3
VS4 1 s4 0
R4 s4 3 33e-1
VS5 6 s5 0
I5 s5 8 DC 68e-2
VS6 11 s6 0
R6 s6 9 15e2
VS7 4 s7 0
V7 e7 s7 DC 47e-1
RI7 e7 6 18e-1
VS8 2 s8 0
R8 s8 13 27e2
VS9 7 s9 0
R9 s9 5 33e1
VS10 7 s10 0
R10 s10 12 22e-2
VS11 3 s11 0
V11 e11 s11 DC 15e0
RI11 e11 7 68e-2
VS12 6 s12 0
V12 e12 s12 DC 12e0
RI12 e12 5 68e-1
VS13 10 s13 0
I13 s13 11 DC 12e-2
VS14 0 s14 0
V14 e14 s14 DC 47e0
RI14 e14 2 39e-2
VS15 2 s15 0
R15 s15 10 56e1
VS16 5 s16 0
V16 e16 s16 DC 27e0
RI16 e16 9 27e-3
.control
set numdgt=17
op
print v(1) v(2) v(3) v(4) v(5) v(6) v(7) v(8) v(9) v(10)
print v(11) v(12) v(13) v(14)
print i(vs0) i(vs1) i(vs2) i(vs3) i(vs4) i(vs5) i(vs6) i(vs7) i(vs8) i(vs9)
print i(vs10) i(vs11) i(vs12) i(vs13) i(vs14) i(vs15) i(vs16)
.endc
.end
