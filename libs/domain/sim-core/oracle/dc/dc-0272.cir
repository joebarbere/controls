controls oracle dc-0272
* Generated (plan F2.7, ADR 0012): do not edit; regenerate with `pnpm sim oracle regen`. dc seed 20261030 index 272 nodes 23 elements 27
.options sparse gmin=1e-12 noopac
RG1 1 0 1000000000000
RG2 2 0 1000000000000
RG3 3 0 1000000000000
RG4 4 0 1000000000000
RG5 5 0 1000000000000
RG6 6 0 1000000000000
RG7 7 0 1000000000000
RG8 8 0 1000000000000
RG9 9 0 1000000000000
RG10 10 0 1000000000000
RG11 11 0 1000000000000
RG12 12 0 1000000000000
RG13 13 0 1000000000000
RG14 14 0 1000000000000
RG15 15 0 1000000000000
RG16 16 0 1000000000000
RG17 17 0 1000000000000
RG18 18 0 1000000000000
RG19 19 0 1000000000000
RG20 20 0 1000000000000
RG21 21 0 1000000000000
RG22 22 0 1000000000000
VS0 0 s0 0
R0 s0 17 12e3
VS1 8 s1 0
R1 s1 14 12e3
VS2 6 s2 0
R2 s2 4 82e2
VS3 22 s3 0
R3 s3 14 82e0
VS4 4 s4 0
R4 s4 5 18e3
VS5 14 s5 0
I5 s5 11 DC 27e-1
VS6 15 s6 0
R6 s6 19 15e-1
VS7 5 s7 0
R7 s7 17 27e1
VS8 0 s8 0
V8 e8 s8 DC 68e1
RI8 e8 11 27e-2
VS9 10 s9 0
R9 s9 2 47e-2
VS10 12 s10 0
R10 s10 16 56e1
VS11 0 s11 0
V11 e11 s11 DC 39e0
RI11 e11 1 68e-3
VS12 20 s12 0
R12 s12 8 15e3
VS13 8 s13 0
V13 e13 s13 DC 27e0
RI13 e13 18 47e-1
VS14 7 s14 0
R14 s14 17 56e2
VS15 7 s15 0
R15 s15 21 15e-2
VS16 15 s16 0
R16 s16 10 82e-2
VS17 16 s17 0
V17 e17 s17 DC 68e1
RI17 e17 0 82e-3
VS18 6 s18 0
R18 s18 1 12e0
VS19 16 s19 0
R19 s19 20 82e2
VS20 15 s20 0
R20 s20 3 10e-1
VS21 9 s21 0
R21 s21 1 10e0
VS22 16 s22 0
R22 s22 13 22e3
VS23 15 s23 0
R23 s23 0 27e-2
VS24 20 s24 0
R24 s24 21 12e3
VS25 3 s25 0
R25 s25 1 12e1
VS26 19 s26 0
R26 s26 22 47e1
.control
set numdgt=17
op
print v(1) v(2) v(3) v(4) v(5) v(6) v(7) v(8) v(9) v(10)
print v(11) v(12) v(13) v(14) v(15) v(16) v(17) v(18) v(19) v(20)
print v(21) v(22)
print i(vs0) i(vs1) i(vs2) i(vs3) i(vs4) i(vs5) i(vs6) i(vs7) i(vs8) i(vs9)
print i(vs10) i(vs11) i(vs12) i(vs13) i(vs14) i(vs15) i(vs16) i(vs17) i(vs18) i(vs19)
print i(vs20) i(vs21) i(vs22) i(vs23) i(vs24) i(vs25) i(vs26)
.endc
.end
