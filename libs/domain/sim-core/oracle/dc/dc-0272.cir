controls oracle dc-0272
* Generated (plan F2.7, ADR 0012): do not edit; regenerate with `pnpm sim oracle regen`. dc seed 20261030 index 272 nodes 23 elements 32
.options sparse gmin=1e-12 noopac
RG1 1 0 1000000000000
RG2 2 0 1000000000000
RG3 3 0 1000000000000
RG4 4 0 1000000000000
RG5 5 0 1000000000000
RG6 6 0 1000000000000
RG7 7 0 1000000000000
RG8 8 0 1000000000000
RG9 9 0 1000000000000
RG10 10 0 1000000000000
RG11 11 0 1000000000000
RG12 12 0 1000000000000
RG13 13 0 1000000000000
RG14 14 0 1000000000000
RG15 15 0 1000000000000
RG16 16 0 1000000000000
RG17 17 0 1000000000000
RG18 18 0 1000000000000
RG19 19 0 1000000000000
RG20 20 0 1000000000000
RG21 21 0 1000000000000
RG22 22 0 1000000000000
VS0 0 s0 0
R0 s0 17 12e3
VS1 20 s1 0
R1 s1 8 15e3
VS2 0 s2 0
V2 e2 s2 DC 68e1
RI2 e2 11 27e-2
VS3 7 s3 0
R3 s3 17 56e2
VS4 10 s4 0
R4 s4 2 47e-2
VS5 8 s5 0
R5 s5 14 12e3
VS6 17 s6 0
V6 e6 s6 DC 27e-1
RI6 e6 2 33e-2
VS7 3 s7 0
R7 s7 1 12e1
VS8 5 s8 0
R8 s8 17 27e1
VS9 15 s9 0
R9 s9 0 27e-2
VS10 15 s10 0
R10 s10 19 15e-1
VS11 11 s11 0
R11 s11 9 22e-1
VS12 16 s12 0
R12 s12 13 22e3
VS13 18 s13 0
R13 s13 11 18e0
VS14 12 s14 0
R14 s14 17 47e2
VS15 15 s15 0
R15 s15 3 10e-1
VS16 12 s16 0
R16 s16 16 56e1
VS17 6 s17 0
R17 s17 4 82e2
VS18 0 s18 0
V18 e18 s18 DC 39e0
RI18 e18 1 68e-3
VS19 7 s19 0
R19 s19 21 15e-2
VS20 19 s20 0
R20 s20 22 47e1
VS21 6 s21 0
R21 s21 1 12e0
VS22 2 s22 0
R22 s22 13 56e1
VS23 8 s23 0
V23 e23 s23 DC 27e0
RI23 e23 18 47e-1
VS24 9 s24 0
R24 s24 1 10e0
VS25 22 s25 0
R25 s25 14 82e0
VS26 15 s26 0
R26 s26 10 82e-2
VS27 14 s27 0
I27 s27 11 DC 27e-1
VS28 16 s28 0
V28 e28 s28 DC 68e1
RI28 e28 0 82e-3
VS29 16 s29 0
R29 s29 20 82e2
VS30 20 s30 0
R30 s30 21 12e3
VS31 4 s31 0
R31 s31 5 18e3
.control
set numdgt=17
op
print v(1) v(2) v(3) v(4) v(5) v(6) v(7) v(8) v(9) v(10)
print v(11) v(12) v(13) v(14) v(15) v(16) v(17) v(18) v(19) v(20)
print v(21) v(22)
print i(vs0) i(vs1) i(vs2) i(vs3) i(vs4) i(vs5) i(vs6) i(vs7) i(vs8) i(vs9)
print i(vs10) i(vs11) i(vs12) i(vs13) i(vs14) i(vs15) i(vs16) i(vs17) i(vs18) i(vs19)
print i(vs20) i(vs21) i(vs22) i(vs23) i(vs24) i(vs25) i(vs26) i(vs27) i(vs28) i(vs29)
print i(vs30) i(vs31)
.endc
.end
