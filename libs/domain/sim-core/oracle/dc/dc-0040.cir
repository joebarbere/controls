controls oracle dc-0040
* Generated (plan F2.7, ADR 0012): do not edit; regenerate with `pnpm sim oracle regen`. dc seed 20261030 index 40 nodes 3 elements 4
.options sparse gmin=1e-12 noopac
RG1 1 0 1000000000000
RG2 2 0 1000000000000
VS0 0 s0 0
R0 s0 1 27e-2
VS1 0 s1 0
V1 e1 s1 DC 56e0
RI1 e1 1 15e-3
VS2 2 s2 0
V2 e2 s2 DC 82e-1
RI2 e2 0 12e-2
VS3 1 s3 0
R3 s3 2 33e3
.control
set numdgt=17
op
print v(1) v(2)
print i(vs0) i(vs1) i(vs2) i(vs3)
.endc
.end
