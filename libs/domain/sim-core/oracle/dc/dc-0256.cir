controls oracle dc-0256
* Generated (plan F2.7, ADR 0012): do not edit; regenerate with `pnpm sim oracle regen`. dc seed 20261030 index 256 nodes 16 elements 28
.options sparse gmin=1e-12 noopac
RG1 1 0 1000000000000
RG2 2 0 1000000000000
RG3 3 0 1000000000000
RG4 4 0 1000000000000
RG5 5 0 1000000000000
RG6 6 0 1000000000000
RG7 7 0 1000000000000
RG8 8 0 1000000000000
RG9 9 0 1000000000000
RG10 10 0 1000000000000
RG11 11 0 1000000000000
RG12 12 0 1000000000000
RG13 13 0 1000000000000
RG14 14 0 1000000000000
RG15 15 0 1000000000000
VS0 8 s0 0
R0 s0 15 12e1
VS1 11 s1 0
R1 s1 12 33e1
VS2 0 s2 0
V2 e2 s2 DC 82e1
RI2 e2 12 47e-2
VS3 15 s3 0
R3 s3 9 68e0
VS4 15 s4 0
R4 s4 2 22e-2
VS5 6 s5 0
R5 s5 15 33e0
VS6 14 s6 0
V6 e6 s6 DC 33e0
RI6 e6 9 12e-1
VS7 8 s7 0
R7 s7 13 68e1
VS8 15 s8 0
I8 s8 14 DC 12e-4
VS9 1 s9 0
R9 s9 13 39e2
VS10 13 s10 0
I10 s10 10 DC 18e-2
VS11 12 s11 0
R11 s11 5 56e0
VS12 8 s12 0
I12 s12 7 DC 56e-2
VS13 9 s13 0
R13 s13 10 22e-2
VS14 4 s14 0
V14 e14 s14 DC 15e0
RI14 e14 7 39e-3
VS15 10 s15 0
R15 s15 15 68e-2
VS16 9 s16 0
R16 s16 13 56e0
VS17 3 s17 0
R17 s17 1 27e2
VS18 7 s18 0
R18 s18 6 27e-1
VS19 14 s19 0
V19 e19 s19 DC 10e-1
RI19 e19 3 82e-2
VS20 10 s20 0
R20 s20 2 33e2
VS21 14 s21 0
R21 s21 3 56e-1
VS22 0 s22 0
R22 s22 15 56e-1
VS23 6 s23 0
R23 s23 11 82e-2
VS24 14 s24 0
V24 e24 s24 DC 82e1
RI24 e24 7 82e-3
VS25 4 s25 0
I25 s25 2 DC 12e-2
VS26 8 s26 0
R26 s26 2 15e0
VS27 5 s27 0
R27 s27 8 39e3
.control
set numdgt=17
op
print v(1) v(2) v(3) v(4) v(5) v(6) v(7) v(8) v(9) v(10)
print v(11) v(12) v(13) v(14) v(15)
print i(vs0) i(vs1) i(vs2) i(vs3) i(vs4) i(vs5) i(vs6) i(vs7) i(vs8) i(vs9)
print i(vs10) i(vs11) i(vs12) i(vs13) i(vs14) i(vs15) i(vs16) i(vs17) i(vs18) i(vs19)
print i(vs20) i(vs21) i(vs22) i(vs23) i(vs24) i(vs25) i(vs26) i(vs27)
.endc
.end
