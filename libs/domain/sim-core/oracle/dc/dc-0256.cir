controls oracle dc-0256
* Generated (plan F2.7, ADR 0012): do not edit; regenerate with `pnpm sim oracle regen`. dc seed 20261030 index 256 nodes 16 elements 29
.options sparse gmin=1e-12 noopac
RG1 1 0 1000000000000
RG2 2 0 1000000000000
RG3 3 0 1000000000000
RG4 4 0 1000000000000
RG5 5 0 1000000000000
RG6 6 0 1000000000000
RG7 7 0 1000000000000
RG8 8 0 1000000000000
RG9 9 0 1000000000000
RG10 10 0 1000000000000
RG11 11 0 1000000000000
RG12 12 0 1000000000000
RG13 13 0 1000000000000
RG14 14 0 1000000000000
RG15 15 0 1000000000000
VS0 7 s0 0
R0 s0 6 27e-1
VS1 8 s1 0
R1 s1 15 12e1
VS2 13 s2 0
I2 s2 10 DC 18e-2
VS3 0 s3 0
V3 e3 s3 DC 82e1
RI3 e3 7 82e-3
VS4 15 s4 0
I4 s4 0 DC 12e-4
VS5 8 s5 0
R5 s5 2 15e0
VS6 14 s6 0
R6 s6 13 56e0
VS7 9 s7 0
V7 e7 s7 DC 82e1
RI7 e7 12 47e-2
VS8 5 s8 0
R8 s8 8 39e3
VS9 15 s9 0
R9 s9 2 22e-2
VS10 6 s10 0
R10 s10 15 33e0
VS11 10 s11 0
R11 s11 2 33e2
VS12 9 s12 0
R12 s12 15 56e-1
VS13 8 s13 0
I13 s13 7 DC 56e-2
VS14 8 s14 0
R14 s14 13 68e1
VS15 10 s15 0
R15 s15 15 68e-2
VS16 1 s16 0
R16 s16 13 39e2
VS17 15 s17 0
R17 s17 14 68e0
VS18 4 s18 0
R18 s18 9 22e2
VS19 6 s19 0
R19 s19 11 82e-2
VS20 12 s20 0
R20 s20 5 56e0
VS21 4 s21 0
I21 s21 2 DC 12e-2
VS22 4 s22 0
V22 e22 s22 DC 15e0
RI22 e22 7 39e-3
VS23 0 s23 0
V23 e23 s23 DC 10e-1
RI23 e23 3 82e-2
VS24 14 s24 0
R24 s24 10 22e-2
VS25 0 s25 0
R25 s25 3 56e-1
VS26 11 s26 0
R26 s26 12 33e1
VS27 3 s27 0
R27 s27 1 27e2
VS28 0 s28 0
V28 e28 s28 DC 33e0
RI28 e28 14 12e-1
.control
set numdgt=17
op
print v(1) v(2) v(3) v(4) v(5) v(6) v(7) v(8) v(9) v(10)
print v(11) v(12) v(13) v(14) v(15)
print i(vs0) i(vs1) i(vs2) i(vs3) i(vs4) i(vs5) i(vs6) i(vs7) i(vs8) i(vs9)
print i(vs10) i(vs11) i(vs12) i(vs13) i(vs14) i(vs15) i(vs16) i(vs17) i(vs18) i(vs19)
print i(vs20) i(vs21) i(vs22) i(vs23) i(vs24) i(vs25) i(vs26) i(vs27) i(vs28)
.endc
.end
