controls oracle dc-0011
* Generated (plan F2.7, ADR 0012): do not edit; regenerate with `pnpm sim oracle regen`. dc seed 20261030 index 11 nodes 7 elements 14
.options sparse gmin=1e-12 noopac
RG1 1 0 1000000000000
RG2 2 0 1000000000000
RG3 3 0 1000000000000
RG4 4 0 1000000000000
RG5 5 0 1000000000000
RG6 6 0 1000000000000
VS0 5 s0 0
R0 s0 2 68e2
VS1 0 s1 0
R1 s1 6 33e2
VS2 6 s2 0
I2 s2 0 DC 18e-4
VS3 1 s3 0
R3 s3 3 47e0
VS4 0 s4 0
V4 e4 s4 DC 47e0
RI4 e4 4 12e-1
VS5 3 s5 0
R5 s5 6 82e3
VS6 5 s6 0
R6 s6 6 15e2
VS7 4 s7 0
R7 s7 5 12e-2
VS8 6 s8 0
I8 s8 5 DC 47e-3
VS9 5 s9 0
V9 e9 s9 DC 27e-1
RI9 e9 6 68e-2
VS10 1 s10 0
I10 s10 6 DC 68e-2
VS11 0 s11 0
R11 s11 3 56e-2
VS12 0 s12 0
R12 s12 2 15e1
VS13 1 s13 0
R13 s13 6 82e2
.control
set numdgt=17
op
print v(1) v(2) v(3) v(4) v(5) v(6)
print i(vs0) i(vs1) i(vs2) i(vs3) i(vs4) i(vs5) i(vs6) i(vs7) i(vs8) i(vs9)
print i(vs10) i(vs11) i(vs12) i(vs13)
.endc
.end
