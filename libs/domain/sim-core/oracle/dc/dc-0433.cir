controls oracle dc-0433
* Generated (plan F2.7, ADR 0012): do not edit; regenerate with `pnpm sim oracle regen`. dc seed 20261030 index 433 nodes 12 elements 24
.options sparse gmin=1e-12 noopac
RG1 1 0 1000000000000
RG2 2 0 1000000000000
RG3 3 0 1000000000000
RG4 4 0 1000000000000
RG5 5 0 1000000000000
RG6 6 0 1000000000000
RG7 7 0 1000000000000
RG8 8 0 1000000000000
RG9 9 0 1000000000000
RG10 10 0 1000000000000
RG11 11 0 1000000000000
VS0 0 s0 0
V0 e0 s0 DC 56e-1
RI0 e0 2 18e-2
VS1 10 s1 0
R1 s1 0 68e2
VS2 3 s2 0
R2 s2 6 27e0
VS3 6 s3 0
R3 s3 2 47e-1
VS4 6 s4 0
R4 s4 9 22e-2
VS5 1 s5 0
V5 e5 s5 DC 33e0
RI5 e5 7 27e-2
VS6 2 s6 0
R6 s6 7 68e-2
VS7 3 s7 0
I7 s7 7 DC 22e-3
VS8 0 s8 0
V8 e8 s8 DC 27e-1
RI8 e8 10 56e-2
VS9 8 s9 0
R9 s9 9 39e0
VS10 2 s10 0
R10 s10 0 15e1
VS11 11 s11 0
R11 s11 1 33e0
VS12 5 s12 0
R12 s12 8 47e-2
VS13 0 s13 0
R13 s13 3 82e1
VS14 8 s14 0
V14 e14 s14 DC 56e-1
RI14 e14 7 22e-1
VS15 0 s15 0
R15 s15 5 12e3
VS16 7 s16 0
I16 s16 3 DC 39e-2
VS17 11 s17 0
R17 s17 8 18e0
VS18 3 s18 0
R18 s18 8 82e1
VS19 10 s19 0
R19 s19 7 82e-1
VS20 11 s20 0
R20 s20 4 68e-1
VS21 2 s21 0
I21 s21 9 DC 33e-3
VS22 4 s22 0
R22 s22 1 33e-1
VS23 0 s23 0
R23 s23 8 10e-1
.control
set numdgt=17
op
print v(1) v(2) v(3) v(4) v(5) v(6) v(7) v(8) v(9) v(10)
print v(11)
print i(vs0) i(vs1) i(vs2) i(vs3) i(vs4) i(vs5) i(vs6) i(vs7) i(vs8) i(vs9)
print i(vs10) i(vs11) i(vs12) i(vs13) i(vs14) i(vs15) i(vs16) i(vs17) i(vs18) i(vs19)
print i(vs20) i(vs21) i(vs22) i(vs23)
.endc
.end
