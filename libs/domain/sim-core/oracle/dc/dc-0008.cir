controls oracle dc-0008
* Generated (plan F2.7, ADR 0012): do not edit; regenerate with `pnpm sim oracle regen`. dc seed 20261030 index 8 nodes 10 elements 17
.options sparse gmin=1e-12 noopac
RG1 1 0 1000000000000
RG2 2 0 1000000000000
RG3 3 0 1000000000000
RG4 4 0 1000000000000
RG5 5 0 1000000000000
RG6 6 0 1000000000000
RG7 7 0 1000000000000
RG8 8 0 1000000000000
RG9 9 0 1000000000000
VS0 8 s0 0
R0 s0 9 12e1
VS1 2 s1 0
R1 s1 8 10e3
VS2 4 s2 0
R2 s2 9 82e2
VS3 2 s3 0
R3 s3 5 10e0
VS4 2 s4 0
R4 s4 7 18e-1
VS5 6 s5 0
R5 s5 4 10e0
VS6 0 s6 0
V6 e6 s6 DC 10e1
RI6 e6 4 82e-3
VS7 5 s7 0
V7 e7 s7 DC 39e1
RI7 e7 0 56e-3
VS8 9 s8 0
R8 s8 2 22e0
VS9 4 s9 0
R9 s9 2 47e3
VS10 7 s10 0
R10 s10 2 47e3
VS11 3 s11 0
V11 e11 s11 DC 27e0
RI11 e11 2 27e-1
VS12 6 s12 0
R12 s12 1 68e-1
VS13 1 s13 0
R13 s13 3 56e-2
VS14 6 s14 0
V14 e14 s14 DC 22e0
RI14 e14 0 39e-3
VS15 7 s15 0
R15 s15 9 15e3
VS16 3 s16 0
R16 s16 1 33e0
.control
set numdgt=17
op
print v(1) v(2) v(3) v(4) v(5) v(6) v(7) v(8) v(9)
print i(vs0) i(vs1) i(vs2) i(vs3) i(vs4) i(vs5) i(vs6) i(vs7) i(vs8) i(vs9)
print i(vs10) i(vs11) i(vs12) i(vs13) i(vs14) i(vs15) i(vs16)
.endc
.end
