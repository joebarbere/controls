controls oracle dc-0008
* Generated (plan F2.7, ADR 0012): do not edit; regenerate with `pnpm sim oracle regen`. dc seed 20261030 index 8 nodes 10 elements 12
.options sparse gmin=1e-12 noopac
RG1 1 0 1000000000000
RG2 2 0 1000000000000
RG3 3 0 1000000000000
RG4 4 0 1000000000000
RG5 5 0 1000000000000
RG6 6 0 1000000000000
RG7 7 0 1000000000000
RG8 8 0 1000000000000
RG9 9 0 1000000000000
VS0 3 s0 0
R0 s0 8 10e3
VS1 7 s1 0
R1 s1 3 47e3
VS2 0 s2 0
V2 e2 s2 DC 27e0
RI2 e2 3 27e-1
VS3 4 s3 0
R3 s3 9 82e2
VS4 6 s4 0
R4 s4 4 10e0
VS5 1 s5 0
R5 s5 0 56e-2
VS6 3 s6 0
R6 s6 7 18e-1
VS7 3 s7 0
R7 s7 5 10e0
VS8 6 s8 0
V8 e8 s8 DC 22e0
RI8 e8 2 39e-3
VS9 4 s9 0
R9 s9 3 47e3
VS10 2 s10 0
V10 e10 s10 DC 10e1
RI10 e10 4 82e-3
VS11 0 s11 0
R11 s11 1 33e0
.control
set numdgt=17
op
print v(1) v(2) v(3) v(4) v(5) v(6) v(7) v(8) v(9)
print i(vs0) i(vs1) i(vs2) i(vs3) i(vs4) i(vs5) i(vs6) i(vs7) i(vs8) i(vs9)
print i(vs10) i(vs11)
.endc
.end
