controls oracle dc-0382
* Generated (plan F2.7, ADR 0012): do not edit; regenerate with `pnpm sim oracle regen`. dc seed 20261030 index 382 nodes 20 elements 21
.options sparse gmin=1e-12 noopac
RG1 1 0 1000000000000
RG2 2 0 1000000000000
RG3 3 0 1000000000000
RG4 4 0 1000000000000
RG5 5 0 1000000000000
RG6 6 0 1000000000000
RG7 7 0 1000000000000
RG8 8 0 1000000000000
RG9 9 0 1000000000000
RG10 10 0 1000000000000
RG11 11 0 1000000000000
RG12 12 0 1000000000000
RG13 13 0 1000000000000
RG14 14 0 1000000000000
RG15 15 0 1000000000000
RG16 16 0 1000000000000
RG17 17 0 1000000000000
RG18 18 0 1000000000000
RG19 19 0 1000000000000
VS0 2 s0 0
R0 s0 15 47e-2
VS1 0 s1 0
V1 e1 s1 DC 27e-1
RI1 e1 15 33e-3
VS2 19 s2 0
R2 s2 9 10e0
VS3 16 s3 0
R3 s3 2 68e1
VS4 4 s4 0
R4 s4 17 39e1
VS5 18 s5 0
R5 s5 19 27e-2
VS6 17 s6 0
R6 s6 19 33e-1
VS7 12 s7 0
R7 s7 1 56e-2
VS8 11 s8 0
R8 s8 9 12e0
VS9 6 s9 0
R9 s9 19 33e-1
VS10 17 s10 0
V10 e10 s10 DC 82e-1
RI10 e10 13 27e-3
VS11 3 s11 0
R11 s11 9 39e3
VS12 0 s12 0
V12 e12 s12 DC 15e1
RI12 e12 19 15e-1
VS13 17 s13 0
R13 s13 7 39e3
VS14 1 s14 0
R14 s14 4 39e-2
VS15 13 s15 0
R15 s15 8 18e1
VS16 10 s16 0
R16 s16 14 27e-2
VS17 7 s17 0
R17 s17 5 12e-1
VS18 16 s18 0
R18 s18 17 18e-1
VS19 14 s19 0
V19 e19 s19 DC 12e-1
RI19 e19 18 18e-1
VS20 7 s20 0
R20 s20 9 68e-2
.control
set numdgt=17
op
print v(1) v(2) v(3) v(4) v(5) v(6) v(7) v(8) v(9) v(10)
print v(11) v(12) v(13) v(14) v(15) v(16) v(17) v(18) v(19)
print i(vs0) i(vs1) i(vs2) i(vs3) i(vs4) i(vs5) i(vs6) i(vs7) i(vs8) i(vs9)
print i(vs10) i(vs11) i(vs12) i(vs13) i(vs14) i(vs15) i(vs16) i(vs17) i(vs18) i(vs19)
print i(vs20)
.endc
.end
