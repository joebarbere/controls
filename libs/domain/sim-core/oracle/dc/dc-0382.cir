controls oracle dc-0382
* Generated (plan F2.7, ADR 0012): do not edit; regenerate with `pnpm sim oracle regen`. dc seed 20261030 index 382 nodes 20 elements 28
.options sparse gmin=1e-12 noopac
RG1 1 0 1000000000000
RG2 2 0 1000000000000
RG3 3 0 1000000000000
RG4 4 0 1000000000000
RG5 5 0 1000000000000
RG6 6 0 1000000000000
RG7 7 0 1000000000000
RG8 8 0 1000000000000
RG9 9 0 1000000000000
RG10 10 0 1000000000000
RG11 11 0 1000000000000
RG12 12 0 1000000000000
RG13 13 0 1000000000000
RG14 14 0 1000000000000
RG15 15 0 1000000000000
RG16 16 0 1000000000000
RG17 17 0 1000000000000
RG18 18 0 1000000000000
RG19 19 0 1000000000000
VS0 0 s0 0
V0 e0 s0 DC 82e-1
RI0 e0 13 27e-3
VS1 2 s1 0
R1 s1 15 47e-2
VS2 7 s2 0
R2 s2 5 12e-1
VS3 10 s3 0
R3 s3 16 12e0
VS4 16 s4 0
R4 s4 11 22e2
VS5 7 s5 0
R5 s5 9 68e-2
VS6 13 s6 0
R6 s6 8 18e1
VS7 16 s7 0
R7 s7 0 18e-1
VS8 17 s8 0
V8 e8 s8 DC 39e1
RI8 e8 3 22e-1
VS9 6 s9 0
R9 s9 4 56e0
VS10 12 s10 0
R10 s10 1 56e-2
VS11 0 s11 0
R11 s11 7 39e3
VS12 4 s12 0
R12 s12 0 39e1
VS13 11 s13 0
R13 s13 9 12e0
VS14 1 s14 0
R14 s14 8 82e-2
VS15 2 s15 0
R15 s15 5 33e3
VS16 6 s16 0
R16 s16 19 33e-1
VS17 17 s17 0
V17 e17 s17 DC 27e-1
RI17 e17 15 33e-3
VS18 18 s18 0
R18 s18 19 27e-2
VS19 16 s19 0
R19 s19 2 68e1
VS20 14 s20 0
V20 e20 s20 DC 12e-1
RI20 e20 18 18e-1
VS21 10 s21 0
R21 s21 14 27e-2
VS22 3 s22 0
R22 s22 9 39e3
VS23 10 s23 0
R23 s23 12 27e3
VS24 0 s24 0
R24 s24 19 33e-1
VS25 17 s25 0
V25 e25 s25 DC 15e1
RI25 e25 19 15e-1
VS26 1 s26 0
R26 s26 4 39e-2
VS27 19 s27 0
R27 s27 9 10e0
.control
set numdgt=17
op
print v(1) v(2) v(3) v(4) v(5) v(6) v(7) v(8) v(9) v(10)
print v(11) v(12) v(13) v(14) v(15) v(16) v(17) v(18) v(19)
print i(vs0) i(vs1) i(vs2) i(vs3) i(vs4) i(vs5) i(vs6) i(vs7) i(vs8) i(vs9)
print i(vs10) i(vs11) i(vs12) i(vs13) i(vs14) i(vs15) i(vs16) i(vs17) i(vs18) i(vs19)
print i(vs20) i(vs21) i(vs22) i(vs23) i(vs24) i(vs25) i(vs26) i(vs27)
.endc
.end
