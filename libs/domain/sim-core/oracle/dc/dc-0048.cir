controls oracle dc-0048
* Generated (plan F2.7, ADR 0012): do not edit; regenerate with `pnpm sim oracle regen`. dc seed 20261030 index 48 nodes 18 elements 24
.options sparse gmin=1e-12 noopac
RG1 1 0 1000000000000
RG2 2 0 1000000000000
RG3 3 0 1000000000000
RG4 4 0 1000000000000
RG5 5 0 1000000000000
RG6 6 0 1000000000000
RG7 7 0 1000000000000
RG8 8 0 1000000000000
RG9 9 0 1000000000000
RG10 10 0 1000000000000
RG11 11 0 1000000000000
RG12 12 0 1000000000000
RG13 13 0 1000000000000
RG14 14 0 1000000000000
RG15 15 0 1000000000000
RG16 16 0 1000000000000
RG17 17 0 1000000000000
VS0 8 s0 0
R0 s0 3 12e-2
VS1 1 s1 0
R1 s1 8 10e3
VS2 13 s2 0
R2 s2 2 56e2
VS3 7 s3 0
R3 s3 6 33e-1
VS4 9 s4 0
R4 s4 14 39e-1
VS5 17 s5 0
R5 s5 14 47e2
VS6 14 s6 0
R6 s6 4 68e-2
VS7 2 s7 0
R7 s7 12 68e-1
VS8 0 s8 0
V8 e8 s8 DC 15e-1
RI8 e8 1 47e-1
VS9 4 s9 0
I9 s9 0 DC 47e-2
VS10 14 s10 0
R10 s10 13 12e1
VS11 5 s11 0
R11 s11 8 68e0
VS12 17 s12 0
R12 s12 15 27e-1
VS13 16 s13 0
R13 s13 0 12e-2
VS14 16 s14 0
R14 s14 14 68e1
VS15 10 s15 0
R15 s15 8 27e3
VS16 8 s16 0
I16 s16 5 DC 56e-2
VS17 16 s17 0
I17 s17 0 DC 56e-1
VS18 11 s18 0
R18 s18 1 27e3
VS19 12 s19 0
R19 s19 8 56e1
VS20 11 s20 0
R20 s20 5 33e2
VS21 4 s21 0
R21 s21 11 47e1
VS22 7 s22 0
R22 s22 16 68e2
VS23 4 s23 0
R23 s23 13 82e0
.control
set numdgt=17
op
print v(1) v(2) v(3) v(4) v(5) v(6) v(7) v(8) v(9) v(10)
print v(11) v(12) v(13) v(14) v(15) v(16) v(17)
print i(vs0) i(vs1) i(vs2) i(vs3) i(vs4) i(vs5) i(vs6) i(vs7) i(vs8) i(vs9)
print i(vs10) i(vs11) i(vs12) i(vs13) i(vs14) i(vs15) i(vs16) i(vs17) i(vs18) i(vs19)
print i(vs20) i(vs21) i(vs22) i(vs23)
.endc
.end
