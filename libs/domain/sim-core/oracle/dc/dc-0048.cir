controls oracle dc-0048
* Generated (plan F2.7, ADR 0012): do not edit; regenerate with `pnpm sim oracle regen`. dc seed 20261030 index 48 nodes 18 elements 28
.options sparse gmin=1e-12 noopac
RG1 1 0 1000000000000
RG2 2 0 1000000000000
RG3 3 0 1000000000000
RG4 4 0 1000000000000
RG5 5 0 1000000000000
RG6 6 0 1000000000000
RG7 7 0 1000000000000
RG8 8 0 1000000000000
RG9 9 0 1000000000000
RG10 10 0 1000000000000
RG11 11 0 1000000000000
RG12 12 0 1000000000000
RG13 13 0 1000000000000
RG14 14 0 1000000000000
RG15 15 0 1000000000000
RG16 16 0 1000000000000
RG17 17 0 1000000000000
VS0 14 s0 0
R0 s0 4 68e-2
VS1 16 s1 0
R1 s1 0 12e-2
VS2 8 s2 0
R2 s2 3 12e-2
VS3 7 s3 0
R3 s3 16 68e2
VS4 4 s4 0
I4 s4 0 DC 47e-2
VS5 10 s5 0
R5 s5 8 27e3
VS6 11 s6 0
R6 s6 5 33e2
VS7 9 s7 0
R7 s7 14 39e-1
VS8 14 s8 0
R8 s8 13 12e1
VS9 10 s9 0
R9 s9 15 10e3
VS10 7 s10 0
R10 s10 6 33e-1
VS11 3 s11 0
R11 s11 4 39e-1
VS12 17 s12 0
R12 s12 14 47e2
VS13 2 s13 0
R13 s13 12 68e-1
VS14 17 s14 0
R14 s14 15 27e-1
VS15 13 s15 0
R15 s15 2 56e2
VS16 10 s16 0
R16 s16 9 47e2
VS17 2 s17 0
R17 s17 6 12e0
VS18 12 s18 0
R18 s18 8 56e1
VS19 16 s19 0
R19 s19 14 68e1
VS20 1 s20 0
R20 s20 8 10e3
VS21 11 s21 0
R21 s21 1 27e3
VS22 5 s22 0
R22 s22 8 68e0
VS23 4 s23 0
R23 s23 11 47e1
VS24 4 s24 0
R24 s24 13 82e0
VS25 0 s25 0
V25 e25 s25 DC 15e-1
RI25 e25 1 47e-1
VS26 8 s26 0
I26 s26 5 DC 56e-2
VS27 16 s27 0
I27 s27 0 DC 56e-1
.control
set numdgt=17
op
print v(1) v(2) v(3) v(4) v(5) v(6) v(7) v(8) v(9) v(10)
print v(11) v(12) v(13) v(14) v(15) v(16) v(17)
print i(vs0) i(vs1) i(vs2) i(vs3) i(vs4) i(vs5) i(vs6) i(vs7) i(vs8) i(vs9)
print i(vs10) i(vs11) i(vs12) i(vs13) i(vs14) i(vs15) i(vs16) i(vs17) i(vs18) i(vs19)
print i(vs20) i(vs21) i(vs22) i(vs23) i(vs24) i(vs25) i(vs26) i(vs27)
.endc
.end
