controls oracle dc-0353
* Generated (plan F2.7, ADR 0012): do not edit; regenerate with `pnpm sim oracle regen`. dc seed 20261030 index 353 nodes 15 elements 26
.options sparse gmin=1e-12 noopac
RG1 1 0 1000000000000
RG2 2 0 1000000000000
RG3 3 0 1000000000000
RG4 4 0 1000000000000
RG5 5 0 1000000000000
RG6 6 0 1000000000000
RG7 7 0 1000000000000
RG8 8 0 1000000000000
RG9 9 0 1000000000000
RG10 10 0 1000000000000
RG11 11 0 1000000000000
RG12 12 0 1000000000000
RG13 13 0 1000000000000
RG14 14 0 1000000000000
VS0 14 s0 0
R0 s0 5 56e-2
VS1 1 s1 0
R1 s1 9 47e1
VS2 0 s2 0
V2 e2 s2 DC 10e-1
RI2 e2 4 22e-1
VS3 4 s3 0
R3 s3 7 47e2
VS4 1 s4 0
R4 s4 10 10e-1
VS5 9 s5 0
V5 e5 s5 DC 22e1
RI5 e5 13 22e-1
VS6 13 s6 0
R6 s6 12 47e2
VS7 11 s7 0
R7 s7 13 27e-1
VS8 6 s8 0
R8 s8 4 22e0
VS9 5 s9 0
R9 s9 3 47e-1
VS10 6 s10 0
I10 s10 11 DC 33e-3
VS11 3 s11 0
R11 s11 2 82e2
VS12 1 s12 0
V12 e12 s12 DC 68e0
RI12 e12 8 39e-3
VS13 6 s13 0
R13 s13 12 18e-1
VS14 5 s14 0
R14 s14 13 82e-2
VS15 10 s15 0
R15 s15 4 10e3
VS16 7 s16 0
R16 s16 8 15e3
VS17 3 s17 0
R17 s17 14 12e3
VS18 4 s18 0
R18 s18 0 47e0
VS19 10 s19 0
V19 e19 s19 DC 33e-1
RI19 e19 8 27e-2
VS20 5 s20 0
R20 s20 0 56e1
VS21 14 s21 0
R21 s21 1 15e1
VS22 14 s22 0
R22 s22 4 12e2
VS23 14 s23 0
R23 s23 10 18e3
VS24 11 s24 0
R24 s24 1 10e1
VS25 6 s25 0
R25 s25 2 56e1
.control
set numdgt=17
op
print v(1) v(2) v(3) v(4) v(5) v(6) v(7) v(8) v(9) v(10)
print v(11) v(12) v(13) v(14)
print i(vs0) i(vs1) i(vs2) i(vs3) i(vs4) i(vs5) i(vs6) i(vs7) i(vs8) i(vs9)
print i(vs10) i(vs11) i(vs12) i(vs13) i(vs14) i(vs15) i(vs16) i(vs17) i(vs18) i(vs19)
print i(vs20) i(vs21) i(vs22) i(vs23) i(vs24) i(vs25)
.endc
.end
