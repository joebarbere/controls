controls oracle dc-0234
* Generated (plan F2.7, ADR 0012): do not edit; regenerate with `pnpm sim oracle regen`. dc seed 20261030 index 234 nodes 16 elements 26
.options sparse gmin=1e-12 noopac
RG1 1 0 1000000000000
RG2 2 0 1000000000000
RG3 3 0 1000000000000
RG4 4 0 1000000000000
RG5 5 0 1000000000000
RG6 6 0 1000000000000
RG7 7 0 1000000000000
RG8 8 0 1000000000000
RG9 9 0 1000000000000
RG10 10 0 1000000000000
RG11 11 0 1000000000000
RG12 12 0 1000000000000
RG13 13 0 1000000000000
RG14 14 0 1000000000000
RG15 15 0 1000000000000
VS0 12 s0 0
R0 s0 1 18e1
VS1 11 s1 0
R1 s1 12 82e-1
VS2 7 s2 0
I2 s2 8 DC 39e-3
VS3 9 s3 0
R3 s3 10 39e2
VS4 5 s4 0
R4 s4 1 15e0
VS5 0 s5 0
V5 e5 s5 DC 33e0
RI5 e5 9 47e-2
VS6 6 s6 0
R6 s6 3 33e-1
VS7 15 s7 0
R7 s7 2 22e2
VS8 9 s8 0
R8 s8 11 47e1
VS9 3 s9 0
R9 s9 13 47e0
VS10 14 s10 0
R10 s10 2 15e0
VS11 13 s11 0
R11 s11 9 10e0
VS12 8 s12 0
R12 s12 6 33e3
VS13 6 s13 0
R13 s13 15 12e0
VS14 2 s14 0
R14 s14 6 15e-1
VS15 7 s15 0
R15 s15 0 56e3
VS16 7 s16 0
R16 s16 12 56e0
VS17 15 s17 0
R17 s17 2 22e1
VS18 6 s18 0
R18 s18 1 82e-2
VS19 4 s19 0
R19 s19 6 10e-2
VS20 13 s20 0
R20 s20 7 68e3
VS21 14 s21 0
I21 s21 5 DC 33e-1
VS22 9 s22 0
R22 s22 2 56e2
VS23 8 s23 0
I23 s23 1 DC 82e-2
VS24 3 s24 0
I24 s24 15 DC 12e-4
VS25 13 s25 0
R25 s25 6 12e2
.control
set numdgt=17
op
print v(1) v(2) v(3) v(4) v(5) v(6) v(7) v(8) v(9) v(10)
print v(11) v(12) v(13) v(14) v(15)
print i(vs0) i(vs1) i(vs2) i(vs3) i(vs4) i(vs5) i(vs6) i(vs7) i(vs8) i(vs9)
print i(vs10) i(vs11) i(vs12) i(vs13) i(vs14) i(vs15) i(vs16) i(vs17) i(vs18) i(vs19)
print i(vs20) i(vs21) i(vs22) i(vs23) i(vs24) i(vs25)
.endc
.end
