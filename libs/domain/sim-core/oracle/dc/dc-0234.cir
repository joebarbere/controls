controls oracle dc-0234
* Generated (plan F2.7, ADR 0012): do not edit; regenerate with `pnpm sim oracle regen`. dc seed 20261030 index 234 nodes 16 elements 30
.options sparse gmin=1e-12 noopac
RG1 1 0 1000000000000
RG2 2 0 1000000000000
RG3 3 0 1000000000000
RG4 4 0 1000000000000
RG5 5 0 1000000000000
RG6 6 0 1000000000000
RG7 7 0 1000000000000
RG8 8 0 1000000000000
RG9 9 0 1000000000000
RG10 10 0 1000000000000
RG11 11 0 1000000000000
RG12 12 0 1000000000000
RG13 13 0 1000000000000
RG14 14 0 1000000000000
RG15 15 0 1000000000000
VS0 5 s0 0
R0 s0 15 12e0
VS1 13 s1 0
R1 s1 7 68e3
VS2 7 s2 0
R2 s2 12 56e0
VS3 14 s3 0
R3 s3 2 15e0
VS4 0 s4 0
R4 s4 1 15e0
VS5 12 s5 0
R5 s5 1 18e1
VS6 15 s6 0
R6 s6 2 22e2
VS7 0 s7 0
V7 e7 s7 DC 47e-1
RI7 e7 14 27e-1
VS8 9 s8 0
R8 s8 10 39e2
VS9 3 s9 0
R9 s9 13 47e0
VS10 9 s10 0
R10 s10 11 47e1
VS11 10 s11 0
V11 e11 s11 DC 68e1
RI11 e11 4 15e-3
VS12 15 s12 0
R12 s12 2 22e1
VS13 13 s13 0
R13 s13 9 10e0
VS14 8 s14 0
R14 s14 5 33e3
VS15 11 s15 0
R15 s15 12 82e-1
VS16 7 s16 0
I16 s16 8 DC 39e-3
VS17 14 s17 0
I17 s17 0 DC 33e-1
VS18 3 s18 0
I18 s18 15 DC 12e-4
VS19 2 s19 0
R19 s19 5 15e-1
VS20 6 s20 0
R20 s20 8 68e-1
VS21 13 s21 0
R21 s21 5 12e2
VS22 5 s22 0
R22 s22 1 82e-2
VS23 0 s23 0
V23 e23 s23 DC 12e-1
RI23 e23 5 18e-1
VS24 6 s24 0
V24 e24 s24 DC 33e0
RI24 e24 9 47e-2
VS25 8 s25 0
I25 s25 1 DC 82e-2
VS26 9 s26 0
R26 s26 2 56e2
VS27 7 s27 0
R27 s27 6 56e3
VS28 4 s28 0
R28 s28 5 10e-2
VS29 5 s29 0
R29 s29 3 33e-1
.control
set numdgt=17
op
print v(1) v(2) v(3) v(4) v(5) v(6) v(7) v(8) v(9) v(10)
print v(11) v(12) v(13) v(14) v(15)
print i(vs0) i(vs1) i(vs2) i(vs3) i(vs4) i(vs5) i(vs6) i(vs7) i(vs8) i(vs9)
print i(vs10) i(vs11) i(vs12) i(vs13) i(vs14) i(vs15) i(vs16) i(vs17) i(vs18) i(vs19)
print i(vs20) i(vs21) i(vs22) i(vs23) i(vs24) i(vs25) i(vs26) i(vs27) i(vs28) i(vs29)
.endc
.end
