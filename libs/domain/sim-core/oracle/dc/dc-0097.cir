controls oracle dc-0097
* Generated (plan F2.7, ADR 0012): do not edit; regenerate with `pnpm sim oracle regen`. dc seed 20261030 index 97 nodes 25 elements 42
.options sparse gmin=1e-12 noopac
RG1 1 0 1000000000000
RG2 2 0 1000000000000
RG3 3 0 1000000000000
RG4 4 0 1000000000000
RG5 5 0 1000000000000
RG6 6 0 1000000000000
RG7 7 0 1000000000000
RG8 8 0 1000000000000
RG9 9 0 1000000000000
RG10 10 0 1000000000000
RG11 11 0 1000000000000
RG12 12 0 1000000000000
RG13 13 0 1000000000000
RG14 14 0 1000000000000
RG15 15 0 1000000000000
RG16 16 0 1000000000000
RG17 17 0 1000000000000
RG18 18 0 1000000000000
RG19 19 0 1000000000000
RG20 20 0 1000000000000
RG21 21 0 1000000000000
RG22 22 0 1000000000000
RG23 23 0 1000000000000
RG24 24 0 1000000000000
VS0 6 s0 0
R0 s0 14 22e1
VS1 23 s1 0
R1 s1 17 33e0
VS2 11 s2 0
R2 s2 8 15e-2
VS3 8 s3 0
R3 s3 7 18e-2
VS4 0 s4 0
V4 e4 s4 DC 33e0
RI4 e4 8 56e-3
VS5 11 s5 0
R5 s5 17 82e-1
VS6 13 s6 0
R6 s6 8 10e3
VS7 11 s7 0
R7 s7 20 22e2
VS8 22 s8 0
R8 s8 1 47e2
VS9 15 s9 0
R9 s9 11 68e1
VS10 12 s10 0
I10 s10 9 DC 68e-2
VS11 19 s11 0
R11 s11 7 10e-2
VS12 5 s12 0
R12 s12 4 68e-1
VS13 18 s13 0
R13 s13 11 82e1
VS14 14 s14 0
R14 s14 15 10e1
VS15 14 s15 0
I15 s15 23 DC 18e-2
VS16 9 s16 0
R16 s16 7 82e3
VS17 23 s17 0
R17 s17 24 47e0
VS18 23 s18 0
V18 e18 s18 DC 82e0
RI18 e18 11 33e-3
VS19 22 s19 0
R19 s19 15 82e2
VS20 2 s20 0
R20 s20 5 68e2
VS21 21 s21 0
R21 s21 18 39e2
VS22 6 s22 0
R22 s22 12 56e1
VS23 20 s23 0
R23 s23 13 12e2
VS24 14 s24 0
R24 s24 1 10e0
VS25 19 s25 0
V25 e25 s25 DC 68e1
RI25 e25 15 18e-1
VS26 10 s26 0
R26 s26 13 68e0
VS27 4 s27 0
R27 s27 12 10e1
VS28 1 s28 0
R28 s28 19 82e3
VS29 1 s29 0
R29 s29 8 33e3
VS30 3 s30 0
R30 s30 23 27e3
VS31 16 s31 0
R31 s31 14 15e2
VS32 21 s32 0
R32 s32 8 82e0
VS33 7 s33 0
R33 s33 0 12e1
VS34 9 s34 0
R34 s34 16 22e0
VS35 10 s35 0
R35 s35 24 39e3
VS36 19 s36 0
R36 s36 12 22e2
VS37 15 s37 0
R37 s37 4 39e3
VS38 14 s38 0
R38 s38 3 12e3
VS39 2 s39 0
V39 e39 s39 DC 68e-1
RI39 e39 22 27e-3
VS40 10 s40 0
R40 s40 2 82e0
VS41 10 s41 0
R41 s41 18 33e-1
.control
set numdgt=17
op
print v(1) v(2) v(3) v(4) v(5) v(6) v(7) v(8) v(9) v(10)
print v(11) v(12) v(13) v(14) v(15) v(16) v(17) v(18) v(19) v(20)
print v(21) v(22) v(23) v(24)
print i(vs0) i(vs1) i(vs2) i(vs3) i(vs4) i(vs5) i(vs6) i(vs7) i(vs8) i(vs9)
print i(vs10) i(vs11) i(vs12) i(vs13) i(vs14) i(vs15) i(vs16) i(vs17) i(vs18) i(vs19)
print i(vs20) i(vs21) i(vs22) i(vs23) i(vs24) i(vs25) i(vs26) i(vs27) i(vs28) i(vs29)
print i(vs30) i(vs31) i(vs32) i(vs33) i(vs34) i(vs35) i(vs36) i(vs37) i(vs38) i(vs39)
print i(vs40) i(vs41)
.endc
.end
