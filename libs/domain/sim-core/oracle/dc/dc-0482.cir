controls oracle dc-0482
* Generated (plan F2.7, ADR 0012): do not edit; regenerate with `pnpm sim oracle regen`. dc seed 20261030 index 482 nodes 14 elements 30
.options sparse gmin=1e-12 noopac
RG1 1 0 1000000000000
RG2 2 0 1000000000000
RG3 3 0 1000000000000
RG4 4 0 1000000000000
RG5 5 0 1000000000000
RG6 6 0 1000000000000
RG7 7 0 1000000000000
RG8 8 0 1000000000000
RG9 9 0 1000000000000
RG10 10 0 1000000000000
RG11 11 0 1000000000000
RG12 12 0 1000000000000
RG13 13 0 1000000000000
VS0 12 s0 0
R0 s0 6 18e1
VS1 3 s1 0
R1 s1 13 27e3
VS2 0 s2 0
V2 e2 s2 DC 15e-1
RI2 e2 2 56e-1
VS3 3 s3 0
V3 e3 s3 DC 68e0
RI3 e3 4 18e-1
VS4 9 s4 0
R4 s4 7 68e1
VS5 9 s5 0
R5 s5 3 68e2
VS6 11 s6 0
I6 s6 9 DC 39e-3
VS7 10 s7 0
R7 s7 13 10e-1
VS8 1 s8 0
R8 s8 5 33e3
VS9 5 s9 0
R9 s9 4 82e3
VS10 8 s10 0
V10 e10 s10 DC 39e0
RI10 e10 5 22e-2
VS11 2 s11 0
R11 s11 0 33e2
VS12 10 s12 0
I12 s12 13 DC 82e-1
VS13 7 s13 0
R13 s13 8 47e0
VS14 13 s14 0
R14 s14 11 47e-2
VS15 10 s15 0
R15 s15 0 12e2
VS16 9 s16 0
I16 s16 6 DC 47e-4
VS17 10 s17 0
I17 s17 5 DC 33e-1
VS18 12 s18 0
I18 s18 2 DC 27e-2
VS19 3 s19 0
R19 s19 6 12e2
VS20 6 s20 0
R20 s20 5 12e3
VS21 13 s21 0
R21 s21 1 22e2
VS22 9 s22 0
I22 s22 6 DC 82e-2
VS23 8 s23 0
V23 e23 s23 DC 82e-1
RI23 e23 11 12e-1
VS24 9 s24 0
V24 e24 s24 DC 27e0
RI24 e24 8 33e-2
VS25 8 s25 0
I25 s25 4 DC 18e-2
VS26 2 s26 0
V26 e26 s26 DC 47e-1
RI26 e26 6 10e-2
VS27 2 s27 0
V27 e27 s27 DC 33e0
RI27 e27 12 39e-3
VS28 0 s28 0
V28 e28 s28 DC 22e0
RI28 e28 5 27e-2
VS29 0 s29 0
R29 s29 7 12e0
.control
set numdgt=17
op
print v(1) v(2) v(3) v(4) v(5) v(6) v(7) v(8) v(9) v(10)
print v(11) v(12) v(13)
print i(vs0) i(vs1) i(vs2) i(vs3) i(vs4) i(vs5) i(vs6) i(vs7) i(vs8) i(vs9)
print i(vs10) i(vs11) i(vs12) i(vs13) i(vs14) i(vs15) i(vs16) i(vs17) i(vs18) i(vs19)
print i(vs20) i(vs21) i(vs22) i(vs23) i(vs24) i(vs25) i(vs26) i(vs27) i(vs28) i(vs29)
.endc
.end
