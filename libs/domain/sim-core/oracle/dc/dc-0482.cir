controls oracle dc-0482
* Generated (plan F2.7, ADR 0012): do not edit; regenerate with `pnpm sim oracle regen`. dc seed 20261030 index 482 nodes 14 elements 26
.options sparse gmin=1e-12 noopac
RG1 1 0 1000000000000
RG2 2 0 1000000000000
RG3 3 0 1000000000000
RG4 4 0 1000000000000
RG5 5 0 1000000000000
RG6 6 0 1000000000000
RG7 7 0 1000000000000
RG8 8 0 1000000000000
RG9 9 0 1000000000000
RG10 10 0 1000000000000
RG11 11 0 1000000000000
RG12 12 0 1000000000000
RG13 13 0 1000000000000
VS0 11 s0 0
I0 s0 0 DC 39e-3
VS1 0 s1 0
R1 s1 7 68e1
VS2 2 s2 0
R2 s2 6 33e2
VS3 0 s3 0
V3 e3 s3 DC 27e0
RI3 e3 8 33e-2
VS4 7 s4 0
R4 s4 8 47e0
VS5 9 s5 0
R5 s5 5 12e3
VS6 12 s6 0
R6 s6 9 18e1
VS7 6 s7 0
V7 e7 s7 DC 15e-1
RI7 e7 2 56e-1
VS8 8 s8 0
V8 e8 s8 DC 82e-1
RI8 e8 11 12e-1
VS9 10 s9 0
I9 s9 13 DC 82e-1
VS10 8 s10 0
I10 s10 4 DC 18e-2
VS11 6 s11 0
V11 e11 s11 DC 22e0
RI11 e11 5 27e-2
VS12 10 s12 0
I12 s12 5 DC 33e-1
VS13 10 s13 0
R13 s13 6 12e2
VS14 13 s14 0
R14 s14 11 47e-2
VS15 3 s15 0
V15 e15 s15 DC 68e0
RI15 e15 4 18e-1
VS16 12 s16 0
I16 s16 2 DC 27e-2
VS17 6 s17 0
R17 s17 7 12e0
VS18 8 s18 0
V18 e18 s18 DC 39e0
RI18 e18 5 22e-2
VS19 3 s19 0
R19 s19 9 12e2
VS20 1 s20 0
R20 s20 5 33e3
VS21 3 s21 0
R21 s21 13 27e3
VS22 13 s22 0
R22 s22 1 22e2
VS23 0 s23 0
R23 s23 3 68e2
VS24 0 s24 0
I24 s24 9 DC 82e-2
VS25 0 s25 0
I25 s25 9 DC 47e-4
.control
set numdgt=17
op
print v(1) v(2) v(3) v(4) v(5) v(6) v(7) v(8) v(9) v(10)
print v(11) v(12) v(13)
print i(vs0) i(vs1) i(vs2) i(vs3) i(vs4) i(vs5) i(vs6) i(vs7) i(vs8) i(vs9)
print i(vs10) i(vs11) i(vs12) i(vs13) i(vs14) i(vs15) i(vs16) i(vs17) i(vs18) i(vs19)
print i(vs20) i(vs21) i(vs22) i(vs23) i(vs24) i(vs25)
.endc
.end
