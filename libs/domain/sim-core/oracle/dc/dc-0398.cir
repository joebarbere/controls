controls oracle dc-0398
* Generated (plan F2.7, ADR 0012): do not edit; regenerate with `pnpm sim oracle regen`. dc seed 20261030 index 398 nodes 21 elements 36
.options sparse gmin=1e-12 noopac
RG1 1 0 1000000000000
RG2 2 0 1000000000000
RG3 3 0 1000000000000
RG4 4 0 1000000000000
RG5 5 0 1000000000000
RG6 6 0 1000000000000
RG7 7 0 1000000000000
RG8 8 0 1000000000000
RG9 9 0 1000000000000
RG10 10 0 1000000000000
RG11 11 0 1000000000000
RG12 12 0 1000000000000
RG13 13 0 1000000000000
RG14 14 0 1000000000000
RG15 15 0 1000000000000
RG16 16 0 1000000000000
RG17 17 0 1000000000000
RG18 18 0 1000000000000
RG19 19 0 1000000000000
RG20 20 0 1000000000000
VS0 15 s0 0
I0 s0 20 DC 22e-1
VS1 0 s1 0
V1 e1 s1 DC 27e1
RI1 e1 18 68e-3
VS2 20 s2 0
I2 s2 0 DC 18e-4
VS3 11 s3 0
R3 s3 12 33e-2
VS4 7 s4 0
R4 s4 15 47e-2
VS5 4 s5 0
R5 s5 3 18e2
VS6 11 s6 0
R6 s6 10 27e-1
VS7 16 s7 0
R7 s7 10 68e1
VS8 6 s8 0
R8 s8 7 56e-1
VS9 10 s9 0
R9 s9 19 33e0
VS10 14 s10 0
I10 s10 3 DC 33e-2
VS11 2 s11 0
R11 s11 1 39e0
VS12 13 s12 0
R12 s12 17 39e-1
VS13 18 s13 0
I13 s13 5 DC 10e-2
VS14 2 s14 0
V14 e14 s14 DC 27e-1
RI14 e14 18 18e-2
VS15 19 s15 0
V15 e15 s15 DC 47e1
RI15 e15 10 39e-3
VS16 4 s16 0
V16 e16 s16 DC 22e-1
RI16 e16 16 82e-3
VS17 8 s17 0
V17 e17 s17 DC 33e-1
RI17 e17 0 12e-3
VS18 8 s18 0
R18 s18 1 68e1
VS19 17 s19 0
R19 s19 15 12e-2
VS20 16 s20 0
I20 s20 15 DC 68e-4
VS21 13 s21 0
V21 e21 s21 DC 27e0
RI21 e21 1 33e-3
VS22 13 s22 0
R22 s22 7 82e3
VS23 5 s23 0
R23 s23 19 68e-2
VS24 12 s24 0
R24 s24 9 27e-1
VS25 3 s25 0
V25 e25 s25 DC 22e1
RI25 e25 18 56e-2
VS26 14 s26 0
R26 s26 20 12e3
VS27 14 s27 0
V27 e27 s27 DC 33e-1
RI27 e27 15 82e-3
VS28 6 s28 0
R28 s28 1 18e1
VS29 8 s29 0
I29 s29 17 DC 10e-4
VS30 0 s30 0
V30 e30 s30 DC 12e0
RI30 e30 5 82e-1
VS31 12 s31 0
V31 e31 s31 DC 82e0
RI31 e31 9 15e-3
VS32 5 s32 0
R32 s32 9 12e1
VS33 0 s33 0
R33 s33 4 33e0
VS34 9 s34 0
R34 s34 1 39e2
VS35 20 s35 0
R35 s35 5 68e-2
.control
set numdgt=17
op
print v(1) v(2) v(3) v(4) v(5) v(6) v(7) v(8) v(9) v(10)
print v(11) v(12) v(13) v(14) v(15) v(16) v(17) v(18) v(19) v(20)
print i(vs0) i(vs1) i(vs2) i(vs3) i(vs4) i(vs5) i(vs6) i(vs7) i(vs8) i(vs9)
print i(vs10) i(vs11) i(vs12) i(vs13) i(vs14) i(vs15) i(vs16) i(vs17) i(vs18) i(vs19)
print i(vs20) i(vs21) i(vs22) i(vs23) i(vs24) i(vs25) i(vs26) i(vs27) i(vs28) i(vs29)
print i(vs30) i(vs31) i(vs32) i(vs33) i(vs34) i(vs35)
.endc
.end
