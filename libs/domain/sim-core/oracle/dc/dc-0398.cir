controls oracle dc-0398
* Generated (plan F2.7, ADR 0012): do not edit; regenerate with `pnpm sim oracle regen`. dc seed 20261030 index 398 nodes 21 elements 32
.options sparse gmin=1e-12 noopac
RG1 1 0 1000000000000
RG2 2 0 1000000000000
RG3 3 0 1000000000000
RG4 4 0 1000000000000
RG5 5 0 1000000000000
RG6 6 0 1000000000000
RG7 7 0 1000000000000
RG8 8 0 1000000000000
RG9 9 0 1000000000000
RG10 10 0 1000000000000
RG11 11 0 1000000000000
RG12 12 0 1000000000000
RG13 13 0 1000000000000
RG14 14 0 1000000000000
RG15 15 0 1000000000000
RG16 16 0 1000000000000
RG17 17 0 1000000000000
RG18 18 0 1000000000000
RG19 19 0 1000000000000
RG20 20 0 1000000000000
VS0 8 s0 0
I0 s0 17 DC 10e-4
VS1 15 s1 0
I1 s1 20 DC 22e-1
VS2 20 s2 0
I2 s2 0 DC 18e-4
VS3 11 s3 0
R3 s3 10 27e-1
VS4 0 s4 0
V4 e4 s4 DC 12e0
RI4 e4 5 82e-1
VS5 18 s5 0
I5 s5 5 DC 10e-2
VS6 5 s6 0
R6 s6 19 68e-2
VS7 12 s7 0
V7 e7 s7 DC 82e0
RI7 e7 9 15e-3
VS8 9 s8 0
R8 s8 1 39e2
VS9 5 s9 0
R9 s9 9 12e1
VS10 19 s10 0
V10 e10 s10 DC 47e1
RI10 e10 10 39e-3
VS11 14 s11 0
I11 s11 3 DC 33e-2
VS12 2 s12 0
R12 s12 1 39e0
VS13 12 s13 0
R13 s13 9 27e-1
VS14 4 s14 0
V14 e14 s14 DC 22e-1
RI14 e14 16 82e-3
VS15 4 s15 0
R15 s15 3 18e2
VS16 13 s16 0
R16 s16 7 82e3
VS17 14 s17 0
V17 e17 s17 DC 33e-1
RI17 e17 15 82e-3
VS18 6 s18 0
R18 s18 1 18e1
VS19 11 s19 0
R19 s19 12 33e-2
VS20 20 s20 0
R20 s20 5 68e-2
VS21 0 s21 0
V21 e21 s21 DC 27e1
RI21 e21 18 68e-3
VS22 17 s22 0
R22 s22 15 12e-2
VS23 14 s23 0
R23 s23 20 12e3
VS24 2 s24 0
V24 e24 s24 DC 27e-1
RI24 e24 18 18e-2
VS25 13 s25 0
V25 e25 s25 DC 27e0
RI25 e25 1 33e-3
VS26 10 s26 0
R26 s26 19 33e0
VS27 8 s27 0
R27 s27 1 68e1
VS28 16 s28 0
I28 s28 15 DC 68e-4
VS29 8 s29 0
V29 e29 s29 DC 33e-1
RI29 e29 0 12e-3
VS30 0 s30 0
R30 s30 4 33e0
VS31 16 s31 0
R31 s31 10 68e1
.control
set numdgt=17
op
print v(1) v(2) v(3) v(4) v(5) v(6) v(7) v(8) v(9) v(10)
print v(11) v(12) v(13) v(14) v(15) v(16) v(17) v(18) v(19) v(20)
print i(vs0) i(vs1) i(vs2) i(vs3) i(vs4) i(vs5) i(vs6) i(vs7) i(vs8) i(vs9)
print i(vs10) i(vs11) i(vs12) i(vs13) i(vs14) i(vs15) i(vs16) i(vs17) i(vs18) i(vs19)
print i(vs20) i(vs21) i(vs22) i(vs23) i(vs24) i(vs25) i(vs26) i(vs27) i(vs28) i(vs29)
print i(vs30) i(vs31)
.endc
.end
