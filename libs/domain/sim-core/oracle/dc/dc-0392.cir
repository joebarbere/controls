controls oracle dc-0392
* Generated (plan F2.7, ADR 0012): do not edit; regenerate with `pnpm sim oracle regen`. dc seed 20261030 index 392 nodes 23 elements 25
.options sparse gmin=1e-12 noopac
RG1 1 0 1000000000000
RG2 2 0 1000000000000
RG3 3 0 1000000000000
RG4 4 0 1000000000000
RG5 5 0 1000000000000
RG6 6 0 1000000000000
RG7 7 0 1000000000000
RG8 8 0 1000000000000
RG9 9 0 1000000000000
RG10 10 0 1000000000000
RG11 11 0 1000000000000
RG12 12 0 1000000000000
RG13 13 0 1000000000000
RG14 14 0 1000000000000
RG15 15 0 1000000000000
RG16 16 0 1000000000000
RG17 17 0 1000000000000
RG18 18 0 1000000000000
RG19 19 0 1000000000000
RG20 20 0 1000000000000
RG21 21 0 1000000000000
RG22 22 0 1000000000000
VS0 5 s0 0
R0 s0 0 39e-2
VS1 4 s1 0
R1 s1 19 56e2
VS2 10 s2 0
R2 s2 16 22e-2
VS3 3 s3 0
R3 s3 1 56e1
VS4 0 s4 0
R4 s4 21 15e2
VS5 0 s5 0
V5 e5 s5 DC 47e0
RI5 e5 2 27e-3
VS6 4 s6 0
R6 s6 0 56e-1
VS7 14 s7 0
R7 s7 17 15e0
VS8 2 s8 0
R8 s8 1 33e2
VS9 11 s9 0
R9 s9 14 22e0
VS10 6 s10 0
R10 s10 4 10e1
VS11 19 s11 0
R11 s11 0 27e3
VS12 12 s12 0
R12 s12 3 39e-1
VS13 20 s13 0
V13 e13 s13 DC 12e0
RI13 e13 19 56e-1
VS14 10 s14 0
V14 e14 s14 DC 39e1
RI14 e14 13 22e-1
VS15 16 s15 0
R15 s15 20 18e-2
VS16 2 s16 0
R16 s16 18 56e0
VS17 19 s17 0
R17 s17 22 33e0
VS18 0 s18 0
R18 s18 8 68e-1
VS19 0 s19 0
R19 s19 20 22e3
VS20 1 s20 0
R20 s20 14 27e1
VS21 4 s21 0
R21 s21 1 27e1
VS22 7 s22 0
R22 s22 6 33e-1
VS23 15 s23 0
R23 s23 17 47e-1
VS24 9 s24 0
R24 s24 10 82e-1
.control
set numdgt=17
op
print v(1) v(2) v(3) v(4) v(5) v(6) v(7) v(8) v(9) v(10)
print v(11) v(12) v(13) v(14) v(15) v(16) v(17) v(18) v(19) v(20)
print v(21) v(22)
print i(vs0) i(vs1) i(vs2) i(vs3) i(vs4) i(vs5) i(vs6) i(vs7) i(vs8) i(vs9)
print i(vs10) i(vs11) i(vs12) i(vs13) i(vs14) i(vs15) i(vs16) i(vs17) i(vs18) i(vs19)
print i(vs20) i(vs21) i(vs22) i(vs23) i(vs24)
.endc
.end
