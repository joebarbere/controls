controls oracle dc-0392
* Generated (plan F2.7, ADR 0012): do not edit; regenerate with `pnpm sim oracle regen`. dc seed 20261030 index 392 nodes 23 elements 35
.options sparse gmin=1e-12 noopac
RG1 1 0 1000000000000
RG2 2 0 1000000000000
RG3 3 0 1000000000000
RG4 4 0 1000000000000
RG5 5 0 1000000000000
RG6 6 0 1000000000000
RG7 7 0 1000000000000
RG8 8 0 1000000000000
RG9 9 0 1000000000000
RG10 10 0 1000000000000
RG11 11 0 1000000000000
RG12 12 0 1000000000000
RG13 13 0 1000000000000
RG14 14 0 1000000000000
RG15 15 0 1000000000000
RG16 16 0 1000000000000
RG17 17 0 1000000000000
RG18 18 0 1000000000000
RG19 19 0 1000000000000
RG20 20 0 1000000000000
RG21 21 0 1000000000000
RG22 22 0 1000000000000
VS0 15 s0 0
R0 s0 22 22e-2
VS1 0 s1 0
V1 e1 s1 DC 12e0
RI1 e1 19 56e-1
VS2 21 s2 0
R2 s2 3 15e0
VS3 13 s3 0
R3 s3 19 22e3
VS4 18 s4 0
R4 s4 22 22e-1
VS5 10 s5 0
V5 e5 s5 DC 39e1
RI5 e5 13 22e-1
VS6 18 s6 0
R6 s6 11 22e0
VS7 4 s7 0
V7 e7 s7 DC 47e0
RI7 e7 2 27e-3
VS8 5 s8 0
R8 s8 4 39e-2
VS9 15 s9 0
R9 s9 17 47e-1
VS10 4 s10 0
R10 s10 21 15e2
VS11 8 s11 0
R11 s11 9 68e2
VS12 3 s12 0
R12 s12 1 56e1
VS13 15 s13 0
R13 s13 7 68e1
VS14 11 s14 0
R14 s14 14 22e0
VS15 2 s15 0
R15 s15 18 56e0
VS16 20 s16 0
R16 s16 19 56e2
VS17 20 s17 0
R17 s17 4 56e-1
VS18 1 s18 0
R18 s18 14 27e1
VS19 12 s19 0
R19 s19 3 39e-1
VS20 20 s20 0
R20 s20 1 27e1
VS21 6 s21 0
R21 s21 20 10e1
VS22 9 s22 0
R22 s22 10 82e-1
VS23 16 s23 0
R23 s23 0 18e-2
VS24 9 s24 0
R24 s24 1 33e-1
VS25 20 s25 0
R25 s25 12 82e0
VS26 19 s26 0
R26 s26 5 47e0
VS27 19 s27 0
R27 s27 4 27e3
VS28 10 s28 0
R28 s28 16 22e-2
VS29 4 s29 0
R29 s29 0 22e3
VS30 2 s30 0
R30 s30 1 33e2
VS31 7 s31 0
R31 s31 6 33e-1
VS32 14 s32 0
R32 s32 17 15e0
VS33 19 s33 0
R33 s33 22 33e0
VS34 4 s34 0
R34 s34 8 68e-1
.control
set numdgt=17
op
print v(1) v(2) v(3) v(4) v(5) v(6) v(7) v(8) v(9) v(10)
print v(11) v(12) v(13) v(14) v(15) v(16) v(17) v(18) v(19) v(20)
print v(21) v(22)
print i(vs0) i(vs1) i(vs2) i(vs3) i(vs4) i(vs5) i(vs6) i(vs7) i(vs8) i(vs9)
print i(vs10) i(vs11) i(vs12) i(vs13) i(vs14) i(vs15) i(vs16) i(vs17) i(vs18) i(vs19)
print i(vs20) i(vs21) i(vs22) i(vs23) i(vs24) i(vs25) i(vs26) i(vs27) i(vs28) i(vs29)
print i(vs30) i(vs31) i(vs32) i(vs33) i(vs34)
.endc
.end
