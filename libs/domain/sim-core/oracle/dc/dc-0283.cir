controls oracle dc-0283
* Generated (plan F2.7, ADR 0012): do not edit; regenerate with `pnpm sim oracle regen`. dc seed 20261030 index 283 nodes 30 elements 33
.options sparse gmin=1e-12 noopac
RG1 1 0 1000000000000
RG2 2 0 1000000000000
RG3 3 0 1000000000000
RG4 4 0 1000000000000
RG5 5 0 1000000000000
RG6 6 0 1000000000000
RG7 7 0 1000000000000
RG8 8 0 1000000000000
RG9 9 0 1000000000000
RG10 10 0 1000000000000
RG11 11 0 1000000000000
RG12 12 0 1000000000000
RG13 13 0 1000000000000
RG14 14 0 1000000000000
RG15 15 0 1000000000000
RG16 16 0 1000000000000
RG17 17 0 1000000000000
RG18 18 0 1000000000000
RG19 19 0 1000000000000
RG20 20 0 1000000000000
RG21 21 0 1000000000000
RG22 22 0 1000000000000
RG23 23 0 1000000000000
RG24 24 0 1000000000000
RG25 25 0 1000000000000
RG26 26 0 1000000000000
RG27 27 0 1000000000000
RG28 28 0 1000000000000
RG29 29 0 1000000000000
VS0 5 s0 0
R0 s0 8 47e-2
VS1 11 s1 0
R1 s1 1 22e3
VS2 22 s2 0
I2 s2 7 DC 68e-4
VS3 16 s3 0
R3 s3 18 15e-1
VS4 7 s4 0
R4 s4 21 27e1
VS5 7 s5 0
R5 s5 15 82e-1
VS6 8 s6 0
R6 s6 10 39e0
VS7 28 s7 0
R7 s7 10 18e0
VS8 25 s8 0
R8 s8 21 47e-1
VS9 0 s9 0
V9 e9 s9 DC 27e1
RI9 e9 4 27e-2
VS10 27 s10 0
R10 s10 6 15e-2
VS11 15 s11 0
R11 s11 24 33e2
VS12 11 s12 0
V12 e12 s12 DC 15e0
RI12 e12 20 10e-3
VS13 7 s13 0
R13 s13 11 18e3
VS14 21 s14 0
R14 s14 4 15e1
VS15 28 s15 0
R15 s15 2 18e-1
VS16 9 s16 0
R16 s16 10 15e-1
VS17 18 s17 0
R17 s17 9 47e1
VS18 3 s18 0
R18 s18 21 15e1
VS19 9 s19 0
R19 s19 4 56e-1
VS20 23 s20 0
R20 s20 9 12e2
VS21 13 s21 0
I21 s21 16 DC 68e-3
VS22 9 s22 0
V22 e22 s22 DC 33e1
RI22 e22 24 10e-1
VS23 13 s23 0
R23 s23 28 10e0
VS24 18 s24 0
R24 s24 26 47e2
VS25 21 s25 0
R25 s25 22 15e3
VS26 7 s26 0
V26 e26 s26 DC 15e0
RI26 e26 17 18e-1
VS27 13 s27 0
R27 s27 19 47e0
VS28 26 s28 0
R28 s28 22 39e1
VS29 9 s29 0
R29 s29 29 15e1
VS30 14 s30 0
V30 e30 s30 DC 56e1
RI30 e30 25 39e-3
VS31 9 s31 0
R31 s31 27 68e-2
VS32 12 s32 0
R32 s32 19 10e1
.control
set numdgt=17
op
print v(1) v(2) v(3) v(4) v(5) v(6) v(7) v(8) v(9) v(10)
print v(11) v(12) v(13) v(14) v(15) v(16) v(17) v(18) v(19) v(20)
print v(21) v(22) v(23) v(24) v(25) v(26) v(27) v(28) v(29)
print i(vs0) i(vs1) i(vs2) i(vs3) i(vs4) i(vs5) i(vs6) i(vs7) i(vs8) i(vs9)
print i(vs10) i(vs11) i(vs12) i(vs13) i(vs14) i(vs15) i(vs16) i(vs17) i(vs18) i(vs19)
print i(vs20) i(vs21) i(vs22) i(vs23) i(vs24) i(vs25) i(vs26) i(vs27) i(vs28) i(vs29)
print i(vs30) i(vs31) i(vs32)
.endc
.end
