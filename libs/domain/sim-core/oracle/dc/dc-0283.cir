controls oracle dc-0283
* Generated (plan F2.7, ADR 0012): do not edit; regenerate with `pnpm sim oracle regen`. dc seed 20261030 index 283 nodes 30 elements 44
.options sparse gmin=1e-12 noopac
RG1 1 0 1000000000000
RG2 2 0 1000000000000
RG3 3 0 1000000000000
RG4 4 0 1000000000000
RG5 5 0 1000000000000
RG6 6 0 1000000000000
RG7 7 0 1000000000000
RG8 8 0 1000000000000
RG9 9 0 1000000000000
RG10 10 0 1000000000000
RG11 11 0 1000000000000
RG12 12 0 1000000000000
RG13 13 0 1000000000000
RG14 14 0 1000000000000
RG15 15 0 1000000000000
RG16 16 0 1000000000000
RG17 17 0 1000000000000
RG18 18 0 1000000000000
RG19 19 0 1000000000000
RG20 20 0 1000000000000
RG21 21 0 1000000000000
RG22 22 0 1000000000000
RG23 23 0 1000000000000
RG24 24 0 1000000000000
RG25 25 0 1000000000000
RG26 26 0 1000000000000
RG27 27 0 1000000000000
RG28 28 0 1000000000000
RG29 29 0 1000000000000
VS0 13 s0 0
R0 s0 28 10e0
VS1 18 s1 0
R1 s1 0 47e1
VS2 0 s2 0
V2 e2 s2 DC 33e1
RI2 e2 24 10e-1
VS3 14 s3 0
V3 e3 s3 DC 56e1
RI3 e3 25 39e-3
VS4 21 s4 0
R4 s4 4 15e1
VS5 3 s5 0
R5 s5 21 15e1
VS6 12 s6 0
R6 s6 19 10e1
VS7 7 s7 0
R7 s7 21 27e1
VS8 19 s8 0
R8 s8 14 22e3
VS9 0 s9 0
R9 s9 9 15e-1
VS10 27 s10 0
V10 e10 s10 DC 33e1
RI10 e10 23 27e-2
VS11 27 s11 0
R11 s11 6 15e-2
VS12 0 s12 0
R12 s12 1 22e-1
VS13 10 s13 0
V13 e13 s13 DC 27e1
RI13 e13 4 27e-2
VS14 28 s14 0
V14 e14 s14 DC 33e0
RI14 e14 12 33e-3
VS15 8 s15 0
R15 s15 9 39e0
VS16 20 s16 0
R16 s16 3 22e0
VS17 0 s17 0
R17 s17 27 68e-2
VS18 28 s18 0
R18 s18 2 18e-1
VS19 7 s19 0
R19 s19 11 18e3
VS20 0 s20 0
R20 s20 29 15e1
VS21 7 s21 0
R21 s21 15 82e-1
VS22 17 s22 0
R22 s22 28 39e-2
VS23 5 s23 0
R23 s23 8 47e-2
VS24 13 s24 0
I24 s24 16 DC 68e-3
VS25 26 s25 0
R25 s25 22 39e1
VS26 28 s26 0
R26 s26 9 18e0
VS27 11 s27 0
R27 s27 1 22e3
VS28 10 s28 0
R28 s28 1 22e-2
VS29 5 s29 0
R29 s29 2 82e1
VS30 11 s30 0
V30 e30 s30 DC 15e0
RI30 e30 20 10e-3
VS31 0 s31 0
R31 s31 4 56e-1
VS32 23 s32 0
R32 s32 0 12e2
VS33 29 s33 0
R33 s33 11 56e-2
VS34 19 s34 0
R34 s34 16 10e3
VS35 21 s35 0
R35 s35 22 15e3
VS36 12 s36 0
R36 s36 6 39e2
VS37 22 s37 0
I37 s37 7 DC 68e-4
VS38 15 s38 0
R38 s38 24 33e2
VS39 25 s39 0
R39 s39 21 47e-1
VS40 16 s40 0
R40 s40 18 15e-1
VS41 18 s41 0
R41 s41 26 47e2
VS42 7 s42 0
V42 e42 s42 DC 15e0
RI42 e42 17 18e-1
VS43 13 s43 0
R43 s43 19 47e0
.control
set numdgt=17
op
print v(1) v(2) v(3) v(4) v(5) v(6) v(7) v(8) v(9) v(10)
print v(11) v(12) v(13) v(14) v(15) v(16) v(17) v(18) v(19) v(20)
print v(21) v(22) v(23) v(24) v(25) v(26) v(27) v(28) v(29)
print i(vs0) i(vs1) i(vs2) i(vs3) i(vs4) i(vs5) i(vs6) i(vs7) i(vs8) i(vs9)
print i(vs10) i(vs11) i(vs12) i(vs13) i(vs14) i(vs15) i(vs16) i(vs17) i(vs18) i(vs19)
print i(vs20) i(vs21) i(vs22) i(vs23) i(vs24) i(vs25) i(vs26) i(vs27) i(vs28) i(vs29)
print i(vs30) i(vs31) i(vs32) i(vs33) i(vs34) i(vs35) i(vs36) i(vs37) i(vs38) i(vs39)
print i(vs40) i(vs41) i(vs42) i(vs43)
.endc
.end
