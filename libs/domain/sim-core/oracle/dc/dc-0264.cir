controls oracle dc-0264
* Generated (plan F2.7, ADR 0012): do not edit; regenerate with `pnpm sim oracle regen`. dc seed 20261030 index 264 nodes 7 elements 15
.options sparse gmin=1e-12 noopac
RG1 1 0 1000000000000
RG2 2 0 1000000000000
RG3 3 0 1000000000000
RG4 4 0 1000000000000
RG5 5 0 1000000000000
RG6 6 0 1000000000000
VS0 2 s0 0
R0 s0 0 27e1
VS1 0 s1 0
V1 e1 s1 DC 39e1
RI1 e1 1 12e-2
VS2 5 s2 0
V2 e2 s2 DC 68e0
RI2 e2 3 39e-2
VS3 2 s3 0
I3 s3 5 DC 56e-3
VS4 4 s4 0
R4 s4 1 27e3
VS5 6 s5 0
R5 s5 1 82e3
VS6 2 s6 0
R6 s6 3 47e1
VS7 5 s7 0
R7 s7 4 18e-2
VS8 6 s8 0
I8 s8 3 DC 18e-4
VS9 0 s9 0
I9 s9 4 DC 18e-3
VS10 0 s10 0
R10 s10 3 10e3
VS11 0 s11 0
R11 s11 6 27e3
VS12 1 s12 0
I12 s12 2 DC 33e-1
VS13 4 s13 0
R13 s13 0 56e-2
VS14 2 s14 0
I14 s14 6 DC 10e-4
.control
set numdgt=17
op
print v(1) v(2) v(3) v(4) v(5) v(6)
print i(vs0) i(vs1) i(vs2) i(vs3) i(vs4) i(vs5) i(vs6) i(vs7) i(vs8) i(vs9)
print i(vs10) i(vs11) i(vs12) i(vs13) i(vs14)
.endc
.end
