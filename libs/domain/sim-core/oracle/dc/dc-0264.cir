controls oracle dc-0264
* Generated (plan F2.7, ADR 0012): do not edit; regenerate with `pnpm sim oracle regen`. dc seed 20261030 index 264 nodes 7 elements 13
.options sparse gmin=1e-12 noopac
RG1 1 0 1000000000000
RG2 2 0 1000000000000
RG3 3 0 1000000000000
RG4 4 0 1000000000000
RG5 5 0 1000000000000
RG6 6 0 1000000000000
VS0 2 s0 0
R0 s0 3 47e1
VS1 0 s1 0
R1 s1 6 27e3
VS2 2 s2 0
I2 s2 5 DC 56e-3
VS3 6 s3 0
R3 s3 1 82e3
VS4 4 s4 0
R4 s4 1 27e3
VS5 1 s5 0
I5 s5 2 DC 33e-1
VS6 2 s6 0
R6 s6 0 27e1
VS7 5 s7 0
R7 s7 4 18e-2
VS8 0 s8 0
I8 s8 4 DC 18e-3
VS9 0 s9 0
V9 e9 s9 DC 39e1
RI9 e9 1 12e-2
VS10 6 s10 0
I10 s10 3 DC 18e-4
VS11 4 s11 0
R11 s11 0 56e-2
VS12 2 s12 0
I12 s12 6 DC 10e-4
.control
set numdgt=17
op
print v(1) v(2) v(3) v(4) v(5) v(6)
print i(vs0) i(vs1) i(vs2) i(vs3) i(vs4) i(vs5) i(vs6) i(vs7) i(vs8) i(vs9)
print i(vs10) i(vs11) i(vs12)
.endc
.end
