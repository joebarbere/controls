controls oracle dc-0009
* Generated (plan F2.7, ADR 0012): do not edit; regenerate with `pnpm sim oracle regen`. dc seed 20261030 index 9 nodes 21 elements 41
.options sparse gmin=1e-12 noopac
RG1 1 0 1000000000000
RG2 2 0 1000000000000
RG3 3 0 1000000000000
RG4 4 0 1000000000000
RG5 5 0 1000000000000
RG6 6 0 1000000000000
RG7 7 0 1000000000000
RG8 8 0 1000000000000
RG9 9 0 1000000000000
RG10 10 0 1000000000000
RG11 11 0 1000000000000
RG12 12 0 1000000000000
RG13 13 0 1000000000000
RG14 14 0 1000000000000
RG15 15 0 1000000000000
RG16 16 0 1000000000000
RG17 17 0 1000000000000
RG18 18 0 1000000000000
RG19 19 0 1000000000000
RG20 20 0 1000000000000
VS0 0 s0 0
V0 e0 s0 DC 47e0
RI0 e0 5 27e-1
VS1 17 s1 0
R1 s1 20 39e1
VS2 15 s2 0
R2 s2 3 56e0
VS3 18 s3 0
V3 e3 s3 DC 82e-1
RI3 e3 19 39e-1
VS4 9 s4 0
R4 s4 2 39e1
VS5 2 s5 0
V5 e5 s5 DC 56e1
RI5 e5 9 27e-3
VS6 3 s6 0
I6 s6 1 DC 12e-2
VS7 5 s7 0
R7 s7 11 27e2
VS8 19 s8 0
R8 s8 3 18e-1
VS9 18 s9 0
V9 e9 s9 DC 47e-1
RI9 e9 6 33e-2
VS10 14 s10 0
V10 e10 s10 DC 22e-1
RI10 e10 12 56e-3
VS11 9 s11 0
R11 s11 12 27e1
VS12 15 s12 0
R12 s12 13 82e3
VS13 4 s13 0
I13 s13 14 DC 12e-1
VS14 8 s14 0
R14 s14 5 10e2
VS15 10 s15 0
R15 s15 19 22e-2
VS16 14 s16 0
R16 s16 6 15e3
VS17 1 s17 0
R17 s17 11 56e-1
VS18 12 s18 0
I18 s18 18 DC 56e-2
VS19 2 s19 0
R19 s19 14 10e1
VS20 12 s20 0
V20 e20 s20 DC 56e0
RI20 e20 20 22e-2
VS21 17 s21 0
R21 s21 13 82e0
VS22 7 s22 0
V22 e22 s22 DC 47e0
RI22 e22 0 33e-3
VS23 7 s23 0
V23 e23 s23 DC 39e0
RI23 e23 6 39e-1
VS24 20 s24 0
R24 s24 5 18e-2
VS25 19 s25 0
I25 s25 20 DC 56e-1
VS26 4 s26 0
R26 s26 0 10e-1
VS27 5 s27 0
R27 s27 4 27e2
VS28 19 s28 0
R28 s28 16 56e2
VS29 11 s29 0
R29 s29 14 12e-2
VS30 2 s30 0
R30 s30 10 10e1
VS31 16 s31 0
R31 s31 17 39e3
VS32 18 s32 0
R32 s32 1 18e0
VS33 13 s33 0
R33 s33 10 27e2
VS34 18 s34 0
R34 s34 20 33e2
VS35 0 s35 0
R35 s35 15 27e-2
VS36 8 s36 0
R36 s36 13 33e3
VS37 3 s37 0
V37 e37 s37 DC 18e-1
RI37 e37 14 27e-1
VS38 14 s38 0
R38 s38 15 68e1
VS39 3 s39 0
R39 s39 18 39e1
VS40 0 s40 0
I40 s40 13 DC 27e-4
.control
set numdgt=17
op
print v(1) v(2) v(3) v(4) v(5) v(6) v(7) v(8) v(9) v(10)
print v(11) v(12) v(13) v(14) v(15) v(16) v(17) v(18) v(19) v(20)
print i(vs0) i(vs1) i(vs2) i(vs3) i(vs4) i(vs5) i(vs6) i(vs7) i(vs8) i(vs9)
print i(vs10) i(vs11) i(vs12) i(vs13) i(vs14) i(vs15) i(vs16) i(vs17) i(vs18) i(vs19)
print i(vs20) i(vs21) i(vs22) i(vs23) i(vs24) i(vs25) i(vs26) i(vs27) i(vs28) i(vs29)
print i(vs30) i(vs31) i(vs32) i(vs33) i(vs34) i(vs35) i(vs36) i(vs37) i(vs38) i(vs39)
print i(vs40)
.endc
.end
