controls oracle dc-0009
* Generated (plan F2.7, ADR 0012): do not edit; regenerate with `pnpm sim oracle regen`. dc seed 20261030 index 9 nodes 21 elements 40
.options sparse gmin=1e-12 noopac
RG1 1 0 1000000000000
RG2 2 0 1000000000000
RG3 3 0 1000000000000
RG4 4 0 1000000000000
RG5 5 0 1000000000000
RG6 6 0 1000000000000
RG7 7 0 1000000000000
RG8 8 0 1000000000000
RG9 9 0 1000000000000
RG10 10 0 1000000000000
RG11 11 0 1000000000000
RG12 12 0 1000000000000
RG13 13 0 1000000000000
RG14 14 0 1000000000000
RG15 15 0 1000000000000
RG16 16 0 1000000000000
RG17 17 0 1000000000000
RG18 18 0 1000000000000
RG19 19 0 1000000000000
RG20 20 0 1000000000000
VS0 0 s0 0
R0 s0 2 10e1
VS1 9 s1 0
R1 s1 12 27e1
VS2 19 s2 0
R2 s2 3 18e-1
VS3 5 s3 0
R3 s3 11 27e2
VS4 18 s4 0
R4 s4 20 33e2
VS5 16 s5 0
R5 s5 17 39e3
VS6 15 s6 0
R6 s6 3 56e0
VS7 18 s7 0
R7 s7 1 18e0
VS8 4 s8 0
I8 s8 2 DC 12e-1
VS9 5 s9 0
R9 s9 4 27e2
VS10 0 s10 0
V10 e10 s10 DC 56e1
RI10 e10 9 27e-3
VS11 1 s11 0
R11 s11 11 56e-1
VS12 18 s12 0
V12 e12 s12 DC 47e-1
RI12 e12 6 33e-2
VS13 7 s13 0
V13 e13 s13 DC 39e0
RI13 e13 6 39e-1
VS14 10 s14 0
R14 s14 19 22e-2
VS15 19 s15 0
I15 s15 20 DC 56e-1
VS16 17 s16 0
R16 s16 20 39e1
VS17 3 s17 0
I17 s17 1 DC 12e-2
VS18 14 s18 0
I18 s18 13 DC 27e-4
VS19 8 s19 0
R19 s19 5 10e2
VS20 11 s20 0
R20 s20 2 12e-2
VS21 9 s21 0
R21 s21 0 39e1
VS22 2 s22 0
R22 s22 15 68e1
VS23 18 s23 0
V23 e23 s23 DC 82e-1
RI23 e23 19 39e-1
VS24 12 s24 0
I24 s24 18 DC 56e-2
VS25 4 s25 0
R25 s25 14 10e-1
VS26 2 s26 0
R26 s26 6 15e3
VS27 3 s27 0
R27 s27 18 39e1
VS28 14 s28 0
R28 s28 15 27e-2
VS29 2 s29 0
V29 e29 s29 DC 22e-1
RI29 e29 12 56e-3
VS30 8 s30 0
R30 s30 13 33e3
VS31 15 s31 0
R31 s31 13 82e3
VS32 7 s32 0
V32 e32 s32 DC 47e0
RI32 e32 14 33e-3
VS33 17 s33 0
R33 s33 13 82e0
VS34 12 s34 0
V34 e34 s34 DC 56e0
RI34 e34 20 22e-2
VS35 3 s35 0
V35 e35 s35 DC 18e-1
RI35 e35 2 27e-1
VS36 20 s36 0
R36 s36 5 18e-2
VS37 0 s37 0
R37 s37 10 10e1
VS38 13 s38 0
R38 s38 10 27e2
VS39 14 s39 0
V39 e39 s39 DC 47e0
RI39 e39 5 27e-1
.control
set numdgt=17
op
print v(1) v(2) v(3) v(4) v(5) v(6) v(7) v(8) v(9) v(10)
print v(11) v(12) v(13) v(14) v(15) v(16) v(17) v(18) v(19) v(20)
print i(vs0) i(vs1) i(vs2) i(vs3) i(vs4) i(vs5) i(vs6) i(vs7) i(vs8) i(vs9)
print i(vs10) i(vs11) i(vs12) i(vs13) i(vs14) i(vs15) i(vs16) i(vs17) i(vs18) i(vs19)
print i(vs20) i(vs21) i(vs22) i(vs23) i(vs24) i(vs25) i(vs26) i(vs27) i(vs28) i(vs29)
print i(vs30) i(vs31) i(vs32) i(vs33) i(vs34) i(vs35) i(vs36) i(vs37) i(vs38) i(vs39)
.endc
.end
