controls oracle dc-0196
* Generated (plan F2.7, ADR 0012): do not edit; regenerate with `pnpm sim oracle regen`. dc seed 20261030 index 196 nodes 4 elements 4
.options sparse gmin=1e-12 noopac
RG1 1 0 1000000000000
RG2 2 0 1000000000000
RG3 3 0 1000000000000
VS0 0 s0 0
V0 e0 s0 DC 27e-1
RI0 e0 1 10e-3
VS1 2 s1 0
R1 s1 3 68e-2
VS2 3 s2 0
I2 s2 1 DC 22e-2
VS3 0 s3 0
R3 s3 2 10e-2
.control
set numdgt=17
op
print v(1) v(2) v(3)
print i(vs0) i(vs1) i(vs2) i(vs3)
.endc
.end
