controls oracle dc-0438
* Generated (plan F2.7, ADR 0012): do not edit; regenerate with `pnpm sim oracle regen`. dc seed 20261030 index 438 nodes 5 elements 10
.options sparse gmin=1e-12 noopac
RG1 1 0 1000000000000
RG2 2 0 1000000000000
RG3 3 0 1000000000000
RG4 4 0 1000000000000
VS0 2 s0 0
I0 s0 4 DC 27e-1
VS1 3 s1 0
R1 s1 2 22e2
VS2 3 s2 0
R2 s2 1 15e0
VS3 2 s3 0
R3 s3 0 22e0
VS4 0 s4 0
V4 e4 s4 DC 27e-1
RI4 e4 1 18e-1
VS5 1 s5 0
V5 e5 s5 DC 56e-1
RI5 e5 3 82e-1
VS6 1 s6 0
R6 s6 4 18e0
VS7 1 s7 0
V7 e7 s7 DC 82e-1
RI7 e7 0 12e-1
VS8 0 s8 0
I8 s8 3 DC 18e-3
VS9 4 s9 0
R9 s9 2 68e0
.control
set numdgt=17
op
print v(1) v(2) v(3) v(4)
print i(vs0) i(vs1) i(vs2) i(vs3) i(vs4) i(vs5) i(vs6) i(vs7) i(vs8) i(vs9)
.endc
.end
