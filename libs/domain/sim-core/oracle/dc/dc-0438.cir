controls oracle dc-0438
* Generated (plan F2.7, ADR 0012): do not edit; regenerate with `pnpm sim oracle regen`. dc seed 20261030 index 438 nodes 5 elements 9
.options sparse gmin=1e-12 noopac
RG1 1 0 1000000000000
RG2 2 0 1000000000000
RG3 3 0 1000000000000
RG4 4 0 1000000000000
VS0 0 s0 0
V0 e0 s0 DC 82e-1
RI0 e0 1 12e-1
VS1 0 s1 0
V1 e1 s1 DC 56e-1
RI1 e1 3 82e-1
VS2 3 s2 0
R2 s2 2 22e2
VS3 3 s3 0
R3 s3 0 15e0
VS4 1 s4 0
I4 s4 3 DC 18e-3
VS5 1 s5 0
V5 e5 s5 DC 27e-1
RI5 e5 0 18e-1
VS6 0 s6 0
R6 s6 4 18e0
VS7 4 s7 0
R7 s7 2 68e0
VS8 2 s8 0
I8 s8 4 DC 27e-1
.control
set numdgt=17
op
print v(1) v(2) v(3) v(4)
print i(vs0) i(vs1) i(vs2) i(vs3) i(vs4) i(vs5) i(vs6) i(vs7) i(vs8)
.endc
.end
