controls oracle dc-0052
* Generated (plan F2.7, ADR 0012): do not edit; regenerate with `pnpm sim oracle regen`. dc seed 20261030 index 52 nodes 22 elements 38
.options sparse gmin=1e-12 noopac
RG1 1 0 1000000000000
RG2 2 0 1000000000000
RG3 3 0 1000000000000
RG4 4 0 1000000000000
RG5 5 0 1000000000000
RG6 6 0 1000000000000
RG7 7 0 1000000000000
RG8 8 0 1000000000000
RG9 9 0 1000000000000
RG10 10 0 1000000000000
RG11 11 0 1000000000000
RG12 12 0 1000000000000
RG13 13 0 1000000000000
RG14 14 0 1000000000000
RG15 15 0 1000000000000
RG16 16 0 1000000000000
RG17 17 0 1000000000000
RG18 18 0 1000000000000
RG19 19 0 1000000000000
RG20 20 0 1000000000000
RG21 21 0 1000000000000
VS0 14 s0 0
R0 s0 16 12e3
VS1 0 s1 0
V1 e1 s1 DC 27e-1
RI1 e1 1 15e-2
VS2 4 s2 0
I2 s2 12 DC 18e-4
VS3 17 s3 0
R3 s3 16 15e-2
VS4 2 s4 0
R4 s4 7 22e-2
VS5 0 s5 0
V5 e5 s5 DC 68e0
RI5 e5 14 22e-3
VS6 4 s6 0
R6 s6 15 82e-1
VS7 5 s7 0
V7 e7 s7 DC 22e1
RI7 e7 1 39e-1
VS8 4 s8 0
R8 s8 8 12e0
VS9 2 s9 0
V9 e9 s9 DC 12e1
RI9 e9 5 22e-2
VS10 19 s10 0
R10 s10 21 27e1
VS11 11 s11 0
R11 s11 3 10e2
VS12 5 s12 0
R12 s12 16 27e3
VS13 13 s13 0
R13 s13 6 18e1
VS14 11 s14 0
V14 e14 s14 DC 27e0
RI14 e14 2 68e-3
VS15 3 s15 0
R15 s15 1 12e0
VS16 14 s16 0
I16 s16 11 DC 68e-2
VS17 13 s17 0
R17 s17 11 47e-2
VS18 1 s18 0
R18 s18 5 39e1
VS19 12 s19 0
R19 s19 5 22e-1
VS20 2 s20 0
R20 s20 0 10e0
VS21 9 s21 0
R21 s21 20 27e3
VS22 8 s22 0
I22 s22 21 DC 27e-3
VS23 5 s23 0
R23 s23 9 33e1
VS24 3 s24 0
V24 e24 s24 DC 68e0
RI24 e24 2 47e-3
VS25 17 s25 0
V25 e25 s25 DC 82e-1
RI25 e25 9 82e-3
VS26 18 s26 0
V26 e26 s26 DC 12e0
RI26 e26 8 22e-3
VS27 3 s27 0
R27 s27 15 47e-1
VS28 6 s28 0
R28 s28 16 82e0
VS29 20 s29 0
V29 e29 s29 DC 15e1
RI29 e29 19 33e-1
VS30 4 s30 0
R30 s30 6 39e1
VS31 17 s31 0
R31 s31 13 39e-2
VS32 15 s32 0
R32 s32 18 15e-1
VS33 6 s33 0
V33 e33 s33 DC 68e0
RI33 e33 18 15e-2
VS34 16 s34 0
R34 s34 14 27e-1
VS35 16 s35 0
R35 s35 10 27e-1
VS36 14 s36 0
R36 s36 21 68e-2
VS37 21 s37 0
V37 e37 s37 DC 12e-1
RI37 e37 6 12e-1
.control
set numdgt=17
op
print v(1) v(2) v(3) v(4) v(5) v(6) v(7) v(8) v(9) v(10)
print v(11) v(12) v(13) v(14) v(15) v(16) v(17) v(18) v(19) v(20)
print v(21)
print i(vs0) i(vs1) i(vs2) i(vs3) i(vs4) i(vs5) i(vs6) i(vs7) i(vs8) i(vs9)
print i(vs10) i(vs11) i(vs12) i(vs13) i(vs14) i(vs15) i(vs16) i(vs17) i(vs18) i(vs19)
print i(vs20) i(vs21) i(vs22) i(vs23) i(vs24) i(vs25) i(vs26) i(vs27) i(vs28) i(vs29)
print i(vs30) i(vs31) i(vs32) i(vs33) i(vs34) i(vs35) i(vs36) i(vs37)
.endc
.end
