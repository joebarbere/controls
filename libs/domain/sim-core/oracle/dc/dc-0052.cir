controls oracle dc-0052
* Generated (plan F2.7, ADR 0012): do not edit; regenerate with `pnpm sim oracle regen`. dc seed 20261030 index 52 nodes 22 elements 41
.options sparse gmin=1e-12 noopac
RG1 1 0 1000000000000
RG2 2 0 1000000000000
RG3 3 0 1000000000000
RG4 4 0 1000000000000
RG5 5 0 1000000000000
RG6 6 0 1000000000000
RG7 7 0 1000000000000
RG8 8 0 1000000000000
RG9 9 0 1000000000000
RG10 10 0 1000000000000
RG11 11 0 1000000000000
RG12 12 0 1000000000000
RG13 13 0 1000000000000
RG14 14 0 1000000000000
RG15 15 0 1000000000000
RG16 16 0 1000000000000
RG17 17 0 1000000000000
RG18 18 0 1000000000000
RG19 19 0 1000000000000
RG20 20 0 1000000000000
RG21 21 0 1000000000000
VS0 19 s0 0
R0 s0 21 27e1
VS1 3 s1 0
R1 s1 15 47e-1
VS2 0 s2 0
V2 e2 s2 DC 22e1
RI2 e2 1 39e-1
VS3 11 s3 0
R3 s3 3 10e2
VS4 9 s4 0
R4 s4 20 27e3
VS5 13 s5 0
V5 e5 s5 DC 68e0
RI5 e5 14 22e-3
VS6 8 s6 0
I6 s6 21 DC 27e-3
VS7 17 s7 0
R7 s7 16 15e-2
VS8 15 s8 0
R8 s8 18 15e-1
VS9 3 s9 0
V9 e9 s9 DC 68e0
RI9 e9 2 47e-3
VS10 14 s10 0
R10 s10 21 68e-2
VS11 0 s11 0
R11 s11 16 27e3
VS12 14 s12 0
R12 s12 16 12e3
VS13 18 s13 0
V13 e13 s13 DC 12e0
RI13 e13 8 22e-3
VS14 4 s14 0
R14 s14 7 47e0
VS15 16 s15 0
R15 s15 14 27e-1
VS16 14 s16 0
R16 s16 12 68e2
VS17 5 s17 0
R17 s17 11 47e-2
VS18 3 s18 0
R18 s18 1 12e0
VS19 4 s19 0
R19 s19 8 12e0
VS20 14 s20 0
I20 s20 11 DC 68e-2
VS21 16 s21 0
R21 s21 10 27e-1
VS22 2 s22 0
R22 s22 7 22e-2
VS23 5 s23 0
R23 s23 6 18e1
VS24 21 s24 0
V24 e24 s24 DC 12e-1
RI24 e24 6 12e-1
VS25 20 s25 0
V25 e25 s25 DC 15e1
RI25 e25 19 33e-1
VS26 4 s26 0
R26 s26 15 82e-1
VS27 4 s27 0
I27 s27 12 DC 18e-4
VS28 6 s28 0
R28 s28 16 82e0
VS29 1 s29 0
R29 s29 0 39e1
VS30 17 s30 0
R30 s30 5 39e-2
VS31 17 s31 0
V31 e31 s31 DC 82e-1
RI31 e31 9 82e-3
VS32 11 s32 0
V32 e32 s32 DC 27e0
RI32 e32 2 68e-3
VS33 0 s33 0
R33 s33 9 33e1
VS34 14 s34 0
R34 s34 10 33e-1
VS35 2 s35 0
R35 s35 13 10e0
VS36 6 s36 0
V36 e36 s36 DC 68e0
RI36 e36 18 15e-2
VS37 4 s37 0
R37 s37 6 39e1
VS38 2 s38 0
V38 e38 s38 DC 12e1
RI38 e38 0 22e-2
VS39 13 s39 0
V39 e39 s39 DC 27e-1
RI39 e39 1 15e-2
VS40 12 s40 0
R40 s40 0 22e-1
.control
set numdgt=17
op
print v(1) v(2) v(3) v(4) v(5) v(6) v(7) v(8) v(9) v(10)
print v(11) v(12) v(13) v(14) v(15) v(16) v(17) v(18) v(19) v(20)
print v(21)
print i(vs0) i(vs1) i(vs2) i(vs3) i(vs4) i(vs5) i(vs6) i(vs7) i(vs8) i(vs9)
print i(vs10) i(vs11) i(vs12) i(vs13) i(vs14) i(vs15) i(vs16) i(vs17) i(vs18) i(vs19)
print i(vs20) i(vs21) i(vs22) i(vs23) i(vs24) i(vs25) i(vs26) i(vs27) i(vs28) i(vs29)
print i(vs30) i(vs31) i(vs32) i(vs33) i(vs34) i(vs35) i(vs36) i(vs37) i(vs38) i(vs39)
print i(vs40)
.endc
.end
