controls oracle dc-0315
* Generated (plan F2.7, ADR 0012): do not edit; regenerate with `pnpm sim oracle regen`. dc seed 20261030 index 315 nodes 25 elements 51
.options sparse gmin=1e-12 noopac
RG1 1 0 1000000000000
RG2 2 0 1000000000000
RG3 3 0 1000000000000
RG4 4 0 1000000000000
RG5 5 0 1000000000000
RG6 6 0 1000000000000
RG7 7 0 1000000000000
RG8 8 0 1000000000000
RG9 9 0 1000000000000
RG10 10 0 1000000000000
RG11 11 0 1000000000000
RG12 12 0 1000000000000
RG13 13 0 1000000000000
RG14 14 0 1000000000000
RG15 15 0 1000000000000
RG16 16 0 1000000000000
RG17 17 0 1000000000000
RG18 18 0 1000000000000
RG19 19 0 1000000000000
RG20 20 0 1000000000000
RG21 21 0 1000000000000
RG22 22 0 1000000000000
RG23 23 0 1000000000000
RG24 24 0 1000000000000
VS0 20 s0 0
R0 s0 24 15e-2
VS1 5 s1 0
I1 s1 15 DC 27e-3
VS2 17 s2 0
R2 s2 23 39e2
VS3 4 s3 0
I3 s3 2 DC 47e-3
VS4 0 s4 0
V4 e4 s4 DC 39e-1
RI4 e4 12 15e-1
VS5 17 s5 0
R5 s5 3 33e2
VS6 24 s6 0
R6 s6 15 22e2
VS7 2 s7 0
I7 s7 12 DC 47e-1
VS8 8 s8 0
I8 s8 20 DC 82e-2
VS9 18 s9 0
V9 e9 s9 DC 12e0
RI9 e9 0 68e-3
VS10 18 s10 0
V10 e10 s10 DC 82e-1
RI10 e10 14 12e-2
VS11 23 s11 0
R11 s11 12 27e-2
VS12 13 s12 0
R12 s12 18 10e2
VS13 6 s13 0
R13 s13 0 47e2
VS14 5 s14 0
R14 s14 18 18e3
VS15 19 s15 0
R15 s15 9 10e0
VS16 23 s16 0
V16 e16 s16 DC 68e1
RI16 e16 6 47e-2
VS17 11 s17 0
R17 s17 7 56e3
VS18 1 s18 0
R18 s18 5 27e1
VS19 4 s19 0
R19 s19 20 15e-2
VS20 13 s20 0
R20 s20 16 10e-2
VS21 1 s21 0
I21 s21 8 DC 82e-4
VS22 2 s22 0
R22 s22 24 33e-1
VS23 9 s23 0
R23 s23 21 27e0
VS24 11 s24 0
R24 s24 15 15e1
VS25 17 s25 0
R25 s25 18 56e2
VS26 24 s26 0
R26 s26 5 33e1
VS27 22 s27 0
V27 e27 s27 DC 27e1
RI27 e27 18 56e-2
VS28 8 s28 0
R28 s28 15 82e3
VS29 23 s29 0
R29 s29 6 82e0
VS30 19 s30 0
V30 e30 s30 DC 22e0
RI30 e30 16 18e-3
VS31 13 s31 0
R31 s31 23 12e-2
VS32 2 s32 0
V32 e32 s32 DC 68e0
RI32 e32 19 10e-3
VS33 15 s33 0
I33 s33 9 DC 18e-1
VS34 22 s34 0
R34 s34 3 56e-1
VS35 12 s35 0
R35 s35 14 27e-2
VS36 13 s36 0
R36 s36 3 22e-1
VS37 23 s37 0
V37 e37 s37 DC 39e0
RI37 e37 19 33e-1
VS38 18 s38 0
I38 s38 22 DC 12e-4
VS39 19 s39 0
V39 e39 s39 DC 27e-1
RI39 e39 9 68e-2
VS40 18 s40 0
R40 s40 2 18e2
VS41 5 s41 0
R41 s41 12 39e-2
VS42 23 s42 0
R42 s42 9 27e-2
VS43 17 s43 0
I43 s43 13 DC 12e-3
VS44 10 s44 0
R44 s44 1 39e2
VS45 4 s45 0
R45 s45 8 47e3
VS46 7 s46 0
R46 s46 19 10e-1
VS47 10 s47 0
V47 e47 s47 DC 22e0
RI47 e47 2 18e-1
VS48 24 s48 0
V48 e48 s48 DC 33e-1
RI48 e48 21 68e-2
VS49 4 s49 0
V49 e49 s49 DC 27e-1
RI49 e49 24 56e-3
VS50 19 s50 0
I50 s50 9 DC 82e-3
.control
set numdgt=17
op
print v(1) v(2) v(3) v(4) v(5) v(6) v(7) v(8) v(9) v(10)
print v(11) v(12) v(13) v(14) v(15) v(16) v(17) v(18) v(19) v(20)
print v(21) v(22) v(23) v(24)
print i(vs0) i(vs1) i(vs2) i(vs3) i(vs4) i(vs5) i(vs6) i(vs7) i(vs8) i(vs9)
print i(vs10) i(vs11) i(vs12) i(vs13) i(vs14) i(vs15) i(vs16) i(vs17) i(vs18) i(vs19)
print i(vs20) i(vs21) i(vs22) i(vs23) i(vs24) i(vs25) i(vs26) i(vs27) i(vs28) i(vs29)
print i(vs30) i(vs31) i(vs32) i(vs33) i(vs34) i(vs35) i(vs36) i(vs37) i(vs38) i(vs39)
print i(vs40) i(vs41) i(vs42) i(vs43) i(vs44) i(vs45) i(vs46) i(vs47) i(vs48) i(vs49)
print i(vs50)
.endc
.end
