controls oracle dc-0315
* Generated (plan F2.7, ADR 0012): do not edit; regenerate with `pnpm sim oracle regen`. dc seed 20261030 index 315 nodes 25 elements 49
.options sparse gmin=1e-12 noopac
RG1 1 0 1000000000000
RG2 2 0 1000000000000
RG3 3 0 1000000000000
RG4 4 0 1000000000000
RG5 5 0 1000000000000
RG6 6 0 1000000000000
RG7 7 0 1000000000000
RG8 8 0 1000000000000
RG9 9 0 1000000000000
RG10 10 0 1000000000000
RG11 11 0 1000000000000
RG12 12 0 1000000000000
RG13 13 0 1000000000000
RG14 14 0 1000000000000
RG15 15 0 1000000000000
RG16 16 0 1000000000000
RG17 17 0 1000000000000
RG18 18 0 1000000000000
RG19 19 0 1000000000000
RG20 20 0 1000000000000
RG21 21 0 1000000000000
RG22 22 0 1000000000000
RG23 23 0 1000000000000
RG24 24 0 1000000000000
VS0 13 s0 0
R0 s0 23 12e-2
VS1 9 s1 0
R1 s1 21 27e0
VS2 0 s2 0
V2 e2 s2 DC 12e0
RI2 e2 24 68e-3
VS3 18 s3 0
V3 e3 s3 DC 33e-1
RI3 e3 21 68e-2
VS4 23 s4 0
R4 s4 9 27e-2
VS5 4 s5 0
V5 e5 s5 DC 27e-1
RI5 e5 18 56e-3
VS6 18 s6 0
R6 s6 5 33e1
VS7 17 s7 0
R7 s7 23 39e2
VS8 19 s8 0
V8 e8 s8 DC 22e0
RI8 e8 16 18e-3
VS9 2 s9 0
I9 s9 12 DC 47e-1
VS10 1 s10 0
R10 s10 5 27e1
VS11 19 s11 0
R11 s11 9 10e0
VS12 6 s12 0
R12 s12 24 47e2
VS13 11 s13 0
R13 s13 7 56e3
VS14 13 s14 0
R14 s14 0 10e2
VS15 13 s15 0
R15 s15 3 22e-1
VS16 17 s16 0
R16 s16 3 33e2
VS17 22 s17 0
V17 e17 s17 DC 27e1
RI17 e17 0 56e-2
VS18 15 s18 0
I18 s18 9 DC 18e-1
VS19 2 s19 0
V19 e19 s19 DC 68e0
RI19 e19 19 10e-3
VS20 8 s20 0
I20 s20 20 DC 82e-2
VS21 23 s21 0
R21 s21 12 27e-2
VS22 11 s22 0
R22 s22 15 15e1
VS23 10 s23 0
V23 e23 s23 DC 22e0
RI23 e23 2 18e-1
VS24 19 s24 0
I24 s24 9 DC 82e-3
VS25 4 s25 0
I25 s25 2 DC 47e-3
VS26 13 s26 0
R26 s26 16 10e-2
VS27 17 s27 0
I27 s27 13 DC 12e-3
VS28 20 s28 0
R28 s28 18 15e-2
VS29 8 s29 0
R29 s29 15 82e3
VS30 7 s30 0
R30 s30 19 10e-1
VS31 4 s31 0
R31 s31 8 47e3
VS32 17 s32 0
R32 s32 0 56e2
VS33 0 s33 0
I33 s33 22 DC 12e-4
VS34 2 s34 0
R34 s34 18 33e-1
VS35 18 s35 0
R35 s35 15 22e2
VS36 0 s36 0
R36 s36 2 18e2
VS37 23 s37 0
R37 s37 6 82e0
VS38 4 s38 0
R38 s38 20 15e-2
VS39 23 s39 0
V39 e39 s39 DC 39e0
RI39 e39 19 33e-1
VS40 23 s40 0
V40 e40 s40 DC 68e1
RI40 e40 6 47e-2
VS41 1 s41 0
I41 s41 8 DC 82e-4
VS42 0 s42 0
V42 e42 s42 DC 82e-1
RI42 e42 14 12e-2
VS43 5 s43 0
I43 s43 15 DC 27e-3
VS44 12 s44 0
R44 s44 14 27e-2
VS45 24 s45 0
V45 e45 s45 DC 39e-1
RI45 e45 12 15e-1
VS46 19 s46 0
V46 e46 s46 DC 27e-1
RI46 e46 9 68e-2
VS47 5 s47 0
R47 s47 12 39e-2
VS48 5 s48 0
R48 s48 0 18e3
.control
set numdgt=17
op
print v(1) v(2) v(3) v(4) v(5) v(6) v(7) v(8) v(9) v(10)
print v(11) v(12) v(13) v(14) v(15) v(16) v(17) v(18) v(19) v(20)
print v(21) v(22) v(23) v(24)
print i(vs0) i(vs1) i(vs2) i(vs3) i(vs4) i(vs5) i(vs6) i(vs7) i(vs8) i(vs9)
print i(vs10) i(vs11) i(vs12) i(vs13) i(vs14) i(vs15) i(vs16) i(vs17) i(vs18) i(vs19)
print i(vs20) i(vs21) i(vs22) i(vs23) i(vs24) i(vs25) i(vs26) i(vs27) i(vs28) i(vs29)
print i(vs30) i(vs31) i(vs32) i(vs33) i(vs34) i(vs35) i(vs36) i(vs37) i(vs38) i(vs39)
print i(vs40) i(vs41) i(vs42) i(vs43) i(vs44) i(vs45) i(vs46) i(vs47) i(vs48)
.endc
.end
