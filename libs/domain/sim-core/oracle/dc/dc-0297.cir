controls oracle dc-0297
* Generated (plan F2.7, ADR 0012): do not edit; regenerate with `pnpm sim oracle regen`. dc seed 20261030 index 297 nodes 23 elements 49
.options sparse gmin=1e-12 noopac
RG1 1 0 1000000000000
RG2 2 0 1000000000000
RG3 3 0 1000000000000
RG4 4 0 1000000000000
RG5 5 0 1000000000000
RG6 6 0 1000000000000
RG7 7 0 1000000000000
RG8 8 0 1000000000000
RG9 9 0 1000000000000
RG10 10 0 1000000000000
RG11 11 0 1000000000000
RG12 12 0 1000000000000
RG13 13 0 1000000000000
RG14 14 0 1000000000000
RG15 15 0 1000000000000
RG16 16 0 1000000000000
RG17 17 0 1000000000000
RG18 18 0 1000000000000
RG19 19 0 1000000000000
RG20 20 0 1000000000000
RG21 21 0 1000000000000
RG22 22 0 1000000000000
VS0 9 s0 0
R0 s0 6 27e0
VS1 20 s1 0
R1 s1 7 56e3
VS2 4 s2 0
R2 s2 12 47e3
VS3 22 s3 0
I3 s3 12 DC 33e-3
VS4 9 s4 0
R4 s4 10 68e3
VS5 19 s5 0
I5 s5 11 DC 27e-1
VS6 4 s6 0
I6 s6 12 DC 39e-4
VS7 19 s7 0
R7 s7 17 47e2
VS8 14 s8 0
R8 s8 13 27e-1
VS9 0 s9 0
V9 e9 s9 DC 56e1
RI9 e9 7 15e-2
VS10 0 s10 0
R10 s10 7 68e2
VS11 14 s11 0
R11 s11 7 18e-1
VS12 9 s12 0
R12 s12 10 10e-2
VS13 0 s13 0
R13 s13 4 39e-2
VS14 1 s14 0
R14 s14 15 56e-2
VS15 2 s15 0
R15 s15 0 12e-1
VS16 6 s16 0
I16 s16 7 DC 10e-3
VS17 1 s17 0
R17 s17 18 47e-2
VS18 20 s18 0
R18 s18 5 56e0
VS19 3 s19 0
R19 s19 22 39e2
VS20 11 s20 0
V20 e20 s20 DC 27e0
RI20 e20 5 82e-3
VS21 13 s21 0
R21 s21 11 47e-2
VS22 19 s22 0
V22 e22 s22 DC 27e0
RI22 e22 22 12e-3
VS23 8 s23 0
I23 s23 18 DC 15e-3
VS24 9 s24 0
R24 s24 16 10e1
VS25 2 s25 0
V25 e25 s25 DC 39e-1
RI25 e25 20 27e-2
VS26 5 s26 0
R26 s26 16 18e-1
VS27 0 s27 0
I27 s27 7 DC 12e-1
VS28 22 s28 0
R28 s28 20 18e-1
VS29 20 s29 0
R29 s29 2 39e-1
VS30 16 s30 0
I30 s30 6 DC 10e-1
VS31 18 s31 0
V31 e31 s31 DC 82e1
RI31 e31 5 15e-1
VS32 11 s32 0
R32 s32 21 27e3
VS33 9 s33 0
R33 s33 20 82e-2
VS34 21 s34 0
V34 e34 s34 DC 82e-1
RI34 e34 8 56e-2
VS35 5 s35 0
R35 s35 17 10e-1
VS36 0 s36 0
R36 s36 8 47e0
VS37 7 s37 0
I37 s37 4 DC 27e-1
VS38 1 s38 0
R38 s38 7 22e2
VS39 6 s39 0
R39 s39 3 27e-1
VS40 7 s40 0
R40 s40 12 18e2
VS41 2 s41 0
I41 s41 15 DC 10e-2
VS42 11 s42 0
R42 s42 0 18e-1
VS43 15 s43 0
V43 e43 s43 DC 27e1
RI43 e43 22 10e-3
VS44 9 s44 0
V44 e44 s44 DC 22e-1
RI44 e44 18 47e-1
VS45 11 s45 0
R45 s45 10 10e1
VS46 20 s46 0
R46 s46 11 56e-2
VS47 7 s47 0
I47 s47 5 DC 82e-4
VS48 16 s48 0
R48 s48 11 82e1
.control
set numdgt=17
op
print v(1) v(2) v(3) v(4) v(5) v(6) v(7) v(8) v(9) v(10)
print v(11) v(12) v(13) v(14) v(15) v(16) v(17) v(18) v(19) v(20)
print v(21) v(22)
print i(vs0) i(vs1) i(vs2) i(vs3) i(vs4) i(vs5) i(vs6) i(vs7) i(vs8) i(vs9)
print i(vs10) i(vs11) i(vs12) i(vs13) i(vs14) i(vs15) i(vs16) i(vs17) i(vs18) i(vs19)
print i(vs20) i(vs21) i(vs22) i(vs23) i(vs24) i(vs25) i(vs26) i(vs27) i(vs28) i(vs29)
print i(vs30) i(vs31) i(vs32) i(vs33) i(vs34) i(vs35) i(vs36) i(vs37) i(vs38) i(vs39)
print i(vs40) i(vs41) i(vs42) i(vs43) i(vs44) i(vs45) i(vs46) i(vs47) i(vs48)
.endc
.end
