controls oracle dc-0297
* Generated (plan F2.7, ADR 0012): do not edit; regenerate with `pnpm sim oracle regen`. dc seed 20261030 index 297 nodes 23 elements 41
.options sparse gmin=1e-12 noopac
RG1 1 0 1000000000000
RG2 2 0 1000000000000
RG3 3 0 1000000000000
RG4 4 0 1000000000000
RG5 5 0 1000000000000
RG6 6 0 1000000000000
RG7 7 0 1000000000000
RG8 8 0 1000000000000
RG9 9 0 1000000000000
RG10 10 0 1000000000000
RG11 11 0 1000000000000
RG12 12 0 1000000000000
RG13 13 0 1000000000000
RG14 14 0 1000000000000
RG15 15 0 1000000000000
RG16 16 0 1000000000000
RG17 17 0 1000000000000
RG18 18 0 1000000000000
RG19 19 0 1000000000000
RG20 20 0 1000000000000
RG21 21 0 1000000000000
RG22 22 0 1000000000000
VS0 5 s0 0
R0 s0 16 18e-1
VS1 0 s1 0
V1 e1 s1 DC 27e1
RI1 e1 22 10e-3
VS2 5 s2 0
R2 s2 17 10e-1
VS3 20 s3 0
R3 s3 5 56e0
VS4 20 s4 0
R4 s4 11 56e-2
VS5 15 s5 0
R5 s5 12 18e2
VS6 18 s6 0
V6 e6 s6 DC 82e1
RI6 e6 5 15e-1
VS7 9 s7 0
R7 s7 10 68e3
VS8 2 s8 0
V8 e8 s8 DC 39e-1
RI8 e8 20 27e-2
VS9 21 s9 0
V9 e9 s9 DC 82e-1
RI9 e9 8 56e-2
VS10 8 s10 0
I10 s10 18 DC 15e-3
VS11 11 s11 0
R11 s11 21 27e3
VS12 14 s12 0
R12 s12 15 18e-1
VS13 9 s13 0
R13 s13 6 27e0
VS14 22 s14 0
R14 s14 20 18e-1
VS15 22 s15 0
I15 s15 12 DC 33e-3
VS16 9 s16 0
R16 s16 20 82e-2
VS17 7 s17 0
V17 e17 s17 DC 56e1
RI17 e17 15 15e-2
VS18 9 s18 0
R18 s18 16 10e1
VS19 15 s19 0
I19 s19 4 DC 27e-1
VS20 1 s20 0
R20 s20 18 47e-2
VS21 7 s21 0
I21 s21 15 DC 12e-1
VS22 3 s22 0
R22 s22 22 39e2
VS23 9 s23 0
R23 s23 10 10e-2
VS24 2 s24 0
I24 s24 0 DC 10e-2
VS25 7 s25 0
R25 s25 8 47e0
VS26 20 s26 0
R26 s26 2 39e-1
VS27 20 s27 0
R27 s27 15 56e3
VS28 11 s28 0
V28 e28 s28 DC 27e0
RI28 e28 5 82e-3
VS29 19 s29 0
I29 s29 11 DC 27e-1
VS30 16 s30 0
R30 s30 11 82e1
VS31 6 s31 0
I31 s31 15 DC 10e-3
VS32 13 s32 0
R32 s32 11 47e-2
VS33 16 s33 0
I33 s33 6 DC 10e-1
VS34 11 s34 0
R34 s34 7 18e-1
VS35 4 s35 0
I35 s35 12 DC 39e-4
VS36 19 s36 0
V36 e36 s36 DC 27e0
RI36 e36 22 12e-3
VS37 7 s37 0
R37 s37 15 68e2
VS38 15 s38 0
I38 s38 5 DC 82e-4
VS39 9 s39 0
V39 e39 s39 DC 22e-1
RI39 e39 18 47e-1
VS40 4 s40 0
R40 s40 12 47e3
.control
set numdgt=17
op
print v(1) v(2) v(3) v(4) v(5) v(6) v(7) v(8) v(9) v(10)
print v(11) v(12) v(13) v(14) v(15) v(16) v(17) v(18) v(19) v(20)
print v(21) v(22)
print i(vs0) i(vs1) i(vs2) i(vs3) i(vs4) i(vs5) i(vs6) i(vs7) i(vs8) i(vs9)
print i(vs10) i(vs11) i(vs12) i(vs13) i(vs14) i(vs15) i(vs16) i(vs17) i(vs18) i(vs19)
print i(vs20) i(vs21) i(vs22) i(vs23) i(vs24) i(vs25) i(vs26) i(vs27) i(vs28) i(vs29)
print i(vs30) i(vs31) i(vs32) i(vs33) i(vs34) i(vs35) i(vs36) i(vs37) i(vs38) i(vs39)
print i(vs40)
.endc
.end
