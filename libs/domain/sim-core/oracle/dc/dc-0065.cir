controls oracle dc-0065
* Generated (plan F2.7, ADR 0012): do not edit; regenerate with `pnpm sim oracle regen`. dc seed 20261030 index 65 nodes 23 elements 32
.options sparse gmin=1e-12 noopac
RG1 1 0 1000000000000
RG2 2 0 1000000000000
RG3 3 0 1000000000000
RG4 4 0 1000000000000
RG5 5 0 1000000000000
RG6 6 0 1000000000000
RG7 7 0 1000000000000
RG8 8 0 1000000000000
RG9 9 0 1000000000000
RG10 10 0 1000000000000
RG11 11 0 1000000000000
RG12 12 0 1000000000000
RG13 13 0 1000000000000
RG14 14 0 1000000000000
RG15 15 0 1000000000000
RG16 16 0 1000000000000
RG17 17 0 1000000000000
RG18 18 0 1000000000000
RG19 19 0 1000000000000
RG20 20 0 1000000000000
RG21 21 0 1000000000000
RG22 22 0 1000000000000
VS0 10 s0 0
R0 s0 11 18e0
VS1 19 s1 0
R1 s1 15 68e-1
VS2 6 s2 0
R2 s2 4 68e1
VS3 20 s3 0
R3 s3 12 27e3
VS4 0 s4 0
V4 e4 s4 DC 12e0
RI4 e4 13 18e-3
VS5 2 s5 0
R5 s5 1 82e0
VS6 1 s6 0
R6 s6 7 10e3
VS7 0 s7 0
R7 s7 2 18e1
VS8 16 s8 0
R8 s8 2 10e-2
VS9 12 s9 0
R9 s9 11 56e3
VS10 9 s10 0
R10 s10 0 22e0
VS11 16 s11 0
R11 s11 0 10e3
VS12 4 s12 0
R12 s12 18 10e1
VS13 0 s13 0
R13 s13 3 27e3
VS14 6 s14 0
R14 s14 15 47e1
VS15 9 s15 0
V15 e15 s15 DC 18e0
RI15 e15 21 56e-1
VS16 13 s16 0
R16 s16 5 12e3
VS17 11 s17 0
R17 s17 15 68e-1
VS18 17 s18 0
R18 s18 8 39e-1
VS19 5 s19 0
R19 s19 19 47e2
VS20 3 s20 0
R20 s20 21 15e3
VS21 13 s21 0
R21 s21 22 39e-2
VS22 7 s22 0
V22 e22 s22 DC 47e-1
RI22 e22 20 15e-2
VS23 19 s23 0
V23 e23 s23 DC 56e-1
RI23 e23 4 68e-3
VS24 20 s24 0
R24 s24 17 22e1
VS25 18 s25 0
R25 s25 10 47e-1
VS26 14 s26 0
R26 s26 8 39e-1
VS27 14 s27 0
R27 s27 1 39e0
VS28 22 s28 0
I28 s28 4 DC 56e-2
VS29 19 s29 0
R29 s29 3 39e1
VS30 3 s30 0
R30 s30 22 27e0
VS31 19 s31 0
R31 s31 17 56e0
.control
set numdgt=17
op
print v(1) v(2) v(3) v(4) v(5) v(6) v(7) v(8) v(9) v(10)
print v(11) v(12) v(13) v(14) v(15) v(16) v(17) v(18) v(19) v(20)
print v(21) v(22)
print i(vs0) i(vs1) i(vs2) i(vs3) i(vs4) i(vs5) i(vs6) i(vs7) i(vs8) i(vs9)
print i(vs10) i(vs11) i(vs12) i(vs13) i(vs14) i(vs15) i(vs16) i(vs17) i(vs18) i(vs19)
print i(vs20) i(vs21) i(vs22) i(vs23) i(vs24) i(vs25) i(vs26) i(vs27) i(vs28) i(vs29)
print i(vs30) i(vs31)
.endc
.end
