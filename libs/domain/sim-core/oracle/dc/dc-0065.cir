controls oracle dc-0065
* Generated (plan F2.7, ADR 0012): do not edit; regenerate with `pnpm sim oracle regen`. dc seed 20261030 index 65 nodes 23 elements 24
.options sparse gmin=1e-12 noopac
RG1 1 0 1000000000000
RG2 2 0 1000000000000
RG3 3 0 1000000000000
RG4 4 0 1000000000000
RG5 5 0 1000000000000
RG6 6 0 1000000000000
RG7 7 0 1000000000000
RG8 8 0 1000000000000
RG9 9 0 1000000000000
RG10 10 0 1000000000000
RG11 11 0 1000000000000
RG12 12 0 1000000000000
RG13 13 0 1000000000000
RG14 14 0 1000000000000
RG15 15 0 1000000000000
RG16 16 0 1000000000000
RG17 17 0 1000000000000
RG18 18 0 1000000000000
RG19 19 0 1000000000000
RG20 20 0 1000000000000
RG21 21 0 1000000000000
RG22 22 0 1000000000000
VS0 0 s0 0
V0 e0 s0 DC 56e-1
RI0 e0 4 68e-3
VS1 10 s1 0
R1 s1 11 18e0
VS2 12 s2 0
R2 s2 11 56e3
VS3 22 s3 0
I3 s3 4 DC 56e-2
VS4 0 s4 0
R4 s4 19 56e0
VS5 20 s5 0
R5 s5 19 22e1
VS6 2 s6 0
R6 s6 1 82e0
VS7 17 s7 0
R7 s7 2 18e1
VS8 19 s8 0
R8 s8 8 39e-1
VS9 17 s9 0
V9 e9 s9 DC 12e0
RI9 e9 13 18e-3
VS10 11 s10 0
R10 s10 15 68e-1
VS11 16 s11 0
R11 s11 2 10e-2
VS12 0 s12 0
R12 s12 15 68e-1
VS13 9 s13 0
R13 s13 17 22e0
VS14 3 s14 0
R14 s14 22 27e0
VS15 0 s15 0
R15 s15 3 39e1
VS16 17 s16 0
R16 s16 3 27e3
VS17 6 s17 0
R17 s17 15 47e1
VS18 14 s18 0
R18 s18 1 39e0
VS19 18 s19 0
R19 s19 10 47e-1
VS20 20 s20 0
R20 s20 12 27e3
VS21 9 s21 0
V21 e21 s21 DC 18e0
RI21 e21 21 56e-1
VS22 1 s22 0
R22 s22 7 10e3
VS23 5 s23 0
R23 s23 0 47e2
.control
set numdgt=17
op
print v(1) v(2) v(3) v(4) v(5) v(6) v(7) v(8) v(9) v(10)
print v(11) v(12) v(13) v(14) v(15) v(16) v(17) v(18) v(19) v(20)
print v(21) v(22)
print i(vs0) i(vs1) i(vs2) i(vs3) i(vs4) i(vs5) i(vs6) i(vs7) i(vs8) i(vs9)
print i(vs10) i(vs11) i(vs12) i(vs13) i(vs14) i(vs15) i(vs16) i(vs17) i(vs18) i(vs19)
print i(vs20) i(vs21) i(vs22) i(vs23)
.endc
.end
