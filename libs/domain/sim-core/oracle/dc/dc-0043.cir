controls oracle dc-0043
* Generated (plan F2.7, ADR 0012): do not edit; regenerate with `pnpm sim oracle regen`. dc seed 20261030 index 43 nodes 17 elements 23
.options sparse gmin=1e-12 noopac
RG1 1 0 1000000000000
RG2 2 0 1000000000000
RG3 3 0 1000000000000
RG4 4 0 1000000000000
RG5 5 0 1000000000000
RG6 6 0 1000000000000
RG7 7 0 1000000000000
RG8 8 0 1000000000000
RG9 9 0 1000000000000
RG10 10 0 1000000000000
RG11 11 0 1000000000000
RG12 12 0 1000000000000
RG13 13 0 1000000000000
RG14 14 0 1000000000000
RG15 15 0 1000000000000
RG16 16 0 1000000000000
VS0 9 s0 0
R0 s0 1 22e3
VS1 0 s1 0
V1 e1 s1 DC 56e1
RI1 e1 13 82e-3
VS2 8 s2 0
R2 s2 2 18e3
VS3 13 s3 0
R3 s3 0 10e0
VS4 13 s4 0
R4 s4 12 15e1
VS5 7 s5 0
R5 s5 1 18e3
VS6 10 s6 0
R6 s6 13 68e0
VS7 5 s7 0
R7 s7 16 22e3
VS8 4 s8 0
R8 s8 10 82e0
VS9 6 s9 0
V9 e9 s9 DC 12e1
RI9 e9 14 39e-3
VS10 9 s10 0
R10 s10 15 22e-2
VS11 15 s11 0
R11 s11 3 39e-1
VS12 12 s12 0
R12 s12 7 18e0
VS13 11 s13 0
R13 s13 4 47e-1
VS14 8 s14 0
R14 s14 12 39e1
VS15 6 s15 0
V15 e15 s15 DC 82e-1
RI15 e15 9 56e-2
VS16 0 s16 0
R16 s16 14 56e-1
VS17 9 s17 0
R17 s17 10 39e-1
VS18 1 s18 0
I18 s18 15 DC 10e-4
VS19 11 s19 0
R19 s19 5 12e2
VS20 13 s20 0
R20 s20 5 18e0
VS21 16 s21 0
R21 s21 7 12e-2
VS22 3 s22 0
V22 e22 s22 DC 33e1
RI22 e22 2 82e-1
.control
set numdgt=17
op
print v(1) v(2) v(3) v(4) v(5) v(6) v(7) v(8) v(9) v(10)
print v(11) v(12) v(13) v(14) v(15) v(16)
print i(vs0) i(vs1) i(vs2) i(vs3) i(vs4) i(vs5) i(vs6) i(vs7) i(vs8) i(vs9)
print i(vs10) i(vs11) i(vs12) i(vs13) i(vs14) i(vs15) i(vs16) i(vs17) i(vs18) i(vs19)
print i(vs20) i(vs21) i(vs22)
.endc
.end
