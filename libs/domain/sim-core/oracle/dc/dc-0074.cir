controls oracle dc-0074
* Generated (plan F2.7, ADR 0012): do not edit; regenerate with `pnpm sim oracle regen`. dc seed 20261030 index 74 nodes 27 elements 56
.options sparse gmin=1e-12 noopac
RG1 1 0 1000000000000
RG2 2 0 1000000000000
RG3 3 0 1000000000000
RG4 4 0 1000000000000
RG5 5 0 1000000000000
RG6 6 0 1000000000000
RG7 7 0 1000000000000
RG8 8 0 1000000000000
RG9 9 0 1000000000000
RG10 10 0 1000000000000
RG11 11 0 1000000000000
RG12 12 0 1000000000000
RG13 13 0 1000000000000
RG14 14 0 1000000000000
RG15 15 0 1000000000000
RG16 16 0 1000000000000
RG17 17 0 1000000000000
RG18 18 0 1000000000000
RG19 19 0 1000000000000
RG20 20 0 1000000000000
RG21 21 0 1000000000000
RG22 22 0 1000000000000
RG23 23 0 1000000000000
RG24 24 0 1000000000000
RG25 25 0 1000000000000
RG26 26 0 1000000000000
VS0 15 s0 0
R0 s0 19 68e3
VS1 12 s1 0
I1 s1 11 DC 68e-2
VS2 16 s2 0
R2 s2 9 33e-1
VS3 0 s3 0
V3 e3 s3 DC 15e-1
RI3 e3 6 15e-2
VS4 11 s4 0
R4 s4 9 10e2
VS5 25 s5 0
R5 s5 1 10e1
VS6 24 s6 0
R6 s6 22 27e1
VS7 22 s7 0
R7 s7 0 27e-1
VS8 20 s8 0
R8 s8 4 82e1
VS9 4 s9 0
R9 s9 7 33e1
VS10 13 s10 0
R10 s10 14 27e2
VS11 8 s11 0
V11 e11 s11 DC 39e-1
RI11 e11 12 68e-2
VS12 23 s12 0
V12 e12 s12 DC 39e0
RI12 e12 11 68e-1
VS13 15 s13 0
R13 s13 11 12e-1
VS14 16 s14 0
I14 s14 9 DC 22e-4
VS15 18 s15 0
R15 s15 4 22e2
VS16 13 s16 0
R16 s16 8 18e0
VS17 16 s17 0
R17 s17 22 56e-2
VS18 23 s18 0
R18 s18 10 68e1
VS19 16 s19 0
I19 s19 14 DC 18e-1
VS20 19 s20 0
R20 s20 6 68e-2
VS21 24 s21 0
R21 s21 25 33e-1
VS22 14 s22 0
R22 s22 4 39e3
VS23 3 s23 0
R23 s23 19 10e1
VS24 9 s24 0
I24 s24 0 DC 82e-1
VS25 15 s25 0
R25 s25 24 15e-1
VS26 20 s26 0
R26 s26 12 68e-2
VS27 22 s27 0
R27 s27 17 18e3
VS28 15 s28 0
R28 s28 5 47e-2
VS29 21 s29 0
R29 s29 14 47e-1
VS30 20 s30 0
R30 s30 1 39e2
VS31 2 s31 0
R31 s31 26 33e1
VS32 16 s32 0
V32 e32 s32 DC 18e-1
RI32 e32 17 33e-1
VS33 2 s33 0
I33 s33 1 DC 27e-4
VS34 2 s34 0
V34 e34 s34 DC 10e-1
RI34 e34 26 47e-1
VS35 4 s35 0
R35 s35 3 27e0
VS36 2 s36 0
R36 s36 3 39e-1
VS37 8 s37 0
V37 e37 s37 DC 27e0
RI37 e37 3 18e-1
VS38 11 s38 0
I38 s38 9 DC 33e-4
VS39 24 s39 0
V39 e39 s39 DC 82e-1
RI39 e39 12 22e-3
VS40 12 s40 0
R40 s40 23 82e1
VS41 23 s41 0
I41 s41 8 DC 27e-3
VS42 6 s42 0
I42 s42 0 DC 33e-1
VS43 25 s43 0
I43 s43 3 DC 12e-3
VS44 4 s44 0
R44 s44 5 47e0
VS45 6 s45 0
R45 s45 25 68e-2
VS46 18 s46 0
R46 s46 14 82e2
VS47 11 s47 0
R47 s47 8 22e-2
VS48 22 s48 0
I48 s48 17 DC 22e-4
VS49 26 s49 0
R49 s49 18 82e-2
VS50 9 s50 0
R50 s50 3 82e-1
VS51 17 s51 0
R51 s51 20 18e-2
VS52 16 s52 0
R52 s52 7 27e-1
VS53 2 s53 0
R53 s53 13 33e2
VS54 1 s54 0
R54 s54 21 27e3
VS55 5 s55 0
R55 s55 10 15e1
.control
set numdgt=17
op
print v(1) v(2) v(3) v(4) v(5) v(6) v(7) v(8) v(9) v(10)
print v(11) v(12) v(13) v(14) v(15) v(16) v(17) v(18) v(19) v(20)
print v(21) v(22) v(23) v(24) v(25) v(26)
print i(vs0) i(vs1) i(vs2) i(vs3) i(vs4) i(vs5) i(vs6) i(vs7) i(vs8) i(vs9)
print i(vs10) i(vs11) i(vs12) i(vs13) i(vs14) i(vs15) i(vs16) i(vs17) i(vs18) i(vs19)
print i(vs20) i(vs21) i(vs22) i(vs23) i(vs24) i(vs25) i(vs26) i(vs27) i(vs28) i(vs29)
print i(vs30) i(vs31) i(vs32) i(vs33) i(vs34) i(vs35) i(vs36) i(vs37) i(vs38) i(vs39)
print i(vs40) i(vs41) i(vs42) i(vs43) i(vs44) i(vs45) i(vs46) i(vs47) i(vs48) i(vs49)
print i(vs50) i(vs51) i(vs52) i(vs53) i(vs54) i(vs55)
.endc
.end
