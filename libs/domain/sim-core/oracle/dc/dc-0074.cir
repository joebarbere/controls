controls oracle dc-0074
* Generated (plan F2.7, ADR 0012): do not edit; regenerate with `pnpm sim oracle regen`. dc seed 20261030 index 74 nodes 27 elements 53
.options sparse gmin=1e-12 noopac
RG1 1 0 1000000000000
RG2 2 0 1000000000000
RG3 3 0 1000000000000
RG4 4 0 1000000000000
RG5 5 0 1000000000000
RG6 6 0 1000000000000
RG7 7 0 1000000000000
RG8 8 0 1000000000000
RG9 9 0 1000000000000
RG10 10 0 1000000000000
RG11 11 0 1000000000000
RG12 12 0 1000000000000
RG13 13 0 1000000000000
RG14 14 0 1000000000000
RG15 15 0 1000000000000
RG16 16 0 1000000000000
RG17 17 0 1000000000000
RG18 18 0 1000000000000
RG19 19 0 1000000000000
RG20 20 0 1000000000000
RG21 21 0 1000000000000
RG22 22 0 1000000000000
RG23 23 0 1000000000000
RG24 24 0 1000000000000
RG25 25 0 1000000000000
RG26 26 0 1000000000000
VS0 13 s0 0
R0 s0 14 27e2
VS1 0 s1 0
R1 s1 26 33e1
VS2 16 s2 0
R2 s2 22 56e-2
VS3 11 s3 0
I3 s3 9 DC 33e-4
VS4 25 s4 0
I4 s4 3 DC 12e-3
VS5 22 s5 0
R5 s5 4 27e-1
VS6 0 s6 0
R6 s6 13 33e2
VS7 23 s7 0
I7 s7 8 DC 27e-3
VS8 0 s8 0
V8 e8 s8 DC 10e-1
RI8 e8 26 47e-1
VS9 22 s9 0
I9 s9 17 DC 22e-4
VS10 15 s10 0
R10 s10 24 15e-1
VS11 21 s11 0
R11 s11 14 47e-1
VS12 15 s12 0
R12 s12 11 12e-1
VS13 14 s13 0
R13 s13 2 39e3
VS14 3 s14 0
R14 s14 19 10e1
VS15 9 s15 0
I15 s15 4 DC 82e-1
VS16 17 s16 0
R16 s16 20 18e-2
VS17 1 s17 0
R17 s17 21 27e3
VS18 8 s18 0
V18 e18 s18 DC 39e-1
RI18 e18 12 68e-2
VS19 8 s19 0
V19 e19 s19 DC 27e0
RI19 e19 3 18e-1
VS20 15 s20 0
R20 s20 19 68e3
VS21 23 s21 0
V21 e21 s21 DC 39e0
RI21 e21 11 68e-1
VS22 6 s22 0
R22 s22 25 68e-2
VS23 12 s23 0
R23 s23 23 82e1
VS24 16 s24 0
R24 s24 9 33e-1
VS25 26 s25 0
R25 s25 18 82e-2
VS26 18 s26 0
R26 s26 2 22e2
VS27 20 s27 0
R27 s27 12 68e-2
VS28 16 s28 0
I28 s28 14 DC 18e-1
VS29 11 s29 0
R29 s29 8 22e-2
VS30 9 s30 0
R30 s30 3 82e-1
VS31 11 s31 0
R31 s31 9 10e2
VS32 2 s32 0
R32 s32 5 47e0
VS33 23 s33 0
R33 s33 10 68e1
VS34 20 s34 0
R34 s34 2 82e1
VS35 20 s35 0
R35 s35 1 39e2
VS36 2 s36 0
R36 s36 3 27e0
VS37 16 s37 0
I37 s37 9 DC 22e-4
VS38 24 s38 0
R38 s38 25 33e-1
VS39 22 s39 0
R39 s39 17 18e3
VS40 6 s40 0
I40 s40 4 DC 33e-1
VS41 0 s41 0
I41 s41 1 DC 27e-4
VS42 25 s42 0
R42 s42 1 10e1
VS43 18 s43 0
R43 s43 14 82e2
VS44 24 s44 0
R44 s44 22 27e1
VS45 13 s45 0
R45 s45 8 18e0
VS46 0 s46 0
R46 s46 3 39e-1
VS47 2 s47 0
R47 s47 7 33e1
VS48 16 s48 0
V48 e48 s48 DC 18e-1
RI48 e48 17 33e-1
VS49 19 s49 0
R49 s49 6 68e-2
VS50 24 s50 0
V50 e50 s50 DC 82e-1
RI50 e50 12 22e-3
VS51 15 s51 0
R51 s51 5 47e-2
VS52 12 s52 0
I52 s52 11 DC 68e-2
.control
set numdgt=17
op
print v(1) v(2) v(3) v(4) v(5) v(6) v(7) v(8) v(9) v(10)
print v(11) v(12) v(13) v(14) v(15) v(16) v(17) v(18) v(19) v(20)
print v(21) v(22) v(23) v(24) v(25) v(26)
print i(vs0) i(vs1) i(vs2) i(vs3) i(vs4) i(vs5) i(vs6) i(vs7) i(vs8) i(vs9)
print i(vs10) i(vs11) i(vs12) i(vs13) i(vs14) i(vs15) i(vs16) i(vs17) i(vs18) i(vs19)
print i(vs20) i(vs21) i(vs22) i(vs23) i(vs24) i(vs25) i(vs26) i(vs27) i(vs28) i(vs29)
print i(vs30) i(vs31) i(vs32) i(vs33) i(vs34) i(vs35) i(vs36) i(vs37) i(vs38) i(vs39)
print i(vs40) i(vs41) i(vs42) i(vs43) i(vs44) i(vs45) i(vs46) i(vs47) i(vs48) i(vs49)
print i(vs50) i(vs51) i(vs52)
.endc
.end
