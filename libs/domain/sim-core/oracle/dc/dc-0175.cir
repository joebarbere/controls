controls oracle dc-0175
* Generated (plan F2.7, ADR 0012): do not edit; regenerate with `pnpm sim oracle regen`. dc seed 20261030 index 175 nodes 8 elements 8
.options sparse gmin=1e-12 noopac
RG1 1 0 1000000000000
RG2 2 0 1000000000000
RG3 3 0 1000000000000
RG4 4 0 1000000000000
RG5 5 0 1000000000000
RG6 6 0 1000000000000
RG7 7 0 1000000000000
VS0 0 s0 0
V0 e0 s0 DC 39e-1
RI0 e0 6 22e-2
VS1 0 s1 0
R1 s1 3 33e3
VS2 2 s2 0
V2 e2 s2 DC 39e0
RI2 e2 0 27e-2
VS3 6 s3 0
R3 s3 1 12e1
VS4 0 s4 0
R4 s4 6 22e1
VS5 0 s5 0
R5 s5 4 39e3
VS6 0 s6 0
R6 s6 5 22e0
VS7 4 s7 0
R7 s7 7 27e3
.control
set numdgt=17
op
print v(1) v(2) v(3) v(4) v(5) v(6) v(7)
print i(vs0) i(vs1) i(vs2) i(vs3) i(vs4) i(vs5) i(vs6) i(vs7)
.endc
.end
