controls oracle dc-0175
* Generated (plan F2.7, ADR 0012): do not edit; regenerate with `pnpm sim oracle regen`. dc seed 20261030 index 175 nodes 8 elements 13
.options sparse gmin=1e-12 noopac
RG1 1 0 1000000000000
RG2 2 0 1000000000000
RG3 3 0 1000000000000
RG4 4 0 1000000000000
RG5 5 0 1000000000000
RG6 6 0 1000000000000
RG7 7 0 1000000000000
VS0 4 s0 0
R0 s0 7 27e3
VS1 0 s1 0
V1 e1 s1 DC 15e0
RI1 e1 6 82e-3
VS2 2 s2 0
V2 e2 s2 DC 39e0
RI2 e2 3 27e-2
VS3 1 s3 0
R3 s3 3 47e2
VS4 3 s4 0
V4 e4 s4 DC 15e0
RI4 e4 7 12e-2
VS5 3 s5 0
R5 s5 4 39e3
VS6 3 s6 0
R6 s6 5 22e0
VS7 4 s7 0
R7 s7 5 47e3
VS8 3 s8 0
R8 s8 0 33e3
VS9 0 s9 0
R9 s9 4 12e1
VS10 2 s10 0
R10 s10 1 12e-1
VS11 6 s11 0
R11 s11 1 12e1
VS12 3 s12 0
V12 e12 s12 DC 39e-1
RI12 e12 6 22e-2
.control
set numdgt=17
op
print v(1) v(2) v(3) v(4) v(5) v(6) v(7)
print i(vs0) i(vs1) i(vs2) i(vs3) i(vs4) i(vs5) i(vs6) i(vs7) i(vs8) i(vs9)
print i(vs10) i(vs11) i(vs12)
.endc
.end
