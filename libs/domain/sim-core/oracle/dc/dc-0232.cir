controls oracle dc-0232
* Generated (plan F2.7, ADR 0012): do not edit; regenerate with `pnpm sim oracle regen`. dc seed 20261030 index 232 nodes 25 elements 37
.options sparse gmin=1e-12 noopac
RG1 1 0 1000000000000
RG2 2 0 1000000000000
RG3 3 0 1000000000000
RG4 4 0 1000000000000
RG5 5 0 1000000000000
RG6 6 0 1000000000000
RG7 7 0 1000000000000
RG8 8 0 1000000000000
RG9 9 0 1000000000000
RG10 10 0 1000000000000
RG11 11 0 1000000000000
RG12 12 0 1000000000000
RG13 13 0 1000000000000
RG14 14 0 1000000000000
RG15 15 0 1000000000000
RG16 16 0 1000000000000
RG17 17 0 1000000000000
RG18 18 0 1000000000000
RG19 19 0 1000000000000
RG20 20 0 1000000000000
RG21 21 0 1000000000000
RG22 22 0 1000000000000
RG23 23 0 1000000000000
RG24 24 0 1000000000000
VS0 1 s0 0
R0 s0 9 47e-1
VS1 10 s1 0
R1 s1 6 15e3
VS2 23 s2 0
I2 s2 10 DC 56e-2
VS3 22 s3 0
R3 s3 24 39e-2
VS4 10 s4 0
R4 s4 14 15e2
VS5 0 s5 0
V5 e5 s5 DC 47e1
RI5 e5 1 39e-2
VS6 5 s6 0
R6 s6 10 18e1
VS7 24 s7 0
V7 e7 s7 DC 33e-1
RI7 e7 3 15e-1
VS8 17 s8 0
V8 e8 s8 DC 39e-1
RI8 e8 15 18e-1
VS9 0 s9 0
R9 s9 24 33e3
VS10 13 s10 0
R10 s10 22 18e2
VS11 2 s11 0
V11 e11 s11 DC 82e0
RI11 e11 11 56e-3
VS12 14 s12 0
R12 s12 19 33e3
VS13 24 s13 0
R13 s13 1 22e0
VS14 17 s14 0
R14 s14 22 12e2
VS15 21 s15 0
V15 e15 s15 DC 15e0
RI15 e15 11 22e-1
VS16 13 s16 0
R16 s16 20 82e-2
VS17 19 s17 0
R17 s17 21 56e0
VS18 3 s18 0
R18 s18 17 56e-1
VS19 8 s19 0
R19 s19 10 39e-1
VS20 24 s20 0
R20 s20 6 15e2
VS21 18 s21 0
R21 s21 3 10e-1
VS22 4 s22 0
R22 s22 12 18e1
VS23 23 s23 0
V23 e23 s23 DC 10e-1
RI23 e23 21 56e-2
VS24 11 s24 0
R24 s24 14 47e1
VS25 12 s25 0
R25 s25 13 27e3
VS26 7 s26 0
R26 s26 19 10e1
VS27 2 s27 0
R27 s27 22 47e-2
VS28 12 s28 0
R28 s28 8 18e-2
VS29 12 s29 0
R29 s29 10 22e-2
VS30 13 s30 0
I30 s30 8 DC 22e-1
VS31 23 s31 0
R31 s31 17 39e3
VS32 11 s32 0
R32 s32 4 27e-1
VS33 21 s33 0
R33 s33 16 27e-2
VS34 15 s34 0
V34 e34 s34 DC 33e0
RI34 e34 0 33e-2
VS35 2 s35 0
R35 s35 0 18e0
VS36 6 s36 0
R36 s36 1 56e-1
.control
set numdgt=17
op
print v(1) v(2) v(3) v(4) v(5) v(6) v(7) v(8) v(9) v(10)
print v(11) v(12) v(13) v(14) v(15) v(16) v(17) v(18) v(19) v(20)
print v(21) v(22) v(23) v(24)
print i(vs0) i(vs1) i(vs2) i(vs3) i(vs4) i(vs5) i(vs6) i(vs7) i(vs8) i(vs9)
print i(vs10) i(vs11) i(vs12) i(vs13) i(vs14) i(vs15) i(vs16) i(vs17) i(vs18) i(vs19)
print i(vs20) i(vs21) i(vs22) i(vs23) i(vs24) i(vs25) i(vs26) i(vs27) i(vs28) i(vs29)
print i(vs30) i(vs31) i(vs32) i(vs33) i(vs34) i(vs35) i(vs36)
.endc
.end
