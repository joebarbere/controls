controls oracle dc-0026
* Generated (plan F2.7, ADR 0012): do not edit; regenerate with `pnpm sim oracle regen`. dc seed 20261030 index 26 nodes 28 elements 49
.options sparse gmin=1e-12 noopac
RG1 1 0 1000000000000
RG2 2 0 1000000000000
RG3 3 0 1000000000000
RG4 4 0 1000000000000
RG5 5 0 1000000000000
RG6 6 0 1000000000000
RG7 7 0 1000000000000
RG8 8 0 1000000000000
RG9 9 0 1000000000000
RG10 10 0 1000000000000
RG11 11 0 1000000000000
RG12 12 0 1000000000000
RG13 13 0 1000000000000
RG14 14 0 1000000000000
RG15 15 0 1000000000000
RG16 16 0 1000000000000
RG17 17 0 1000000000000
RG18 18 0 1000000000000
RG19 19 0 1000000000000
RG20 20 0 1000000000000
RG21 21 0 1000000000000
RG22 22 0 1000000000000
RG23 23 0 1000000000000
RG24 24 0 1000000000000
RG25 25 0 1000000000000
RG26 26 0 1000000000000
RG27 27 0 1000000000000
VS0 20 s0 0
R0 s0 26 27e2
VS1 0 s1 0
R1 s1 26 12e1
VS2 0 s2 0
V2 e2 s2 DC 27e1
RI2 e2 22 82e-3
VS3 26 s3 0
R3 s3 2 10e2
VS4 12 s4 0
R4 s4 22 18e0
VS5 3 s5 0
R5 s5 19 22e1
VS6 5 s6 0
R6 s6 12 15e1
VS7 21 s7 0
R7 s7 8 33e3
VS8 25 s8 0
R8 s8 27 27e0
VS9 18 s9 0
R9 s9 20 56e-1
VS10 5 s10 0
R10 s10 25 56e-2
VS11 24 s11 0
R11 s11 9 22e-1
VS12 6 s12 0
R12 s12 15 22e-1
VS13 10 s13 0
V13 e13 s13 DC 56e-1
RI13 e13 24 12e-3
VS14 6 s14 0
R14 s14 27 18e0
VS15 10 s15 0
R15 s15 3 10e0
VS16 1 s16 0
I16 s16 10 DC 22e-1
VS17 8 s17 0
R17 s17 11 18e3
VS18 7 s18 0
I18 s18 3 DC 68e-2
VS19 11 s19 0
R19 s19 25 10e0
VS20 20 s20 0
R20 s20 26 10e1
VS21 20 s21 0
R21 s21 24 27e1
VS22 0 s22 0
R22 s22 20 68e-1
VS23 4 s23 0
R23 s23 13 39e3
VS24 22 s24 0
R24 s24 3 27e0
VS25 27 s25 0
R25 s25 18 39e0
VS26 6 s26 0
R26 s26 19 10e-2
VS27 6 s27 0
R27 s27 13 47e2
VS28 3 s28 0
R28 s28 9 47e-2
VS29 17 s29 0
R29 s29 9 47e-1
VS30 16 s30 0
R30 s30 13 22e0
VS31 21 s31 0
V31 e31 s31 DC 22e0
RI31 e31 9 12e-1
VS32 7 s32 0
R32 s32 1 68e1
VS33 23 s33 0
R33 s33 11 39e2
VS34 1 s34 0
V34 e34 s34 DC 27e-1
RI34 e34 22 82e-3
VS35 20 s35 0
V35 e35 s35 DC 15e1
RI35 e35 23 22e-1
VS36 25 s36 0
R36 s36 14 18e0
VS37 14 s37 0
R37 s37 9 15e1
VS38 25 s38 0
I38 s38 2 DC 68e-4
VS39 1 s39 0
R39 s39 12 15e3
VS40 9 s40 0
V40 e40 s40 DC 56e0
RI40 e40 7 33e-2
VS41 6 s41 0
V41 e41 s41 DC 18e1
RI41 e41 9 47e-1
VS42 20 s42 0
R42 s42 0 10e-2
VS43 4 s43 0
R43 s43 27 22e1
VS44 12 s44 0
V44 e44 s44 DC 15e0
RI44 e44 8 82e-3
VS45 17 s45 0
V45 e45 s45 DC 47e1
RI45 e45 2 82e-3
VS46 15 s46 0
R46 s46 16 10e0
VS47 9 s47 0
R47 s47 11 33e0
VS48 4 s48 0
I48 s48 9 DC 15e-1
.control
set numdgt=17
op
print v(1) v(2) v(3) v(4) v(5) v(6) v(7) v(8) v(9) v(10)
print v(11) v(12) v(13) v(14) v(15) v(16) v(17) v(18) v(19) v(20)
print v(21) v(22) v(23) v(24) v(25) v(26) v(27)
print i(vs0) i(vs1) i(vs2) i(vs3) i(vs4) i(vs5) i(vs6) i(vs7) i(vs8) i(vs9)
print i(vs10) i(vs11) i(vs12) i(vs13) i(vs14) i(vs15) i(vs16) i(vs17) i(vs18) i(vs19)
print i(vs20) i(vs21) i(vs22) i(vs23) i(vs24) i(vs25) i(vs26) i(vs27) i(vs28) i(vs29)
print i(vs30) i(vs31) i(vs32) i(vs33) i(vs34) i(vs35) i(vs36) i(vs37) i(vs38) i(vs39)
print i(vs40) i(vs41) i(vs42) i(vs43) i(vs44) i(vs45) i(vs46) i(vs47) i(vs48)
.endc
.end
