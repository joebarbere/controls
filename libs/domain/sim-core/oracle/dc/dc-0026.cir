controls oracle dc-0026
* Generated (plan F2.7, ADR 0012): do not edit; regenerate with `pnpm sim oracle regen`. dc seed 20261030 index 26 nodes 28 elements 40
.options sparse gmin=1e-12 noopac
RG1 1 0 1000000000000
RG2 2 0 1000000000000
RG3 3 0 1000000000000
RG4 4 0 1000000000000
RG5 5 0 1000000000000
RG6 6 0 1000000000000
RG7 7 0 1000000000000
RG8 8 0 1000000000000
RG9 9 0 1000000000000
RG10 10 0 1000000000000
RG11 11 0 1000000000000
RG12 12 0 1000000000000
RG13 13 0 1000000000000
RG14 14 0 1000000000000
RG15 15 0 1000000000000
RG16 16 0 1000000000000
RG17 17 0 1000000000000
RG18 18 0 1000000000000
RG19 19 0 1000000000000
RG20 20 0 1000000000000
RG21 21 0 1000000000000
RG22 22 0 1000000000000
RG23 23 0 1000000000000
RG24 24 0 1000000000000
RG25 25 0 1000000000000
RG26 26 0 1000000000000
RG27 27 0 1000000000000
VS0 15 s0 0
R0 s0 16 10e0
VS1 0 s1 0
V1 e1 s1 DC 27e1
RI1 e1 22 82e-3
VS2 6 s2 0
R2 s2 15 22e-1
VS3 11 s3 0
R3 s3 25 10e0
VS4 20 s4 0
R4 s4 26 10e1
VS5 17 s5 0
R5 s5 9 47e-1
VS6 9 s6 0
V6 e6 s6 DC 56e0
RI6 e6 7 33e-2
VS7 0 s7 0
R7 s7 26 12e1
VS8 14 s8 0
R8 s8 9 15e1
VS9 12 s9 0
R9 s9 22 18e0
VS10 10 s10 0
V10 e10 s10 DC 56e-1
RI10 e10 24 12e-3
VS11 23 s11 0
R11 s11 11 39e2
VS12 4 s12 0
R12 s12 13 39e3
VS13 5 s13 0
R13 s13 12 15e1
VS14 1 s14 0
R14 s14 12 15e3
VS15 25 s15 0
R15 s15 27 27e0
VS16 9 s16 0
R16 s16 11 33e0
VS17 20 s17 0
R17 s17 0 10e-2
VS18 18 s18 0
R18 s18 20 56e-1
VS19 26 s19 0
R19 s19 2 10e2
VS20 7 s20 0
I20 s20 3 DC 68e-2
VS21 4 s21 0
I21 s21 9 DC 15e-1
VS22 12 s22 0
V22 e22 s22 DC 15e0
RI22 e22 8 82e-3
VS23 24 s23 0
R23 s23 9 22e-1
VS24 25 s24 0
I24 s24 2 DC 68e-4
VS25 8 s25 0
R25 s25 11 18e3
VS26 0 s26 0
R26 s26 20 68e-1
VS27 3 s27 0
R27 s27 9 47e-2
VS28 6 s28 0
V28 e28 s28 DC 18e1
RI28 e28 9 47e-1
VS29 17 s29 0
V29 e29 s29 DC 47e1
RI29 e29 2 82e-3
VS30 6 s30 0
R30 s30 19 10e-2
VS31 1 s31 0
I31 s31 10 DC 22e-1
VS32 20 s32 0
R32 s32 24 27e1
VS33 22 s33 0
R33 s33 3 27e0
VS34 20 s34 0
R34 s34 26 27e2
VS35 6 s35 0
R35 s35 13 47e2
VS36 21 s36 0
R36 s36 8 33e3
VS37 6 s37 0
R37 s37 27 18e0
VS38 25 s38 0
R38 s38 14 18e0
VS39 10 s39 0
R39 s39 3 10e0
.control
set numdgt=17
op
print v(1) v(2) v(3) v(4) v(5) v(6) v(7) v(8) v(9) v(10)
print v(11) v(12) v(13) v(14) v(15) v(16) v(17) v(18) v(19) v(20)
print v(21) v(22) v(23) v(24) v(25) v(26) v(27)
print i(vs0) i(vs1) i(vs2) i(vs3) i(vs4) i(vs5) i(vs6) i(vs7) i(vs8) i(vs9)
print i(vs10) i(vs11) i(vs12) i(vs13) i(vs14) i(vs15) i(vs16) i(vs17) i(vs18) i(vs19)
print i(vs20) i(vs21) i(vs22) i(vs23) i(vs24) i(vs25) i(vs26) i(vs27) i(vs28) i(vs29)
print i(vs30) i(vs31) i(vs32) i(vs33) i(vs34) i(vs35) i(vs36) i(vs37) i(vs38) i(vs39)
.endc
.end
