controls oracle dc-0003
* Generated (plan F2.7, ADR 0012): do not edit; regenerate with `pnpm sim oracle regen`. dc seed 20261030 index 3 nodes 30 elements 61
.options sparse gmin=1e-12 noopac
RG1 1 0 1000000000000
RG2 2 0 1000000000000
RG3 3 0 1000000000000
RG4 4 0 1000000000000
RG5 5 0 1000000000000
RG6 6 0 1000000000000
RG7 7 0 1000000000000
RG8 8 0 1000000000000
RG9 9 0 1000000000000
RG10 10 0 1000000000000
RG11 11 0 1000000000000
RG12 12 0 1000000000000
RG13 13 0 1000000000000
RG14 14 0 1000000000000
RG15 15 0 1000000000000
RG16 16 0 1000000000000
RG17 17 0 1000000000000
RG18 18 0 1000000000000
RG19 19 0 1000000000000
RG20 20 0 1000000000000
RG21 21 0 1000000000000
RG22 22 0 1000000000000
RG23 23 0 1000000000000
RG24 24 0 1000000000000
RG25 25 0 1000000000000
RG26 26 0 1000000000000
RG27 27 0 1000000000000
RG28 28 0 1000000000000
RG29 29 0 1000000000000
VS0 17 s0 0
R0 s0 5 27e2
VS1 21 s1 0
R1 s1 23 47e3
VS2 0 s2 0
V2 e2 s2 DC 27e-1
RI2 e2 26 33e-3
VS3 19 s3 0
R3 s3 8 18e-1
VS4 5 s4 0
I4 s4 8 DC 82e-4
VS5 20 s5 0
R5 s5 5 56e-1
VS6 22 s6 0
R6 s6 9 47e3
VS7 8 s7 0
R7 s7 1 22e-1
VS8 4 s8 0
V8 e8 s8 DC 68e0
RI8 e8 5 33e-1
VS9 28 s9 0
V9 e9 s9 DC 68e1
RI9 e9 16 22e-3
VS10 8 s10 0
R10 s10 6 56e-1
VS11 20 s11 0
V11 e11 s11 DC 10e-1
RI11 e11 1 15e-2
VS12 28 s12 0
R12 s12 26 47e-2
VS13 0 s13 0
R13 s13 2 18e2
VS14 12 s14 0
R14 s14 15 12e-2
VS15 15 s15 0
R15 s15 25 18e1
VS16 27 s16 0
R16 s16 8 33e-1
VS17 17 s17 0
R17 s17 18 12e2
VS18 25 s18 0
R18 s18 6 39e-2
VS19 8 s19 0
V19 e19 s19 DC 33e-1
RI19 e19 18 22e-3
VS20 9 s20 0
I20 s20 3 DC 56e-2
VS21 10 s21 0
R21 s21 4 18e-1
VS22 19 s22 0
R22 s22 7 68e0
VS23 14 s23 0
R23 s23 5 15e-2
VS24 25 s24 0
R24 s24 10 68e-2
VS25 12 s25 0
R25 s25 25 39e1
VS26 5 s26 0
V26 e26 s26 DC 18e0
RI26 e26 3 18e-2
VS27 1 s27 0
I27 s27 0 DC 82e-1
VS28 15 s28 0
R28 s28 18 18e2
VS29 24 s29 0
V29 e29 s29 DC 39e-1
RI29 e29 21 47e-1
VS30 18 s30 0
R30 s30 14 15e-1
VS31 14 s31 0
I31 s31 25 DC 47e-1
VS32 21 s32 0
R32 s32 18 68e1
VS33 29 s33 0
V33 e33 s33 DC 56e0
RI33 e33 22 68e-2
VS34 19 s34 0
I34 s34 18 DC 27e-2
VS35 29 s35 0
V35 e35 s35 DC 22e1
RI35 e35 27 12e-2
VS36 13 s36 0
R36 s36 18 10e-1
VS37 9 s37 0
R37 s37 23 27e1
VS38 2 s38 0
R38 s38 10 18e0
VS39 10 s39 0
R39 s39 8 82e-2
VS40 13 s40 0
R40 s40 19 82e2
VS41 3 s41 0
R41 s41 22 10e3
VS42 2 s42 0
V42 e42 s42 DC 12e0
RI42 e42 4 33e-1
VS43 11 s43 0
R43 s43 2 56e-1
VS44 4 s44 0
I44 s44 16 DC 10e-1
VS45 2 s45 0
R45 s45 23 27e-2
VS46 11 s46 0
R46 s46 0 56e-2
VS47 25 s47 0
R47 s47 18 10e1
VS48 20 s48 0
R48 s48 22 10e1
VS49 2 s49 0
V49 e49 s49 DC 47e0
RI49 e49 15 22e-3
VS50 16 s50 0
R50 s50 24 12e2
VS51 13 s51 0
V51 e51 s51 DC 15e0
RI51 e51 28 33e-1
VS52 27 s52 0
R52 s52 7 10e3
VS53 20 s53 0
I53 s53 21 DC 47e-4
VS54 13 s54 0
R54 s54 9 18e0
VS55 25 s55 0
I55 s55 9 DC 39e-2
VS56 14 s56 0
V56 e56 s56 DC 15e-1
RI56 e56 25 33e-3
VS57 23 s57 0
R57 s57 28 22e1
VS58 0 s58 0
R58 s58 7 18e-2
VS59 5 s59 0
I59 s59 24 DC 56e-1
VS60 13 s60 0
V60 e60 s60 DC 12e-1
RI60 e60 3 22e-1
.control
set numdgt=17
op
print v(1) v(2) v(3) v(4) v(5) v(6) v(7) v(8) v(9) v(10)
print v(11) v(12) v(13) v(14) v(15) v(16) v(17) v(18) v(19) v(20)
print v(21) v(22) v(23) v(24) v(25) v(26) v(27) v(28) v(29)
print i(vs0) i(vs1) i(vs2) i(vs3) i(vs4) i(vs5) i(vs6) i(vs7) i(vs8) i(vs9)
print i(vs10) i(vs11) i(vs12) i(vs13) i(vs14) i(vs15) i(vs16) i(vs17) i(vs18) i(vs19)
print i(vs20) i(vs21) i(vs22) i(vs23) i(vs24) i(vs25) i(vs26) i(vs27) i(vs28) i(vs29)
print i(vs30) i(vs31) i(vs32) i(vs33) i(vs34) i(vs35) i(vs36) i(vs37) i(vs38) i(vs39)
print i(vs40) i(vs41) i(vs42) i(vs43) i(vs44) i(vs45) i(vs46) i(vs47) i(vs48) i(vs49)
print i(vs50) i(vs51) i(vs52) i(vs53) i(vs54) i(vs55) i(vs56) i(vs57) i(vs58) i(vs59)
print i(vs60)
.endc
.end
