controls oracle dc-0003
* Generated (plan F2.7, ADR 0012): do not edit; regenerate with `pnpm sim oracle regen`. dc seed 20261030 index 3 nodes 30 elements 58
.options sparse gmin=1e-12 noopac
RG1 1 0 1000000000000
RG2 2 0 1000000000000
RG3 3 0 1000000000000
RG4 4 0 1000000000000
RG5 5 0 1000000000000
RG6 6 0 1000000000000
RG7 7 0 1000000000000
RG8 8 0 1000000000000
RG9 9 0 1000000000000
RG10 10 0 1000000000000
RG11 11 0 1000000000000
RG12 12 0 1000000000000
RG13 13 0 1000000000000
RG14 14 0 1000000000000
RG15 15 0 1000000000000
RG16 16 0 1000000000000
RG17 17 0 1000000000000
RG18 18 0 1000000000000
RG19 19 0 1000000000000
RG20 20 0 1000000000000
RG21 21 0 1000000000000
RG22 22 0 1000000000000
RG23 23 0 1000000000000
RG24 24 0 1000000000000
RG25 25 0 1000000000000
RG26 26 0 1000000000000
RG27 27 0 1000000000000
RG28 28 0 1000000000000
RG29 29 0 1000000000000
VS0 25 s0 0
R0 s0 6 39e-2
VS1 0 s1 0
R1 s1 1 22e-1
VS2 20 s2 0
R2 s2 5 56e-1
VS3 13 s3 0
R3 s3 8 10e-1
VS4 15 s4 0
R4 s4 8 18e2
VS5 14 s5 0
I5 s5 25 DC 47e-1
VS6 21 s6 0
R6 s6 8 68e1
VS7 0 s7 0
V7 e7 s7 DC 33e-1
RI7 e7 8 22e-3
VS8 10 s8 0
R8 s8 0 82e-2
VS9 13 s9 0
V9 e9 s9 DC 15e0
RI9 e9 28 33e-1
VS10 16 s10 0
R10 s10 24 12e2
VS11 22 s11 0
R11 s11 9 47e3
VS12 20 s12 0
I12 s12 21 DC 47e-4
VS13 14 s13 0
V13 e13 s13 DC 15e-1
RI13 e13 25 33e-3
VS14 2 s14 0
R14 s14 10 18e0
VS15 27 s15 0
R15 s15 7 10e3
VS16 17 s16 0
R16 s16 5 27e2
VS17 15 s17 0
R17 s17 25 18e1
VS18 19 s18 0
I18 s18 8 DC 27e-2
VS19 4 s19 0
I19 s19 16 DC 10e-1
VS20 18 s20 0
R20 s20 7 18e-2
VS21 20 s21 0
V21 e21 s21 DC 10e-1
RI21 e21 1 15e-2
VS22 29 s22 0
V22 e22 s22 DC 22e1
RI22 e22 27 12e-2
VS23 25 s23 0
I23 s23 9 DC 39e-2
VS24 13 s24 0
V24 e24 s24 DC 12e-1
RI24 e24 3 22e-1
VS25 14 s25 0
R25 s25 5 15e-2
VS26 9 s26 0
I26 s26 3 DC 56e-2
VS27 3 s27 0
R27 s27 22 10e3
VS28 13 s28 0
R28 s28 19 82e2
VS29 5 s29 0
I29 s29 0 DC 82e-4
VS30 12 s30 0
R30 s30 15 12e-2
VS31 12 s31 0
R31 s31 25 39e1
VS32 20 s32 0
R32 s32 22 10e1
VS33 19 s33 0
R33 s33 7 68e0
VS34 17 s34 0
R34 s34 8 12e2
VS35 28 s35 0
R35 s35 26 47e-2
VS36 8 s36 0
R36 s36 14 15e-1
VS37 13 s37 0
R37 s37 9 18e0
VS38 2 s38 0
R38 s38 23 27e-2
VS39 28 s39 0
V39 e39 s39 DC 68e1
RI39 e39 16 22e-3
VS40 25 s40 0
R40 s40 10 68e-2
VS41 2 s41 0
V41 e41 s41 DC 12e0
RI41 e41 4 33e-1
VS42 23 s42 0
R42 s42 28 22e1
VS43 5 s43 0
I43 s43 24 DC 56e-1
VS44 18 s44 0
V44 e44 s44 DC 27e-1
RI44 e44 26 33e-3
VS45 21 s45 0
R45 s45 23 47e3
VS46 1 s46 0
I46 s46 18 DC 82e-1
VS47 27 s47 0
R47 s47 0 33e-1
VS48 2 s48 0
V48 e48 s48 DC 47e0
RI48 e48 15 22e-3
VS49 4 s49 0
V49 e49 s49 DC 68e0
RI49 e49 5 33e-1
VS50 10 s50 0
R50 s50 4 18e-1
VS51 0 s51 0
R51 s51 6 56e-1
VS52 25 s52 0
R52 s52 8 10e1
VS53 19 s53 0
R53 s53 0 18e-1
VS54 9 s54 0
R54 s54 23 27e1
VS55 11 s55 0
R55 s55 2 56e-1
VS56 18 s56 0
R56 s56 2 18e2
VS57 5 s57 0
V57 e57 s57 DC 18e0
RI57 e57 3 18e-2
.control
set numdgt=17
op
print v(1) v(2) v(3) v(4) v(5) v(6) v(7) v(8) v(9) v(10)
print v(11) v(12) v(13) v(14) v(15) v(16) v(17) v(18) v(19) v(20)
print v(21) v(22) v(23) v(24) v(25) v(26) v(27) v(28) v(29)
print i(vs0) i(vs1) i(vs2) i(vs3) i(vs4) i(vs5) i(vs6) i(vs7) i(vs8) i(vs9)
print i(vs10) i(vs11) i(vs12) i(vs13) i(vs14) i(vs15) i(vs16) i(vs17) i(vs18) i(vs19)
print i(vs20) i(vs21) i(vs22) i(vs23) i(vs24) i(vs25) i(vs26) i(vs27) i(vs28) i(vs29)
print i(vs30) i(vs31) i(vs32) i(vs33) i(vs34) i(vs35) i(vs36) i(vs37) i(vs38) i(vs39)
print i(vs40) i(vs41) i(vs42) i(vs43) i(vs44) i(vs45) i(vs46) i(vs47) i(vs48) i(vs49)
print i(vs50) i(vs51) i(vs52) i(vs53) i(vs54) i(vs55) i(vs56) i(vs57)
.endc
.end
