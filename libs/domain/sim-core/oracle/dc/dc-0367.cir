controls oracle dc-0367
* Generated (plan F2.7, ADR 0012): do not edit; regenerate with `pnpm sim oracle regen`. dc seed 20261030 index 367 nodes 19 elements 29
.options sparse gmin=1e-12 noopac
RG1 1 0 1000000000000
RG2 2 0 1000000000000
RG3 3 0 1000000000000
RG4 4 0 1000000000000
RG5 5 0 1000000000000
RG6 6 0 1000000000000
RG7 7 0 1000000000000
RG8 8 0 1000000000000
RG9 9 0 1000000000000
RG10 10 0 1000000000000
RG11 11 0 1000000000000
RG12 12 0 1000000000000
RG13 13 0 1000000000000
RG14 14 0 1000000000000
RG15 15 0 1000000000000
RG16 16 0 1000000000000
RG17 17 0 1000000000000
RG18 18 0 1000000000000
VS0 5 s0 0
R0 s0 4 12e3
VS1 0 s1 0
V1 e1 s1 DC 18e0
RI1 e1 9 33e-2
VS2 1 s2 0
I2 s2 3 DC 22e-3
VS3 18 s3 0
R3 s3 16 15e-2
VS4 11 s4 0
R4 s4 12 22e2
VS5 5 s5 0
R5 s5 16 10e0
VS6 8 s6 0
V6 e6 s6 DC 12e1
RI6 e6 2 68e-3
VS7 17 s7 0
V7 e7 s7 DC 47e0
RI7 e7 8 68e-1
VS8 3 s8 0
R8 s8 15 68e0
VS9 8 s9 0
R9 s9 13 82e-2
VS10 15 s10 0
V10 e10 s10 DC 68e1
RI10 e10 6 15e-2
VS11 1 s11 0
R11 s11 12 12e1
VS12 10 s12 0
R12 s12 9 47e2
VS13 12 s13 0
V13 e13 s13 DC 18e-1
RI13 e13 17 18e-3
VS14 13 s14 0
V14 e14 s14 DC 39e0
RI14 e14 0 18e-2
VS15 16 s15 0
I15 s15 17 DC 39e-3
VS16 9 s16 0
R16 s16 12 56e1
VS17 18 s17 0
R17 s17 6 10e0
VS18 14 s18 0
R18 s18 15 47e2
VS19 8 s19 0
R19 s19 16 15e1
VS20 15 s20 0
R20 s20 12 22e2
VS21 2 s21 0
V21 e21 s21 DC 47e1
RI21 e21 5 68e-1
VS22 11 s22 0
V22 e22 s22 DC 12e-1
RI22 e22 3 12e-2
VS23 7 s23 0
R23 s23 16 18e-2
VS24 1 s24 0
R24 s24 15 39e3
VS25 4 s25 0
R25 s25 3 56e2
VS26 2 s26 0
R26 s26 10 15e-1
VS27 8 s27 0
R27 s27 12 47e3
VS28 14 s28 0
R28 s28 7 68e2
.control
set numdgt=17
op
print v(1) v(2) v(3) v(4) v(5) v(6) v(7) v(8) v(9) v(10)
print v(11) v(12) v(13) v(14) v(15) v(16) v(17) v(18)
print i(vs0) i(vs1) i(vs2) i(vs3) i(vs4) i(vs5) i(vs6) i(vs7) i(vs8) i(vs9)
print i(vs10) i(vs11) i(vs12) i(vs13) i(vs14) i(vs15) i(vs16) i(vs17) i(vs18) i(vs19)
print i(vs20) i(vs21) i(vs22) i(vs23) i(vs24) i(vs25) i(vs26) i(vs27) i(vs28)
.endc
.end
