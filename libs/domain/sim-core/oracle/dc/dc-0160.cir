controls oracle dc-0160
* Generated (plan F2.7, ADR 0012): do not edit; regenerate with `pnpm sim oracle regen`. dc seed 20261030 index 160 nodes 6 elements 8
.options sparse gmin=1e-12 noopac
RG1 1 0 1000000000000
RG2 2 0 1000000000000
RG3 3 0 1000000000000
RG4 4 0 1000000000000
RG5 5 0 1000000000000
VS0 4 s0 0
R0 s0 1 68e2
VS1 5 s1 0
I1 s1 0 DC 10e-3
VS2 0 s2 0
R2 s2 1 33e0
VS3 2 s3 0
R3 s3 3 56e3
VS4 2 s4 0
R4 s4 0 10e-2
VS5 4 s5 0
R5 s5 5 56e1
VS6 5 s6 0
R6 s6 0 56e-2
VS7 4 s7 0
R7 s7 5 56e0
.control
set numdgt=17
op
print v(1) v(2) v(3) v(4) v(5)
print i(vs0) i(vs1) i(vs2) i(vs3) i(vs4) i(vs5) i(vs6) i(vs7)
.endc
.end
