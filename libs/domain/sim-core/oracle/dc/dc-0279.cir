controls oracle dc-0279
* Generated (plan F2.7, ADR 0012): do not edit; regenerate with `pnpm sim oracle regen`. dc seed 20261030 index 279 nodes 11 elements 16
.options sparse gmin=1e-12 noopac
RG1 1 0 1000000000000
RG2 2 0 1000000000000
RG3 3 0 1000000000000
RG4 4 0 1000000000000
RG5 5 0 1000000000000
RG6 6 0 1000000000000
RG7 7 0 1000000000000
RG8 8 0 1000000000000
RG9 9 0 1000000000000
RG10 10 0 1000000000000
VS0 10 s0 0
R0 s0 3 12e3
VS1 4 s1 0
R1 s1 3 15e1
VS2 6 s2 0
R2 s2 3 18e0
VS3 7 s3 0
R3 s3 1 56e2
VS4 8 s4 0
R4 s4 3 33e0
VS5 8 s5 0
R5 s5 2 12e0
VS6 6 s6 0
R6 s6 9 15e-1
VS7 1 s7 0
R7 s7 4 56e0
VS8 7 s8 0
R8 s8 5 15e-2
VS9 9 s9 0
R9 s9 2 12e-1
VS10 7 s10 0
I10 s10 10 DC 33e-2
VS11 5 s11 0
R11 s11 10 10e0
VS12 0 s12 0
V12 e12 s12 DC 27e0
RI12 e12 4 82e-2
VS13 9 s13 0
R13 s13 4 22e2
VS14 0 s14 0
R14 s14 2 82e3
VS15 4 s15 0
R15 s15 5 27e0
.control
set numdgt=17
op
print v(1) v(2) v(3) v(4) v(5) v(6) v(7) v(8) v(9) v(10)
print i(vs0) i(vs1) i(vs2) i(vs3) i(vs4) i(vs5) i(vs6) i(vs7) i(vs8) i(vs9)
print i(vs10) i(vs11) i(vs12) i(vs13) i(vs14) i(vs15)
.endc
.end
