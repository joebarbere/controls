controls oracle dc-0279
* Generated (plan F2.7, ADR 0012): do not edit; regenerate with `pnpm sim oracle regen`. dc seed 20261030 index 279 nodes 11 elements 11
.options sparse gmin=1e-12 noopac
RG1 1 0 1000000000000
RG2 2 0 1000000000000
RG3 3 0 1000000000000
RG4 4 0 1000000000000
RG5 5 0 1000000000000
RG6 6 0 1000000000000
RG7 7 0 1000000000000
RG8 8 0 1000000000000
RG9 9 0 1000000000000
RG10 10 0 1000000000000
VS0 8 s0 0
R0 s0 3 33e0
VS1 1 s1 0
R1 s1 4 56e0
VS2 7 s2 0
R2 s2 1 56e2
VS3 7 s3 0
I3 s3 10 DC 33e-2
VS4 6 s4 0
R4 s4 3 18e0
VS5 4 s5 0
R5 s5 5 27e0
VS6 4 s6 0
R6 s6 3 15e1
VS7 9 s7 0
R7 s7 2 12e-1
VS8 10 s8 0
R8 s8 3 12e3
VS9 9 s9 0
R9 s9 4 22e2
VS10 0 s10 0
V10 e10 s10 DC 27e0
RI10 e10 4 82e-2
.control
set numdgt=17
op
print v(1) v(2) v(3) v(4) v(5) v(6) v(7) v(8) v(9) v(10)
print i(vs0) i(vs1) i(vs2) i(vs3) i(vs4) i(vs5) i(vs6) i(vs7) i(vs8) i(vs9)
print i(vs10)
.endc
.end
