controls oracle dc-0235
* Generated (plan F2.7, ADR 0012): do not edit; regenerate with `pnpm sim oracle regen`. dc seed 20261030 index 235 nodes 15 elements 21
.options sparse gmin=1e-12 noopac
RG1 1 0 1000000000000
RG2 2 0 1000000000000
RG3 3 0 1000000000000
RG4 4 0 1000000000000
RG5 5 0 1000000000000
RG6 6 0 1000000000000
RG7 7 0 1000000000000
RG8 8 0 1000000000000
RG9 9 0 1000000000000
RG10 10 0 1000000000000
RG11 11 0 1000000000000
RG12 12 0 1000000000000
RG13 13 0 1000000000000
RG14 14 0 1000000000000
VS0 12 s0 0
R0 s0 10 12e-1
VS1 7 s1 0
R1 s1 3 22e1
VS2 3 s2 0
R2 s2 4 82e2
VS3 12 s3 0
R3 s3 14 56e2
VS4 7 s4 0
R4 s4 10 22e-2
VS5 13 s5 0
R5 s5 12 82e-1
VS6 13 s6 0
R6 s6 4 47e-2
VS7 9 s7 0
R7 s7 2 47e-1
VS8 8 s8 0
R8 s8 12 39e-1
VS9 12 s9 0
R9 s9 2 82e-2
VS10 11 s10 0
R10 s10 8 68e-2
VS11 0 s11 0
V11 e11 s11 DC 27e1
RI11 e11 11 12e-1
VS12 5 s12 0
R12 s12 14 18e0
VS13 3 s13 0
R13 s13 2 56e-2
VS14 3 s14 0
R14 s14 1 15e2
VS15 14 s15 0
R15 s15 0 12e0
VS16 6 s16 0
R16 s16 13 47e2
VS17 8 s17 0
R17 s17 5 39e2
VS18 11 s18 0
R18 s18 9 82e-2
VS19 1 s19 0
R19 s19 6 39e-1
VS20 2 s20 0
R20 s20 9 22e2
.control
set numdgt=17
op
print v(1) v(2) v(3) v(4) v(5) v(6) v(7) v(8) v(9) v(10)
print v(11) v(12) v(13) v(14)
print i(vs0) i(vs1) i(vs2) i(vs3) i(vs4) i(vs5) i(vs6) i(vs7) i(vs8) i(vs9)
print i(vs10) i(vs11) i(vs12) i(vs13) i(vs14) i(vs15) i(vs16) i(vs17) i(vs18) i(vs19)
print i(vs20)
.endc
.end
