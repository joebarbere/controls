controls oracle dc-0235
* Generated (plan F2.7, ADR 0012): do not edit; regenerate with `pnpm sim oracle regen`. dc seed 20261030 index 235 nodes 15 elements 16
.options sparse gmin=1e-12 noopac
RG1 1 0 1000000000000
RG2 2 0 1000000000000
RG3 3 0 1000000000000
RG4 4 0 1000000000000
RG5 5 0 1000000000000
RG6 6 0 1000000000000
RG7 7 0 1000000000000
RG8 8 0 1000000000000
RG9 9 0 1000000000000
RG10 10 0 1000000000000
RG11 11 0 1000000000000
RG12 12 0 1000000000000
RG13 13 0 1000000000000
RG14 14 0 1000000000000
VS0 7 s0 0
R0 s0 3 22e1
VS1 8 s1 0
R1 s1 12 39e-1
VS2 3 s2 0
R2 s2 2 56e-2
VS3 3 s3 0
R3 s3 4 82e2
VS4 13 s4 0
R4 s4 12 82e-1
VS5 14 s5 0
R5 s5 0 12e0
VS6 3 s6 0
R6 s6 1 15e2
VS7 12 s7 0
R7 s7 14 56e2
VS8 2 s8 0
R8 s8 9 22e2
VS9 5 s9 0
R9 s9 14 18e0
VS10 6 s10 0
R10 s10 13 47e2
VS11 0 s11 0
V11 e11 s11 DC 27e1
RI11 e11 11 12e-1
VS12 12 s12 0
R12 s12 2 82e-2
VS13 7 s13 0
R13 s13 10 22e-2
VS14 9 s14 0
R14 s14 2 47e-1
VS15 11 s15 0
R15 s15 8 68e-2
.control
set numdgt=17
op
print v(1) v(2) v(3) v(4) v(5) v(6) v(7) v(8) v(9) v(10)
print v(11) v(12) v(13) v(14)
print i(vs0) i(vs1) i(vs2) i(vs3) i(vs4) i(vs5) i(vs6) i(vs7) i(vs8) i(vs9)
print i(vs10) i(vs11) i(vs12) i(vs13) i(vs14) i(vs15)
.endc
.end
