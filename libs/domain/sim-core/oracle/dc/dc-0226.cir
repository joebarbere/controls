controls oracle dc-0226
* Generated (plan F2.7, ADR 0012): do not edit; regenerate with `pnpm sim oracle regen`. dc seed 20261030 index 226 nodes 4 elements 7
.options sparse gmin=1e-12 noopac
RG1 1 0 1000000000000
RG2 2 0 1000000000000
RG3 3 0 1000000000000
VS0 0 s0 0
R0 s0 2 18e2
VS1 2 s1 0
R1 s1 0 15e1
VS2 0 s2 0
V2 e2 s2 DC 12e1
RI2 e2 2 33e-1
VS3 2 s3 0
V3 e3 s3 DC 68e1
RI3 e3 3 47e-3
VS4 3 s4 0
R4 s4 0 18e2
VS5 1 s5 0
R5 s5 2 39e-2
VS6 3 s6 0
V6 e6 s6 DC 12e1
RI6 e6 1 27e-2
.control
set numdgt=17
op
print v(1) v(2) v(3)
print i(vs0) i(vs1) i(vs2) i(vs3) i(vs4) i(vs5) i(vs6)
.endc
.end
