controls oracle dc-0484
* Generated (plan F2.7, ADR 0012): do not edit; regenerate with `pnpm sim oracle regen`. dc seed 20261030 index 484 nodes 21 elements 24
.options sparse gmin=1e-12 noopac
RG1 1 0 1000000000000
RG2 2 0 1000000000000
RG3 3 0 1000000000000
RG4 4 0 1000000000000
RG5 5 0 1000000000000
RG6 6 0 1000000000000
RG7 7 0 1000000000000
RG8 8 0 1000000000000
RG9 9 0 1000000000000
RG10 10 0 1000000000000
RG11 11 0 1000000000000
RG12 12 0 1000000000000
RG13 13 0 1000000000000
RG14 14 0 1000000000000
RG15 15 0 1000000000000
RG16 16 0 1000000000000
RG17 17 0 1000000000000
RG18 18 0 1000000000000
RG19 19 0 1000000000000
RG20 20 0 1000000000000
VS0 5 s0 0
R0 s0 2 27e-1
VS1 0 s1 0
V1 e1 s1 DC 12e-1
RI1 e1 8 27e-1
VS2 16 s2 0
R2 s2 8 68e1
VS3 8 s3 0
R3 s3 14 33e-2
VS4 18 s4 0
V4 e4 s4 DC 56e1
RI4 e4 3 12e-3
VS5 2 s5 0
I5 s5 0 DC 18e-1
VS6 19 s6 0
R6 s6 2 18e1
VS7 3 s7 0
V7 e7 s7 DC 82e1
RI7 e7 14 18e-1
VS8 3 s8 0
R8 s8 9 47e-1
VS9 13 s9 0
V9 e9 s9 DC 22e-1
RI9 e9 8 12e-2
VS10 12 s10 0
I10 s10 14 DC 82e-1
VS11 8 s11 0
R11 s11 4 82e-2
VS12 0 s12 0
R12 s12 1 10e0
VS13 9 s13 0
R13 s13 6 22e2
VS14 0 s14 0
R14 s14 20 10e-1
VS15 17 s15 0
R15 s15 8 10e2
VS16 19 s16 0
R16 s16 11 12e-2
VS17 5 s17 0
R17 s17 14 12e-2
VS18 19 s18 0
V18 e18 s18 DC 68e-1
RI18 e18 2 68e-2
VS19 10 s19 0
R19 s19 18 68e-1
VS20 15 s20 0
R20 s20 5 56e3
VS21 12 s21 0
R21 s21 1 82e2
VS22 8 s22 0
R22 s22 10 56e0
VS23 0 s23 0
V23 e23 s23 DC 18e-1
RI23 e23 7 18e-2
.control
set numdgt=17
op
print v(1) v(2) v(3) v(4) v(5) v(6) v(7) v(8) v(9) v(10)
print v(11) v(12) v(13) v(14) v(15) v(16) v(17) v(18) v(19) v(20)
print i(vs0) i(vs1) i(vs2) i(vs3) i(vs4) i(vs5) i(vs6) i(vs7) i(vs8) i(vs9)
print i(vs10) i(vs11) i(vs12) i(vs13) i(vs14) i(vs15) i(vs16) i(vs17) i(vs18) i(vs19)
print i(vs20) i(vs21) i(vs22) i(vs23)
.endc
.end
