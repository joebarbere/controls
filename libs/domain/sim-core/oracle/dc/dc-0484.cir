controls oracle dc-0484
* Generated (plan F2.7, ADR 0012): do not edit; regenerate with `pnpm sim oracle regen`. dc seed 20261030 index 484 nodes 21 elements 31
.options sparse gmin=1e-12 noopac
RG1 1 0 1000000000000
RG2 2 0 1000000000000
RG3 3 0 1000000000000
RG4 4 0 1000000000000
RG5 5 0 1000000000000
RG6 6 0 1000000000000
RG7 7 0 1000000000000
RG8 8 0 1000000000000
RG9 9 0 1000000000000
RG10 10 0 1000000000000
RG11 11 0 1000000000000
RG12 12 0 1000000000000
RG13 13 0 1000000000000
RG14 14 0 1000000000000
RG15 15 0 1000000000000
RG16 16 0 1000000000000
RG17 17 0 1000000000000
RG18 18 0 1000000000000
RG19 19 0 1000000000000
RG20 20 0 1000000000000
VS0 14 s0 0
R0 s0 1 10e0
VS1 14 s1 0
R1 s1 20 10e-1
VS2 8 s2 0
R2 s2 4 82e-2
VS3 6 s3 0
R3 s3 17 56e3
VS4 7 s4 0
R4 s4 13 27e3
VS5 0 s5 0
V5 e5 s5 DC 68e-1
RI5 e5 2 68e-2
VS6 18 s6 0
V6 e6 s6 DC 56e1
RI6 e6 3 12e-3
VS7 3 s7 0
V7 e7 s7 DC 82e1
RI7 e7 19 18e-1
VS8 5 s8 0
R8 s8 19 12e-2
VS9 13 s9 0
V9 e9 s9 DC 15e-1
RI9 e9 10 22e-2
VS10 13 s10 0
V10 e10 s10 DC 22e-1
RI10 e10 8 12e-2
VS11 14 s11 0
V11 e11 s11 DC 12e-1
RI11 e11 8 27e-1
VS12 3 s12 0
R12 s12 9 47e-1
VS13 0 s13 0
R13 s13 2 18e1
VS14 9 s14 0
R14 s14 6 22e2
VS15 10 s15 0
R15 s15 18 68e-1
VS16 14 s16 0
V16 e16 s16 DC 18e-1
RI16 e16 7 18e-2
VS17 0 s17 0
R17 s17 11 12e-2
VS18 5 s18 0
R18 s18 2 27e-1
VS19 12 s19 0
R19 s19 15 82e-1
VS20 12 s20 0
R20 s20 1 82e2
VS21 8 s21 0
R21 s21 19 33e-2
VS22 12 s22 0
I22 s22 19 DC 82e-1
VS23 17 s23 0
R23 s23 8 10e2
VS24 4 s24 0
R24 s24 19 33e-1
VS25 16 s25 0
R25 s25 8 68e1
VS26 15 s26 0
R26 s26 5 56e3
VS27 5 s27 0
V27 e27 s27 DC 22e-1
RI27 e27 20 12e-2
VS28 8 s28 0
R28 s28 10 56e0
VS29 2 s29 0
I29 s29 14 DC 18e-1
VS30 16 s30 0
R30 s30 11 39e2
.control
set numdgt=17
op
print v(1) v(2) v(3) v(4) v(5) v(6) v(7) v(8) v(9) v(10)
print v(11) v(12) v(13) v(14) v(15) v(16) v(17) v(18) v(19) v(20)
print i(vs0) i(vs1) i(vs2) i(vs3) i(vs4) i(vs5) i(vs6) i(vs7) i(vs8) i(vs9)
print i(vs10) i(vs11) i(vs12) i(vs13) i(vs14) i(vs15) i(vs16) i(vs17) i(vs18) i(vs19)
print i(vs20) i(vs21) i(vs22) i(vs23) i(vs24) i(vs25) i(vs26) i(vs27) i(vs28) i(vs29)
print i(vs30)
.endc
.end
