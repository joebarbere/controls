controls oracle dc-0371
* Generated (plan F2.7, ADR 0012): do not edit; regenerate with `pnpm sim oracle regen`. dc seed 20261030 index 371 nodes 3 elements 5
.options sparse gmin=1e-12 noopac
RG1 1 0 1000000000000
RG2 2 0 1000000000000
VS0 0 s0 0
V0 e0 s0 DC 39e-1
RI0 e0 2 82e-2
VS1 2 s1 0
R1 s1 1 27e2
VS2 1 s2 0
R2 s2 0 12e-2
VS3 1 s3 0
R3 s3 0 68e2
VS4 0 s4 0
R4 s4 2 82e1
.control
set numdgt=17
op
print v(1) v(2)
print i(vs0) i(vs1) i(vs2) i(vs3) i(vs4)
.endc
.end
