controls oracle dc-0335
* Generated (plan F2.7, ADR 0012): do not edit; regenerate with `pnpm sim oracle regen`. dc seed 20261030 index 335 nodes 19 elements 20
.options sparse gmin=1e-12 noopac
RG1 1 0 1000000000000
RG2 2 0 1000000000000
RG3 3 0 1000000000000
RG4 4 0 1000000000000
RG5 5 0 1000000000000
RG6 6 0 1000000000000
RG7 7 0 1000000000000
RG8 8 0 1000000000000
RG9 9 0 1000000000000
RG10 10 0 1000000000000
RG11 11 0 1000000000000
RG12 12 0 1000000000000
RG13 13 0 1000000000000
RG14 14 0 1000000000000
RG15 15 0 1000000000000
RG16 16 0 1000000000000
RG17 17 0 1000000000000
RG18 18 0 1000000000000
VS0 1 s0 0
R0 s0 10 18e-1
VS1 8 s1 0
R1 s1 0 27e2
VS2 1 s2 0
R2 s2 9 18e3
VS3 2 s3 0
R3 s3 17 39e-2
VS4 16 s4 0
R4 s4 2 39e2
VS5 4 s5 0
R5 s5 7 39e-1
VS6 17 s6 0
R6 s6 6 56e-1
VS7 15 s7 0
R7 s7 1 22e0
VS8 16 s8 0
R8 s8 3 68e1
VS9 13 s9 0
R9 s9 3 39e0
VS10 15 s10 0
R10 s10 7 27e0
VS11 0 s11 0
V11 e11 s11 DC 47e0
RI11 e11 15 27e-3
VS12 11 s12 0
R12 s12 15 18e-1
VS13 11 s13 0
V13 e13 s13 DC 27e1
RI13 e13 15 12e-3
VS14 5 s14 0
R14 s14 3 22e2
VS15 18 s15 0
R15 s15 15 82e-2
VS16 11 s16 0
V16 e16 s16 DC 56e0
RI16 e16 2 56e-2
VS17 14 s17 0
R17 s17 17 82e-2
VS18 18 s18 0
R18 s18 4 33e-2
VS19 0 s19 0
V19 e19 s19 DC 82e0
RI19 e19 12 22e-2
.control
set numdgt=17
op
print v(1) v(2) v(3) v(4) v(5) v(6) v(7) v(8) v(9) v(10)
print v(11) v(12) v(13) v(14) v(15) v(16) v(17) v(18)
print i(vs0) i(vs1) i(vs2) i(vs3) i(vs4) i(vs5) i(vs6) i(vs7) i(vs8) i(vs9)
print i(vs10) i(vs11) i(vs12) i(vs13) i(vs14) i(vs15) i(vs16) i(vs17) i(vs18) i(vs19)
.endc
.end
