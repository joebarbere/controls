controls oracle dc-0079
* Generated (plan F2.7, ADR 0012): do not edit; regenerate with `pnpm sim oracle regen`. dc seed 20261030 index 79 nodes 9 elements 15
.options sparse gmin=1e-12 noopac
RG1 1 0 1000000000000
RG2 2 0 1000000000000
RG3 3 0 1000000000000
RG4 4 0 1000000000000
RG5 5 0 1000000000000
RG6 6 0 1000000000000
RG7 7 0 1000000000000
RG8 8 0 1000000000000
VS0 3 s0 0
R0 s0 5 56e3
VS1 6 s1 0
R1 s1 7 33e-1
VS2 2 s2 0
R2 s2 7 56e3
VS3 6 s3 0
R3 s3 0 47e2
VS4 6 s4 0
R4 s4 0 22e0
VS5 3 s5 0
R5 s5 6 33e3
VS6 8 s6 0
R6 s6 2 39e-2
VS7 3 s7 0
R7 s7 1 10e-1
VS8 0 s8 0
R8 s8 5 18e-1
VS9 0 s9 0
V9 e9 s9 DC 82e1
RI9 e9 4 12e-2
VS10 1 s10 0
R10 s10 4 15e0
VS11 2 s11 0
V11 e11 s11 DC 10e-1
RI11 e11 0 18e-1
VS12 1 s12 0
R12 s12 8 68e2
VS13 7 s13 0
I13 s13 6 DC 22e-3
VS14 5 s14 0
R14 s14 8 47e-2
.control
set numdgt=17
op
print v(1) v(2) v(3) v(4) v(5) v(6) v(7) v(8)
print i(vs0) i(vs1) i(vs2) i(vs3) i(vs4) i(vs5) i(vs6) i(vs7) i(vs8) i(vs9)
print i(vs10) i(vs11) i(vs12) i(vs13) i(vs14)
.endc
.end
