controls oracle dc-0079
* Generated (plan F2.7, ADR 0012): do not edit; regenerate with `pnpm sim oracle regen`. dc seed 20261030 index 79 nodes 9 elements 14
.options sparse gmin=1e-12 noopac
RG1 1 0 1000000000000
RG2 2 0 1000000000000
RG3 3 0 1000000000000
RG4 4 0 1000000000000
RG5 5 0 1000000000000
RG6 6 0 1000000000000
RG7 7 0 1000000000000
RG8 8 0 1000000000000
VS0 8 s0 0
R0 s0 0 39e-2
VS1 2 s1 0
R1 s1 4 15e0
VS2 1 s2 0
R2 s2 5 18e-1
VS3 6 s3 0
R3 s3 1 47e2
VS4 5 s4 0
R4 s4 8 47e-2
VS5 0 s5 0
V5 e5 s5 DC 10e-1
RI5 e5 1 18e-1
VS6 2 s6 0
R6 s6 8 68e2
VS7 6 s7 0
R7 s7 7 33e-1
VS8 3 s8 0
R8 s8 6 33e3
VS9 7 s9 0
I9 s9 6 DC 22e-3
VS10 3 s10 0
R10 s10 5 56e3
VS11 3 s11 0
R11 s11 2 10e-1
VS12 6 s12 0
R12 s12 1 22e0
VS13 1 s13 0
V13 e13 s13 DC 82e1
RI13 e13 4 12e-2
.control
set numdgt=17
op
print v(1) v(2) v(3) v(4) v(5) v(6) v(7) v(8)
print i(vs0) i(vs1) i(vs2) i(vs3) i(vs4) i(vs5) i(vs6) i(vs7) i(vs8) i(vs9)
print i(vs10) i(vs11) i(vs12) i(vs13)
.endc
.end
