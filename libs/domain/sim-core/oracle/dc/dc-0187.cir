controls oracle dc-0187
* Generated (plan F2.7, ADR 0012): do not edit; regenerate with `pnpm sim oracle regen`. dc seed 20261030 index 187 nodes 3 elements 3
.options sparse gmin=1e-12 noopac
RG1 1 0 1000000000000
RG2 2 0 1000000000000
VS0 1 s0 0
R0 s0 2 56e-1
VS1 0 s1 0
V1 e1 s1 DC 18e0
RI1 e1 2 33e-2
VS2 1 s2 0
R2 s2 0 27e-1
.control
set numdgt=17
op
print v(1) v(2)
print i(vs0) i(vs1) i(vs2)
.endc
.end
