controls oracle dc-0246
* Generated (plan F2.7, ADR 0012): do not edit; regenerate with `pnpm sim oracle regen`. dc seed 20261030 index 246 nodes 3 elements 6
.options sparse gmin=1e-12 noopac
RG1 1 0 1000000000000
RG2 2 0 1000000000000
VS0 2 s0 0
I0 s0 1 DC 33e-1
VS1 2 s1 0
R1 s1 0 33e1
VS2 0 s2 0
R2 s2 1 39e-1
VS3 1 s3 0
R3 s3 2 82e-2
VS4 1 s4 0
I4 s4 0 DC 22e-4
VS5 0 s5 0
I5 s5 2 DC 18e-3
.control
set numdgt=17
op
print v(1) v(2)
print i(vs0) i(vs1) i(vs2) i(vs3) i(vs4) i(vs5)
.endc
.end
