controls oracle dc-0246
* Generated (plan F2.7, ADR 0012): do not edit; regenerate with `pnpm sim oracle regen`. dc seed 20261030 index 246 nodes 3 elements 5
.options sparse gmin=1e-12 noopac
RG1 1 0 1000000000000
RG2 2 0 1000000000000
VS0 0 s0 0
I0 s0 2 DC 18e-3
VS1 0 s1 0
R1 s1 1 39e-1
VS2 2 s2 0
R2 s2 0 33e1
VS3 1 s3 0
I3 s3 0 DC 22e-4
VS4 2 s4 0
I4 s4 1 DC 33e-1
.control
set numdgt=17
op
print v(1) v(2)
print i(vs0) i(vs1) i(vs2) i(vs3) i(vs4)
.endc
.end
