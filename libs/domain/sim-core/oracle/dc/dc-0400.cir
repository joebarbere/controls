controls oracle dc-0400
* Generated (plan F2.7, ADR 0012): do not edit; regenerate with `pnpm sim oracle regen`. dc seed 20261030 index 400 nodes 21 elements 41
.options sparse gmin=1e-12 noopac
RG1 1 0 1000000000000
RG2 2 0 1000000000000
RG3 3 0 1000000000000
RG4 4 0 1000000000000
RG5 5 0 1000000000000
RG6 6 0 1000000000000
RG7 7 0 1000000000000
RG8 8 0 1000000000000
RG9 9 0 1000000000000
RG10 10 0 1000000000000
RG11 11 0 1000000000000
RG12 12 0 1000000000000
RG13 13 0 1000000000000
RG14 14 0 1000000000000
RG15 15 0 1000000000000
RG16 16 0 1000000000000
RG17 17 0 1000000000000
RG18 18 0 1000000000000
RG19 19 0 1000000000000
RG20 20 0 1000000000000
VS0 17 s0 0
R0 s0 18 12e-2
VS1 17 s1 0
R1 s1 18 22e-2
VS2 3 s2 0
R2 s2 18 39e0
VS3 8 s3 0
R3 s3 9 27e-1
VS4 19 s4 0
R4 s4 2 33e-2
VS5 0 s5 0
V5 e5 s5 DC 15e1
RI5 e5 12 22e-3
VS6 10 s6 0
V6 e6 s6 DC 10e0
RI6 e6 14 12e-3
VS7 7 s7 0
R7 s7 12 47e0
VS8 16 s8 0
R8 s8 15 18e3
VS9 6 s9 0
R9 s9 18 82e-2
VS10 19 s10 0
R10 s10 16 15e-1
VS11 14 s11 0
R11 s11 17 56e-1
VS12 16 s12 0
I12 s12 1 DC 82e-4
VS13 10 s13 0
R13 s13 1 47e3
VS14 1 s14 0
I14 s14 3 DC 10e-3
VS15 0 s15 0
R15 s15 18 18e1
VS16 4 s16 0
R16 s16 11 68e2
VS17 14 s17 0
R17 s17 3 33e-2
VS18 6 s18 0
R18 s18 14 82e0
VS19 7 s19 0
V19 e19 s19 DC 39e1
RI19 e19 9 18e-3
VS20 18 s20 0
R20 s20 10 15e2
VS21 6 s21 0
R21 s21 17 47e2
VS22 14 s22 0
V22 e22 s22 DC 22e1
RI22 e22 13 56e-1
VS23 6 s23 0
R23 s23 7 47e-2
VS24 16 s24 0
R24 s24 14 82e3
VS25 1 s25 0
V25 e25 s25 DC 15e0
RI25 e25 15 82e-3
VS26 16 s26 0
R26 s26 17 27e2
VS27 5 s27 0
R27 s27 0 18e-2
VS28 7 s28 0
R28 s28 11 22e-1
VS29 6 s29 0
I29 s29 9 DC 68e-2
VS30 2 s30 0
I30 s30 19 DC 27e-2
VS31 13 s31 0
V31 e31 s31 DC 33e0
RI31 e31 10 22e-2
VS32 6 s32 0
V32 e32 s32 DC 33e-1
RI32 e32 10 22e-3
VS33 4 s33 0
R33 s33 12 22e1
VS34 12 s34 0
I34 s34 2 DC 68e-1
VS35 6 s35 0
I35 s35 12 DC 15e-2
VS36 2 s36 0
R36 s36 8 15e3
VS37 17 s37 0
R37 s37 4 27e3
VS38 4 s38 0
R38 s38 5 22e2
VS39 20 s39 0
V39 e39 s39 DC 33e0
RI39 e39 17 33e-3
VS40 13 s40 0
R40 s40 20 39e2
.control
set numdgt=17
op
print v(1) v(2) v(3) v(4) v(5) v(6) v(7) v(8) v(9) v(10)
print v(11) v(12) v(13) v(14) v(15) v(16) v(17) v(18) v(19) v(20)
print i(vs0) i(vs1) i(vs2) i(vs3) i(vs4) i(vs5) i(vs6) i(vs7) i(vs8) i(vs9)
print i(vs10) i(vs11) i(vs12) i(vs13) i(vs14) i(vs15) i(vs16) i(vs17) i(vs18) i(vs19)
print i(vs20) i(vs21) i(vs22) i(vs23) i(vs24) i(vs25) i(vs26) i(vs27) i(vs28) i(vs29)
print i(vs30) i(vs31) i(vs32) i(vs33) i(vs34) i(vs35) i(vs36) i(vs37) i(vs38) i(vs39)
print i(vs40)
.endc
.end
