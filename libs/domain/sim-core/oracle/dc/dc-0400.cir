controls oracle dc-0400
* Generated (plan F2.7, ADR 0012): do not edit; regenerate with `pnpm sim oracle regen`. dc seed 20261030 index 400 nodes 21 elements 40
.options sparse gmin=1e-12 noopac
RG1 1 0 1000000000000
RG2 2 0 1000000000000
RG3 3 0 1000000000000
RG4 4 0 1000000000000
RG5 5 0 1000000000000
RG6 6 0 1000000000000
RG7 7 0 1000000000000
RG8 8 0 1000000000000
RG9 9 0 1000000000000
RG10 10 0 1000000000000
RG11 11 0 1000000000000
RG12 12 0 1000000000000
RG13 13 0 1000000000000
RG14 14 0 1000000000000
RG15 15 0 1000000000000
RG16 16 0 1000000000000
RG17 17 0 1000000000000
RG18 18 0 1000000000000
RG19 19 0 1000000000000
RG20 20 0 1000000000000
VS0 7 s0 0
R0 s0 18 22e-2
VS1 0 s1 0
V1 e1 s1 DC 39e1
RI1 e1 9 18e-3
VS2 18 s2 0
R2 s2 10 15e2
VS3 16 s3 0
R3 s3 14 82e3
VS4 6 s4 0
R4 s4 7 47e2
VS5 0 s5 0
R5 s5 12 47e0
VS6 6 s6 0
I6 s6 9 DC 68e-2
VS7 2 s7 0
I7 s7 19 DC 27e-2
VS8 4 s8 0
R8 s8 5 22e2
VS9 6 s9 0
R9 s9 14 82e0
VS10 19 s10 0
R10 s10 2 33e-2
VS11 3 s11 0
R11 s11 18 39e0
VS12 13 s12 0
V12 e12 s12 DC 33e0
RI12 e12 10 22e-2
VS13 14 s13 0
R13 s13 3 33e-2
VS14 16 s14 0
R14 s14 15 18e3
VS15 6 s15 0
V15 e15 s15 DC 33e-1
RI15 e15 10 22e-3
VS16 20 s16 0
V16 e16 s16 DC 33e0
RI16 e16 7 33e-3
VS17 6 s17 0
I17 s17 12 DC 15e-2
VS18 16 s18 0
I18 s18 1 DC 82e-4
VS19 6 s19 0
R19 s19 0 47e-2
VS20 1 s20 0
I20 s20 3 DC 10e-3
VS21 10 s21 0
V21 e21 s21 DC 10e0
RI21 e21 14 12e-3
VS22 13 s22 0
R22 s22 20 39e2
VS23 7 s23 0
R23 s23 4 27e3
VS24 10 s24 0
R24 s24 1 47e3
VS25 2 s25 0
R25 s25 8 15e3
VS26 5 s26 0
R26 s26 17 18e-2
VS27 14 s27 0
V27 e27 s27 DC 22e1
RI27 e27 13 56e-1
VS28 12 s28 0
I28 s28 2 DC 68e-1
VS29 6 s29 0
R29 s29 18 82e-2
VS30 0 s30 0
R30 s30 11 22e-1
VS31 17 s31 0
V31 e31 s31 DC 15e1
RI31 e31 12 22e-3
VS32 7 s32 0
R32 s32 18 12e-2
VS33 14 s33 0
R33 s33 7 56e-1
VS34 17 s34 0
R34 s34 18 18e1
VS35 4 s35 0
R35 s35 12 22e1
VS36 19 s36 0
R36 s36 16 15e-1
VS37 16 s37 0
R37 s37 7 27e2
VS38 4 s38 0
R38 s38 11 68e2
VS39 8 s39 0
R39 s39 9 27e-1
.control
set numdgt=17
op
print v(1) v(2) v(3) v(4) v(5) v(6) v(7) v(8) v(9) v(10)
print v(11) v(12) v(13) v(14) v(15) v(16) v(17) v(18) v(19) v(20)
print i(vs0) i(vs1) i(vs2) i(vs3) i(vs4) i(vs5) i(vs6) i(vs7) i(vs8) i(vs9)
print i(vs10) i(vs11) i(vs12) i(vs13) i(vs14) i(vs15) i(vs16) i(vs17) i(vs18) i(vs19)
print i(vs20) i(vs21) i(vs22) i(vs23) i(vs24) i(vs25) i(vs26) i(vs27) i(vs28) i(vs29)
print i(vs30) i(vs31) i(vs32) i(vs33) i(vs34) i(vs35) i(vs36) i(vs37) i(vs38) i(vs39)
.endc
.end
