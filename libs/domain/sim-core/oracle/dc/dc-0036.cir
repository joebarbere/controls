controls oracle dc-0036
* Generated (plan F2.7, ADR 0012): do not edit; regenerate with `pnpm sim oracle regen`. dc seed 20261030 index 36 nodes 26 elements 38
.options sparse gmin=1e-12 noopac
RG1 1 0 1000000000000
RG2 2 0 1000000000000
RG3 3 0 1000000000000
RG4 4 0 1000000000000
RG5 5 0 1000000000000
RG6 6 0 1000000000000
RG7 7 0 1000000000000
RG8 8 0 1000000000000
RG9 9 0 1000000000000
RG10 10 0 1000000000000
RG11 11 0 1000000000000
RG12 12 0 1000000000000
RG13 13 0 1000000000000
RG14 14 0 1000000000000
RG15 15 0 1000000000000
RG16 16 0 1000000000000
RG17 17 0 1000000000000
RG18 18 0 1000000000000
RG19 19 0 1000000000000
RG20 20 0 1000000000000
RG21 21 0 1000000000000
RG22 22 0 1000000000000
RG23 23 0 1000000000000
RG24 24 0 1000000000000
RG25 25 0 1000000000000
VS0 25 s0 0
R0 s0 15 33e0
VS1 0 s1 0
V1 e1 s1 DC 33e-1
RI1 e1 5 18e-3
VS2 7 s2 0
I2 s2 8 DC 68e-1
VS3 2 s3 0
R3 s3 16 82e3
VS4 4 s4 0
R4 s4 17 47e1
VS5 20 s5 0
R5 s5 21 22e1
VS6 17 s6 0
R6 s6 6 82e0
VS7 22 s7 0
R7 s7 10 33e-1
VS8 14 s8 0
R8 s8 24 12e-1
VS9 13 s9 0
R9 s9 11 22e1
VS10 10 s10 0
R10 s10 5 22e0
VS11 12 s11 0
R11 s11 21 15e-2
VS12 10 s12 0
R12 s12 23 27e3
VS13 20 s13 0
R13 s13 14 18e2
VS14 4 s14 0
R14 s14 14 68e2
VS15 17 s15 0
V15 e15 s15 DC 47e0
RI15 e15 11 47e-1
VS16 8 s16 0
V16 e16 s16 DC 56e1
RI16 e16 11 56e-1
VS17 24 s17 0
R17 s17 21 27e-2
VS18 12 s18 0
R18 s18 14 22e3
VS19 15 s19 0
V19 e19 s19 DC 15e-1
RI19 e19 12 47e-2
VS20 13 s20 0
R20 s20 2 18e1
VS21 25 s21 0
R21 s21 1 22e-2
VS22 7 s22 0
V22 e22 s22 DC 56e0
RI22 e22 16 68e-2
VS23 25 s23 0
R23 s23 9 27e-1
VS24 14 s24 0
R24 s24 16 33e3
VS25 1 s25 0
R25 s25 12 27e-2
VS26 3 s26 0
R26 s26 10 47e2
VS27 18 s27 0
R27 s27 0 18e0
VS28 4 s28 0
R28 s28 0 56e0
VS29 13 s29 0
R29 s29 25 82e0
VS30 19 s30 0
R30 s30 17 15e2
VS31 21 s31 0
R31 s31 0 12e1
VS32 22 s32 0
V32 e32 s32 DC 33e0
RI32 e32 21 15e-3
VS33 4 s33 0
R33 s33 2 10e-1
VS34 18 s34 0
R34 s34 4 12e1
VS35 25 s35 0
R35 s35 10 27e2
VS36 5 s36 0
R36 s36 11 12e2
VS37 17 s37 0
R37 s37 7 18e1
.control
set numdgt=17
op
print v(1) v(2) v(3) v(4) v(5) v(6) v(7) v(8) v(9) v(10)
print v(11) v(12) v(13) v(14) v(15) v(16) v(17) v(18) v(19) v(20)
print v(21) v(22) v(23) v(24) v(25)
print i(vs0) i(vs1) i(vs2) i(vs3) i(vs4) i(vs5) i(vs6) i(vs7) i(vs8) i(vs9)
print i(vs10) i(vs11) i(vs12) i(vs13) i(vs14) i(vs15) i(vs16) i(vs17) i(vs18) i(vs19)
print i(vs20) i(vs21) i(vs22) i(vs23) i(vs24) i(vs25) i(vs26) i(vs27) i(vs28) i(vs29)
print i(vs30) i(vs31) i(vs32) i(vs33) i(vs34) i(vs35) i(vs36) i(vs37)
.endc
.end
