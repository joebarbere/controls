controls oracle dc-0036
* Generated (plan F2.7, ADR 0012): do not edit; regenerate with `pnpm sim oracle regen`. dc seed 20261030 index 36 nodes 26 elements 43
.options sparse gmin=1e-12 noopac
RG1 1 0 1000000000000
RG2 2 0 1000000000000
RG3 3 0 1000000000000
RG4 4 0 1000000000000
RG5 5 0 1000000000000
RG6 6 0 1000000000000
RG7 7 0 1000000000000
RG8 8 0 1000000000000
RG9 9 0 1000000000000
RG10 10 0 1000000000000
RG11 11 0 1000000000000
RG12 12 0 1000000000000
RG13 13 0 1000000000000
RG14 14 0 1000000000000
RG15 15 0 1000000000000
RG16 16 0 1000000000000
RG17 17 0 1000000000000
RG18 18 0 1000000000000
RG19 19 0 1000000000000
RG20 20 0 1000000000000
RG21 21 0 1000000000000
RG22 22 0 1000000000000
RG23 23 0 1000000000000
RG24 24 0 1000000000000
RG25 25 0 1000000000000
VS0 1 s0 0
R0 s0 12 27e-2
VS1 24 s1 0
R1 s1 21 27e-2
VS2 4 s2 0
R2 s2 2 56e0
VS3 17 s3 0
R3 s3 6 82e0
VS4 24 s4 0
R4 s4 23 47e2
VS5 0 s5 0
I5 s5 8 DC 68e-1
VS6 17 s6 0
R6 s6 0 18e1
VS7 20 s7 0
R7 s7 21 22e1
VS8 13 s8 0
R8 s8 7 18e1
VS9 14 s9 0
R9 s9 16 33e3
VS10 22 s10 0
R10 s10 10 33e-1
VS11 21 s11 0
R11 s11 2 12e1
VS12 25 s12 0
R12 s12 15 33e0
VS13 0 s13 0
V13 e13 s13 DC 56e0
RI13 e13 16 68e-2
VS14 25 s14 0
R14 s14 1 22e-2
VS15 4 s15 0
R15 s15 17 47e1
VS16 23 s16 0
R16 s16 19 33e2
VS17 20 s17 0
R17 s17 14 18e2
VS18 25 s18 0
R18 s18 9 27e-1
VS19 18 s19 0
R19 s19 4 12e1
VS20 19 s20 0
R20 s20 17 15e2
VS21 14 s21 0
R21 s21 24 12e-1
VS22 18 s22 0
R22 s22 2 18e0
VS23 5 s23 0
R23 s23 11 12e2
VS24 7 s24 0
R24 s24 16 82e3
VS25 15 s25 0
V25 e25 s25 DC 15e-1
RI25 e25 12 47e-2
VS26 13 s26 0
R26 s26 25 82e0
VS27 4 s27 0
R27 s27 14 68e2
VS28 9 s28 0
R28 s28 14 18e-1
VS29 12 s29 0
R29 s29 21 15e-2
VS30 13 s30 0
R30 s30 11 22e1
VS31 3 s31 0
R31 s31 10 47e2
VS32 10 s32 0
R32 s32 23 27e3
VS33 6 s33 0
R33 s33 21 22e1
VS34 17 s34 0
V34 e34 s34 DC 47e0
RI34 e34 11 47e-1
VS35 25 s35 0
R35 s35 10 27e2
VS36 8 s36 0
V36 e36 s36 DC 56e1
RI36 e36 11 56e-1
VS37 10 s37 0
R37 s37 5 22e0
VS38 2 s38 0
V38 e38 s38 DC 33e-1
RI38 e38 5 18e-3
VS39 3 s39 0
R39 s39 8 15e2
VS40 12 s40 0
R40 s40 14 22e3
VS41 4 s41 0
R41 s41 7 10e-1
VS42 22 s42 0
V42 e42 s42 DC 33e0
RI42 e42 21 15e-3
.control
set numdgt=17
op
print v(1) v(2) v(3) v(4) v(5) v(6) v(7) v(8) v(9) v(10)
print v(11) v(12) v(13) v(14) v(15) v(16) v(17) v(18) v(19) v(20)
print v(21) v(22) v(23) v(24) v(25)
print i(vs0) i(vs1) i(vs2) i(vs3) i(vs4) i(vs5) i(vs6) i(vs7) i(vs8) i(vs9)
print i(vs10) i(vs11) i(vs12) i(vs13) i(vs14) i(vs15) i(vs16) i(vs17) i(vs18) i(vs19)
print i(vs20) i(vs21) i(vs22) i(vs23) i(vs24) i(vs25) i(vs26) i(vs27) i(vs28) i(vs29)
print i(vs30) i(vs31) i(vs32) i(vs33) i(vs34) i(vs35) i(vs36) i(vs37) i(vs38) i(vs39)
print i(vs40) i(vs41) i(vs42)
.endc
.end
