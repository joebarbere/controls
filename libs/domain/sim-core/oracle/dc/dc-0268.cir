controls oracle dc-0268
* Generated (plan F2.7, ADR 0012): do not edit; regenerate with `pnpm sim oracle regen`. dc seed 20261030 index 268 nodes 30 elements 32
.options sparse gmin=1e-12 noopac
RG1 1 0 1000000000000
RG2 2 0 1000000000000
RG3 3 0 1000000000000
RG4 4 0 1000000000000
RG5 5 0 1000000000000
RG6 6 0 1000000000000
RG7 7 0 1000000000000
RG8 8 0 1000000000000
RG9 9 0 1000000000000
RG10 10 0 1000000000000
RG11 11 0 1000000000000
RG12 12 0 1000000000000
RG13 13 0 1000000000000
RG14 14 0 1000000000000
RG15 15 0 1000000000000
RG16 16 0 1000000000000
RG17 17 0 1000000000000
RG18 18 0 1000000000000
RG19 19 0 1000000000000
RG20 20 0 1000000000000
RG21 21 0 1000000000000
RG22 22 0 1000000000000
RG23 23 0 1000000000000
RG24 24 0 1000000000000
RG25 25 0 1000000000000
RG26 26 0 1000000000000
RG27 27 0 1000000000000
RG28 28 0 1000000000000
RG29 29 0 1000000000000
VS0 25 s0 0
R0 s0 19 15e2
VS1 0 s1 0
R1 s1 27 18e0
VS2 16 s2 0
R2 s2 19 15e0
VS3 0 s3 0
R3 s3 28 18e2
VS4 11 s4 0
R4 s4 5 68e1
VS5 25 s5 0
R5 s5 14 22e-2
VS6 2 s6 0
R6 s6 0 47e2
VS7 25 s7 0
R7 s7 9 56e3
VS8 0 s8 0
V8 e8 s8 DC 10e0
RI8 e8 16 18e-2
VS9 12 s9 0
R9 s9 3 68e0
VS10 8 s10 0
R10 s10 29 18e-2
VS11 5 s11 0
R11 s11 13 33e-2
VS12 11 s12 0
R12 s12 16 47e-2
VS13 13 s13 0
R13 s13 0 56e-2
VS14 20 s14 0
V14 e14 s14 DC 15e1
RI14 e14 21 12e-1
VS15 15 s15 0
R15 s15 4 82e-2
VS16 16 s16 0
R16 s16 26 27e-1
VS17 28 s17 0
R17 s17 23 10e0
VS18 7 s18 0
R18 s18 15 47e-1
VS19 9 s19 0
R19 s19 24 10e2
VS20 15 s20 0
R20 s20 12 39e3
VS21 17 s21 0
R21 s21 23 56e0
VS22 7 s22 0
I22 s22 12 DC 82e-3
VS23 15 s23 0
R23 s23 13 27e1
VS24 11 s24 0
R24 s24 18 22e-2
VS25 25 s25 0
R25 s25 8 47e-1
VS26 25 s26 0
V26 e26 s26 DC 15e-1
RI26 e26 10 39e-3
VS27 25 s27 0
R27 s27 17 56e-2
VS28 19 s28 0
R28 s28 22 18e3
VS29 26 s29 0
R29 s29 21 33e0
VS30 1 s30 0
R30 s30 24 68e3
VS31 26 s31 0
V31 e31 s31 DC 27e-1
RI31 e31 6 68e-1
.control
set numdgt=17
op
print v(1) v(2) v(3) v(4) v(5) v(6) v(7) v(8) v(9) v(10)
print v(11) v(12) v(13) v(14) v(15) v(16) v(17) v(18) v(19) v(20)
print v(21) v(22) v(23) v(24) v(25) v(26) v(27) v(28) v(29)
print i(vs0) i(vs1) i(vs2) i(vs3) i(vs4) i(vs5) i(vs6) i(vs7) i(vs8) i(vs9)
print i(vs10) i(vs11) i(vs12) i(vs13) i(vs14) i(vs15) i(vs16) i(vs17) i(vs18) i(vs19)
print i(vs20) i(vs21) i(vs22) i(vs23) i(vs24) i(vs25) i(vs26) i(vs27) i(vs28) i(vs29)
print i(vs30) i(vs31)
.endc
.end
