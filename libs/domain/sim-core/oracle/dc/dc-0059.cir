controls oracle dc-0059
* Generated (plan F2.7, ADR 0012): do not edit; regenerate with `pnpm sim oracle regen`. dc seed 20261030 index 59 nodes 21 elements 31
.options sparse gmin=1e-12 noopac
RG1 1 0 1000000000000
RG2 2 0 1000000000000
RG3 3 0 1000000000000
RG4 4 0 1000000000000
RG5 5 0 1000000000000
RG6 6 0 1000000000000
RG7 7 0 1000000000000
RG8 8 0 1000000000000
RG9 9 0 1000000000000
RG10 10 0 1000000000000
RG11 11 0 1000000000000
RG12 12 0 1000000000000
RG13 13 0 1000000000000
RG14 14 0 1000000000000
RG15 15 0 1000000000000
RG16 16 0 1000000000000
RG17 17 0 1000000000000
RG18 18 0 1000000000000
RG19 19 0 1000000000000
RG20 20 0 1000000000000
VS0 3 s0 0
R0 s0 15 22e3
VS1 14 s1 0
R1 s1 15 15e-1
VS2 0 s2 0
V2 e2 s2 DC 68e-1
RI2 e2 18 82e-3
VS3 9 s3 0
R3 s3 2 12e-1
VS4 2 s4 0
R4 s4 11 15e-1
VS5 13 s5 0
R5 s5 1 47e-2
VS6 16 s6 0
V6 e6 s6 DC 82e0
RI6 e6 15 12e-1
VS7 2 s7 0
R7 s7 12 22e1
VS8 2 s8 0
R8 s8 6 10e3
VS9 18 s9 0
R9 s9 15 47e1
VS10 6 s10 0
V10 e10 s10 DC 15e0
RI10 e10 5 10e-1
VS11 7 s11 0
R11 s11 2 15e3
VS12 17 s12 0
R12 s12 5 82e3
VS13 18 s13 0
R13 s13 2 12e3
VS14 7 s14 0
R14 s14 3 47e-1
VS15 19 s15 0
V15 e15 s15 DC 10e1
RI15 e15 4 56e-3
VS16 10 s16 0
V16 e16 s16 DC 22e0
RI16 e16 19 39e-2
VS17 20 s17 0
R17 s17 10 56e-2
VS18 4 s18 0
V18 e18 s18 DC 68e1
RI18 e18 1 12e-1
VS19 7 s19 0
V19 e19 s19 DC 27e-1
RI19 e19 16 12e-3
VS20 19 s20 0
R20 s20 15 22e-1
VS21 2 s21 0
R21 s21 8 22e3
VS22 7 s22 0
R22 s22 8 68e0
VS23 17 s23 0
R23 s23 13 56e-1
VS24 19 s24 0
V24 e24 s24 DC 10e0
RI24 e24 2 10e-3
VS25 19 s25 0
R25 s25 9 12e0
VS26 12 s26 0
R26 s26 7 39e0
VS27 18 s27 0
R27 s27 1 39e3
VS28 20 s28 0
R28 s28 15 27e-1
VS29 0 s29 0
R29 s29 4 39e2
VS30 14 s30 0
R30 s30 11 27e0
.control
set numdgt=17
op
print v(1) v(2) v(3) v(4) v(5) v(6) v(7) v(8) v(9) v(10)
print v(11) v(12) v(13) v(14) v(15) v(16) v(17) v(18) v(19) v(20)
print i(vs0) i(vs1) i(vs2) i(vs3) i(vs4) i(vs5) i(vs6) i(vs7) i(vs8) i(vs9)
print i(vs10) i(vs11) i(vs12) i(vs13) i(vs14) i(vs15) i(vs16) i(vs17) i(vs18) i(vs19)
print i(vs20) i(vs21) i(vs22) i(vs23) i(vs24) i(vs25) i(vs26) i(vs27) i(vs28) i(vs29)
print i(vs30)
.endc
.end
