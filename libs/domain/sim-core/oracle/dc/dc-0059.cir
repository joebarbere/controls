controls oracle dc-0059
* Generated (plan F2.7, ADR 0012): do not edit; regenerate with `pnpm sim oracle regen`. dc seed 20261030 index 59 nodes 21 elements 23
.options sparse gmin=1e-12 noopac
RG1 1 0 1000000000000
RG2 2 0 1000000000000
RG3 3 0 1000000000000
RG4 4 0 1000000000000
RG5 5 0 1000000000000
RG6 6 0 1000000000000
RG7 7 0 1000000000000
RG8 8 0 1000000000000
RG9 9 0 1000000000000
RG10 10 0 1000000000000
RG11 11 0 1000000000000
RG12 12 0 1000000000000
RG13 13 0 1000000000000
RG14 14 0 1000000000000
RG15 15 0 1000000000000
RG16 16 0 1000000000000
RG17 17 0 1000000000000
RG18 18 0 1000000000000
RG19 19 0 1000000000000
RG20 20 0 1000000000000
VS0 0 s0 0
V0 e0 s0 DC 27e-1
RI0 e0 16 12e-3
VS1 2 s1 0
R1 s1 8 22e3
VS2 13 s2 0
R2 s2 1 47e-2
VS3 0 s3 0
R3 s3 2 15e3
VS4 7 s4 0
R4 s4 1 39e3
VS5 2 s5 0
R5 s5 11 15e-1
VS6 0 s6 0
R6 s6 3 47e-1
VS7 19 s7 0
R7 s7 15 22e-1
VS8 17 s8 0
R8 s8 5 82e3
VS9 20 s9 0
R9 s9 10 56e-2
VS10 3 s10 0
R10 s10 15 22e3
VS11 18 s11 0
V11 e11 s11 DC 68e-1
RI11 e11 7 82e-3
VS12 12 s12 0
R12 s12 0 39e0
VS13 7 s13 0
R13 s13 15 47e1
VS14 4 s14 0
V14 e14 s14 DC 68e1
RI14 e14 1 12e-1
VS15 14 s15 0
R15 s15 15 15e-1
VS16 19 s16 0
R16 s16 9 12e0
VS17 19 s17 0
V17 e17 s17 DC 10e1
RI17 e17 4 56e-3
VS18 17 s18 0
R18 s18 13 56e-1
VS19 2 s19 0
R19 s19 6 10e3
VS20 19 s20 0
V20 e20 s20 DC 10e0
RI20 e20 2 10e-3
VS21 20 s21 0
R21 s21 15 27e-1
VS22 7 s22 0
R22 s22 2 12e3
.control
set numdgt=17
op
print v(1) v(2) v(3) v(4) v(5) v(6) v(7) v(8) v(9) v(10)
print v(11) v(12) v(13) v(14) v(15) v(16) v(17) v(18) v(19) v(20)
print i(vs0) i(vs1) i(vs2) i(vs3) i(vs4) i(vs5) i(vs6) i(vs7) i(vs8) i(vs9)
print i(vs10) i(vs11) i(vs12) i(vs13) i(vs14) i(vs15) i(vs16) i(vs17) i(vs18) i(vs19)
print i(vs20) i(vs21) i(vs22)
.endc
.end
