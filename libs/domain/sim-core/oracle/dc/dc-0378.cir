controls oracle dc-0378
* Generated (plan F2.7, ADR 0012): do not edit; regenerate with `pnpm sim oracle regen`. dc seed 20261030 index 378 nodes 27 elements 46
.options sparse gmin=1e-12 noopac
RG1 1 0 1000000000000
RG2 2 0 1000000000000
RG3 3 0 1000000000000
RG4 4 0 1000000000000
RG5 5 0 1000000000000
RG6 6 0 1000000000000
RG7 7 0 1000000000000
RG8 8 0 1000000000000
RG9 9 0 1000000000000
RG10 10 0 1000000000000
RG11 11 0 1000000000000
RG12 12 0 1000000000000
RG13 13 0 1000000000000
RG14 14 0 1000000000000
RG15 15 0 1000000000000
RG16 16 0 1000000000000
RG17 17 0 1000000000000
RG18 18 0 1000000000000
RG19 19 0 1000000000000
RG20 20 0 1000000000000
RG21 21 0 1000000000000
RG22 22 0 1000000000000
RG23 23 0 1000000000000
RG24 24 0 1000000000000
RG25 25 0 1000000000000
RG26 26 0 1000000000000
VS0 9 s0 0
R0 s0 22 47e1
VS1 12 s1 0
R1 s1 5 47e0
VS2 20 s2 0
R2 s2 5 47e-1
VS3 4 s3 0
R3 s3 2 15e-1
VS4 6 s4 0
R4 s4 7 47e2
VS5 0 s5 0
R5 s5 6 39e3
VS6 19 s6 0
R6 s6 13 82e3
VS7 3 s7 0
R7 s7 17 33e0
VS8 4 s8 0
R8 s8 0 68e3
VS9 0 s9 0
V9 e9 s9 DC 12e-1
RI9 e9 14 22e-2
VS10 15 s10 0
R10 s10 4 27e0
VS11 18 s11 0
I11 s11 23 DC 68e-3
VS12 25 s12 0
R12 s12 14 82e-2
VS13 12 s13 0
V13 e13 s13 DC 82e0
RI13 e13 18 10e-3
VS14 20 s14 0
R14 s14 24 10e-2
VS15 11 s15 0
R15 s15 2 22e2
VS16 10 s16 0
R16 s16 24 33e-2
VS17 12 s17 0
V17 e17 s17 DC 56e-1
RI17 e17 8 47e-3
VS18 11 s18 0
R18 s18 8 47e0
VS19 10 s19 0
V19 e19 s19 DC 12e0
RI19 e19 1 12e-1
VS20 3 s20 0
R20 s20 23 22e0
VS21 12 s21 0
R21 s21 22 22e1
VS22 6 s22 0
R22 s22 12 47e-1
VS23 6 s23 0
R23 s23 13 10e-1
VS24 3 s24 0
V24 e24 s24 DC 18e0
RI24 e24 7 18e-3
VS25 13 s25 0
I25 s25 8 DC 22e-4
VS26 17 s26 0
R26 s26 13 33e2
VS27 26 s27 0
R27 s27 23 68e-1
VS28 8 s28 0
R28 s28 17 39e0
VS29 16 s29 0
V29 e29 s29 DC 27e-1
RI29 e29 1 82e-2
VS30 3 s30 0
R30 s30 25 82e3
VS31 16 s31 0
R31 s31 18 56e-1
VS32 4 s32 0
R32 s32 19 18e0
VS33 25 s33 0
V33 e33 s33 DC 12e0
RI33 e33 2 10e-1
VS34 20 s34 0
R34 s34 12 18e2
VS35 21 s35 0
R35 s35 20 68e0
VS36 8 s36 0
R36 s36 15 10e0
VS37 16 s37 0
R37 s37 23 12e3
VS38 5 s38 0
R38 s38 21 15e3
VS39 20 s39 0
V39 e39 s39 DC 47e-1
RI39 e39 26 47e-1
VS40 13 s40 0
I40 s40 9 DC 27e-2
VS41 26 s41 0
R41 s41 15 33e0
VS42 20 s42 0
R42 s42 21 82e3
VS43 4 s43 0
V43 e43 s43 DC 15e0
RI43 e43 9 68e-2
VS44 25 s44 0
R44 s44 16 12e1
VS45 0 s45 0
R45 s45 10 47e3
.control
set numdgt=17
op
print v(1) v(2) v(3) v(4) v(5) v(6) v(7) v(8) v(9) v(10)
print v(11) v(12) v(13) v(14) v(15) v(16) v(17) v(18) v(19) v(20)
print v(21) v(22) v(23) v(24) v(25) v(26)
print i(vs0) i(vs1) i(vs2) i(vs3) i(vs4) i(vs5) i(vs6) i(vs7) i(vs8) i(vs9)
print i(vs10) i(vs11) i(vs12) i(vs13) i(vs14) i(vs15) i(vs16) i(vs17) i(vs18) i(vs19)
print i(vs20) i(vs21) i(vs22) i(vs23) i(vs24) i(vs25) i(vs26) i(vs27) i(vs28) i(vs29)
print i(vs30) i(vs31) i(vs32) i(vs33) i(vs34) i(vs35) i(vs36) i(vs37) i(vs38) i(vs39)
print i(vs40) i(vs41) i(vs42) i(vs43) i(vs44) i(vs45)
.endc
.end
