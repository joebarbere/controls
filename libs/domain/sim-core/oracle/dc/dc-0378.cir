controls oracle dc-0378
* Generated (plan F2.7, ADR 0012): do not edit; regenerate with `pnpm sim oracle regen`. dc seed 20261030 index 378 nodes 27 elements 43
.options sparse gmin=1e-12 noopac
RG1 1 0 1000000000000
RG2 2 0 1000000000000
RG3 3 0 1000000000000
RG4 4 0 1000000000000
RG5 5 0 1000000000000
RG6 6 0 1000000000000
RG7 7 0 1000000000000
RG8 8 0 1000000000000
RG9 9 0 1000000000000
RG10 10 0 1000000000000
RG11 11 0 1000000000000
RG12 12 0 1000000000000
RG13 13 0 1000000000000
RG14 14 0 1000000000000
RG15 15 0 1000000000000
RG16 16 0 1000000000000
RG17 17 0 1000000000000
RG18 18 0 1000000000000
RG19 19 0 1000000000000
RG20 20 0 1000000000000
RG21 21 0 1000000000000
RG22 22 0 1000000000000
RG23 23 0 1000000000000
RG24 24 0 1000000000000
RG25 25 0 1000000000000
RG26 26 0 1000000000000
VS0 6 s0 0
R0 s0 0 47e-1
VS1 26 s1 0
R1 s1 23 68e-1
VS2 25 s2 0
R2 s2 16 12e1
VS3 0 s3 0
V3 e3 s3 DC 82e0
RI3 e3 18 10e-3
VS4 8 s4 0
R4 s4 15 10e0
VS5 20 s5 0
R5 s5 21 82e3
VS6 5 s6 0
R6 s6 21 15e3
VS7 13 s7 0
I7 s7 9 DC 27e-2
VS8 25 s8 0
V8 e8 s8 DC 12e0
RI8 e8 2 10e-1
VS9 8 s9 0
R9 s9 17 39e0
VS10 19 s10 0
R10 s10 13 82e3
VS11 11 s11 0
R11 s11 2 22e2
VS12 18 s12 0
I12 s12 23 DC 68e-3
VS13 12 s13 0
R13 s13 6 39e3
VS14 0 s14 0
R14 s14 5 47e0
VS15 6 s15 0
R15 s15 13 10e-1
VS16 20 s16 0
R16 s16 0 18e2
VS17 17 s17 0
R17 s17 13 33e2
VS18 21 s18 0
R18 s18 20 68e0
VS19 0 s19 0
V19 e19 s19 DC 56e-1
RI19 e19 8 47e-3
VS20 3 s20 0
R20 s20 17 33e0
VS21 25 s21 0
R21 s21 14 82e-2
VS22 3 s22 0
R22 s22 25 82e3
VS23 13 s23 0
I23 s23 8 DC 22e-4
VS24 9 s24 0
R24 s24 22 47e1
VS25 12 s25 0
V25 e25 s25 DC 12e-1
RI25 e25 14 22e-2
VS26 16 s26 0
V26 e26 s26 DC 27e-1
RI26 e26 1 82e-2
VS27 0 s27 0
R27 s27 22 22e1
VS28 16 s28 0
R28 s28 18 56e-1
VS29 15 s29 0
R29 s29 4 27e0
VS30 12 s30 0
R30 s30 10 47e3
VS31 20 s31 0
V31 e31 s31 DC 47e-1
RI31 e31 26 47e-1
VS32 4 s32 0
V32 e32 s32 DC 15e0
RI32 e32 9 68e-2
VS33 3 s33 0
R33 s33 23 22e0
VS34 16 s34 0
R34 s34 23 12e3
VS35 4 s35 0
R35 s35 2 15e-1
VS36 20 s36 0
R36 s36 5 47e-1
VS37 11 s37 0
R37 s37 8 47e0
VS38 3 s38 0
V38 e38 s38 DC 18e0
RI38 e38 7 18e-3
VS39 20 s39 0
R39 s39 24 10e-2
VS40 26 s40 0
R40 s40 15 33e0
VS41 6 s41 0
R41 s41 7 47e2
VS42 4 s42 0
R42 s42 12 68e3
.control
set numdgt=17
op
print v(1) v(2) v(3) v(4) v(5) v(6) v(7) v(8) v(9) v(10)
print v(11) v(12) v(13) v(14) v(15) v(16) v(17) v(18) v(19) v(20)
print v(21) v(22) v(23) v(24) v(25) v(26)
print i(vs0) i(vs1) i(vs2) i(vs3) i(vs4) i(vs5) i(vs6) i(vs7) i(vs8) i(vs9)
print i(vs10) i(vs11) i(vs12) i(vs13) i(vs14) i(vs15) i(vs16) i(vs17) i(vs18) i(vs19)
print i(vs20) i(vs21) i(vs22) i(vs23) i(vs24) i(vs25) i(vs26) i(vs27) i(vs28) i(vs29)
print i(vs30) i(vs31) i(vs32) i(vs33) i(vs34) i(vs35) i(vs36) i(vs37) i(vs38) i(vs39)
print i(vs40) i(vs41) i(vs42)
.endc
.end
