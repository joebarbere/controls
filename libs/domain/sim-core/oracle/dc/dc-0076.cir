controls oracle dc-0076
* Generated (plan F2.7, ADR 0012): do not edit; regenerate with `pnpm sim oracle regen`. dc seed 20261030 index 76 nodes 29 elements 49
.options sparse gmin=1e-12 noopac
RG1 1 0 1000000000000
RG2 2 0 1000000000000
RG3 3 0 1000000000000
RG4 4 0 1000000000000
RG5 5 0 1000000000000
RG6 6 0 1000000000000
RG7 7 0 1000000000000
RG8 8 0 1000000000000
RG9 9 0 1000000000000
RG10 10 0 1000000000000
RG11 11 0 1000000000000
RG12 12 0 1000000000000
RG13 13 0 1000000000000
RG14 14 0 1000000000000
RG15 15 0 1000000000000
RG16 16 0 1000000000000
RG17 17 0 1000000000000
RG18 18 0 1000000000000
RG19 19 0 1000000000000
RG20 20 0 1000000000000
RG21 21 0 1000000000000
RG22 22 0 1000000000000
RG23 23 0 1000000000000
RG24 24 0 1000000000000
RG25 25 0 1000000000000
RG26 26 0 1000000000000
RG27 27 0 1000000000000
RG28 28 0 1000000000000
VS0 9 s0 0
R0 s0 12 33e2
VS1 5 s1 0
R1 s1 6 22e3
VS2 6 s2 0
R2 s2 24 22e3
VS3 4 s3 0
R3 s3 25 82e0
VS4 5 s4 0
R4 s4 16 39e2
VS5 21 s5 0
I5 s5 15 DC 39e-2
VS6 18 s6 0
R6 s6 2 10e2
VS7 11 s7 0
I7 s7 24 DC 18e-1
VS8 0 s8 0
V8 e8 s8 DC 47e0
RI8 e8 5 56e-3
VS9 17 s9 0
R9 s9 16 15e0
VS10 0 s10 0
R10 s10 16 15e1
VS11 4 s11 0
R11 s11 3 12e0
VS12 12 s12 0
R12 s12 18 22e-2
VS13 21 s13 0
R13 s13 9 18e1
VS14 27 s14 0
R14 s14 8 18e-1
VS15 24 s15 0
R15 s15 1 10e-2
VS16 25 s16 0
I16 s16 14 DC 39e-4
VS17 21 s17 0
R17 s17 18 15e-1
VS18 22 s18 0
R18 s18 25 27e-2
VS19 1 s19 0
R19 s19 27 12e0
VS20 7 s20 0
I20 s20 16 DC 33e-3
VS21 14 s21 0
R21 s21 13 12e0
VS22 17 s22 0
R22 s22 12 82e1
VS23 4 s23 0
R23 s23 28 22e1
VS24 26 s24 0
R24 s24 10 12e3
VS25 4 s25 0
V25 e25 s25 DC 82e-1
RI25 e25 1 39e-3
VS26 4 s26 0
R26 s26 10 82e0
VS27 13 s27 0
R27 s27 5 47e-2
VS28 5 s28 0
I28 s28 12 DC 15e-2
VS29 6 s29 0
R29 s29 15 56e-1
VS30 6 s30 0
R30 s30 7 56e-1
VS31 27 s31 0
R31 s31 25 12e2
VS32 3 s32 0
R32 s32 19 56e1
VS33 11 s33 0
R33 s33 15 27e3
VS34 4 s34 0
R34 s34 5 68e1
VS35 18 s35 0
R35 s35 3 82e2
VS36 11 s36 0
R36 s36 5 27e3
VS37 23 s37 0
R37 s37 19 12e-2
VS38 15 s38 0
R38 s38 21 39e0
VS39 20 s39 0
R39 s39 19 18e0
VS40 4 s40 0
R40 s40 20 47e2
VS41 0 s41 0
V41 e41 s41 DC 33e-1
RI41 e41 7 22e-3
VS42 2 s42 0
R42 s42 23 18e0
VS43 4 s43 0
R43 s43 26 82e0
VS44 8 s44 0
R44 s44 28 47e-2
VS45 14 s45 0
R45 s45 10 68e3
VS46 22 s46 0
R46 s46 4 39e0
VS47 21 s47 0
V47 e47 s47 DC 15e0
RI47 e47 9 33e-3
VS48 2 s48 0
R48 s48 5 18e0
.control
set numdgt=17
op
print v(1) v(2) v(3) v(4) v(5) v(6) v(7) v(8) v(9) v(10)
print v(11) v(12) v(13) v(14) v(15) v(16) v(17) v(18) v(19) v(20)
print v(21) v(22) v(23) v(24) v(25) v(26) v(27) v(28)
print i(vs0) i(vs1) i(vs2) i(vs3) i(vs4) i(vs5) i(vs6) i(vs7) i(vs8) i(vs9)
print i(vs10) i(vs11) i(vs12) i(vs13) i(vs14) i(vs15) i(vs16) i(vs17) i(vs18) i(vs19)
print i(vs20) i(vs21) i(vs22) i(vs23) i(vs24) i(vs25) i(vs26) i(vs27) i(vs28) i(vs29)
print i(vs30) i(vs31) i(vs32) i(vs33) i(vs34) i(vs35) i(vs36) i(vs37) i(vs38) i(vs39)
print i(vs40) i(vs41) i(vs42) i(vs43) i(vs44) i(vs45) i(vs46) i(vs47) i(vs48)
.endc
.end
