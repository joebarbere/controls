controls oracle dc-0139
* Generated (plan F2.7, ADR 0012): do not edit; regenerate with `pnpm sim oracle regen`. dc seed 20261030 index 139 nodes 21 elements 39
.options sparse gmin=1e-12 noopac
RG1 1 0 1000000000000
RG2 2 0 1000000000000
RG3 3 0 1000000000000
RG4 4 0 1000000000000
RG5 5 0 1000000000000
RG6 6 0 1000000000000
RG7 7 0 1000000000000
RG8 8 0 1000000000000
RG9 9 0 1000000000000
RG10 10 0 1000000000000
RG11 11 0 1000000000000
RG12 12 0 1000000000000
RG13 13 0 1000000000000
RG14 14 0 1000000000000
RG15 15 0 1000000000000
RG16 16 0 1000000000000
RG17 17 0 1000000000000
RG18 18 0 1000000000000
RG19 19 0 1000000000000
RG20 20 0 1000000000000
VS0 7 s0 0
R0 s0 1 47e0
VS1 7 s1 0
R1 s1 14 12e3
VS2 2 s2 0
R2 s2 6 56e0
VS3 2 s3 0
R3 s3 18 56e2
VS4 7 s4 0
R4 s4 17 12e2
VS5 10 s5 0
R5 s5 3 15e3
VS6 5 s6 0
R6 s6 19 15e1
VS7 15 s7 0
R7 s7 10 33e1
VS8 3 s8 0
R8 s8 4 12e1
VS9 6 s9 0
R9 s9 3 12e1
VS10 3 s10 0
R10 s10 19 15e-2
VS11 15 s11 0
I11 s11 7 DC 18e-3
VS12 14 s12 0
R12 s12 18 33e-1
VS13 9 s13 0
I13 s13 12 DC 27e-2
VS14 19 s14 0
R14 s14 16 27e-2
VS15 17 s15 0
R15 s15 11 27e3
VS16 0 s16 0
V16 e16 s16 DC 82e0
RI16 e16 18 33e-3
VS17 7 s17 0
V17 e17 s17 DC 82e-1
RI17 e17 11 15e-3
VS18 15 s18 0
R18 s18 5 15e-2
VS19 20 s19 0
R19 s19 14 12e3
VS20 1 s20 0
R20 s20 11 27e-1
VS21 5 s21 0
R21 s21 16 12e3
VS22 12 s22 0
V22 e22 s22 DC 47e1
RI22 e22 18 12e-2
VS23 2 s23 0
V23 e23 s23 DC 39e-1
RI23 e23 9 27e-1
VS24 3 s24 0
R24 s24 13 22e2
VS25 16 s25 0
V25 e25 s25 DC 56e0
RI25 e25 17 12e-2
VS26 12 s26 0
R26 s26 3 82e3
VS27 14 s27 0
R27 s27 12 10e3
VS28 11 s28 0
R28 s28 3 18e-2
VS29 8 s29 0
R29 s29 0 47e2
VS30 9 s30 0
R30 s30 3 68e3
VS31 13 s31 0
V31 e31 s31 DC 12e-1
RI31 e31 14 47e-1
VS32 17 s32 0
I32 s32 12 DC 33e-3
VS33 7 s33 0
R33 s33 12 47e2
VS34 8 s34 0
R34 s34 11 18e0
VS35 20 s35 0
R35 s35 7 68e-1
VS36 2 s36 0
R36 s36 18 15e-1
VS37 15 s37 0
R37 s37 4 12e-1
VS38 8 s38 0
R38 s38 1 15e3
.control
set numdgt=17
op
print v(1) v(2) v(3) v(4) v(5) v(6) v(7) v(8) v(9) v(10)
print v(11) v(12) v(13) v(14) v(15) v(16) v(17) v(18) v(19) v(20)
print i(vs0) i(vs1) i(vs2) i(vs3) i(vs4) i(vs5) i(vs6) i(vs7) i(vs8) i(vs9)
print i(vs10) i(vs11) i(vs12) i(vs13) i(vs14) i(vs15) i(vs16) i(vs17) i(vs18) i(vs19)
print i(vs20) i(vs21) i(vs22) i(vs23) i(vs24) i(vs25) i(vs26) i(vs27) i(vs28) i(vs29)
print i(vs30) i(vs31) i(vs32) i(vs33) i(vs34) i(vs35) i(vs36) i(vs37) i(vs38)
.endc
.end
