controls oracle dc-0139
* Generated (plan F2.7, ADR 0012): do not edit; regenerate with `pnpm sim oracle regen`. dc seed 20261030 index 139 nodes 21 elements 35
.options sparse gmin=1e-12 noopac
RG1 1 0 1000000000000
RG2 2 0 1000000000000
RG3 3 0 1000000000000
RG4 4 0 1000000000000
RG5 5 0 1000000000000
RG6 6 0 1000000000000
RG7 7 0 1000000000000
RG8 8 0 1000000000000
RG9 9 0 1000000000000
RG10 10 0 1000000000000
RG11 11 0 1000000000000
RG12 12 0 1000000000000
RG13 13 0 1000000000000
RG14 14 0 1000000000000
RG15 15 0 1000000000000
RG16 16 0 1000000000000
RG17 17 0 1000000000000
RG18 18 0 1000000000000
RG19 19 0 1000000000000
RG20 20 0 1000000000000
VS0 0 s0 0
V0 e0 s0 DC 12e-1
RI0 e0 14 47e-1
VS1 2 s1 0
R1 s1 18 56e2
VS2 17 s2 0
R2 s2 11 27e3
VS3 14 s3 0
R3 s3 13 10e3
VS4 7 s4 0
R4 s4 14 12e3
VS5 1 s5 0
R5 s5 11 27e-1
VS6 11 s6 0
R6 s6 3 18e-2
VS7 14 s7 0
R7 s7 18 33e-1
VS8 3 s8 0
R8 s8 19 15e-2
VS9 15 s9 0
I9 s9 7 DC 18e-3
VS10 9 s10 0
I10 s10 13 DC 27e-2
VS11 8 s11 0
R11 s11 1 15e3
VS12 2 s12 0
R12 s12 18 15e-1
VS13 13 s13 0
R13 s13 3 82e3
VS14 13 s14 0
V14 e14 s14 DC 47e1
RI14 e14 18 12e-2
VS15 10 s15 0
R15 s15 3 15e3
VS16 20 s16 0
R16 s16 7 68e-1
VS17 7 s17 0
R17 s17 17 12e2
VS18 15 s18 0
R18 s18 10 33e1
VS19 7 s19 0
R19 s19 13 47e2
VS20 5 s20 0
R20 s20 16 12e3
VS21 19 s21 0
R21 s21 16 27e-2
VS22 12 s22 0
V22 e22 s22 DC 82e0
RI22 e22 18 33e-3
VS23 7 s23 0
V23 e23 s23 DC 82e-1
RI23 e23 11 15e-3
VS24 6 s24 0
R24 s24 3 12e1
VS25 9 s25 0
R25 s25 3 68e3
VS26 2 s26 0
R26 s26 6 56e0
VS27 3 s27 0
R27 s27 4 12e1
VS28 16 s28 0
V28 e28 s28 DC 56e0
RI28 e28 17 12e-2
VS29 17 s29 0
I29 s29 13 DC 33e-3
VS30 5 s30 0
R30 s30 19 15e1
VS31 3 s31 0
R31 s31 0 22e2
VS32 15 s32 0
R32 s32 4 12e-1
VS33 15 s33 0
R33 s33 5 15e-2
VS34 8 s34 0
R34 s34 11 18e0
.control
set numdgt=17
op
print v(1) v(2) v(3) v(4) v(5) v(6) v(7) v(8) v(9) v(10)
print v(11) v(12) v(13) v(14) v(15) v(16) v(17) v(18) v(19) v(20)
print i(vs0) i(vs1) i(vs2) i(vs3) i(vs4) i(vs5) i(vs6) i(vs7) i(vs8) i(vs9)
print i(vs10) i(vs11) i(vs12) i(vs13) i(vs14) i(vs15) i(vs16) i(vs17) i(vs18) i(vs19)
print i(vs20) i(vs21) i(vs22) i(vs23) i(vs24) i(vs25) i(vs26) i(vs27) i(vs28) i(vs29)
print i(vs30) i(vs31) i(vs32) i(vs33) i(vs34)
.endc
.end
