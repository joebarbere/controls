controls oracle dc-0241
* Generated (plan F2.7, ADR 0012): do not edit; regenerate with `pnpm sim oracle regen`. dc seed 20261030 index 241 nodes 26 elements 51
.options sparse gmin=1e-12 noopac
RG1 1 0 1000000000000
RG2 2 0 1000000000000
RG3 3 0 1000000000000
RG4 4 0 1000000000000
RG5 5 0 1000000000000
RG6 6 0 1000000000000
RG7 7 0 1000000000000
RG8 8 0 1000000000000
RG9 9 0 1000000000000
RG10 10 0 1000000000000
RG11 11 0 1000000000000
RG12 12 0 1000000000000
RG13 13 0 1000000000000
RG14 14 0 1000000000000
RG15 15 0 1000000000000
RG16 16 0 1000000000000
RG17 17 0 1000000000000
RG18 18 0 1000000000000
RG19 19 0 1000000000000
RG20 20 0 1000000000000
RG21 21 0 1000000000000
RG22 22 0 1000000000000
RG23 23 0 1000000000000
RG24 24 0 1000000000000
RG25 25 0 1000000000000
VS0 3 s0 0
R0 s0 0 15e-1
VS1 3 s1 0
I1 s1 24 DC 18e-1
VS2 6 s2 0
R2 s2 25 22e-1
VS3 11 s3 0
R3 s3 25 68e-2
VS4 0 s4 0
V4 e4 s4 DC 22e1
RI4 e4 25 82e-2
VS5 16 s5 0
R5 s5 23 27e2
VS6 22 s6 0
R6 s6 4 27e3
VS7 1 s7 0
R7 s7 7 47e0
VS8 8 s8 0
V8 e8 s8 DC 15e-1
RI8 e8 3 12e-2
VS9 18 s9 0
R9 s9 14 82e3
VS10 12 s10 0
R10 s10 5 12e3
VS11 20 s11 0
R11 s11 16 56e0
VS12 15 s12 0
V12 e12 s12 DC 56e1
RI12 e12 6 12e-1
VS13 19 s13 0
R13 s13 25 68e-1
VS14 15 s14 0
R14 s14 16 56e2
VS15 25 s15 0
R15 s15 4 68e3
VS16 6 s16 0
R16 s16 0 12e3
VS17 2 s17 0
I17 s17 12 DC 68e-3
VS18 19 s18 0
R18 s18 1 56e3
VS19 0 s19 0
I19 s19 24 DC 56e-4
VS20 2 s20 0
I20 s20 1 DC 18e-2
VS21 2 s21 0
R21 s21 9 33e0
VS22 9 s22 0
R22 s22 12 33e3
VS23 24 s23 0
V23 e23 s23 DC 56e-1
RI23 e23 13 22e-2
VS24 19 s24 0
R24 s24 18 18e3
VS25 7 s25 0
R25 s25 14 82e-1
VS26 24 s26 0
R26 s26 21 27e-1
VS27 6 s27 0
R27 s27 11 33e0
VS28 13 s28 0
V28 e28 s28 DC 68e-1
RI28 e28 16 33e-3
VS29 12 s29 0
R29 s29 8 68e0
VS30 0 s30 0
R30 s30 22 47e-2
VS31 19 s31 0
R31 s31 21 15e2
VS32 5 s32 0
R32 s32 16 22e-1
VS33 18 s33 0
R33 s33 20 47e-2
VS34 12 s34 0
R34 s34 22 15e1
VS35 24 s35 0
R35 s35 6 82e2
VS36 2 s36 0
R36 s36 8 82e-1
VS37 0 s37 0
I37 s37 3 DC 15e-3
VS38 10 s38 0
R38 s38 18 12e-1
VS39 17 s39 0
R39 s39 5 47e-1
VS40 22 s40 0
R40 s40 2 82e-2
VS41 20 s41 0
I41 s41 22 DC 15e-1
VS42 4 s42 0
I42 s42 17 DC 56e-3
VS43 22 s43 0
I43 s43 19 DC 47e-3
VS44 2 s44 0
R44 s44 16 18e-1
VS45 13 s45 0
R45 s45 1 15e-1
VS46 25 s46 0
R46 s46 16 27e-1
VS47 17 s47 0
V47 e47 s47 DC 39e-1
RI47 e47 23 33e-3
VS48 18 s48 0
R48 s48 20 39e3
VS49 18 s49 0
R49 s49 17 56e0
VS50 10 s50 0
V50 e50 s50 DC 47e1
RI50 e50 14 47e-1
.control
set numdgt=17
op
print v(1) v(2) v(3) v(4) v(5) v(6) v(7) v(8) v(9) v(10)
print v(11) v(12) v(13) v(14) v(15) v(16) v(17) v(18) v(19) v(20)
print v(21) v(22) v(23) v(24) v(25)
print i(vs0) i(vs1) i(vs2) i(vs3) i(vs4) i(vs5) i(vs6) i(vs7) i(vs8) i(vs9)
print i(vs10) i(vs11) i(vs12) i(vs13) i(vs14) i(vs15) i(vs16) i(vs17) i(vs18) i(vs19)
print i(vs20) i(vs21) i(vs22) i(vs23) i(vs24) i(vs25) i(vs26) i(vs27) i(vs28) i(vs29)
print i(vs30) i(vs31) i(vs32) i(vs33) i(vs34) i(vs35) i(vs36) i(vs37) i(vs38) i(vs39)
print i(vs40) i(vs41) i(vs42) i(vs43) i(vs44) i(vs45) i(vs46) i(vs47) i(vs48) i(vs49)
print i(vs50)
.endc
.end
