controls oracle dc-0241
* Generated (plan F2.7, ADR 0012): do not edit; regenerate with `pnpm sim oracle regen`. dc seed 20261030 index 241 nodes 26 elements 46
.options sparse gmin=1e-12 noopac
RG1 1 0 1000000000000
RG2 2 0 1000000000000
RG3 3 0 1000000000000
RG4 4 0 1000000000000
RG5 5 0 1000000000000
RG6 6 0 1000000000000
RG7 7 0 1000000000000
RG8 8 0 1000000000000
RG9 9 0 1000000000000
RG10 10 0 1000000000000
RG11 11 0 1000000000000
RG12 12 0 1000000000000
RG13 13 0 1000000000000
RG14 14 0 1000000000000
RG15 15 0 1000000000000
RG16 16 0 1000000000000
RG17 17 0 1000000000000
RG18 18 0 1000000000000
RG19 19 0 1000000000000
RG20 20 0 1000000000000
RG21 21 0 1000000000000
RG22 22 0 1000000000000
RG23 23 0 1000000000000
RG24 24 0 1000000000000
RG25 25 0 1000000000000
VS0 0 s0 0
V0 e0 s0 DC 22e1
RI0 e0 25 82e-2
VS1 17 s1 0
R1 s1 5 47e-1
VS2 18 s2 0
R2 s2 14 82e3
VS3 11 s3 0
R3 s3 25 68e-2
VS4 22 s4 0
R4 s4 2 82e-2
VS5 24 s5 0
R5 s5 21 27e-1
VS6 17 s6 0
V6 e6 s6 DC 39e-1
RI6 e6 23 33e-3
VS7 6 s7 0
R7 s7 25 22e-1
VS8 8 s8 0
V8 e8 s8 DC 15e-1
RI8 e8 3 12e-2
VS9 24 s9 0
R9 s9 6 82e2
VS10 19 s10 0
R10 s10 25 68e-1
VS11 16 s11 0
R11 s11 23 27e2
VS12 0 s12 0
R12 s12 22 47e-2
VS13 19 s13 0
R13 s13 18 18e3
VS14 5 s14 0
R14 s14 16 22e-1
VS15 6 s15 0
R15 s15 0 12e3
VS16 12 s16 0
R16 s16 8 68e0
VS17 3 s17 0
I17 s17 24 DC 18e-1
VS18 0 s18 0
I18 s18 24 DC 56e-4
VS19 0 s19 0
I19 s19 3 DC 15e-3
VS20 13 s20 0
R20 s20 1 15e-1
VS21 22 s21 0
R21 s21 4 27e3
VS22 7 s22 0
R22 s22 14 82e-1
VS23 18 s23 0
R23 s23 20 39e3
VS24 2 s24 0
I24 s24 1 DC 18e-2
VS25 2 s25 0
I25 s25 12 DC 68e-3
VS26 10 s26 0
V26 e26 s26 DC 47e1
RI26 e26 14 47e-1
VS27 25 s27 0
R27 s27 16 27e-1
VS28 2 s28 0
R28 s28 16 18e-1
VS29 12 s29 0
R29 s29 22 15e1
VS30 2 s30 0
R30 s30 8 82e-1
VS31 13 s31 0
V31 e31 s31 DC 68e-1
RI31 e31 16 33e-3
VS32 18 s32 0
R32 s32 17 56e0
VS33 9 s33 0
R33 s33 12 33e3
VS34 19 s34 0
R34 s34 21 15e2
VS35 25 s35 0
R35 s35 4 68e3
VS36 12 s36 0
R36 s36 5 12e3
VS37 18 s37 0
R37 s37 20 47e-2
VS38 4 s38 0
I38 s38 17 DC 56e-3
VS39 10 s39 0
R39 s39 18 12e-1
VS40 22 s40 0
I40 s40 19 DC 47e-3
VS41 3 s41 0
R41 s41 0 15e-1
VS42 20 s42 0
I42 s42 22 DC 15e-1
VS43 15 s43 0
V43 e43 s43 DC 56e1
RI43 e43 6 12e-1
VS44 19 s44 0
R44 s44 1 56e3
VS45 24 s45 0
V45 e45 s45 DC 56e-1
RI45 e45 13 22e-2
.control
set numdgt=17
op
print v(1) v(2) v(3) v(4) v(5) v(6) v(7) v(8) v(9) v(10)
print v(11) v(12) v(13) v(14) v(15) v(16) v(17) v(18) v(19) v(20)
print v(21) v(22) v(23) v(24) v(25)
print i(vs0) i(vs1) i(vs2) i(vs3) i(vs4) i(vs5) i(vs6) i(vs7) i(vs8) i(vs9)
print i(vs10) i(vs11) i(vs12) i(vs13) i(vs14) i(vs15) i(vs16) i(vs17) i(vs18) i(vs19)
print i(vs20) i(vs21) i(vs22) i(vs23) i(vs24) i(vs25) i(vs26) i(vs27) i(vs28) i(vs29)
print i(vs30) i(vs31) i(vs32) i(vs33) i(vs34) i(vs35) i(vs36) i(vs37) i(vs38) i(vs39)
print i(vs40) i(vs41) i(vs42) i(vs43) i(vs44) i(vs45)
.endc
.end
