controls oracle dc-0310
* Generated (plan F2.7, ADR 0012): do not edit; regenerate with `pnpm sim oracle regen`. dc seed 20261030 index 310 nodes 30 elements 48
.options sparse gmin=1e-12 noopac
RG1 1 0 1000000000000
RG2 2 0 1000000000000
RG3 3 0 1000000000000
RG4 4 0 1000000000000
RG5 5 0 1000000000000
RG6 6 0 1000000000000
RG7 7 0 1000000000000
RG8 8 0 1000000000000
RG9 9 0 1000000000000
RG10 10 0 1000000000000
RG11 11 0 1000000000000
RG12 12 0 1000000000000
RG13 13 0 1000000000000
RG14 14 0 1000000000000
RG15 15 0 1000000000000
RG16 16 0 1000000000000
RG17 17 0 1000000000000
RG18 18 0 1000000000000
RG19 19 0 1000000000000
RG20 20 0 1000000000000
RG21 21 0 1000000000000
RG22 22 0 1000000000000
RG23 23 0 1000000000000
RG24 24 0 1000000000000
RG25 25 0 1000000000000
RG26 26 0 1000000000000
RG27 27 0 1000000000000
RG28 28 0 1000000000000
RG29 29 0 1000000000000
VS0 22 s0 0
R0 s0 27 22e1
VS1 8 s1 0
R1 s1 12 39e-2
VS2 10 s2 0
R2 s2 26 56e-1
VS3 0 s3 0
V3 e3 s3 DC 27e0
RI3 e3 28 22e-2
VS4 9 s4 0
R4 s4 0 18e1
VS5 15 s5 0
R5 s5 19 10e-1
VS6 21 s6 0
R6 s6 10 39e-2
VS7 21 s7 0
R7 s7 13 82e3
VS8 8 s8 0
R8 s8 29 82e2
VS9 13 s9 0
R9 s9 6 12e3
VS10 26 s10 0
R10 s10 10 18e3
VS11 13 s11 0
R11 s11 25 56e3
VS12 2 s12 0
R12 s12 4 39e-1
VS13 21 s13 0
I13 s13 18 DC 56e-4
VS14 13 s14 0
R14 s14 17 12e0
VS15 13 s15 0
R15 s15 23 33e2
VS16 20 s16 0
I16 s16 18 DC 15e-2
VS17 10 s17 0
R17 s17 12 39e1
VS18 17 s18 0
R18 s18 24 18e0
VS19 5 s19 0
R19 s19 18 33e3
VS20 16 s20 0
R20 s20 7 56e2
VS21 14 s21 0
R21 s21 6 68e-2
VS22 0 s22 0
R22 s22 2 12e-2
VS23 20 s23 0
I23 s23 17 DC 15e-1
VS24 19 s24 0
R24 s24 27 15e0
VS25 18 s25 0
R25 s25 0 68e3
VS26 18 s26 0
R26 s26 13 56e1
VS27 18 s27 0
V27 e27 s27 DC 82e1
RI27 e27 16 10e-2
VS28 15 s28 0
R28 s28 0 10e1
VS29 19 s29 0
R29 s29 5 12e-1
VS30 9 s30 0
V30 e30 s30 DC 47e1
RI30 e30 8 18e-3
VS31 9 s31 0
V31 e31 s31 DC 12e1
RI31 e31 10 22e-3
VS32 11 s32 0
I32 s32 21 DC 18e-4
VS33 19 s33 0
R33 s33 9 18e2
VS34 22 s34 0
I34 s34 19 DC 22e-2
VS35 15 s35 0
V35 e35 s35 DC 56e-1
RI35 e35 20 10e-3
VS36 0 s36 0
I36 s36 16 DC 33e-3
VS37 28 s37 0
R37 s37 2 47e2
VS38 26 s38 0
I38 s38 19 DC 82e-3
VS39 10 s39 0
I39 s39 9 DC 33e-2
VS40 1 s40 0
I40 s40 8 DC 15e-1
VS41 3 s41 0
R41 s41 22 47e-2
VS42 9 s42 0
I42 s42 22 DC 56e-3
VS43 13 s43 0
R43 s43 11 27e3
VS44 19 s44 0
I44 s44 26 DC 39e-2
VS45 13 s45 0
V45 e45 s45 DC 68e1
RI45 e45 27 56e-3
VS46 26 s46 0
V46 e46 s46 DC 22e-1
RI46 e46 4 18e-2
VS47 9 s47 0
R47 s47 1 22e-1
.control
set numdgt=17
op
print v(1) v(2) v(3) v(4) v(5) v(6) v(7) v(8) v(9) v(10)
print v(11) v(12) v(13) v(14) v(15) v(16) v(17) v(18) v(19) v(20)
print v(21) v(22) v(23) v(24) v(25) v(26) v(27) v(28) v(29)
print i(vs0) i(vs1) i(vs2) i(vs3) i(vs4) i(vs5) i(vs6) i(vs7) i(vs8) i(vs9)
print i(vs10) i(vs11) i(vs12) i(vs13) i(vs14) i(vs15) i(vs16) i(vs17) i(vs18) i(vs19)
print i(vs20) i(vs21) i(vs22) i(vs23) i(vs24) i(vs25) i(vs26) i(vs27) i(vs28) i(vs29)
print i(vs30) i(vs31) i(vs32) i(vs33) i(vs34) i(vs35) i(vs36) i(vs37) i(vs38) i(vs39)
print i(vs40) i(vs41) i(vs42) i(vs43) i(vs44) i(vs45) i(vs46) i(vs47)
.endc
.end
