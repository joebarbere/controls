controls oracle dc-0310
* Generated (plan F2.7, ADR 0012): do not edit; regenerate with `pnpm sim oracle regen`. dc seed 20261030 index 310 nodes 30 elements 56
.options sparse gmin=1e-12 noopac
RG1 1 0 1000000000000
RG2 2 0 1000000000000
RG3 3 0 1000000000000
RG4 4 0 1000000000000
RG5 5 0 1000000000000
RG6 6 0 1000000000000
RG7 7 0 1000000000000
RG8 8 0 1000000000000
RG9 9 0 1000000000000
RG10 10 0 1000000000000
RG11 11 0 1000000000000
RG12 12 0 1000000000000
RG13 13 0 1000000000000
RG14 14 0 1000000000000
RG15 15 0 1000000000000
RG16 16 0 1000000000000
RG17 17 0 1000000000000
RG18 18 0 1000000000000
RG19 19 0 1000000000000
RG20 20 0 1000000000000
RG21 21 0 1000000000000
RG22 22 0 1000000000000
RG23 23 0 1000000000000
RG24 24 0 1000000000000
RG25 25 0 1000000000000
RG26 26 0 1000000000000
RG27 27 0 1000000000000
RG28 28 0 1000000000000
RG29 29 0 1000000000000
VS0 28 s0 0
R0 s0 23 82e0
VS1 0 s1 0
V1 e1 s1 DC 12e1
RI1 e1 10 22e-3
VS2 15 s2 0
R2 s2 19 10e-1
VS3 21 s3 0
R3 s3 9 82e3
VS4 9 s4 0
R4 s4 23 33e2
VS5 13 s5 0
V5 e5 s5 DC 27e0
RI5 e5 28 22e-2
VS6 1 s6 0
I6 s6 8 DC 15e-1
VS7 17 s7 0
R7 s7 24 18e0
VS8 2 s8 0
R8 s8 4 39e-1
VS9 10 s9 0
R9 s9 26 56e-1
VS10 20 s10 0
I10 s10 17 DC 15e-1
VS11 5 s11 0
R11 s11 18 33e3
VS12 7 s12 0
R12 s12 24 39e3
VS13 22 s13 0
I13 s13 19 DC 22e-2
VS14 18 s14 0
V14 e14 s14 DC 82e1
RI14 e14 16 10e-2
VS15 9 s15 0
V15 e15 s15 DC 68e1
RI15 e15 27 56e-3
VS16 29 s16 0
V16 e16 s16 DC 56e1
RI16 e16 1 39e-3
VS17 13 s17 0
R17 s17 2 12e-2
VS18 26 s18 0
I18 s18 19 DC 82e-3
VS19 0 s19 0
R19 s19 1 22e-1
VS20 18 s20 0
R20 s20 13 68e3
VS21 3 s21 0
R21 s21 19 10e0
VS22 11 s22 0
I22 s22 21 DC 18e-4
VS23 21 s23 0
R23 s23 10 39e-2
VS24 26 s24 0
V24 e24 s24 DC 22e-1
RI24 e24 4 18e-2
VS25 19 s25 0
R25 s25 5 12e-1
VS26 3 s26 0
R26 s26 22 47e-2
VS27 15 s27 0
R27 s27 13 10e1
VS28 18 s28 0
R28 s28 9 56e1
VS29 19 s29 0
R29 s29 0 18e2
VS30 0 s30 0
R30 s30 13 18e1
VS31 16 s31 0
R31 s31 7 56e2
VS32 9 s32 0
R32 s32 20 39e-1
VS33 19 s33 0
I33 s33 26 DC 39e-2
VS34 0 s34 0
V34 e34 s34 DC 47e1
RI34 e34 8 18e-3
VS35 0 s35 0
I35 s35 22 DC 56e-3
VS36 26 s36 0
R36 s36 10 18e3
VS37 25 s37 0
R37 s37 29 15e-2
VS38 9 s38 0
R38 s38 11 27e3
VS39 28 s39 0
R39 s39 2 47e2
VS40 10 s40 0
I40 s40 0 DC 33e-2
VS41 21 s41 0
I41 s41 18 DC 56e-4
VS42 22 s42 0
R42 s42 27 22e1
VS43 14 s43 0
R43 s43 6 68e-2
VS44 8 s44 0
R44 s44 29 82e2
VS45 3 s45 0
R45 s45 14 47e3
VS46 9 s46 0
R46 s46 25 56e3
VS47 9 s47 0
R47 s47 6 12e3
VS48 8 s48 0
R48 s48 12 39e-2
VS49 15 s49 0
V49 e49 s49 DC 56e-1
RI49 e49 20 10e-3
VS50 19 s50 0
R50 s50 27 15e0
VS51 9 s51 0
R51 s51 17 12e0
VS52 10 s52 0
R52 s52 12 39e1
VS53 13 s53 0
I53 s53 16 DC 33e-3
VS54 20 s54 0
I54 s54 18 DC 15e-2
VS55 15 s55 0
V55 e55 s55 DC 15e-1
RI55 e55 11 18e-1
.control
set numdgt=17
op
print v(1) v(2) v(3) v(4) v(5) v(6) v(7) v(8) v(9) v(10)
print v(11) v(12) v(13) v(14) v(15) v(16) v(17) v(18) v(19) v(20)
print v(21) v(22) v(23) v(24) v(25) v(26) v(27) v(28) v(29)
print i(vs0) i(vs1) i(vs2) i(vs3) i(vs4) i(vs5) i(vs6) i(vs7) i(vs8) i(vs9)
print i(vs10) i(vs11) i(vs12) i(vs13) i(vs14) i(vs15) i(vs16) i(vs17) i(vs18) i(vs19)
print i(vs20) i(vs21) i(vs22) i(vs23) i(vs24) i(vs25) i(vs26) i(vs27) i(vs28) i(vs29)
print i(vs30) i(vs31) i(vs32) i(vs33) i(vs34) i(vs35) i(vs36) i(vs37) i(vs38) i(vs39)
print i(vs40) i(vs41) i(vs42) i(vs43) i(vs44) i(vs45) i(vs46) i(vs47) i(vs48) i(vs49)
print i(vs50) i(vs51) i(vs52) i(vs53) i(vs54) i(vs55)
.endc
.end
