controls oracle dc-0337
* Generated (plan F2.7, ADR 0012): do not edit; regenerate with `pnpm sim oracle regen`. dc seed 20261030 index 337 nodes 23 elements 36
.options sparse gmin=1e-12 noopac
RG1 1 0 1000000000000
RG2 2 0 1000000000000
RG3 3 0 1000000000000
RG4 4 0 1000000000000
RG5 5 0 1000000000000
RG6 6 0 1000000000000
RG7 7 0 1000000000000
RG8 8 0 1000000000000
RG9 9 0 1000000000000
RG10 10 0 1000000000000
RG11 11 0 1000000000000
RG12 12 0 1000000000000
RG13 13 0 1000000000000
RG14 14 0 1000000000000
RG15 15 0 1000000000000
RG16 16 0 1000000000000
RG17 17 0 1000000000000
RG18 18 0 1000000000000
RG19 19 0 1000000000000
RG20 20 0 1000000000000
RG21 21 0 1000000000000
RG22 22 0 1000000000000
VS0 1 s0 0
R0 s0 13 22e-1
VS1 10 s1 0
R1 s1 11 12e2
VS2 0 s2 0
R2 s2 19 15e0
VS3 8 s3 0
R3 s3 4 47e3
VS4 11 s4 0
I4 s4 17 DC 39e-4
VS5 10 s5 0
R5 s5 22 10e-1
VS6 0 s6 0
V6 e6 s6 DC 33e0
RI6 e6 9 47e-1
VS7 8 s7 0
R7 s7 15 12e-1
VS8 11 s8 0
R8 s8 18 12e1
VS9 21 s9 0
R9 s9 9 82e-2
VS10 18 s10 0
R10 s10 7 39e0
VS11 12 s11 0
R11 s11 10 68e1
VS12 5 s12 0
V12 e12 s12 DC 82e-1
RI12 e12 22 15e-1
VS13 0 s13 0
R13 s13 8 27e3
VS14 6 s14 0
R14 s14 8 68e2
VS15 2 s15 0
I15 s15 8 DC 22e-1
VS16 6 s16 0
V16 e16 s16 DC 18e0
RI16 e16 14 27e-2
VS17 0 s17 0
I17 s17 8 DC 10e-1
VS18 1 s18 0
V18 e18 s18 DC 12e0
RI18 e18 2 18e-3
VS19 19 s19 0
R19 s19 11 56e1
VS20 9 s20 0
R20 s20 20 82e2
VS21 0 s21 0
R21 s21 14 12e1
VS22 5 s22 0
R22 s22 20 10e3
VS23 13 s23 0
R23 s23 5 18e1
VS24 11 s24 0
R24 s24 7 33e0
VS25 10 s25 0
R25 s25 9 22e0
VS26 14 s26 0
R26 s26 19 10e0
VS27 5 s27 0
V27 e27 s27 DC 22e1
RI27 e27 2 39e-2
VS28 14 s28 0
R28 s28 20 39e3
VS29 16 s29 0
R29 s29 15 56e3
VS30 0 s30 0
R30 s30 19 22e0
VS31 1 s31 0
R31 s31 22 56e3
VS32 17 s32 0
R32 s32 8 18e0
VS33 3 s33 0
V33 e33 s33 DC 56e-1
RI33 e33 22 27e-2
VS34 8 s34 0
R34 s34 1 22e-2
VS35 3 s35 0
R35 s35 21 33e-2
.control
set numdgt=17
op
print v(1) v(2) v(3) v(4) v(5) v(6) v(7) v(8) v(9) v(10)
print v(11) v(12) v(13) v(14) v(15) v(16) v(17) v(18) v(19) v(20)
print v(21) v(22)
print i(vs0) i(vs1) i(vs2) i(vs3) i(vs4) i(vs5) i(vs6) i(vs7) i(vs8) i(vs9)
print i(vs10) i(vs11) i(vs12) i(vs13) i(vs14) i(vs15) i(vs16) i(vs17) i(vs18) i(vs19)
print i(vs20) i(vs21) i(vs22) i(vs23) i(vs24) i(vs25) i(vs26) i(vs27) i(vs28) i(vs29)
print i(vs30) i(vs31) i(vs32) i(vs33) i(vs34) i(vs35)
.endc
.end
