controls oracle dc-0337
* Generated (plan F2.7, ADR 0012): do not edit; regenerate with `pnpm sim oracle regen`. dc seed 20261030 index 337 nodes 23 elements 40
.options sparse gmin=1e-12 noopac
RG1 1 0 1000000000000
RG2 2 0 1000000000000
RG3 3 0 1000000000000
RG4 4 0 1000000000000
RG5 5 0 1000000000000
RG6 6 0 1000000000000
RG7 7 0 1000000000000
RG8 8 0 1000000000000
RG9 9 0 1000000000000
RG10 10 0 1000000000000
RG11 11 0 1000000000000
RG12 12 0 1000000000000
RG13 13 0 1000000000000
RG14 14 0 1000000000000
RG15 15 0 1000000000000
RG16 16 0 1000000000000
RG17 17 0 1000000000000
RG18 18 0 1000000000000
RG19 19 0 1000000000000
RG20 20 0 1000000000000
RG21 21 0 1000000000000
RG22 22 0 1000000000000
VS0 8 s0 0
R0 s0 15 12e-1
VS1 10 s1 0
R1 s1 9 22e0
VS2 9 s2 0
R2 s2 20 82e2
VS3 3 s3 0
R3 s3 19 15e0
VS4 12 s4 0
R4 s4 10 68e1
VS5 3 s5 0
R5 s5 8 27e3
VS6 8 s6 0
R6 s6 1 22e-2
VS7 0 s7 0
R7 s7 21 33e-2
VS8 14 s8 0
R8 s8 20 39e3
VS9 0 s9 0
V9 e9 s9 DC 56e-1
RI9 e9 22 27e-2
VS10 13 s10 0
R10 s10 5 18e1
VS11 6 s11 0
R11 s11 8 68e2
VS12 11 s12 0
R12 s12 18 12e1
VS13 5 s13 0
V13 e13 s13 DC 22e1
RI13 e13 2 39e-2
VS14 3 s14 0
R14 s14 19 22e0
VS15 8 s15 0
R15 s15 4 47e3
VS16 19 s16 0
R16 s16 11 56e1
VS17 1 s17 0
V17 e17 s17 DC 12e0
RI17 e17 2 18e-3
VS18 10 s18 0
R18 s18 22 10e-1
VS19 10 s19 0
R19 s19 11 12e2
VS20 5 s20 0
V20 e20 s20 DC 82e-1
RI20 e20 22 15e-1
VS21 3 s21 0
I21 s21 8 DC 10e-1
VS22 17 s22 0
R22 s22 8 18e0
VS23 4 s23 0
V23 e23 s23 DC 68e-1
RI23 e23 7 33e-2
VS24 1 s24 0
R24 s24 22 56e3
VS25 6 s25 0
V25 e25 s25 DC 18e0
RI25 e25 14 27e-2
VS26 3 s26 0
R26 s26 14 12e1
VS27 14 s27 0
R27 s27 16 15e0
VS28 18 s28 0
R28 s28 7 39e0
VS29 11 s29 0
R29 s29 7 33e0
VS30 3 s30 0
V30 e30 s30 DC 33e0
RI30 e30 9 47e-1
VS31 11 s31 0
I31 s31 17 DC 39e-4
VS32 18 s32 0
R32 s32 12 68e0
VS33 17 s33 0
R33 s33 12 27e1
VS34 2 s34 0
I34 s34 8 DC 22e-1
VS35 5 s35 0
R35 s35 20 10e3
VS36 1 s36 0
R36 s36 13 22e-1
VS37 14 s37 0
R37 s37 19 10e0
VS38 16 s38 0
R38 s38 15 56e3
VS39 21 s39 0
R39 s39 9 82e-2
.control
set numdgt=17
op
print v(1) v(2) v(3) v(4) v(5) v(6) v(7) v(8) v(9) v(10)
print v(11) v(12) v(13) v(14) v(15) v(16) v(17) v(18) v(19) v(20)
print v(21) v(22)
print i(vs0) i(vs1) i(vs2) i(vs3) i(vs4) i(vs5) i(vs6) i(vs7) i(vs8) i(vs9)
print i(vs10) i(vs11) i(vs12) i(vs13) i(vs14) i(vs15) i(vs16) i(vs17) i(vs18) i(vs19)
print i(vs20) i(vs21) i(vs22) i(vs23) i(vs24) i(vs25) i(vs26) i(vs27) i(vs28) i(vs29)
print i(vs30) i(vs31) i(vs32) i(vs33) i(vs34) i(vs35) i(vs36) i(vs37) i(vs38) i(vs39)
.endc
.end
