controls oracle dc-0087
* Generated (plan F2.7, ADR 0012): do not edit; regenerate with `pnpm sim oracle regen`. dc seed 20261030 index 87 nodes 19 elements 28
.options sparse gmin=1e-12 noopac
RG1 1 0 1000000000000
RG2 2 0 1000000000000
RG3 3 0 1000000000000
RG4 4 0 1000000000000
RG5 5 0 1000000000000
RG6 6 0 1000000000000
RG7 7 0 1000000000000
RG8 8 0 1000000000000
RG9 9 0 1000000000000
RG10 10 0 1000000000000
RG11 11 0 1000000000000
RG12 12 0 1000000000000
RG13 13 0 1000000000000
RG14 14 0 1000000000000
RG15 15 0 1000000000000
RG16 16 0 1000000000000
RG17 17 0 1000000000000
RG18 18 0 1000000000000
VS0 15 s0 0
R0 s0 14 39e3
VS1 17 s1 0
R1 s1 7 27e3
VS2 1 s2 0
R2 s2 3 18e-1
VS3 11 s3 0
R3 s3 4 33e3
VS4 1 s4 0
R4 s4 9 56e-1
VS5 10 s5 0
R5 s5 1 47e-1
VS6 2 s6 0
R6 s6 9 82e3
VS7 16 s7 0
R7 s7 11 47e0
VS8 16 s8 0
R8 s8 10 12e-1
VS9 8 s9 0
R9 s9 12 56e2
VS10 18 s10 0
R10 s10 3 47e2
VS11 15 s11 0
R11 s11 13 10e2
VS12 15 s12 0
R12 s12 17 15e-1
VS13 11 s13 0
R13 s13 7 56e2
VS14 8 s14 0
R14 s14 15 47e-2
VS15 5 s15 0
R15 s15 12 47e1
VS16 0 s16 0
V16 e16 s16 DC 47e-1
RI16 e16 13 33e-1
VS17 12 s17 0
R17 s17 7 39e1
VS18 4 s18 0
R18 s18 15 68e2
VS19 6 s19 0
R19 s19 5 56e1
VS20 5 s20 0
R20 s20 15 10e-1
VS21 16 s21 0
V21 e21 s21 DC 68e0
RI21 e21 9 10e-2
VS22 16 s22 0
R22 s22 0 27e1
VS23 18 s23 0
R23 s23 15 10e1
VS24 18 s24 0
R24 s24 7 27e0
VS25 18 s25 0
R25 s25 2 12e-2
VS26 6 s26 0
R26 s26 14 12e-1
VS27 1 s27 0
R27 s27 14 12e1
.control
set numdgt=17
op
print v(1) v(2) v(3) v(4) v(5) v(6) v(7) v(8) v(9) v(10)
print v(11) v(12) v(13) v(14) v(15) v(16) v(17) v(18)
print i(vs0) i(vs1) i(vs2) i(vs3) i(vs4) i(vs5) i(vs6) i(vs7) i(vs8) i(vs9)
print i(vs10) i(vs11) i(vs12) i(vs13) i(vs14) i(vs15) i(vs16) i(vs17) i(vs18) i(vs19)
print i(vs20) i(vs21) i(vs22) i(vs23) i(vs24) i(vs25) i(vs26) i(vs27)
.endc
.end
