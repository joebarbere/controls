controls oracle dc-0087
* Generated (plan F2.7, ADR 0012): do not edit; regenerate with `pnpm sim oracle regen`. dc seed 20261030 index 87 nodes 19 elements 20
.options sparse gmin=1e-12 noopac
RG1 1 0 1000000000000
RG2 2 0 1000000000000
RG3 3 0 1000000000000
RG4 4 0 1000000000000
RG5 5 0 1000000000000
RG6 6 0 1000000000000
RG7 7 0 1000000000000
RG8 8 0 1000000000000
RG9 9 0 1000000000000
RG10 10 0 1000000000000
RG11 11 0 1000000000000
RG12 12 0 1000000000000
RG13 13 0 1000000000000
RG14 14 0 1000000000000
RG15 15 0 1000000000000
RG16 16 0 1000000000000
RG17 17 0 1000000000000
RG18 18 0 1000000000000
VS0 11 s0 0
R0 s0 7 56e2
VS1 8 s1 0
R1 s1 15 47e-2
VS2 15 s2 0
R2 s2 17 15e-1
VS3 16 s3 0
R3 s3 15 10e1
VS4 2 s4 0
R4 s4 9 82e3
VS5 15 s5 0
R5 s5 13 10e2
VS6 15 s6 0
R6 s6 14 39e3
VS7 11 s7 0
R7 s7 4 33e3
VS8 10 s8 0
R8 s8 1 47e-1
VS9 16 s9 0
R9 s9 3 47e2
VS10 0 s10 0
R10 s10 18 27e1
VS11 16 s11 0
R11 s11 7 27e0
VS12 6 s12 0
R12 s12 14 12e-1
VS13 0 s13 0
R13 s13 11 47e0
VS14 1 s14 0
R14 s14 9 56e-1
VS15 12 s15 0
R15 s15 7 39e1
VS16 0 s16 0
V16 e16 s16 DC 68e0
RI16 e16 9 10e-2
VS17 5 s17 0
R17 s17 15 10e-1
VS18 0 s18 0
R18 s18 10 12e-1
VS19 16 s19 0
R19 s19 2 12e-2
.control
set numdgt=17
op
print v(1) v(2) v(3) v(4) v(5) v(6) v(7) v(8) v(9) v(10)
print v(11) v(12) v(13) v(14) v(15) v(16) v(17) v(18)
print i(vs0) i(vs1) i(vs2) i(vs3) i(vs4) i(vs5) i(vs6) i(vs7) i(vs8) i(vs9)
print i(vs10) i(vs11) i(vs12) i(vs13) i(vs14) i(vs15) i(vs16) i(vs17) i(vs18) i(vs19)
.endc
.end
