controls oracle dc-0220
* Generated (plan F2.7, ADR 0012): do not edit; regenerate with `pnpm sim oracle regen`. dc seed 20261030 index 220 nodes 21 elements 31
.options sparse gmin=1e-12 noopac
RG1 1 0 1000000000000
RG2 2 0 1000000000000
RG3 3 0 1000000000000
RG4 4 0 1000000000000
RG5 5 0 1000000000000
RG6 6 0 1000000000000
RG7 7 0 1000000000000
RG8 8 0 1000000000000
RG9 9 0 1000000000000
RG10 10 0 1000000000000
RG11 11 0 1000000000000
RG12 12 0 1000000000000
RG13 13 0 1000000000000
RG14 14 0 1000000000000
RG15 15 0 1000000000000
RG16 16 0 1000000000000
RG17 17 0 1000000000000
RG18 18 0 1000000000000
RG19 19 0 1000000000000
RG20 20 0 1000000000000
VS0 12 s0 0
R0 s0 3 33e3
VS1 8 s1 0
R1 s1 13 18e-2
VS2 1 s2 0
R2 s2 10 39e2
VS3 12 s3 0
R3 s3 1 82e-1
VS4 5 s4 0
R4 s4 18 18e1
VS5 7 s5 0
R5 s5 5 33e1
VS6 8 s6 0
R6 s6 6 47e-2
VS7 14 s7 0
I7 s7 13 DC 27e-4
VS8 5 s8 0
R8 s8 14 47e0
VS9 5 s9 0
R9 s9 17 27e-2
VS10 19 s10 0
R10 s10 18 10e1
VS11 20 s11 0
R11 s11 15 10e-1
VS12 7 s12 0
R12 s12 14 18e2
VS13 12 s13 0
R13 s13 13 33e2
VS14 16 s14 0
R14 s14 10 15e1
VS15 0 s15 0
V15 e15 s15 DC 12e1
RI15 e15 14 56e-1
VS16 0 s16 0
V16 e16 s16 DC 15e1
RI16 e16 3 82e-3
VS17 3 s17 0
V17 e17 s17 DC 56e-1
RI17 e17 4 22e-3
VS18 12 s18 0
R18 s18 7 33e-2
VS19 20 s19 0
R19 s19 0 12e2
VS20 8 s20 0
V20 e20 s20 DC 56e1
RI20 e20 0 82e-3
VS21 20 s21 0
R21 s21 9 82e-2
VS22 19 s22 0
R22 s22 12 39e-1
VS23 7 s23 0
V23 e23 s23 DC 15e-1
RI23 e23 4 39e-3
VS24 14 s24 0
R24 s24 15 10e1
VS25 6 s25 0
R25 s25 16 56e0
VS26 18 s26 0
R26 s26 20 56e1
VS27 2 s27 0
R27 s27 5 10e2
VS28 16 s28 0
R28 s28 5 10e2
VS29 17 s29 0
R29 s29 0 15e-1
VS30 11 s30 0
R30 s30 17 33e3
.control
set numdgt=17
op
print v(1) v(2) v(3) v(4) v(5) v(6) v(7) v(8) v(9) v(10)
print v(11) v(12) v(13) v(14) v(15) v(16) v(17) v(18) v(19) v(20)
print i(vs0) i(vs1) i(vs2) i(vs3) i(vs4) i(vs5) i(vs6) i(vs7) i(vs8) i(vs9)
print i(vs10) i(vs11) i(vs12) i(vs13) i(vs14) i(vs15) i(vs16) i(vs17) i(vs18) i(vs19)
print i(vs20) i(vs21) i(vs22) i(vs23) i(vs24) i(vs25) i(vs26) i(vs27) i(vs28) i(vs29)
print i(vs30)
.endc
.end
