controls oracle dc-0220
* Generated (plan F2.7, ADR 0012): do not edit; regenerate with `pnpm sim oracle regen`. dc seed 20261030 index 220 nodes 21 elements 34
.options sparse gmin=1e-12 noopac
RG1 1 0 1000000000000
RG2 2 0 1000000000000
RG3 3 0 1000000000000
RG4 4 0 1000000000000
RG5 5 0 1000000000000
RG6 6 0 1000000000000
RG7 7 0 1000000000000
RG8 8 0 1000000000000
RG9 9 0 1000000000000
RG10 10 0 1000000000000
RG11 11 0 1000000000000
RG12 12 0 1000000000000
RG13 13 0 1000000000000
RG14 14 0 1000000000000
RG15 15 0 1000000000000
RG16 16 0 1000000000000
RG17 17 0 1000000000000
RG18 18 0 1000000000000
RG19 19 0 1000000000000
RG20 20 0 1000000000000
VS0 11 s0 0
R0 s0 9 68e3
VS1 8 s1 0
R1 s1 6 47e-2
VS2 0 s2 0
V2 e2 s2 DC 15e-1
RI2 e2 4 39e-3
VS3 12 s3 0
R3 s3 0 33e-2
VS4 17 s4 0
R4 s4 20 15e-1
VS5 5 s5 0
R5 s5 17 27e-2
VS6 7 s6 0
R6 s6 2 39e1
VS7 0 s7 0
R7 s7 14 18e2
VS8 1 s8 0
R8 s8 10 39e2
VS9 12 s9 0
R9 s9 1 82e-1
VS10 2 s10 0
R10 s10 5 10e2
VS11 8 s11 0
V11 e11 s11 DC 56e1
RI11 e11 20 82e-3
VS12 12 s12 0
R12 s12 3 33e3
VS13 7 s13 0
R13 s13 9 82e-2
VS14 16 s14 0
R14 s14 10 15e1
VS15 12 s15 0
R15 s15 13 33e2
VS16 16 s16 0
R16 s16 11 10e-2
VS17 14 s17 0
I17 s17 13 DC 27e-4
VS18 19 s18 0
R18 s18 12 39e-1
VS19 20 s19 0
V19 e19 s19 DC 15e1
RI19 e19 3 82e-3
VS20 18 s20 0
R20 s20 7 56e1
VS21 19 s21 0
R21 s21 18 10e1
VS22 7 s22 0
R22 s22 15 10e-1
VS23 5 s23 0
R23 s23 14 47e0
VS24 14 s24 0
R24 s24 15 10e1
VS25 20 s25 0
V25 e25 s25 DC 12e1
RI25 e25 14 56e-1
VS26 0 s26 0
R26 s26 5 33e1
VS27 16 s27 0
R27 s27 5 10e2
VS28 8 s28 0
R28 s28 13 18e-2
VS29 6 s29 0
R29 s29 16 56e0
VS30 7 s30 0
R30 s30 20 12e2
VS31 3 s31 0
V31 e31 s31 DC 56e-1
RI31 e31 4 22e-3
VS32 5 s32 0
R32 s32 18 18e1
VS33 11 s33 0
R33 s33 17 33e3
.control
set numdgt=17
op
print v(1) v(2) v(3) v(4) v(5) v(6) v(7) v(8) v(9) v(10)
print v(11) v(12) v(13) v(14) v(15) v(16) v(17) v(18) v(19) v(20)
print i(vs0) i(vs1) i(vs2) i(vs3) i(vs4) i(vs5) i(vs6) i(vs7) i(vs8) i(vs9)
print i(vs10) i(vs11) i(vs12) i(vs13) i(vs14) i(vs15) i(vs16) i(vs17) i(vs18) i(vs19)
print i(vs20) i(vs21) i(vs22) i(vs23) i(vs24) i(vs25) i(vs26) i(vs27) i(vs28) i(vs29)
print i(vs30) i(vs31) i(vs32) i(vs33)
.endc
.end
