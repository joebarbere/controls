controls oracle dc-0118
* Generated (plan F2.7, ADR 0012): do not edit; regenerate with `pnpm sim oracle regen`. dc seed 20261030 index 118 nodes 29 elements 47
.options sparse gmin=1e-12 noopac
RG1 1 0 1000000000000
RG2 2 0 1000000000000
RG3 3 0 1000000000000
RG4 4 0 1000000000000
RG5 5 0 1000000000000
RG6 6 0 1000000000000
RG7 7 0 1000000000000
RG8 8 0 1000000000000
RG9 9 0 1000000000000
RG10 10 0 1000000000000
RG11 11 0 1000000000000
RG12 12 0 1000000000000
RG13 13 0 1000000000000
RG14 14 0 1000000000000
RG15 15 0 1000000000000
RG16 16 0 1000000000000
RG17 17 0 1000000000000
RG18 18 0 1000000000000
RG19 19 0 1000000000000
RG20 20 0 1000000000000
RG21 21 0 1000000000000
RG22 22 0 1000000000000
RG23 23 0 1000000000000
RG24 24 0 1000000000000
RG25 25 0 1000000000000
RG26 26 0 1000000000000
RG27 27 0 1000000000000
RG28 28 0 1000000000000
VS0 0 s0 0
I0 s0 12 DC 68e-1
VS1 18 s1 0
R1 s1 2 33e-1
VS2 0 s2 0
V2 e2 s2 DC 10e1
RI2 e2 11 56e-1
VS3 27 s3 0
R3 s3 0 33e-2
VS4 18 s4 0
R4 s4 16 68e2
VS5 6 s5 0
V5 e5 s5 DC 33e-1
RI5 e5 13 47e-2
VS6 25 s6 0
V6 e6 s6 DC 22e0
RI6 e6 17 15e-1
VS7 7 s7 0
V7 e7 s7 DC 22e-1
RI7 e7 8 56e-1
VS8 15 s8 0
R8 s8 20 22e-1
VS9 1 s9 0
R9 s9 10 12e-1
VS10 14 s10 0
R10 s10 8 82e-2
VS11 19 s11 0
R11 s11 11 82e-2
VS12 18 s12 0
R12 s12 22 10e0
VS13 28 s13 0
R13 s13 17 15e1
VS14 15 s14 0
R14 s14 8 10e-2
VS15 2 s15 0
R15 s15 21 33e-1
VS16 16 s16 0
R16 s16 11 39e0
VS17 6 s17 0
R17 s17 20 68e3
VS18 14 s18 0
I18 s18 22 DC 22e-2
VS19 20 s19 0
R19 s19 2 27e0
VS20 28 s20 0
R20 s20 26 33e-2
VS21 13 s21 0
R21 s21 14 27e1
VS22 4 s22 0
R22 s22 15 47e2
VS23 26 s23 0
R23 s23 3 18e3
VS24 12 s24 0
R24 s24 5 56e-2
VS25 12 s25 0
R25 s25 10 47e2
VS26 11 s26 0
R26 s26 8 33e1
VS27 3 s27 0
R27 s27 9 33e0
VS28 16 s28 0
V28 e28 s28 DC 47e-1
RI28 e28 24 18e-1
VS29 2 s29 0
I29 s29 7 DC 47e-3
VS30 0 s30 0
R30 s30 1 12e1
VS31 16 s31 0
R31 s31 15 56e0
VS32 5 s32 0
R32 s32 7 12e1
VS33 23 s33 0
R33 s33 12 27e-1
VS34 11 s34 0
R34 s34 26 68e2
VS35 23 s35 0
R35 s35 22 18e0
VS36 9 s36 0
R36 s36 19 56e0
VS37 13 s37 0
V37 e37 s37 DC 10e0
RI37 e37 3 68e-2
VS38 21 s38 0
R38 s38 13 33e-1
VS39 18 s39 0
R39 s39 5 22e3
VS40 24 s40 0
R40 s40 0 18e0
VS41 11 s41 0
R41 s41 21 27e-2
VS42 16 s42 0
R42 s42 9 33e-2
VS43 25 s43 0
R43 s43 4 10e1
VS44 27 s44 0
R44 s44 16 68e-1
VS45 10 s45 0
R45 s45 3 22e-2
VS46 24 s46 0
I46 s46 4 DC 56e-2
.control
set numdgt=17
op
print v(1) v(2) v(3) v(4) v(5) v(6) v(7) v(8) v(9) v(10)
print v(11) v(12) v(13) v(14) v(15) v(16) v(17) v(18) v(19) v(20)
print v(21) v(22) v(23) v(24) v(25) v(26) v(27) v(28)
print i(vs0) i(vs1) i(vs2) i(vs3) i(vs4) i(vs5) i(vs6) i(vs7) i(vs8) i(vs9)
print i(vs10) i(vs11) i(vs12) i(vs13) i(vs14) i(vs15) i(vs16) i(vs17) i(vs18) i(vs19)
print i(vs20) i(vs21) i(vs22) i(vs23) i(vs24) i(vs25) i(vs26) i(vs27) i(vs28) i(vs29)
print i(vs30) i(vs31) i(vs32) i(vs33) i(vs34) i(vs35) i(vs36) i(vs37) i(vs38) i(vs39)
print i(vs40) i(vs41) i(vs42) i(vs43) i(vs44) i(vs45) i(vs46)
.endc
.end
