controls oracle dc-0118
* Generated (plan F2.7, ADR 0012): do not edit; regenerate with `pnpm sim oracle regen`. dc seed 20261030 index 118 nodes 29 elements 35
.options sparse gmin=1e-12 noopac
RG1 1 0 1000000000000
RG2 2 0 1000000000000
RG3 3 0 1000000000000
RG4 4 0 1000000000000
RG5 5 0 1000000000000
RG6 6 0 1000000000000
RG7 7 0 1000000000000
RG8 8 0 1000000000000
RG9 9 0 1000000000000
RG10 10 0 1000000000000
RG11 11 0 1000000000000
RG12 12 0 1000000000000
RG13 13 0 1000000000000
RG14 14 0 1000000000000
RG15 15 0 1000000000000
RG16 16 0 1000000000000
RG17 17 0 1000000000000
RG18 18 0 1000000000000
RG19 19 0 1000000000000
RG20 20 0 1000000000000
RG21 21 0 1000000000000
RG22 22 0 1000000000000
RG23 23 0 1000000000000
RG24 24 0 1000000000000
RG25 25 0 1000000000000
RG26 26 0 1000000000000
RG27 27 0 1000000000000
RG28 28 0 1000000000000
VS0 18 s0 0
R0 s0 22 10e0
VS1 25 s1 0
R1 s1 4 10e1
VS2 24 s2 0
I2 s2 4 DC 56e-2
VS3 18 s3 0
R3 s3 16 68e2
VS4 0 s4 0
V4 e4 s4 DC 22e-1
RI4 e4 8 56e-1
VS5 16 s5 0
V5 e5 s5 DC 47e-1
RI5 e5 24 18e-1
VS6 27 s6 0
R6 s6 16 68e-1
VS7 2 s7 0
I7 s7 0 DC 47e-3
VS8 6 s8 0
R8 s8 20 68e3
VS9 20 s9 0
R9 s9 2 27e0
VS10 4 s10 0
R10 s10 15 47e2
VS11 12 s11 0
R11 s11 10 47e2
VS12 23 s12 0
R12 s12 22 18e0
VS13 15 s13 0
R13 s13 8 10e-2
VS14 16 s14 0
R14 s14 7 39e0
VS15 16 s15 0
R15 s15 9 33e-2
VS16 28 s16 0
R16 s16 26 33e-2
VS17 14 s17 0
I17 s17 22 DC 22e-2
VS18 28 s18 0
R18 s18 17 15e1
VS19 1 s19 0
R19 s19 10 12e-1
VS20 21 s20 0
R20 s20 13 33e-1
VS21 2 s21 0
R21 s21 21 33e-1
VS22 7 s22 0
R22 s22 8 33e1
VS23 16 s23 0
R23 s23 15 56e0
VS24 10 s24 0
R24 s24 3 22e-2
VS25 18 s25 0
R25 s25 2 33e-1
VS26 12 s26 0
R26 s26 5 56e-2
VS27 19 s27 0
R27 s27 7 82e-2
VS28 11 s28 0
I28 s28 12 DC 68e-1
VS29 24 s29 0
R29 s29 11 18e0
VS30 26 s30 0
R30 s30 3 18e3
VS31 7 s31 0
R31 s31 21 27e-2
VS32 7 s32 0
R32 s32 26 68e2
VS33 14 s33 0
R33 s33 8 82e-2
VS34 15 s34 0
R34 s34 20 22e-1
.control
set numdgt=17
op
print v(1) v(2) v(3) v(4) v(5) v(6) v(7) v(8) v(9) v(10)
print v(11) v(12) v(13) v(14) v(15) v(16) v(17) v(18) v(19) v(20)
print v(21) v(22) v(23) v(24) v(25) v(26) v(27) v(28)
print i(vs0) i(vs1) i(vs2) i(vs3) i(vs4) i(vs5) i(vs6) i(vs7) i(vs8) i(vs9)
print i(vs10) i(vs11) i(vs12) i(vs13) i(vs14) i(vs15) i(vs16) i(vs17) i(vs18) i(vs19)
print i(vs20) i(vs21) i(vs22) i(vs23) i(vs24) i(vs25) i(vs26) i(vs27) i(vs28) i(vs29)
print i(vs30) i(vs31) i(vs32) i(vs33) i(vs34)
.endc
.end
