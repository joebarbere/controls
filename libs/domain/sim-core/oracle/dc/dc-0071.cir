controls oracle dc-0071
* Generated (plan F2.7, ADR 0012): do not edit; regenerate with `pnpm sim oracle regen`. dc seed 20261030 index 71 nodes 14 elements 24
.options sparse gmin=1e-12 noopac
RG1 1 0 1000000000000
RG2 2 0 1000000000000
RG3 3 0 1000000000000
RG4 4 0 1000000000000
RG5 5 0 1000000000000
RG6 6 0 1000000000000
RG7 7 0 1000000000000
RG8 8 0 1000000000000
RG9 9 0 1000000000000
RG10 10 0 1000000000000
RG11 11 0 1000000000000
RG12 12 0 1000000000000
RG13 13 0 1000000000000
VS0 5 s0 0
R0 s0 10 15e-1
VS1 12 s1 0
R1 s1 0 68e-1
VS2 5 s2 0
I2 s2 12 DC 22e-3
VS3 12 s3 0
R3 s3 1 33e3
VS4 0 s4 0
V4 e4 s4 DC 10e-1
RI4 e4 13 18e-3
VS5 2 s5 0
R5 s5 8 10e2
VS6 8 s6 0
R6 s6 6 82e-1
VS7 3 s7 0
R7 s7 2 39e1
VS8 8 s8 0
I8 s8 0 DC 33e-2
VS9 4 s9 0
R9 s9 13 39e-2
VS10 13 s10 0
R10 s10 7 39e0
VS11 13 s11 0
R11 s11 5 27e0
VS12 11 s12 0
I12 s12 1 DC 22e-3
VS13 11 s13 0
R13 s13 4 15e1
VS14 5 s14 0
V14 e14 s14 DC 18e1
RI14 e14 11 18e-2
VS15 6 s15 0
V15 e15 s15 DC 39e1
RI15 e15 4 15e-1
VS16 6 s16 0
R16 s16 11 56e-2
VS17 10 s17 0
V17 e17 s17 DC 12e0
RI17 e17 12 39e-3
VS18 13 s18 0
R18 s18 9 22e1
VS19 0 s19 0
I19 s19 9 DC 22e-2
VS20 8 s20 0
R20 s20 4 22e1
VS21 0 s21 0
R21 s21 3 22e2
VS22 9 s22 0
R22 s22 1 47e-1
VS23 7 s23 0
R23 s23 3 68e0
.control
set numdgt=17
op
print v(1) v(2) v(3) v(4) v(5) v(6) v(7) v(8) v(9) v(10)
print v(11) v(12) v(13)
print i(vs0) i(vs1) i(vs2) i(vs3) i(vs4) i(vs5) i(vs6) i(vs7) i(vs8) i(vs9)
print i(vs10) i(vs11) i(vs12) i(vs13) i(vs14) i(vs15) i(vs16) i(vs17) i(vs18) i(vs19)
print i(vs20) i(vs21) i(vs22) i(vs23)
.endc
.end
