controls oracle dc-0071
* Generated (plan F2.7, ADR 0012): do not edit; regenerate with `pnpm sim oracle regen`. dc seed 20261030 index 71 nodes 14 elements 23
.options sparse gmin=1e-12 noopac
RG1 1 0 1000000000000
RG2 2 0 1000000000000
RG3 3 0 1000000000000
RG4 4 0 1000000000000
RG5 5 0 1000000000000
RG6 6 0 1000000000000
RG7 7 0 1000000000000
RG8 8 0 1000000000000
RG9 9 0 1000000000000
RG10 10 0 1000000000000
RG11 11 0 1000000000000
RG12 12 0 1000000000000
RG13 13 0 1000000000000
VS0 5 s0 0
R0 s0 10 15e-1
VS1 11 s1 0
I1 s1 1 DC 22e-3
VS2 2 s2 0
R2 s2 8 10e2
VS3 3 s3 0
I3 s3 9 DC 22e-2
VS4 5 s4 0
I4 s4 12 DC 22e-3
VS5 8 s5 0
R5 s5 4 22e1
VS6 13 s6 0
R6 s6 7 39e0
VS7 4 s7 0
R7 s7 13 39e-2
VS8 12 s8 0
R8 s8 3 68e-1
VS9 8 s9 0
R9 s9 0 82e-1
VS10 0 s10 0
V10 e10 s10 DC 39e1
RI10 e10 4 15e-1
VS11 9 s11 0
R11 s11 1 47e-1
VS12 13 s12 0
R12 s12 5 27e0
VS13 5 s13 0
V13 e13 s13 DC 18e1
RI13 e13 11 18e-2
VS14 10 s14 0
V14 e14 s14 DC 12e0
RI14 e14 12 39e-3
VS15 3 s15 0
V15 e15 s15 DC 10e-1
RI15 e15 13 18e-3
VS16 8 s16 0
I16 s16 3 DC 33e-2
VS17 13 s17 0
R17 s17 9 22e1
VS18 3 s18 0
R18 s18 6 22e2
VS19 0 s19 0
R19 s19 11 56e-2
VS20 6 s20 0
R20 s20 2 39e1
VS21 7 s21 0
R21 s21 6 68e0
VS22 11 s22 0
R22 s22 4 15e1
.control
set numdgt=17
op
print v(1) v(2) v(3) v(4) v(5) v(6) v(7) v(8) v(9) v(10)
print v(11) v(12) v(13)
print i(vs0) i(vs1) i(vs2) i(vs3) i(vs4) i(vs5) i(vs6) i(vs7) i(vs8) i(vs9)
print i(vs10) i(vs11) i(vs12) i(vs13) i(vs14) i(vs15) i(vs16) i(vs17) i(vs18) i(vs19)
print i(vs20) i(vs21) i(vs22)
.endc
.end
