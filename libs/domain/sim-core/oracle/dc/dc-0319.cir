controls oracle dc-0319
* Generated (plan F2.7, ADR 0012): do not edit; regenerate with `pnpm sim oracle regen`. dc seed 20261030 index 319 nodes 24 elements 36
.options sparse gmin=1e-12 noopac
RG1 1 0 1000000000000
RG2 2 0 1000000000000
RG3 3 0 1000000000000
RG4 4 0 1000000000000
RG5 5 0 1000000000000
RG6 6 0 1000000000000
RG7 7 0 1000000000000
RG8 8 0 1000000000000
RG9 9 0 1000000000000
RG10 10 0 1000000000000
RG11 11 0 1000000000000
RG12 12 0 1000000000000
RG13 13 0 1000000000000
RG14 14 0 1000000000000
RG15 15 0 1000000000000
RG16 16 0 1000000000000
RG17 17 0 1000000000000
RG18 18 0 1000000000000
RG19 19 0 1000000000000
RG20 20 0 1000000000000
RG21 21 0 1000000000000
RG22 22 0 1000000000000
RG23 23 0 1000000000000
VS0 20 s0 0
I0 s0 16 DC 39e-4
VS1 16 s1 0
R1 s1 19 68e1
VS2 2 s2 0
I2 s2 1 DC 68e-4
VS3 0 s3 0
V3 e3 s3 DC 82e1
RI3 e3 17 15e-3
VS4 20 s4 0
R4 s4 13 33e-1
VS5 18 s5 0
V5 e5 s5 DC 47e1
RI5 e5 22 15e-2
VS6 18 s6 0
V6 e6 s6 DC 82e-1
RI6 e6 8 56e-1
VS7 10 s7 0
R7 s7 12 33e0
VS8 18 s8 0
R8 s8 16 56e0
VS9 7 s9 0
I9 s9 18 DC 27e-2
VS10 4 s10 0
R10 s10 20 56e2
VS11 9 s11 0
V11 e11 s11 DC 39e1
RI11 e11 15 56e-3
VS12 12 s12 0
I12 s12 3 DC 27e-1
VS13 19 s13 0
R13 s13 3 27e-2
VS14 11 s14 0
V14 e14 s14 DC 27e1
RI14 e14 4 47e-1
VS15 20 s15 0
R15 s15 0 68e2
VS16 5 s16 0
R16 s16 14 18e2
VS17 7 s17 0
R17 s17 10 56e1
VS18 0 s18 0
R18 s18 20 22e1
VS19 4 s19 0
R19 s19 6 27e2
VS20 9 s20 0
R20 s20 0 56e1
VS21 23 s21 0
R21 s21 2 10e-1
VS22 1 s22 0
R22 s22 18 33e1
VS23 14 s23 0
R23 s23 0 56e2
VS24 2 s24 0
R24 s24 22 12e1
VS25 10 s25 0
I25 s25 23 DC 15e-2
VS26 11 s26 0
V26 e26 s26 DC 10e0
RI26 e26 4 82e-2
VS27 5 s27 0
V27 e27 s27 DC 12e-1
RI27 e27 19 33e-1
VS28 12 s28 0
V28 e28 s28 DC 68e0
RI28 e28 9 68e-1
VS29 14 s29 0
I29 s29 13 DC 12e-3
VS30 15 s30 0
V30 e30 s30 DC 10e1
RI30 e30 19 12e-3
VS31 20 s31 0
R31 s31 6 12e0
VS32 3 s32 0
V32 e32 s32 DC 39e1
RI32 e32 23 12e-1
VS33 20 s33 0
V33 e33 s33 DC 33e0
RI33 e33 16 56e-3
VS34 18 s34 0
R34 s34 21 39e3
VS35 17 s35 0
R35 s35 1 18e3
.control
set numdgt=17
op
print v(1) v(2) v(3) v(4) v(5) v(6) v(7) v(8) v(9) v(10)
print v(11) v(12) v(13) v(14) v(15) v(16) v(17) v(18) v(19) v(20)
print v(21) v(22) v(23)
print i(vs0) i(vs1) i(vs2) i(vs3) i(vs4) i(vs5) i(vs6) i(vs7) i(vs8) i(vs9)
print i(vs10) i(vs11) i(vs12) i(vs13) i(vs14) i(vs15) i(vs16) i(vs17) i(vs18) i(vs19)
print i(vs20) i(vs21) i(vs22) i(vs23) i(vs24) i(vs25) i(vs26) i(vs27) i(vs28) i(vs29)
print i(vs30) i(vs31) i(vs32) i(vs33) i(vs34) i(vs35)
.endc
.end
