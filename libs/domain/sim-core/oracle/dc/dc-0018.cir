controls oracle dc-0018
* Generated (plan F2.7, ADR 0012): do not edit; regenerate with `pnpm sim oracle regen`. dc seed 20261030 index 18 nodes 25 elements 45
.options sparse gmin=1e-12 noopac
RG1 1 0 1000000000000
RG2 2 0 1000000000000
RG3 3 0 1000000000000
RG4 4 0 1000000000000
RG5 5 0 1000000000000
RG6 6 0 1000000000000
RG7 7 0 1000000000000
RG8 8 0 1000000000000
RG9 9 0 1000000000000
RG10 10 0 1000000000000
RG11 11 0 1000000000000
RG12 12 0 1000000000000
RG13 13 0 1000000000000
RG14 14 0 1000000000000
RG15 15 0 1000000000000
RG16 16 0 1000000000000
RG17 17 0 1000000000000
RG18 18 0 1000000000000
RG19 19 0 1000000000000
RG20 20 0 1000000000000
RG21 21 0 1000000000000
RG22 22 0 1000000000000
RG23 23 0 1000000000000
RG24 24 0 1000000000000
VS0 0 s0 0
V0 e0 s0 DC 22e0
RI0 e0 16 56e-2
VS1 20 s1 0
R1 s1 15 56e3
VS2 21 s2 0
R2 s2 5 12e-2
VS3 3 s3 0
I3 s3 18 DC 82e-4
VS4 20 s4 0
R4 s4 22 82e1
VS5 17 s5 0
V5 e5 s5 DC 22e1
RI5 e5 19 12e-3
VS6 3 s6 0
V6 e6 s6 DC 15e-1
RI6 e6 11 68e-2
VS7 24 s7 0
I7 s7 3 DC 68e-1
VS8 18 s8 0
V8 e8 s8 DC 82e-1
RI8 e8 8 33e-1
VS9 13 s9 0
I9 s9 5 DC 68e-1
VS10 14 s10 0
R10 s10 1 22e2
VS11 21 s11 0
R11 s11 17 12e0
VS12 0 s12 0
R12 s12 22 18e1
VS13 4 s13 0
R13 s13 13 12e1
VS14 1 s14 0
R14 s14 10 39e1
VS15 0 s15 0
R15 s15 3 39e-2
VS16 3 s16 0
V16 e16 s16 DC 22e1
RI16 e16 6 10e-2
VS17 20 s17 0
V17 e17 s17 DC 47e1
RI17 e17 2 39e-2
VS18 12 s18 0
R18 s18 17 56e3
VS19 3 s19 0
R19 s19 18 10e-1
VS20 9 s20 0
R20 s20 24 22e1
VS21 21 s21 0
R21 s21 11 15e2
VS22 2 s22 0
R22 s22 18 47e-1
VS23 9 s23 0
R23 s23 20 22e2
VS24 10 s24 0
R24 s24 9 33e3
VS25 17 s25 0
R25 s25 0 22e2
VS26 16 s26 0
R26 s26 23 12e1
VS27 10 s27 0
V27 e27 s27 DC 82e0
RI27 e27 0 33e-3
VS28 18 s28 0
V28 e28 s28 DC 39e1
RI28 e28 8 18e-1
VS29 6 s29 0
R29 s29 17 56e3
VS30 7 s30 0
R30 s30 5 47e0
VS31 22 s31 0
R31 s31 12 27e3
VS32 15 s32 0
R32 s32 9 15e3
VS33 10 s33 0
R33 s33 0 15e-1
VS34 19 s34 0
R34 s34 0 15e-2
VS35 14 s35 0
R35 s35 16 27e2
VS36 5 s36 0
I36 s36 3 DC 39e-1
VS37 21 s37 0
R37 s37 12 18e2
VS38 24 s38 0
R38 s38 8 27e3
VS39 7 s39 0
R39 s39 3 56e0
VS40 4 s40 0
R40 s40 16 68e-2
VS41 17 s41 0
R41 s41 8 15e3
VS42 23 s42 0
R42 s42 18 68e1
VS43 19 s43 0
R43 s43 5 33e-2
VS44 8 s44 0
R44 s44 13 27e-2
.control
set numdgt=17
op
print v(1) v(2) v(3) v(4) v(5) v(6) v(7) v(8) v(9) v(10)
print v(11) v(12) v(13) v(14) v(15) v(16) v(17) v(18) v(19) v(20)
print v(21) v(22) v(23) v(24)
print i(vs0) i(vs1) i(vs2) i(vs3) i(vs4) i(vs5) i(vs6) i(vs7) i(vs8) i(vs9)
print i(vs10) i(vs11) i(vs12) i(vs13) i(vs14) i(vs15) i(vs16) i(vs17) i(vs18) i(vs19)
print i(vs20) i(vs21) i(vs22) i(vs23) i(vs24) i(vs25) i(vs26) i(vs27) i(vs28) i(vs29)
print i(vs30) i(vs31) i(vs32) i(vs33) i(vs34) i(vs35) i(vs36) i(vs37) i(vs38) i(vs39)
print i(vs40) i(vs41) i(vs42) i(vs43) i(vs44)
.endc
.end
