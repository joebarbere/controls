controls oracle dc-0018
* Generated (plan F2.7, ADR 0012): do not edit; regenerate with `pnpm sim oracle regen`. dc seed 20261030 index 18 nodes 25 elements 42
.options sparse gmin=1e-12 noopac
RG1 1 0 1000000000000
RG2 2 0 1000000000000
RG3 3 0 1000000000000
RG4 4 0 1000000000000
RG5 5 0 1000000000000
RG6 6 0 1000000000000
RG7 7 0 1000000000000
RG8 8 0 1000000000000
RG9 9 0 1000000000000
RG10 10 0 1000000000000
RG11 11 0 1000000000000
RG12 12 0 1000000000000
RG13 13 0 1000000000000
RG14 14 0 1000000000000
RG15 15 0 1000000000000
RG16 16 0 1000000000000
RG17 17 0 1000000000000
RG18 18 0 1000000000000
RG19 19 0 1000000000000
RG20 20 0 1000000000000
RG21 21 0 1000000000000
RG22 22 0 1000000000000
RG23 23 0 1000000000000
RG24 24 0 1000000000000
VS0 24 s0 0
R0 s0 8 27e3
VS1 19 s1 0
R1 s1 5 33e-2
VS2 9 s2 0
R2 s2 20 22e2
VS3 0 s3 0
V3 e3 s3 DC 22e0
RI3 e3 16 56e-2
VS4 21 s4 0
R4 s4 5 12e-2
VS5 3 s5 0
V5 e5 s5 DC 15e-1
RI5 e5 11 68e-2
VS6 21 s6 0
R6 s6 11 15e2
VS7 22 s7 0
R7 s7 12 27e3
VS8 20 s8 0
R8 s8 22 82e1
VS9 8 s9 0
R9 s9 13 27e-2
VS10 21 s10 0
R10 s10 17 12e0
VS11 21 s11 0
R11 s11 12 18e2
VS12 10 s12 0
R12 s12 0 15e-1
VS13 17 s13 0
R13 s13 0 22e2
VS14 4 s14 0
R14 s14 16 68e-2
VS15 3 s15 0
V15 e15 s15 DC 22e1
RI15 e15 6 10e-2
VS16 10 s16 0
V16 e16 s16 DC 82e0
RI16 e16 0 33e-3
VS17 7 s17 0
R17 s17 5 47e0
VS18 18 s18 0
V18 e18 s18 DC 82e-1
RI18 e18 8 33e-1
VS19 17 s19 0
R19 s19 8 15e3
VS20 18 s20 0
V20 e20 s20 DC 39e1
RI20 e20 8 18e-1
VS21 19 s21 0
R21 s21 0 15e-2
VS22 1 s22 0
R22 s22 10 39e1
VS23 23 s23 0
R23 s23 18 68e1
VS24 20 s24 0
V24 e24 s24 DC 47e1
RI24 e24 2 39e-2
VS25 7 s25 0
R25 s25 3 56e0
VS26 24 s26 0
I26 s26 3 DC 68e-1
VS27 3 s27 0
I27 s27 18 DC 82e-4
VS28 10 s28 0
R28 s28 9 33e3
VS29 15 s29 0
R29 s29 9 15e3
VS30 14 s30 0
R30 s30 1 22e2
VS31 5 s31 0
I31 s31 3 DC 39e-1
VS32 13 s32 0
I32 s32 5 DC 68e-1
VS33 17 s33 0
V33 e33 s33 DC 22e1
RI33 e33 19 12e-3
VS34 0 s34 0
R34 s34 22 18e1
VS35 3 s35 0
R35 s35 18 10e-1
VS36 2 s36 0
R36 s36 18 47e-1
VS37 0 s37 0
R37 s37 3 39e-2
VS38 9 s38 0
R38 s38 24 22e1
VS39 14 s39 0
R39 s39 16 27e2
VS40 6 s40 0
R40 s40 17 56e3
VS41 12 s41 0
R41 s41 17 56e3
.control
set numdgt=17
op
print v(1) v(2) v(3) v(4) v(5) v(6) v(7) v(8) v(9) v(10)
print v(11) v(12) v(13) v(14) v(15) v(16) v(17) v(18) v(19) v(20)
print v(21) v(22) v(23) v(24)
print i(vs0) i(vs1) i(vs2) i(vs3) i(vs4) i(vs5) i(vs6) i(vs7) i(vs8) i(vs9)
print i(vs10) i(vs11) i(vs12) i(vs13) i(vs14) i(vs15) i(vs16) i(vs17) i(vs18) i(vs19)
print i(vs20) i(vs21) i(vs22) i(vs23) i(vs24) i(vs25) i(vs26) i(vs27) i(vs28) i(vs29)
print i(vs30) i(vs31) i(vs32) i(vs33) i(vs34) i(vs35) i(vs36) i(vs37) i(vs38) i(vs39)
print i(vs40) i(vs41)
.endc
.end
