controls oracle dc-0358
* Generated (plan F2.7, ADR 0012): do not edit; regenerate with `pnpm sim oracle regen`. dc seed 20261030 index 358 nodes 10 elements 13
.options sparse gmin=1e-12 noopac
RG1 1 0 1000000000000
RG2 2 0 1000000000000
RG3 3 0 1000000000000
RG4 4 0 1000000000000
RG5 5 0 1000000000000
RG6 6 0 1000000000000
RG7 7 0 1000000000000
RG8 8 0 1000000000000
RG9 9 0 1000000000000
VS0 8 s0 0
R0 s0 2 10e-1
VS1 5 s1 0
R1 s1 3 22e1
VS2 0 s2 0
V2 e2 s2 DC 47e-1
RI2 e2 3 12e-3
VS3 8 s3 0
I3 s3 2 DC 68e-3
VS4 7 s4 0
R4 s4 1 27e2
VS5 4 s5 0
R5 s5 2 39e2
VS6 7 s6 0
R6 s6 6 18e1
VS7 6 s7 0
R7 s7 8 47e2
VS8 8 s8 0
R8 s8 3 56e-2
VS9 5 s9 0
R9 s9 2 22e3
VS10 2 s10 0
R10 s10 9 33e-2
VS11 6 s11 0
R11 s11 9 68e3
VS12 5 s12 0
R12 s12 9 68e-2
.control
set numdgt=17
op
print v(1) v(2) v(3) v(4) v(5) v(6) v(7) v(8) v(9)
print i(vs0) i(vs1) i(vs2) i(vs3) i(vs4) i(vs5) i(vs6) i(vs7) i(vs8) i(vs9)
print i(vs10) i(vs11) i(vs12)
.endc
.end
