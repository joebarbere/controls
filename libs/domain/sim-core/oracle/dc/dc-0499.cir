controls oracle dc-0499
* Generated (plan F2.7, ADR 0012): do not edit; regenerate with `pnpm sim oracle regen`. dc seed 20261030 index 499 nodes 23 elements 37
.options sparse gmin=1e-12 noopac
RG1 1 0 1000000000000
RG2 2 0 1000000000000
RG3 3 0 1000000000000
RG4 4 0 1000000000000
RG5 5 0 1000000000000
RG6 6 0 1000000000000
RG7 7 0 1000000000000
RG8 8 0 1000000000000
RG9 9 0 1000000000000
RG10 10 0 1000000000000
RG11 11 0 1000000000000
RG12 12 0 1000000000000
RG13 13 0 1000000000000
RG14 14 0 1000000000000
RG15 15 0 1000000000000
RG16 16 0 1000000000000
RG17 17 0 1000000000000
RG18 18 0 1000000000000
RG19 19 0 1000000000000
RG20 20 0 1000000000000
RG21 21 0 1000000000000
RG22 22 0 1000000000000
VS0 17 s0 0
I0 s0 12 DC 39e-1
VS1 14 s1 0
R1 s1 11 39e0
VS2 4 s2 0
R2 s2 7 22e2
VS3 2 s3 0
R3 s3 10 18e-1
VS4 13 s4 0
R4 s4 12 15e1
VS5 19 s5 0
R5 s5 14 82e-2
VS6 4 s6 0
R6 s6 18 18e0
VS7 6 s7 0
I7 s7 16 DC 12e-1
VS8 0 s8 0
V8 e8 s8 DC 18e0
RI8 e8 20 68e-2
VS9 21 s9 0
R9 s9 1 33e1
VS10 12 s10 0
R10 s10 21 56e2
VS11 11 s11 0
R11 s11 4 18e-1
VS12 22 s12 0
R12 s12 4 10e1
VS13 15 s13 0
R13 s13 10 12e1
VS14 3 s14 0
R14 s14 6 15e0
VS15 5 s15 0
R15 s15 12 18e1
VS16 10 s16 0
R16 s16 6 47e-2
VS17 7 s17 0
V17 e17 s17 DC 56e0
RI17 e17 19 10e-3
VS18 11 s18 0
V18 e18 s18 DC 47e0
RI18 e18 22 12e-3
VS19 0 s19 0
R19 s19 3 15e-2
VS20 4 s20 0
V20 e20 s20 DC 56e1
RI20 e20 15 68e-1
VS21 14 s21 0
R21 s21 1 22e2
VS22 5 s22 0
V22 e22 s22 DC 56e1
RI22 e22 18 68e-2
VS23 8 s23 0
V23 e23 s23 DC 33e1
RI23 e23 14 56e-1
VS24 9 s24 0
R24 s24 1 12e-2
VS25 17 s25 0
R25 s25 20 12e3
VS26 15 s26 0
I26 s26 12 DC 27e-1
VS27 13 s27 0
V27 e27 s27 DC 68e-1
RI27 e27 3 12e-2
VS28 20 s28 0
R28 s28 3 47e0
VS29 20 s29 0
R29 s29 16 27e0
VS30 22 s30 0
I30 s30 14 DC 56e-4
VS31 17 s31 0
R31 s31 16 56e0
VS32 12 s32 0
R32 s32 16 82e-1
VS33 3 s33 0
R33 s33 21 39e-1
VS34 8 s34 0
R34 s34 2 12e3
VS35 9 s35 0
R35 s35 12 18e0
VS36 5 s36 0
V36 e36 s36 DC 10e1
RI36 e36 19 82e-1
.control
set numdgt=17
op
print v(1) v(2) v(3) v(4) v(5) v(6) v(7) v(8) v(9) v(10)
print v(11) v(12) v(13) v(14) v(15) v(16) v(17) v(18) v(19) v(20)
print v(21) v(22)
print i(vs0) i(vs1) i(vs2) i(vs3) i(vs4) i(vs5) i(vs6) i(vs7) i(vs8) i(vs9)
print i(vs10) i(vs11) i(vs12) i(vs13) i(vs14) i(vs15) i(vs16) i(vs17) i(vs18) i(vs19)
print i(vs20) i(vs21) i(vs22) i(vs23) i(vs24) i(vs25) i(vs26) i(vs27) i(vs28) i(vs29)
print i(vs30) i(vs31) i(vs32) i(vs33) i(vs34) i(vs35) i(vs36)
.endc
.end
