controls oracle dc-0499
* Generated (plan F2.7, ADR 0012): do not edit; regenerate with `pnpm sim oracle regen`. dc seed 20261030 index 499 nodes 23 elements 28
.options sparse gmin=1e-12 noopac
RG1 1 0 1000000000000
RG2 2 0 1000000000000
RG3 3 0 1000000000000
RG4 4 0 1000000000000
RG5 5 0 1000000000000
RG6 6 0 1000000000000
RG7 7 0 1000000000000
RG8 8 0 1000000000000
RG9 9 0 1000000000000
RG10 10 0 1000000000000
RG11 11 0 1000000000000
RG12 12 0 1000000000000
RG13 13 0 1000000000000
RG14 14 0 1000000000000
RG15 15 0 1000000000000
RG16 16 0 1000000000000
RG17 17 0 1000000000000
RG18 18 0 1000000000000
RG19 19 0 1000000000000
RG20 20 0 1000000000000
RG21 21 0 1000000000000
RG22 22 0 1000000000000
VS0 6 s0 0
I0 s0 16 DC 12e-1
VS1 13 s1 0
R1 s1 1 33e1
VS2 17 s2 0
R2 s2 20 12e3
VS3 0 s3 0
V3 e3 s3 DC 68e-1
RI3 e3 3 12e-2
VS4 2 s4 0
R4 s4 10 18e-1
VS5 5 s5 0
V5 e5 s5 DC 56e1
RI5 e5 18 68e-2
VS6 17 s6 0
I6 s6 12 DC 39e-1
VS7 4 s7 0
R7 s7 18 18e0
VS8 8 s8 0
V8 e8 s8 DC 33e1
RI8 e8 14 56e-1
VS9 5 s9 0
R9 s9 12 18e1
VS10 15 s10 0
R10 s10 10 12e1
VS11 14 s11 0
R11 s11 1 22e2
VS12 3 s12 0
R12 s12 6 15e0
VS13 12 s13 0
R13 s13 13 56e2
VS14 14 s14 0
R14 s14 11 39e0
VS15 3 s15 0
R15 s15 13 39e-1
VS16 4 s16 0
R16 s16 7 22e2
VS17 15 s17 0
I17 s17 12 DC 27e-1
VS18 20 s18 0
R18 s18 16 27e0
VS19 12 s19 0
R19 s19 16 82e-1
VS20 19 s20 0
R20 s20 14 82e-2
VS21 20 s21 0
R21 s21 3 47e0
VS22 9 s22 0
R22 s22 1 12e-2
VS23 21 s23 0
R23 s23 3 15e-2
VS24 4 s24 0
V24 e24 s24 DC 56e1
RI24 e24 15 68e-1
VS25 10 s25 0
R25 s25 6 47e-2
VS26 22 s26 0
I26 s26 14 DC 56e-4
VS27 22 s27 0
R27 s27 4 10e1
.control
set numdgt=17
op
print v(1) v(2) v(3) v(4) v(5) v(6) v(7) v(8) v(9) v(10)
print v(11) v(12) v(13) v(14) v(15) v(16) v(17) v(18) v(19) v(20)
print v(21) v(22)
print i(vs0) i(vs1) i(vs2) i(vs3) i(vs4) i(vs5) i(vs6) i(vs7) i(vs8) i(vs9)
print i(vs10) i(vs11) i(vs12) i(vs13) i(vs14) i(vs15) i(vs16) i(vs17) i(vs18) i(vs19)
print i(vs20) i(vs21) i(vs22) i(vs23) i(vs24) i(vs25) i(vs26) i(vs27)
.endc
.end
