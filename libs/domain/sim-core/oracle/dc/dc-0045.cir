controls oracle dc-0045
* Generated (plan F2.7, ADR 0012): do not edit; regenerate with `pnpm sim oracle regen`. dc seed 20261030 index 45 nodes 28 elements 46
.options sparse gmin=1e-12 noopac
RG1 1 0 1000000000000
RG2 2 0 1000000000000
RG3 3 0 1000000000000
RG4 4 0 1000000000000
RG5 5 0 1000000000000
RG6 6 0 1000000000000
RG7 7 0 1000000000000
RG8 8 0 1000000000000
RG9 9 0 1000000000000
RG10 10 0 1000000000000
RG11 11 0 1000000000000
RG12 12 0 1000000000000
RG13 13 0 1000000000000
RG14 14 0 1000000000000
RG15 15 0 1000000000000
RG16 16 0 1000000000000
RG17 17 0 1000000000000
RG18 18 0 1000000000000
RG19 19 0 1000000000000
RG20 20 0 1000000000000
RG21 21 0 1000000000000
RG22 22 0 1000000000000
RG23 23 0 1000000000000
RG24 24 0 1000000000000
RG25 25 0 1000000000000
RG26 26 0 1000000000000
RG27 27 0 1000000000000
VS0 2 s0 0
R0 s0 1 56e3
VS1 17 s1 0
R1 s1 7 56e-2
VS2 23 s2 0
R2 s2 15 39e1
VS3 5 s3 0
R3 s3 1 68e-1
VS4 0 s4 0
V4 e4 s4 DC 27e0
RI4 e4 12 82e-1
VS5 13 s5 0
R5 s5 16 15e3
VS6 20 s6 0
R6 s6 11 22e-1
VS7 21 s7 0
R7 s7 22 39e-1
VS8 6 s8 0
R8 s8 3 39e2
VS9 7 s9 0
R9 s9 26 22e-1
VS10 3 s10 0
R10 s10 18 68e3
VS11 18 s11 0
R11 s11 7 15e1
VS12 7 s12 0
I12 s12 3 DC 47e-4
VS13 25 s13 0
R13 s13 27 27e2
VS14 0 s14 0
R14 s14 15 10e2
VS15 17 s15 0
R15 s15 13 68e2
VS16 24 s16 0
I16 s16 1 DC 56e-4
VS17 17 s17 0
R17 s17 1 18e2
VS18 1 s18 0
R18 s18 27 47e3
VS19 15 s19 0
R19 s19 20 56e3
VS20 21 s20 0
R20 s20 17 15e0
VS21 22 s21 0
I21 s21 0 DC 68e-4
VS22 15 s22 0
R22 s22 10 12e-2
VS23 11 s23 0
R23 s23 23 12e2
VS24 0 s24 0
V24 e24 s24 DC 47e0
RI24 e24 8 82e-2
VS25 12 s25 0
R25 s25 23 12e3
VS26 16 s26 0
V26 e26 s26 DC 27e-1
RI26 e26 4 10e-1
VS27 23 s27 0
V27 e27 s27 DC 27e-1
RI27 e27 16 18e-1
VS28 2 s28 0
R28 s28 25 12e2
VS29 19 s29 0
V29 e29 s29 DC 27e0
RI29 e29 24 12e-1
VS30 15 s30 0
R30 s30 9 22e0
VS31 19 s31 0
V31 e31 s31 DC 82e0
RI31 e31 6 15e-1
VS32 23 s32 0
R32 s32 2 10e0
VS33 24 s33 0
R33 s33 13 12e3
VS34 16 s34 0
R34 s34 7 10e0
VS35 4 s35 0
R35 s35 23 39e1
VS36 23 s36 0
R36 s36 24 56e-2
VS37 8 s37 0
R37 s37 10 39e3
VS38 14 s38 0
R38 s38 7 15e-2
VS39 18 s39 0
R39 s39 9 15e1
VS40 20 s40 0
V40 e40 s40 DC 68e-1
RI40 e40 26 22e-3
VS41 20 s41 0
R41 s41 22 56e2
VS42 20 s42 0
R42 s42 0 22e0
VS43 7 s43 0
R43 s43 0 15e-2
VS44 5 s44 0
R44 s44 14 12e-2
VS45 18 s45 0
R45 s45 24 68e-2
.control
set numdgt=17
op
print v(1) v(2) v(3) v(4) v(5) v(6) v(7) v(8) v(9) v(10)
print v(11) v(12) v(13) v(14) v(15) v(16) v(17) v(18) v(19) v(20)
print v(21) v(22) v(23) v(24) v(25) v(26) v(27)
print i(vs0) i(vs1) i(vs2) i(vs3) i(vs4) i(vs5) i(vs6) i(vs7) i(vs8) i(vs9)
print i(vs10) i(vs11) i(vs12) i(vs13) i(vs14) i(vs15) i(vs16) i(vs17) i(vs18) i(vs19)
print i(vs20) i(vs21) i(vs22) i(vs23) i(vs24) i(vs25) i(vs26) i(vs27) i(vs28) i(vs29)
print i(vs30) i(vs31) i(vs32) i(vs33) i(vs34) i(vs35) i(vs36) i(vs37) i(vs38) i(vs39)
print i(vs40) i(vs41) i(vs42) i(vs43) i(vs44) i(vs45)
.endc
.end
