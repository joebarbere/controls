controls oracle dc-0045
* Generated (plan F2.7, ADR 0012): do not edit; regenerate with `pnpm sim oracle regen`. dc seed 20261030 index 45 nodes 28 elements 40
.options sparse gmin=1e-12 noopac
RG1 1 0 1000000000000
RG2 2 0 1000000000000
RG3 3 0 1000000000000
RG4 4 0 1000000000000
RG5 5 0 1000000000000
RG6 6 0 1000000000000
RG7 7 0 1000000000000
RG8 8 0 1000000000000
RG9 9 0 1000000000000
RG10 10 0 1000000000000
RG11 11 0 1000000000000
RG12 12 0 1000000000000
RG13 13 0 1000000000000
RG14 14 0 1000000000000
RG15 15 0 1000000000000
RG16 16 0 1000000000000
RG17 17 0 1000000000000
RG18 18 0 1000000000000
RG19 19 0 1000000000000
RG20 20 0 1000000000000
RG21 21 0 1000000000000
RG22 22 0 1000000000000
RG23 23 0 1000000000000
RG24 24 0 1000000000000
RG25 25 0 1000000000000
RG26 26 0 1000000000000
RG27 27 0 1000000000000
VS0 23 s0 0
R0 s0 16 10e0
VS1 0 s1 0
V1 e1 s1 DC 27e-1
RI1 e1 4 10e-1
VS2 19 s2 0
V2 e2 s2 DC 82e0
RI2 e2 6 15e-1
VS3 16 s3 0
R3 s3 1 56e3
VS4 19 s4 0
V4 e4 s4 DC 27e0
RI4 e4 24 12e-1
VS5 7 s5 0
R5 s5 2 15e-2
VS6 24 s6 0
R6 s6 13 12e3
VS7 8 s7 0
R7 s7 10 39e3
VS8 13 s8 0
R8 s8 0 15e3
VS9 2 s9 0
R9 s9 15 10e2
VS10 3 s10 0
R10 s10 18 68e3
VS11 2 s11 0
V11 e11 s11 DC 47e0
RI11 e11 8 82e-2
VS12 5 s12 0
R12 s12 14 12e-2
VS13 20 s13 0
R13 s13 2 22e0
VS14 0 s14 0
R14 s14 7 10e0
VS15 17 s15 0
R15 s15 13 68e2
VS16 6 s16 0
R16 s16 3 39e2
VS17 14 s17 0
R17 s17 7 15e-2
VS18 16 s18 0
R18 s18 25 12e2
VS19 20 s19 0
R19 s19 22 56e2
VS20 20 s20 0
R20 s20 11 22e-1
VS21 18 s21 0
R21 s21 24 68e-2
VS22 12 s22 0
R22 s22 23 12e3
VS23 15 s23 0
R23 s23 9 22e0
VS24 20 s24 0
V24 e24 s24 DC 68e-1
RI24 e24 26 22e-3
VS25 18 s25 0
R25 s25 7 15e1
VS26 23 s26 0
R26 s26 24 56e-2
VS27 15 s27 0
R27 s27 10 12e-2
VS28 7 s28 0
I28 s28 3 DC 47e-4
VS29 21 s29 0
R29 s29 17 15e0
VS30 24 s30 0
I30 s30 1 DC 56e-4
VS31 1 s31 0
R31 s31 27 47e3
VS32 22 s32 0
I32 s32 2 DC 68e-4
VS33 18 s33 0
R33 s33 9 15e1
VS34 23 s34 0
V34 e34 s34 DC 27e-1
RI34 e34 0 18e-1
VS35 15 s35 0
R35 s35 20 56e3
VS36 17 s36 0
R36 s36 7 56e-2
VS37 5 s37 0
R37 s37 1 68e-1
VS38 17 s38 0
R38 s38 1 18e2
VS39 23 s39 0
R39 s39 15 39e1
.control
set numdgt=17
op
print v(1) v(2) v(3) v(4) v(5) v(6) v(7) v(8) v(9) v(10)
print v(11) v(12) v(13) v(14) v(15) v(16) v(17) v(18) v(19) v(20)
print v(21) v(22) v(23) v(24) v(25) v(26) v(27)
print i(vs0) i(vs1) i(vs2) i(vs3) i(vs4) i(vs5) i(vs6) i(vs7) i(vs8) i(vs9)
print i(vs10) i(vs11) i(vs12) i(vs13) i(vs14) i(vs15) i(vs16) i(vs17) i(vs18) i(vs19)
print i(vs20) i(vs21) i(vs22) i(vs23) i(vs24) i(vs25) i(vs26) i(vs27) i(vs28) i(vs29)
print i(vs30) i(vs31) i(vs32) i(vs33) i(vs34) i(vs35) i(vs36) i(vs37) i(vs38) i(vs39)
.endc
.end
