controls oracle dc-0144
* Generated (plan F2.7, ADR 0012): do not edit; regenerate with `pnpm sim oracle regen`. dc seed 20261030 index 144 nodes 29 elements 40
.options sparse gmin=1e-12 noopac
RG1 1 0 1000000000000
RG2 2 0 1000000000000
RG3 3 0 1000000000000
RG4 4 0 1000000000000
RG5 5 0 1000000000000
RG6 6 0 1000000000000
RG7 7 0 1000000000000
RG8 8 0 1000000000000
RG9 9 0 1000000000000
RG10 10 0 1000000000000
RG11 11 0 1000000000000
RG12 12 0 1000000000000
RG13 13 0 1000000000000
RG14 14 0 1000000000000
RG15 15 0 1000000000000
RG16 16 0 1000000000000
RG17 17 0 1000000000000
RG18 18 0 1000000000000
RG19 19 0 1000000000000
RG20 20 0 1000000000000
RG21 21 0 1000000000000
RG22 22 0 1000000000000
RG23 23 0 1000000000000
RG24 24 0 1000000000000
RG25 25 0 1000000000000
RG26 26 0 1000000000000
RG27 27 0 1000000000000
RG28 28 0 1000000000000
VS0 2 s0 0
R0 s0 17 33e2
VS1 0 s1 0
V1 e1 s1 DC 82e1
RI1 e1 15 15e-1
VS2 2 s2 0
R2 s2 6 10e-1
VS3 10 s3 0
V3 e3 s3 DC 18e0
RI3 e3 27 56e-1
VS4 6 s4 0
V4 e4 s4 DC 18e-1
RI4 e4 8 18e-3
VS5 11 s5 0
V5 e5 s5 DC 22e-1
RI5 e5 3 47e-3
VS6 17 s6 0
R6 s6 24 10e2
VS7 2 s7 0
V7 e7 s7 DC 82e0
RI7 e7 7 12e-2
VS8 21 s8 0
V8 e8 s8 DC 22e1
RI8 e8 25 10e-2
VS9 27 s9 0
R9 s9 13 22e-2
VS10 5 s10 0
R10 s10 19 33e-1
VS11 22 s11 0
V11 e11 s11 DC 39e-1
RI11 e11 7 10e-1
VS12 15 s12 0
R12 s12 23 15e0
VS13 19 s13 0
V13 e13 s13 DC 22e-1
RI13 e13 18 39e-1
VS14 0 s14 0
R14 s14 25 15e1
VS15 24 s15 0
R15 s15 20 27e1
VS16 14 s16 0
R16 s16 10 82e-1
VS17 27 s17 0
R17 s17 21 47e3
VS18 16 s18 0
V18 e18 s18 DC 82e-1
RI18 e18 10 47e-2
VS19 10 s19 0
R19 s19 7 68e0
VS20 10 s20 0
R20 s20 23 47e3
VS21 7 s21 0
R21 s21 9 10e-1
VS22 12 s22 0
R22 s22 22 39e1
VS23 1 s23 0
R23 s23 7 47e0
VS24 4 s24 0
R24 s24 5 12e0
VS25 0 s25 0
R25 s25 9 68e-2
VS26 12 s26 0
R26 s26 5 68e2
VS27 0 s27 0
V27 e27 s27 DC 27e1
RI27 e27 28 47e-1
VS28 3 s28 0
R28 s28 13 39e3
VS29 7 s29 0
V29 e29 s29 DC 18e0
RI29 e29 8 33e-1
VS30 16 s30 0
V30 e30 s30 DC 15e-1
RI30 e30 26 33e-2
VS31 11 s31 0
R31 s31 1 47e1
VS32 10 s32 0
R32 s32 5 10e1
VS33 17 s33 0
R33 s33 22 27e-1
VS34 8 s34 0
V34 e34 s34 DC 15e-1
RI34 e34 0 47e-1
VS35 3 s35 0
R35 s35 1 39e0
VS36 4 s36 0
R36 s36 20 22e1
VS37 26 s37 0
R37 s37 20 15e-2
VS38 28 s38 0
R38 s38 14 15e1
VS39 0 s39 0
R39 s39 18 12e3
.control
set numdgt=17
op
print v(1) v(2) v(3) v(4) v(5) v(6) v(7) v(8) v(9) v(10)
print v(11) v(12) v(13) v(14) v(15) v(16) v(17) v(18) v(19) v(20)
print v(21) v(22) v(23) v(24) v(25) v(26) v(27) v(28)
print i(vs0) i(vs1) i(vs2) i(vs3) i(vs4) i(vs5) i(vs6) i(vs7) i(vs8) i(vs9)
print i(vs10) i(vs11) i(vs12) i(vs13) i(vs14) i(vs15) i(vs16) i(vs17) i(vs18) i(vs19)
print i(vs20) i(vs21) i(vs22) i(vs23) i(vs24) i(vs25) i(vs26) i(vs27) i(vs28) i(vs29)
print i(vs30) i(vs31) i(vs32) i(vs33) i(vs34) i(vs35) i(vs36) i(vs37) i(vs38) i(vs39)
.endc
.end
