controls oracle dc-0144
* Generated (plan F2.7, ADR 0012): do not edit; regenerate with `pnpm sim oracle regen`. dc seed 20261030 index 144 nodes 29 elements 29
.options sparse gmin=1e-12 noopac
RG1 1 0 1000000000000
RG2 2 0 1000000000000
RG3 3 0 1000000000000
RG4 4 0 1000000000000
RG5 5 0 1000000000000
RG6 6 0 1000000000000
RG7 7 0 1000000000000
RG8 8 0 1000000000000
RG9 9 0 1000000000000
RG10 10 0 1000000000000
RG11 11 0 1000000000000
RG12 12 0 1000000000000
RG13 13 0 1000000000000
RG14 14 0 1000000000000
RG15 15 0 1000000000000
RG16 16 0 1000000000000
RG17 17 0 1000000000000
RG18 18 0 1000000000000
RG19 19 0 1000000000000
RG20 20 0 1000000000000
RG21 21 0 1000000000000
RG22 22 0 1000000000000
RG23 23 0 1000000000000
RG24 24 0 1000000000000
RG25 25 0 1000000000000
RG26 26 0 1000000000000
RG27 27 0 1000000000000
RG28 28 0 1000000000000
VS0 26 s0 0
R0 s0 20 15e-2
VS1 14 s1 0
R1 s1 10 82e-1
VS2 0 s2 0
V2 e2 s2 DC 22e-1
RI2 e2 18 39e-1
VS3 27 s3 0
V3 e3 s3 DC 82e1
RI3 e3 15 15e-1
VS4 1 s4 0
R4 s4 7 47e0
VS5 4 s5 0
R5 s5 5 12e0
VS6 2 s6 0
R6 s6 17 33e2
VS7 3 s7 0
R7 s7 13 39e3
VS8 19 s8 0
R8 s8 21 47e3
VS9 2 s9 0
R9 s9 6 10e-1
VS10 17 s10 0
R10 s10 24 10e2
VS11 10 s11 0
R11 s11 23 47e3
VS12 17 s12 0
R12 s12 22 27e-1
VS13 19 s13 0
R13 s13 13 22e-2
VS14 27 s14 0
V14 e14 s14 DC 27e1
RI14 e14 28 47e-1
VS15 16 s15 0
V15 e15 s15 DC 15e-1
RI15 e15 26 33e-2
VS16 27 s16 0
R16 s16 9 68e-2
VS17 24 s17 0
R17 s17 20 27e1
VS18 16 s18 0
V18 e18 s18 DC 82e-1
RI18 e18 10 47e-2
VS19 28 s19 0
R19 s19 14 15e1
VS20 10 s20 0
R20 s20 7 68e0
VS21 12 s21 0
R21 s21 5 68e2
VS22 11 s22 0
V22 e22 s22 DC 22e-1
RI22 e22 3 47e-3
VS23 2 s23 0
V23 e23 s23 DC 82e0
RI23 e23 7 12e-2
VS24 10 s24 0
V24 e24 s24 DC 18e0
RI24 e24 19 56e-1
VS25 7 s25 0
V25 e25 s25 DC 18e0
RI25 e25 8 33e-1
VS26 27 s26 0
R26 s26 25 15e1
VS27 5 s27 0
R27 s27 0 33e-1
VS28 10 s28 0
R28 s28 5 10e1
.control
set numdgt=17
op
print v(1) v(2) v(3) v(4) v(5) v(6) v(7) v(8) v(9) v(10)
print v(11) v(12) v(13) v(14) v(15) v(16) v(17) v(18) v(19) v(20)
print v(21) v(22) v(23) v(24) v(25) v(26) v(27) v(28)
print i(vs0) i(vs1) i(vs2) i(vs3) i(vs4) i(vs5) i(vs6) i(vs7) i(vs8) i(vs9)
print i(vs10) i(vs11) i(vs12) i(vs13) i(vs14) i(vs15) i(vs16) i(vs17) i(vs18) i(vs19)
print i(vs20) i(vs21) i(vs22) i(vs23) i(vs24) i(vs25) i(vs26) i(vs27) i(vs28)
.endc
.end
