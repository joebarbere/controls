controls oracle dc-0381
* Generated (plan F2.7, ADR 0012): do not edit; regenerate with `pnpm sim oracle regen`. dc seed 20261030 index 381 nodes 29 elements 35
.options sparse gmin=1e-12 noopac
RG1 1 0 1000000000000
RG2 2 0 1000000000000
RG3 3 0 1000000000000
RG4 4 0 1000000000000
RG5 5 0 1000000000000
RG6 6 0 1000000000000
RG7 7 0 1000000000000
RG8 8 0 1000000000000
RG9 9 0 1000000000000
RG10 10 0 1000000000000
RG11 11 0 1000000000000
RG12 12 0 1000000000000
RG13 13 0 1000000000000
RG14 14 0 1000000000000
RG15 15 0 1000000000000
RG16 16 0 1000000000000
RG17 17 0 1000000000000
RG18 18 0 1000000000000
RG19 19 0 1000000000000
RG20 20 0 1000000000000
RG21 21 0 1000000000000
RG22 22 0 1000000000000
RG23 23 0 1000000000000
RG24 24 0 1000000000000
RG25 25 0 1000000000000
RG26 26 0 1000000000000
RG27 27 0 1000000000000
RG28 28 0 1000000000000
VS0 12 s0 0
R0 s0 10 39e-1
VS1 0 s1 0
V1 e1 s1 DC 27e1
RI1 e1 12 18e-1
VS2 4 s2 0
R2 s2 9 18e1
VS3 23 s3 0
R3 s3 12 56e1
VS4 9 s4 0
I4 s4 24 DC 10e-4
VS5 16 s5 0
V5 e5 s5 DC 47e0
RI5 e5 13 82e-3
VS6 10 s6 0
V6 e6 s6 DC 12e0
RI6 e6 26 22e-1
VS7 24 s7 0
R7 s7 23 47e-1
VS8 1 s8 0
V8 e8 s8 DC 39e1
RI8 e8 10 56e-2
VS9 8 s9 0
V9 e9 s9 DC 18e-1
RI9 e9 10 27e-3
VS10 19 s10 0
V10 e10 s10 DC 39e1
RI10 e10 12 18e-3
VS11 14 s11 0
R11 s11 9 15e0
VS12 8 s12 0
R12 s12 26 18e3
VS13 10 s13 0
R13 s13 3 27e1
VS14 15 s14 0
R14 s14 18 18e-1
VS15 7 s15 0
R15 s15 16 18e-1
VS16 28 s16 0
R16 s16 27 56e3
VS17 8 s17 0
R17 s17 22 18e-1
VS18 18 s18 0
I18 s18 21 DC 22e-4
VS19 22 s19 0
I19 s19 18 DC 22e-2
VS20 13 s20 0
R20 s20 10 82e-1
VS21 7 s21 0
R21 s21 14 10e-1
VS22 2 s22 0
V22 e22 s22 DC 47e-1
RI22 e22 7 10e-1
VS23 22 s23 0
R23 s23 27 56e2
VS24 3 s24 0
R24 s24 21 27e0
VS25 11 s25 0
R25 s25 20 68e0
VS26 25 s26 0
R26 s26 8 47e0
VS27 4 s27 0
R27 s27 10 27e-2
VS28 25 s28 0
R28 s28 15 56e-2
VS29 11 s29 0
R29 s29 5 15e0
VS30 8 s30 0
R30 s30 2 47e1
VS31 25 s31 0
R31 s31 11 82e-1
VS32 5 s32 0
I32 s32 27 DC 47e-1
VS33 10 s33 0
R33 s33 17 33e1
VS34 25 s34 0
V34 e34 s34 DC 39e0
RI34 e34 6 68e-1
.control
set numdgt=17
op
print v(1) v(2) v(3) v(4) v(5) v(6) v(7) v(8) v(9) v(10)
print v(11) v(12) v(13) v(14) v(15) v(16) v(17) v(18) v(19) v(20)
print v(21) v(22) v(23) v(24) v(25) v(26) v(27) v(28)
print i(vs0) i(vs1) i(vs2) i(vs3) i(vs4) i(vs5) i(vs6) i(vs7) i(vs8) i(vs9)
print i(vs10) i(vs11) i(vs12) i(vs13) i(vs14) i(vs15) i(vs16) i(vs17) i(vs18) i(vs19)
print i(vs20) i(vs21) i(vs22) i(vs23) i(vs24) i(vs25) i(vs26) i(vs27) i(vs28) i(vs29)
print i(vs30) i(vs31) i(vs32) i(vs33) i(vs34)
.endc
.end
