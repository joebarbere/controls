controls oracle dc-0381
* Generated (plan F2.7, ADR 0012): do not edit; regenerate with `pnpm sim oracle regen`. dc seed 20261030 index 381 nodes 29 elements 44
.options sparse gmin=1e-12 noopac
RG1 1 0 1000000000000
RG2 2 0 1000000000000
RG3 3 0 1000000000000
RG4 4 0 1000000000000
RG5 5 0 1000000000000
RG6 6 0 1000000000000
RG7 7 0 1000000000000
RG8 8 0 1000000000000
RG9 9 0 1000000000000
RG10 10 0 1000000000000
RG11 11 0 1000000000000
RG12 12 0 1000000000000
RG13 13 0 1000000000000
RG14 14 0 1000000000000
RG15 15 0 1000000000000
RG16 16 0 1000000000000
RG17 17 0 1000000000000
RG18 18 0 1000000000000
RG19 19 0 1000000000000
RG20 20 0 1000000000000
RG21 21 0 1000000000000
RG22 22 0 1000000000000
RG23 23 0 1000000000000
RG24 24 0 1000000000000
RG25 25 0 1000000000000
RG26 26 0 1000000000000
RG27 27 0 1000000000000
RG28 28 0 1000000000000
VS0 22 s0 0
R0 s0 27 56e2
VS1 23 s1 0
R1 s1 12 56e1
VS2 1 s2 0
R2 s2 17 33e1
VS3 24 s3 0
R3 s3 23 47e-1
VS4 8 s4 0
R4 s4 26 18e3
VS5 4 s5 0
R5 s5 1 27e-2
VS6 25 s6 0
R6 s6 15 56e-2
VS7 18 s7 0
I7 s7 21 DC 22e-4
VS8 18 s8 0
R8 s8 10 18e3
VS9 24 s9 0
R9 s9 0 82e3
VS10 7 s10 0
R10 s10 16 18e-1
VS11 4 s11 0
R11 s11 9 18e1
VS12 0 s12 0
V12 e12 s12 DC 39e1
RI12 e12 1 56e-2
VS13 15 s13 0
R13 s13 18 18e-1
VS14 2 s14 0
V14 e14 s14 DC 47e-1
RI14 e14 7 10e-1
VS15 22 s15 0
I15 s15 18 DC 22e-2
VS16 28 s16 0
R16 s16 27 56e3
VS17 25 s17 0
R17 s17 11 82e-1
VS18 17 s18 0
R18 s18 19 47e1
VS19 8 s19 0
R19 s19 2 47e1
VS20 7 s20 0
R20 s20 14 10e-1
VS21 11 s21 0
R21 s21 20 68e0
VS22 12 s22 0
R22 s22 1 39e-1
VS23 19 s23 0
V23 e23 s23 DC 39e1
RI23 e23 12 18e-3
VS24 25 s24 0
R24 s24 8 47e0
VS25 20 s25 0
R25 s25 9 47e3
VS26 11 s26 0
R26 s26 6 15e3
VS27 19 s27 0
R27 s27 13 15e-2
VS28 25 s28 0
V28 e28 s28 DC 39e0
RI28 e28 6 68e-1
VS29 1 s29 0
R29 s29 3 27e1
VS30 8 s30 0
V30 e30 s30 DC 18e-1
RI30 e30 1 27e-3
VS31 8 s31 0
R31 s31 22 18e-1
VS32 1 s32 0
V32 e32 s32 DC 12e0
RI32 e32 26 22e-1
VS33 25 s33 0
R33 s33 5 12e1
VS34 14 s34 0
R34 s34 9 15e0
VS35 5 s35 0
I35 s35 27 DC 47e-1
VS36 10 s36 0
V36 e36 s36 DC 27e1
RI36 e36 12 18e-1
VS37 13 s37 0
R37 s37 1 82e-1
VS38 21 s38 0
R38 s38 4 56e0
VS39 9 s39 0
I39 s39 24 DC 10e-4
VS40 11 s40 0
R40 s40 5 15e0
VS41 16 s41 0
V41 e41 s41 DC 47e0
RI41 e41 13 82e-3
VS42 28 s42 0
V42 e42 s42 DC 12e0
RI42 e42 24 56e-3
VS43 3 s43 0
R43 s43 21 27e0
.control
set numdgt=17
op
print v(1) v(2) v(3) v(4) v(5) v(6) v(7) v(8) v(9) v(10)
print v(11) v(12) v(13) v(14) v(15) v(16) v(17) v(18) v(19) v(20)
print v(21) v(22) v(23) v(24) v(25) v(26) v(27) v(28)
print i(vs0) i(vs1) i(vs2) i(vs3) i(vs4) i(vs5) i(vs6) i(vs7) i(vs8) i(vs9)
print i(vs10) i(vs11) i(vs12) i(vs13) i(vs14) i(vs15) i(vs16) i(vs17) i(vs18) i(vs19)
print i(vs20) i(vs21) i(vs22) i(vs23) i(vs24) i(vs25) i(vs26) i(vs27) i(vs28) i(vs29)
print i(vs30) i(vs31) i(vs32) i(vs33) i(vs34) i(vs35) i(vs36) i(vs37) i(vs38) i(vs39)
print i(vs40) i(vs41) i(vs42) i(vs43)
.endc
.end
