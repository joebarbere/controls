controls oracle dc-0340
* Generated (plan F2.7, ADR 0012): do not edit; regenerate with `pnpm sim oracle regen`. dc seed 20261030 index 340 nodes 18 elements 30
.options sparse gmin=1e-12 noopac
RG1 1 0 1000000000000
RG2 2 0 1000000000000
RG3 3 0 1000000000000
RG4 4 0 1000000000000
RG5 5 0 1000000000000
RG6 6 0 1000000000000
RG7 7 0 1000000000000
RG8 8 0 1000000000000
RG9 9 0 1000000000000
RG10 10 0 1000000000000
RG11 11 0 1000000000000
RG12 12 0 1000000000000
RG13 13 0 1000000000000
RG14 14 0 1000000000000
RG15 15 0 1000000000000
RG16 16 0 1000000000000
RG17 17 0 1000000000000
VS0 11 s0 0
R0 s0 4 68e3
VS1 0 s1 0
V1 e1 s1 DC 15e0
RI1 e1 17 68e-2
VS2 16 s2 0
R2 s2 10 15e3
VS3 7 s3 0
R3 s3 8 68e1
VS4 16 s4 0
R4 s4 11 10e2
VS5 15 s5 0
R5 s5 1 27e2
VS6 2 s6 0
R6 s6 7 47e3
VS7 0 s7 0
V7 e7 s7 DC 82e1
RI7 e7 16 18e-1
VS8 3 s8 0
V8 e8 s8 DC 56e0
RI8 e8 2 12e-1
VS9 12 s9 0
R9 s9 14 22e-1
VS10 17 s10 0
V10 e10 s10 DC 56e1
RI10 e10 16 56e-1
VS11 3 s11 0
R11 s11 4 47e1
VS12 17 s12 0
R12 s12 9 47e0
VS13 4 s13 0
R13 s13 3 47e-2
VS14 6 s14 0
R14 s14 3 27e3
VS15 8 s15 0
V15 e15 s15 DC 56e-1
RI15 e15 10 56e-3
VS16 7 s16 0
R16 s16 9 82e3
VS17 9 s17 0
R17 s17 13 27e-2
VS18 15 s18 0
R18 s18 6 12e2
VS19 9 s19 0
R19 s19 16 12e0
VS20 15 s20 0
R20 s20 2 68e0
VS21 0 s21 0
I21 s21 14 DC 47e-3
VS22 9 s22 0
R22 s22 1 15e0
VS23 11 s23 0
R23 s23 9 15e2
VS24 12 s24 0
V24 e24 s24 DC 33e-1
RI24 e24 7 56e-3
VS25 3 s25 0
R25 s25 13 27e-1
VS26 5 s26 0
R26 s26 0 18e-1
VS27 5 s27 0
R27 s27 17 12e2
VS28 17 s28 0
R28 s28 0 47e0
VS29 3 s29 0
R29 s29 14 33e0
.control
set numdgt=17
op
print v(1) v(2) v(3) v(4) v(5) v(6) v(7) v(8) v(9) v(10)
print v(11) v(12) v(13) v(14) v(15) v(16) v(17)
print i(vs0) i(vs1) i(vs2) i(vs3) i(vs4) i(vs5) i(vs6) i(vs7) i(vs8) i(vs9)
print i(vs10) i(vs11) i(vs12) i(vs13) i(vs14) i(vs15) i(vs16) i(vs17) i(vs18) i(vs19)
print i(vs20) i(vs21) i(vs22) i(vs23) i(vs24) i(vs25) i(vs26) i(vs27) i(vs28) i(vs29)
.endc
.end
