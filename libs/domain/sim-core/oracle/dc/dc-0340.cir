controls oracle dc-0340
* Generated (plan F2.7, ADR 0012): do not edit; regenerate with `pnpm sim oracle regen`. dc seed 20261030 index 340 nodes 18 elements 25
.options sparse gmin=1e-12 noopac
RG1 1 0 1000000000000
RG2 2 0 1000000000000
RG3 3 0 1000000000000
RG4 4 0 1000000000000
RG5 5 0 1000000000000
RG6 6 0 1000000000000
RG7 7 0 1000000000000
RG8 8 0 1000000000000
RG9 9 0 1000000000000
RG10 10 0 1000000000000
RG11 11 0 1000000000000
RG12 12 0 1000000000000
RG13 13 0 1000000000000
RG14 14 0 1000000000000
RG15 15 0 1000000000000
RG16 16 0 1000000000000
RG17 17 0 1000000000000
VS0 0 s0 0
V0 e0 s0 DC 82e1
RI0 e0 16 18e-1
VS1 0 s1 0
I1 s1 14 DC 47e-3
VS2 3 s2 0
R2 s2 4 47e1
VS3 7 s3 0
R3 s3 9 82e3
VS4 15 s4 0
R4 s4 6 12e2
VS5 3 s5 0
V5 e5 s5 DC 56e0
RI5 e5 2 12e-1
VS6 17 s6 0
V6 e6 s6 DC 56e1
RI6 e6 16 56e-1
VS7 5 s7 0
R7 s7 17 12e2
VS8 17 s8 0
R8 s8 0 47e0
VS9 15 s9 0
R9 s9 2 68e0
VS10 0 s10 0
V10 e10 s10 DC 15e0
RI10 e10 17 68e-2
VS11 12 s11 0
R11 s11 14 22e-1
VS12 15 s12 0
R12 s12 1 27e2
VS13 16 s13 0
R13 s13 11 10e2
VS14 16 s14 0
R14 s14 10 15e3
VS15 7 s15 0
R15 s15 8 68e1
VS16 9 s16 0
R16 s16 13 27e-2
VS17 3 s17 0
R17 s17 14 33e0
VS18 12 s18 0
V18 e18 s18 DC 33e-1
RI18 e18 7 56e-3
VS19 9 s19 0
R19 s19 1 15e0
VS20 4 s20 0
R20 s20 3 47e-2
VS21 11 s21 0
R21 s21 9 15e2
VS22 2 s22 0
R22 s22 7 47e3
VS23 9 s23 0
R23 s23 16 12e0
VS24 17 s24 0
R24 s24 9 47e0
.control
set numdgt=17
op
print v(1) v(2) v(3) v(4) v(5) v(6) v(7) v(8) v(9) v(10)
print v(11) v(12) v(13) v(14) v(15) v(16) v(17)
print i(vs0) i(vs1) i(vs2) i(vs3) i(vs4) i(vs5) i(vs6) i(vs7) i(vs8) i(vs9)
print i(vs10) i(vs11) i(vs12) i(vs13) i(vs14) i(vs15) i(vs16) i(vs17) i(vs18) i(vs19)
print i(vs20) i(vs21) i(vs22) i(vs23) i(vs24)
.endc
.end
