controls oracle dc-0238
* Generated (plan F2.7, ADR 0012): do not edit; regenerate with `pnpm sim oracle regen`. dc seed 20261030 index 238 nodes 6 elements 10
.options sparse gmin=1e-12 noopac
RG1 1 0 1000000000000
RG2 2 0 1000000000000
RG3 3 0 1000000000000
RG4 4 0 1000000000000
RG5 5 0 1000000000000
VS0 1 s0 0
R0 s0 2 10e1
VS1 5 s1 0
R1 s1 2 56e-2
VS2 0 s2 0
V2 e2 s2 DC 33e1
RI2 e2 5 68e-2
VS3 4 s3 0
R3 s3 5 27e-2
VS4 0 s4 0
V4 e4 s4 DC 39e-1
RI4 e4 2 18e-2
VS5 3 s5 0
R5 s5 2 15e0
VS6 4 s6 0
I6 s6 0 DC 47e-4
VS7 3 s7 0
R7 s7 4 68e2
VS8 3 s8 0
R8 s8 1 56e-2
VS9 5 s9 0
V9 e9 s9 DC 15e0
RI9 e9 3 10e-2
.control
set numdgt=17
op
print v(1) v(2) v(3) v(4) v(5)
print i(vs0) i(vs1) i(vs2) i(vs3) i(vs4) i(vs5) i(vs6) i(vs7) i(vs8) i(vs9)
.endc
.end
