controls oracle dc-0238
* Generated (plan F2.7, ADR 0012): do not edit; regenerate with `pnpm sim oracle regen`. dc seed 20261030 index 238 nodes 6 elements 8
.options sparse gmin=1e-12 noopac
RG1 1 0 1000000000000
RG2 2 0 1000000000000
RG3 3 0 1000000000000
RG4 4 0 1000000000000
RG5 5 0 1000000000000
VS0 4 s0 0
I0 s0 5 DC 47e-4
VS1 0 s1 0
V1 e1 s1 DC 15e0
RI1 e1 3 10e-2
VS2 0 s2 0
R2 s2 2 56e-2
VS3 5 s3 0
V3 e3 s3 DC 39e-1
RI3 e3 2 18e-2
VS4 1 s4 0
R4 s4 2 10e1
VS5 3 s5 0
R5 s5 2 15e0
VS6 3 s6 0
R6 s6 4 68e2
VS7 4 s7 0
R7 s7 0 27e-2
.control
set numdgt=17
op
print v(1) v(2) v(3) v(4) v(5)
print i(vs0) i(vs1) i(vs2) i(vs3) i(vs4) i(vs5) i(vs6) i(vs7)
.endc
.end
