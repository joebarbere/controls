controls oracle dc-0307
* Generated (plan F2.7, ADR 0012): do not edit; regenerate with `pnpm sim oracle regen`. dc seed 20261030 index 307 nodes 12 elements 24
.options sparse gmin=1e-12 noopac
RG1 1 0 1000000000000
RG2 2 0 1000000000000
RG3 3 0 1000000000000
RG4 4 0 1000000000000
RG5 5 0 1000000000000
RG6 6 0 1000000000000
RG7 7 0 1000000000000
RG8 8 0 1000000000000
RG9 9 0 1000000000000
RG10 10 0 1000000000000
RG11 11 0 1000000000000
VS0 6 s0 0
R0 s0 10 47e-1
VS1 4 s1 0
R1 s1 3 15e3
VS2 10 s2 0
R2 s2 2 27e-1
VS3 3 s3 0
R3 s3 7 22e2
VS4 10 s4 0
I4 s4 8 DC 82e-2
VS5 8 s5 0
R5 s5 1 82e1
VS6 0 s6 0
V6 e6 s6 DC 33e-1
RI6 e6 11 27e-2
VS7 1 s7 0
R7 s7 4 56e1
VS8 5 s8 0
R8 s8 4 68e-1
VS9 4 s9 0
V9 e9 s9 DC 47e0
RI9 e9 9 33e-3
VS10 10 s10 0
R10 s10 11 39e2
VS11 7 s11 0
R11 s11 11 47e3
VS12 9 s12 0
R12 s12 2 10e0
VS13 3 s13 0
R13 s13 10 82e-2
VS14 8 s14 0
R14 s14 10 56e0
VS15 2 s15 0
R15 s15 4 10e-1
VS16 6 s16 0
R16 s16 10 15e0
VS17 5 s17 0
R17 s17 2 82e-2
VS18 6 s18 0
R18 s18 7 12e-2
VS19 9 s19 0
R19 s19 11 22e2
VS20 10 s20 0
V20 e20 s20 DC 18e1
RI20 e20 8 56e-3
VS21 9 s21 0
R21 s21 1 27e2
VS22 2 s22 0
R22 s22 0 47e1
VS23 11 s23 0
I23 s23 7 DC 22e-2
.control
set numdgt=17
op
print v(1) v(2) v(3) v(4) v(5) v(6) v(7) v(8) v(9) v(10)
print v(11)
print i(vs0) i(vs1) i(vs2) i(vs3) i(vs4) i(vs5) i(vs6) i(vs7) i(vs8) i(vs9)
print i(vs10) i(vs11) i(vs12) i(vs13) i(vs14) i(vs15) i(vs16) i(vs17) i(vs18) i(vs19)
print i(vs20) i(vs21) i(vs22) i(vs23)
.endc
.end
