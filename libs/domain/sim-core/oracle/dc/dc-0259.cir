controls oracle dc-0259
* Generated (plan F2.7, ADR 0012): do not edit; regenerate with `pnpm sim oracle regen`. dc seed 20261030 index 259 nodes 18 elements 33
.options sparse gmin=1e-12 noopac
RG1 1 0 1000000000000
RG2 2 0 1000000000000
RG3 3 0 1000000000000
RG4 4 0 1000000000000
RG5 5 0 1000000000000
RG6 6 0 1000000000000
RG7 7 0 1000000000000
RG8 8 0 1000000000000
RG9 9 0 1000000000000
RG10 10 0 1000000000000
RG11 11 0 1000000000000
RG12 12 0 1000000000000
RG13 13 0 1000000000000
RG14 14 0 1000000000000
RG15 15 0 1000000000000
RG16 16 0 1000000000000
RG17 17 0 1000000000000
VS0 10 s0 0
R0 s0 16 39e1
VS1 2 s1 0
R1 s1 15 15e1
VS2 14 s2 0
R2 s2 17 82e0
VS3 0 s3 0
V3 e3 s3 DC 82e0
RI3 e3 17 27e-1
VS4 17 s4 0
R4 s4 5 22e3
VS5 7 s5 0
V5 e5 s5 DC 39e1
RI5 e5 12 10e-2
VS6 15 s6 0
R6 s6 12 12e2
VS7 7 s7 0
R7 s7 15 47e-1
VS8 6 s8 0
I8 s8 2 DC 82e-3
VS9 4 s9 0
R9 s9 6 22e1
VS10 6 s10 0
I10 s10 17 DC 33e-3
VS11 7 s11 0
V11 e11 s11 DC 15e1
RI11 e11 16 39e-2
VS12 3 s12 0
R12 s12 5 33e-1
VS13 17 s13 0
R13 s13 11 18e-1
VS14 4 s14 0
R14 s14 13 18e3
VS15 0 s15 0
R15 s15 11 47e1
VS16 7 s16 0
R16 s16 17 18e1
VS17 9 s17 0
R17 s17 3 33e-1
VS18 15 s18 0
R18 s18 17 15e-2
VS19 3 s19 0
I19 s19 2 DC 15e-3
VS20 9 s20 0
R20 s20 8 10e2
VS21 4 s21 0
R21 s21 13 68e1
VS22 14 s22 0
R22 s22 4 12e-1
VS23 8 s23 0
R23 s23 4 33e1
VS24 9 s24 0
R24 s24 11 18e2
VS25 12 s25 0
R25 s25 6 10e2
VS26 1 s26 0
R26 s26 14 10e3
VS27 15 s27 0
R27 s27 10 27e3
VS28 4 s28 0
I28 s28 16 DC 33e-3
VS29 9 s29 0
R29 s29 2 56e1
VS30 6 s30 0
R30 s30 17 33e2
VS31 1 s31 0
R31 s31 0 27e0
VS32 1 s32 0
R32 s32 12 15e3
.control
set numdgt=17
op
print v(1) v(2) v(3) v(4) v(5) v(6) v(7) v(8) v(9) v(10)
print v(11) v(12) v(13) v(14) v(15) v(16) v(17)
print i(vs0) i(vs1) i(vs2) i(vs3) i(vs4) i(vs5) i(vs6) i(vs7) i(vs8) i(vs9)
print i(vs10) i(vs11) i(vs12) i(vs13) i(vs14) i(vs15) i(vs16) i(vs17) i(vs18) i(vs19)
print i(vs20) i(vs21) i(vs22) i(vs23) i(vs24) i(vs25) i(vs26) i(vs27) i(vs28) i(vs29)
print i(vs30) i(vs31) i(vs32)
.endc
.end
