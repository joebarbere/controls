controls oracle dc-0259
* Generated (plan F2.7, ADR 0012): do not edit; regenerate with `pnpm sim oracle regen`. dc seed 20261030 index 259 nodes 18 elements 34
.options sparse gmin=1e-12 noopac
RG1 1 0 1000000000000
RG2 2 0 1000000000000
RG3 3 0 1000000000000
RG4 4 0 1000000000000
RG5 5 0 1000000000000
RG6 6 0 1000000000000
RG7 7 0 1000000000000
RG8 8 0 1000000000000
RG9 9 0 1000000000000
RG10 10 0 1000000000000
RG11 11 0 1000000000000
RG12 12 0 1000000000000
RG13 13 0 1000000000000
RG14 14 0 1000000000000
RG15 15 0 1000000000000
RG16 16 0 1000000000000
RG17 17 0 1000000000000
VS0 13 s0 0
R0 s0 6 47e0
VS1 9 s1 0
R1 s1 3 33e-1
VS2 6 s2 0
I2 s2 7 DC 33e-3
VS3 9 s3 0
R3 s3 8 10e2
VS4 1 s4 0
R4 s4 17 27e0
VS5 6 s5 0
I5 s5 2 DC 82e-3
VS6 3 s6 0
I6 s6 2 DC 15e-3
VS7 9 s7 0
R7 s7 2 56e1
VS8 8 s8 0
R8 s8 4 33e1
VS9 0 s9 0
R9 s9 15 47e-1
VS10 15 s10 0
R10 s10 10 27e3
VS11 14 s11 0
R11 s11 7 82e0
VS12 4 s12 0
R12 s12 13 18e3
VS13 14 s13 0
R13 s13 4 12e-1
VS14 6 s14 0
R14 s14 7 33e2
VS15 7 s15 0
R15 s15 11 18e-1
VS16 4 s16 0
I16 s16 16 DC 33e-3
VS17 17 s17 0
R17 s17 11 47e1
VS18 15 s18 0
R18 s18 12 12e2
VS19 4 s19 0
R19 s19 6 22e1
VS20 0 s20 0
V20 e20 s20 DC 15e1
RI20 e20 16 39e-2
VS21 0 s21 0
V21 e21 s21 DC 39e1
RI21 e21 12 10e-2
VS22 4 s22 0
R22 s22 13 68e1
VS23 17 s23 0
V23 e23 s23 DC 82e0
RI23 e23 7 27e-1
VS24 0 s24 0
R24 s24 7 18e1
VS25 3 s25 0
R25 s25 5 33e-1
VS26 10 s26 0
R26 s26 16 39e1
VS27 7 s27 0
R27 s27 5 22e3
VS28 2 s28 0
R28 s28 15 15e1
VS29 1 s29 0
R29 s29 14 10e3
VS30 12 s30 0
R30 s30 6 10e2
VS31 9 s31 0
R31 s31 11 18e2
VS32 1 s32 0
R32 s32 12 15e3
VS33 15 s33 0
R33 s33 7 15e-2
.control
set numdgt=17
op
print v(1) v(2) v(3) v(4) v(5) v(6) v(7) v(8) v(9) v(10)
print v(11) v(12) v(13) v(14) v(15) v(16) v(17)
print i(vs0) i(vs1) i(vs2) i(vs3) i(vs4) i(vs5) i(vs6) i(vs7) i(vs8) i(vs9)
print i(vs10) i(vs11) i(vs12) i(vs13) i(vs14) i(vs15) i(vs16) i(vs17) i(vs18) i(vs19)
print i(vs20) i(vs21) i(vs22) i(vs23) i(vs24) i(vs25) i(vs26) i(vs27) i(vs28) i(vs29)
print i(vs30) i(vs31) i(vs32) i(vs33)
.endc
.end
