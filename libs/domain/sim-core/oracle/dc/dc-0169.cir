controls oracle dc-0169
* Generated (plan F2.7, ADR 0012): do not edit; regenerate with `pnpm sim oracle regen`. dc seed 20261030 index 169 nodes 16 elements 16
.options sparse gmin=1e-12 noopac
RG1 1 0 1000000000000
RG2 2 0 1000000000000
RG3 3 0 1000000000000
RG4 4 0 1000000000000
RG5 5 0 1000000000000
RG6 6 0 1000000000000
RG7 7 0 1000000000000
RG8 8 0 1000000000000
RG9 9 0 1000000000000
RG10 10 0 1000000000000
RG11 11 0 1000000000000
RG12 12 0 1000000000000
RG13 13 0 1000000000000
RG14 14 0 1000000000000
RG15 15 0 1000000000000
VS0 4 s0 0
R0 s0 7 68e0
VS1 2 s1 0
R1 s1 1 12e-2
VS2 9 s2 0
R2 s2 6 56e2
VS3 13 s3 0
R3 s3 4 10e-1
VS4 9 s4 0
R4 s4 5 10e1
VS5 14 s5 0
R5 s5 13 27e1
VS6 10 s6 0
R6 s6 15 10e3
VS7 3 s7 0
R7 s7 11 18e1
VS8 13 s8 0
R8 s8 9 33e0
VS9 13 s9 0
R9 s9 15 33e2
VS10 3 s10 0
R10 s10 13 56e1
VS11 4 s11 0
R11 s11 8 82e1
VS12 6 s12 0
I12 s12 14 DC 39e-1
VS13 0 s13 0
V13 e13 s13 DC 10e0
RI13 e13 12 39e-3
VS14 10 s14 0
R14 s14 12 33e1
VS15 1 s15 0
R15 s15 15 18e-1
.control
set numdgt=17
op
print v(1) v(2) v(3) v(4) v(5) v(6) v(7) v(8) v(9) v(10)
print v(11) v(12) v(13) v(14) v(15)
print i(vs0) i(vs1) i(vs2) i(vs3) i(vs4) i(vs5) i(vs6) i(vs7) i(vs8) i(vs9)
print i(vs10) i(vs11) i(vs12) i(vs13) i(vs14) i(vs15)
.endc
.end
