controls oracle dc-0169
* Generated (plan F2.7, ADR 0012): do not edit; regenerate with `pnpm sim oracle regen`. dc seed 20261030 index 169 nodes 16 elements 24
.options sparse gmin=1e-12 noopac
RG1 1 0 1000000000000
RG2 2 0 1000000000000
RG3 3 0 1000000000000
RG4 4 0 1000000000000
RG5 5 0 1000000000000
RG6 6 0 1000000000000
RG7 7 0 1000000000000
RG8 8 0 1000000000000
RG9 9 0 1000000000000
RG10 10 0 1000000000000
RG11 11 0 1000000000000
RG12 12 0 1000000000000
RG13 13 0 1000000000000
RG14 14 0 1000000000000
RG15 15 0 1000000000000
VS0 3 s0 0
R0 s0 11 18e1
VS1 2 s1 0
R1 s1 1 12e-2
VS2 4 s2 0
R2 s2 0 82e1
VS3 4 s3 0
R3 s3 7 68e0
VS4 1 s4 0
R4 s4 5 18e2
VS5 10 s5 0
R5 s5 12 33e1
VS6 2 s6 0
R6 s6 9 82e0
VS7 1 s7 0
R7 s7 15 18e-1
VS8 2 s8 0
R8 s8 4 15e-1
VS9 0 s9 0
V9 e9 s9 DC 18e0
RI9 e9 2 12e-3
VS10 1 s10 0
R10 s10 14 82e3
VS11 2 s11 0
V11 e11 s11 DC 12e1
RI11 e11 6 22e-3
VS12 13 s12 0
R12 s12 15 33e2
VS13 1 s13 0
R13 s13 11 47e3
VS14 8 s14 0
R14 s14 5 10e1
VS15 13 s15 0
R15 s15 8 33e0
VS16 8 s16 0
R16 s16 7 12e0
VS17 8 s17 0
R17 s17 6 56e2
VS18 13 s18 0
R18 s18 4 10e-1
VS19 14 s19 0
R19 s19 13 27e1
VS20 9 s20 0
V20 e20 s20 DC 10e0
RI20 e20 12 39e-3
VS21 3 s21 0
R21 s21 13 56e1
VS22 6 s22 0
I22 s22 14 DC 39e-1
VS23 10 s23 0
R23 s23 15 10e3
.control
set numdgt=17
op
print v(1) v(2) v(3) v(4) v(5) v(6) v(7) v(8) v(9) v(10)
print v(11) v(12) v(13) v(14) v(15)
print i(vs0) i(vs1) i(vs2) i(vs3) i(vs4) i(vs5) i(vs6) i(vs7) i(vs8) i(vs9)
print i(vs10) i(vs11) i(vs12) i(vs13) i(vs14) i(vs15) i(vs16) i(vs17) i(vs18) i(vs19)
print i(vs20) i(vs21) i(vs22) i(vs23)
.endc
.end
