controls oracle dc-0444
* Generated (plan F2.7, ADR 0012): do not edit; regenerate with `pnpm sim oracle regen`. dc seed 20261030 index 444 nodes 15 elements 25
.options sparse gmin=1e-12 noopac
RG1 1 0 1000000000000
RG2 2 0 1000000000000
RG3 3 0 1000000000000
RG4 4 0 1000000000000
RG5 5 0 1000000000000
RG6 6 0 1000000000000
RG7 7 0 1000000000000
RG8 8 0 1000000000000
RG9 9 0 1000000000000
RG10 10 0 1000000000000
RG11 11 0 1000000000000
RG12 12 0 1000000000000
RG13 13 0 1000000000000
RG14 14 0 1000000000000
VS0 9 s0 0
R0 s0 4 33e1
VS1 0 s1 0
V1 e1 s1 DC 12e0
RI1 e1 3 10e-1
VS2 11 s2 0
R2 s2 4 22e-2
VS3 7 s3 0
R3 s3 1 22e2
VS4 3 s4 0
I4 s4 12 DC 39e-1
VS5 2 s5 0
R5 s5 14 39e3
VS6 14 s6 0
R6 s6 4 10e-1
VS7 8 s7 0
I7 s7 7 DC 39e-4
VS8 8 s8 0
R8 s8 5 47e3
VS9 1 s9 0
R9 s9 11 15e3
VS10 0 s10 0
R10 s10 1 27e2
VS11 8 s11 0
R11 s11 14 68e-1
VS12 9 s12 0
R12 s12 6 68e-2
VS13 14 s13 0
R13 s13 13 10e0
VS14 8 s14 0
R14 s14 11 10e-1
VS15 11 s15 0
R15 s15 10 68e2
VS16 6 s16 0
R16 s16 7 33e3
VS17 5 s17 0
R17 s17 11 39e-1
VS18 10 s18 0
R18 s18 12 22e3
VS19 9 s19 0
R19 s19 5 56e-2
VS20 10 s20 0
R20 s20 14 33e-2
VS21 12 s21 0
V21 e21 s21 DC 68e1
RI21 e21 5 18e-2
VS22 12 s22 0
R22 s22 5 22e-1
VS23 9 s23 0
R23 s23 10 47e-1
VS24 2 s24 0
R24 s24 12 18e-2
.control
set numdgt=17
op
print v(1) v(2) v(3) v(4) v(5) v(6) v(7) v(8) v(9) v(10)
print v(11) v(12) v(13) v(14)
print i(vs0) i(vs1) i(vs2) i(vs3) i(vs4) i(vs5) i(vs6) i(vs7) i(vs8) i(vs9)
print i(vs10) i(vs11) i(vs12) i(vs13) i(vs14) i(vs15) i(vs16) i(vs17) i(vs18) i(vs19)
print i(vs20) i(vs21) i(vs22) i(vs23) i(vs24)
.endc
.end
