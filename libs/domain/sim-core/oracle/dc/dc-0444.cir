controls oracle dc-0444
* Generated (plan F2.7, ADR 0012): do not edit; regenerate with `pnpm sim oracle regen`. dc seed 20261030 index 444 nodes 15 elements 27
.options sparse gmin=1e-12 noopac
RG1 1 0 1000000000000
RG2 2 0 1000000000000
RG3 3 0 1000000000000
RG4 4 0 1000000000000
RG5 5 0 1000000000000
RG6 6 0 1000000000000
RG7 7 0 1000000000000
RG8 8 0 1000000000000
RG9 9 0 1000000000000
RG10 10 0 1000000000000
RG11 11 0 1000000000000
RG12 12 0 1000000000000
RG13 13 0 1000000000000
RG14 14 0 1000000000000
VS0 8 s0 0
I0 s0 7 DC 39e-4
VS1 9 s1 0
R1 s1 10 47e-1
VS2 0 s2 0
V2 e2 s2 DC 12e0
RI2 e2 3 10e-1
VS3 6 s3 0
R3 s3 7 33e3
VS4 10 s4 0
R4 s4 12 22e3
VS5 7 s5 0
R5 s5 1 22e2
VS6 14 s6 0
R6 s6 13 10e0
VS7 2 s7 0
R7 s7 14 39e3
VS8 12 s8 0
R8 s8 5 22e-1
VS9 8 s9 0
R9 s9 14 68e-1
VS10 12 s10 0
V10 e10 s10 DC 68e1
RI10 e10 5 18e-2
VS11 5 s11 0
R11 s11 11 39e-1
VS12 11 s12 0
R12 s12 10 68e2
VS13 13 s13 0
R13 s13 7 68e2
VS14 8 s14 0
R14 s14 11 10e-1
VS15 9 s15 0
R15 s15 5 56e-2
VS16 9 s16 0
R16 s16 4 33e1
VS17 3 s17 0
R17 s17 9 18e-1
VS18 9 s18 0
R18 s18 6 68e-2
VS19 10 s19 0
R19 s19 14 33e-2
VS20 1 s20 0
R20 s20 11 15e3
VS21 3 s21 0
I21 s21 12 DC 39e-1
VS22 8 s22 0
R22 s22 5 47e3
VS23 11 s23 0
R23 s23 4 22e-2
VS24 14 s24 0
R24 s24 4 10e-1
VS25 2 s25 0
R25 s25 12 18e-2
VS26 0 s26 0
R26 s26 1 27e2
.control
set numdgt=17
op
print v(1) v(2) v(3) v(4) v(5) v(6) v(7) v(8) v(9) v(10)
print v(11) v(12) v(13) v(14)
print i(vs0) i(vs1) i(vs2) i(vs3) i(vs4) i(vs5) i(vs6) i(vs7) i(vs8) i(vs9)
print i(vs10) i(vs11) i(vs12) i(vs13) i(vs14) i(vs15) i(vs16) i(vs17) i(vs18) i(vs19)
print i(vs20) i(vs21) i(vs22) i(vs23) i(vs24) i(vs25) i(vs26)
.endc
.end
