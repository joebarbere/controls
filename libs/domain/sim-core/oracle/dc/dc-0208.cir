controls oracle dc-0208
* Generated (plan F2.7, ADR 0012): do not edit; regenerate with `pnpm sim oracle regen`. dc seed 20261030 index 208 nodes 7 elements 13
.options sparse gmin=1e-12 noopac
RG1 1 0 1000000000000
RG2 2 0 1000000000000
RG3 3 0 1000000000000
RG4 4 0 1000000000000
RG5 5 0 1000000000000
RG6 6 0 1000000000000
VS0 5 s0 0
R0 s0 4 68e1
VS1 6 s1 0
I1 s1 4 DC 47e-4
VS2 0 s2 0
V2 e2 s2 DC 15e1
RI2 e2 4 47e-2
VS3 5 s3 0
I3 s3 3 DC 15e-2
VS4 4 s4 0
I4 s4 1 DC 22e-3
VS5 0 s5 0
R5 s5 3 10e0
VS6 5 s6 0
V6 e6 s6 DC 18e0
RI6 e6 1 18e-2
VS7 2 s7 0
I7 s7 5 DC 47e-3
VS8 5 s8 0
R8 s8 1 56e2
VS9 6 s9 0
R9 s9 1 33e-1
VS10 4 s10 0
R10 s10 6 12e0
VS11 3 s11 0
R11 s11 2 15e2
VS12 3 s12 0
R12 s12 1 82e-1
.control
set numdgt=17
op
print v(1) v(2) v(3) v(4) v(5) v(6)
print i(vs0) i(vs1) i(vs2) i(vs3) i(vs4) i(vs5) i(vs6) i(vs7) i(vs8) i(vs9)
print i(vs10) i(vs11) i(vs12)
.endc
.end
