controls oracle dc-0208
* Generated (plan F2.7, ADR 0012): do not edit; regenerate with `pnpm sim oracle regen`. dc seed 20261030 index 208 nodes 7 elements 14
.options sparse gmin=1e-12 noopac
RG1 1 0 1000000000000
RG2 2 0 1000000000000
RG3 3 0 1000000000000
RG4 4 0 1000000000000
RG5 5 0 1000000000000
RG6 6 0 1000000000000
VS0 3 s0 0
R0 s0 1 82e-1
VS1 0 s1 0
V1 e1 s1 DC 18e0
RI1 e1 1 18e-2
VS2 0 s2 0
R2 s2 1 56e2
VS3 4 s3 0
R3 s3 3 10e0
VS4 6 s4 0
I4 s4 5 DC 47e-4
VS5 0 s5 0
I5 s5 3 DC 15e-2
VS6 5 s6 0
R6 s6 6 12e0
VS7 3 s7 0
R7 s7 2 15e2
VS8 2 s8 0
R8 s8 1 39e3
VS9 4 s9 0
V9 e9 s9 DC 15e1
RI9 e9 5 47e-2
VS10 6 s10 0
R10 s10 1 33e-1
VS11 0 s11 0
R11 s11 5 68e1
VS12 5 s12 0
I12 s12 1 DC 22e-3
VS13 2 s13 0
I13 s13 0 DC 47e-3
.control
set numdgt=17
op
print v(1) v(2) v(3) v(4) v(5) v(6)
print i(vs0) i(vs1) i(vs2) i(vs3) i(vs4) i(vs5) i(vs6) i(vs7) i(vs8) i(vs9)
print i(vs10) i(vs11) i(vs12) i(vs13)
.endc
.end
