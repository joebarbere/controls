controls oracle dc-0072
* Generated (plan F2.7, ADR 0012): do not edit; regenerate with `pnpm sim oracle regen`. dc seed 20261030 index 72 nodes 25 elements 43
.options sparse gmin=1e-12 noopac
RG1 1 0 1000000000000
RG2 2 0 1000000000000
RG3 3 0 1000000000000
RG4 4 0 1000000000000
RG5 5 0 1000000000000
RG6 6 0 1000000000000
RG7 7 0 1000000000000
RG8 8 0 1000000000000
RG9 9 0 1000000000000
RG10 10 0 1000000000000
RG11 11 0 1000000000000
RG12 12 0 1000000000000
RG13 13 0 1000000000000
RG14 14 0 1000000000000
RG15 15 0 1000000000000
RG16 16 0 1000000000000
RG17 17 0 1000000000000
RG18 18 0 1000000000000
RG19 19 0 1000000000000
RG20 20 0 1000000000000
RG21 21 0 1000000000000
RG22 22 0 1000000000000
RG23 23 0 1000000000000
RG24 24 0 1000000000000
VS0 11 s0 0
R0 s0 21 39e0
VS1 20 s1 0
R1 s1 23 22e1
VS2 20 s2 0
R2 s2 23 39e0
VS3 11 s3 0
R3 s3 18 82e-2
VS4 21 s4 0
I4 s4 6 DC 39e-4
VS5 22 s5 0
R5 s5 14 47e0
VS6 2 s6 0
R6 s6 14 33e1
VS7 15 s7 0
R7 s7 12 27e-1
VS8 21 s8 0
R8 s8 5 10e-1
VS9 10 s9 0
R9 s9 1 39e-1
VS10 12 s10 0
R10 s10 7 56e2
VS11 14 s11 0
R11 s11 16 82e-2
VS12 1 s12 0
R12 s12 11 15e-2
VS13 13 s13 0
R13 s13 3 15e-1
VS14 7 s14 0
R14 s14 11 12e-1
VS15 20 s15 0
R15 s15 6 82e1
VS16 4 s16 0
R16 s16 14 22e-2
VS17 17 s17 0
I17 s17 3 DC 15e-3
VS18 7 s18 0
R18 s18 6 68e-2
VS19 20 s19 0
R19 s19 10 12e-1
VS20 14 s20 0
R20 s20 0 47e-2
VS21 0 s21 0
V21 e21 s21 DC 27e-1
RI21 e21 13 22e-3
VS22 3 s22 0
R22 s22 6 12e1
VS23 20 s23 0
R23 s23 19 27e0
VS24 8 s24 0
V24 e24 s24 DC 22e-1
RI24 e24 11 10e-3
VS25 24 s25 0
V25 e25 s25 DC 82e1
RI25 e25 20 27e-3
VS26 23 s26 0
R26 s26 18 15e2
VS27 14 s27 0
V27 e27 s27 DC 12e1
RI27 e27 19 27e-1
VS28 19 s28 0
R28 s28 9 22e0
VS29 1 s29 0
R29 s29 15 27e0
VS30 24 s30 0
V30 e30 s30 DC 18e1
RI30 e30 17 56e-1
VS31 17 s31 0
R31 s31 22 12e0
VS32 9 s32 0
R32 s32 22 47e0
VS33 23 s33 0
V33 e33 s33 DC 27e0
RI33 e33 1 27e-2
VS34 6 s34 0
R34 s34 7 47e0
VS35 13 s35 0
I35 s35 19 DC 18e-2
VS36 14 s36 0
R36 s36 23 10e2
VS37 16 s37 0
R37 s37 4 10e-1
VS38 12 s38 0
R38 s38 5 12e3
VS39 18 s39 0
R39 s39 0 39e3
VS40 16 s40 0
R40 s40 23 12e-2
VS41 8 s41 0
R41 s41 14 39e1
VS42 8 s42 0
V42 e42 s42 DC 56e1
RI42 e42 2 33e-2
.control
set numdgt=17
op
print v(1) v(2) v(3) v(4) v(5) v(6) v(7) v(8) v(9) v(10)
print v(11) v(12) v(13) v(14) v(15) v(16) v(17) v(18) v(19) v(20)
print v(21) v(22) v(23) v(24)
print i(vs0) i(vs1) i(vs2) i(vs3) i(vs4) i(vs5) i(vs6) i(vs7) i(vs8) i(vs9)
print i(vs10) i(vs11) i(vs12) i(vs13) i(vs14) i(vs15) i(vs16) i(vs17) i(vs18) i(vs19)
print i(vs20) i(vs21) i(vs22) i(vs23) i(vs24) i(vs25) i(vs26) i(vs27) i(vs28) i(vs29)
print i(vs30) i(vs31) i(vs32) i(vs33) i(vs34) i(vs35) i(vs36) i(vs37) i(vs38) i(vs39)
print i(vs40) i(vs41) i(vs42)
.endc
.end
