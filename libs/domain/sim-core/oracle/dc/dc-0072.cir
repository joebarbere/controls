controls oracle dc-0072
* Generated (plan F2.7, ADR 0012): do not edit; regenerate with `pnpm sim oracle regen`. dc seed 20261030 index 72 nodes 25 elements 39
.options sparse gmin=1e-12 noopac
RG1 1 0 1000000000000
RG2 2 0 1000000000000
RG3 3 0 1000000000000
RG4 4 0 1000000000000
RG5 5 0 1000000000000
RG6 6 0 1000000000000
RG7 7 0 1000000000000
RG8 8 0 1000000000000
RG9 9 0 1000000000000
RG10 10 0 1000000000000
RG11 11 0 1000000000000
RG12 12 0 1000000000000
RG13 13 0 1000000000000
RG14 14 0 1000000000000
RG15 15 0 1000000000000
RG16 16 0 1000000000000
RG17 17 0 1000000000000
RG18 18 0 1000000000000
RG19 19 0 1000000000000
RG20 20 0 1000000000000
RG21 21 0 1000000000000
RG22 22 0 1000000000000
RG23 23 0 1000000000000
RG24 24 0 1000000000000
VS0 21 s0 0
R0 s0 5 10e-1
VS1 0 s1 0
V1 e1 s1 DC 12e1
RI1 e1 19 27e-1
VS2 20 s2 0
R2 s2 23 22e1
VS3 0 s3 0
R3 s3 23 10e2
VS4 22 s4 0
R4 s4 0 47e0
VS5 7 s5 0
R5 s5 6 68e-2
VS6 17 s6 0
I6 s6 3 DC 15e-3
VS7 1 s7 0
R7 s7 15 27e0
VS8 12 s8 0
R8 s8 5 12e3
VS9 2 s9 0
R9 s9 0 33e1
VS10 13 s10 0
I10 s10 19 DC 18e-2
VS11 16 s11 0
V11 e11 s11 DC 27e-1
RI11 e11 13 22e-3
VS12 8 s12 0
R12 s12 0 39e1
VS13 20 s13 0
R13 s13 23 39e0
VS14 0 s14 0
R14 s14 16 47e-2
VS15 20 s15 0
R15 s15 6 82e1
VS16 10 s16 0
R16 s16 1 39e-1
VS17 0 s17 0
R17 s17 14 82e-2
VS18 23 s18 0
V18 e18 s18 DC 27e0
RI18 e18 1 27e-2
VS19 11 s19 0
R19 s19 18 82e-2
VS20 23 s20 0
R20 s20 18 15e2
VS21 3 s21 0
R21 s21 6 12e1
VS22 8 s22 0
V22 e22 s22 DC 56e1
RI22 e22 2 33e-2
VS23 20 s23 0
R23 s23 19 27e0
VS24 7 s24 0
R24 s24 11 12e-1
VS25 6 s25 0
R25 s25 7 47e0
VS26 24 s26 0
V26 e26 s26 DC 82e1
RI26 e26 20 27e-3
VS27 20 s27 0
R27 s27 10 12e-1
VS28 9 s28 0
R28 s28 22 47e0
VS29 21 s29 0
I29 s29 6 DC 39e-4
VS30 8 s30 0
V30 e30 s30 DC 22e-1
RI30 e30 11 10e-3
VS31 18 s31 0
R31 s31 16 39e3
VS32 15 s32 0
R32 s32 12 27e-1
VS33 1 s33 0
R33 s33 11 15e-2
VS34 14 s34 0
R34 s34 23 12e-2
VS35 17 s35 0
R35 s35 22 12e0
VS36 12 s36 0
R36 s36 7 56e2
VS37 14 s37 0
R37 s37 4 10e-1
VS38 11 s38 0
R38 s38 21 39e0
.control
set numdgt=17
op
print v(1) v(2) v(3) v(4) v(5) v(6) v(7) v(8) v(9) v(10)
print v(11) v(12) v(13) v(14) v(15) v(16) v(17) v(18) v(19) v(20)
print v(21) v(22) v(23) v(24)
print i(vs0) i(vs1) i(vs2) i(vs3) i(vs4) i(vs5) i(vs6) i(vs7) i(vs8) i(vs9)
print i(vs10) i(vs11) i(vs12) i(vs13) i(vs14) i(vs15) i(vs16) i(vs17) i(vs18) i(vs19)
print i(vs20) i(vs21) i(vs22) i(vs23) i(vs24) i(vs25) i(vs26) i(vs27) i(vs28) i(vs29)
print i(vs30) i(vs31) i(vs32) i(vs33) i(vs34) i(vs35) i(vs36) i(vs37) i(vs38)
.endc
.end
