controls oracle dc-0171
* Generated (plan F2.7, ADR 0012): do not edit; regenerate with `pnpm sim oracle regen`. dc seed 20261030 index 171 nodes 30 elements 30
.options sparse gmin=1e-12 noopac
RG1 1 0 1000000000000
RG2 2 0 1000000000000
RG3 3 0 1000000000000
RG4 4 0 1000000000000
RG5 5 0 1000000000000
RG6 6 0 1000000000000
RG7 7 0 1000000000000
RG8 8 0 1000000000000
RG9 9 0 1000000000000
RG10 10 0 1000000000000
RG11 11 0 1000000000000
RG12 12 0 1000000000000
RG13 13 0 1000000000000
RG14 14 0 1000000000000
RG15 15 0 1000000000000
RG16 16 0 1000000000000
RG17 17 0 1000000000000
RG18 18 0 1000000000000
RG19 19 0 1000000000000
RG20 20 0 1000000000000
RG21 21 0 1000000000000
RG22 22 0 1000000000000
RG23 23 0 1000000000000
RG24 24 0 1000000000000
RG25 25 0 1000000000000
RG26 26 0 1000000000000
RG27 27 0 1000000000000
RG28 28 0 1000000000000
RG29 29 0 1000000000000
VS0 27 s0 0
R0 s0 26 39e2
VS1 0 s1 0
V1 e1 s1 DC 15e1
RI1 e1 25 39e-1
VS2 24 s2 0
V2 e2 s2 DC 10e-1
RI2 e2 0 27e-1
VS3 16 s3 0
R3 s3 29 82e-1
VS4 8 s4 0
V4 e4 s4 DC 33e1
RI4 e4 15 27e-3
VS5 8 s5 0
R5 s5 23 82e1
VS6 4 s6 0
R6 s6 0 39e-2
VS7 14 s7 0
R7 s7 12 27e3
VS8 22 s8 0
R8 s8 15 47e1
VS9 21 s9 0
V9 e9 s9 DC 18e1
RI9 e9 1 82e-1
VS10 16 s10 0
V10 e10 s10 DC 33e-1
RI10 e10 22 39e-1
VS11 2 s11 0
V11 e11 s11 DC 47e1
RI11 e11 6 39e-2
VS12 4 s12 0
R12 s12 20 18e3
VS13 18 s13 0
R13 s13 3 10e-2
VS14 8 s14 0
R14 s14 15 12e-2
VS15 17 s15 0
R15 s15 15 12e1
VS16 11 s16 0
R16 s16 22 10e-2
VS17 27 s17 0
R17 s17 21 10e-1
VS18 22 s18 0
R18 s18 7 12e1
VS19 9 s19 0
R19 s19 14 39e-2
VS20 22 s20 0
R20 s20 19 12e1
VS21 2 s21 0
R21 s21 22 56e3
VS22 12 s22 0
R22 s22 10 12e-2
VS23 9 s23 0
R23 s23 18 33e1
VS24 9 s24 0
R24 s24 0 12e3
VS25 9 s25 0
R25 s25 28 39e0
VS26 13 s26 0
R26 s26 12 18e0
VS27 5 s27 0
R27 s27 8 10e-2
VS28 8 s28 0
R28 s28 0 22e-1
VS29 21 s29 0
R29 s29 22 18e2
.control
set numdgt=17
op
print v(1) v(2) v(3) v(4) v(5) v(6) v(7) v(8) v(9) v(10)
print v(11) v(12) v(13) v(14) v(15) v(16) v(17) v(18) v(19) v(20)
print v(21) v(22) v(23) v(24) v(25) v(26) v(27) v(28) v(29)
print i(vs0) i(vs1) i(vs2) i(vs3) i(vs4) i(vs5) i(vs6) i(vs7) i(vs8) i(vs9)
print i(vs10) i(vs11) i(vs12) i(vs13) i(vs14) i(vs15) i(vs16) i(vs17) i(vs18) i(vs19)
print i(vs20) i(vs21) i(vs22) i(vs23) i(vs24) i(vs25) i(vs26) i(vs27) i(vs28) i(vs29)
.endc
.end
