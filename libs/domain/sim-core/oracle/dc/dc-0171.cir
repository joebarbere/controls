controls oracle dc-0171
* Generated (plan F2.7, ADR 0012): do not edit; regenerate with `pnpm sim oracle regen`. dc seed 20261030 index 171 nodes 30 elements 42
.options sparse gmin=1e-12 noopac
RG1 1 0 1000000000000
RG2 2 0 1000000000000
RG3 3 0 1000000000000
RG4 4 0 1000000000000
RG5 5 0 1000000000000
RG6 6 0 1000000000000
RG7 7 0 1000000000000
RG8 8 0 1000000000000
RG9 9 0 1000000000000
RG10 10 0 1000000000000
RG11 11 0 1000000000000
RG12 12 0 1000000000000
RG13 13 0 1000000000000
RG14 14 0 1000000000000
RG15 15 0 1000000000000
RG16 16 0 1000000000000
RG17 17 0 1000000000000
RG18 18 0 1000000000000
RG19 19 0 1000000000000
RG20 20 0 1000000000000
RG21 21 0 1000000000000
RG22 22 0 1000000000000
RG23 23 0 1000000000000
RG24 24 0 1000000000000
RG25 25 0 1000000000000
RG26 26 0 1000000000000
RG27 27 0 1000000000000
RG28 28 0 1000000000000
RG29 29 0 1000000000000
VS0 0 s0 0
V0 e0 s0 DC 15e1
RI0 e0 25 39e-1
VS1 12 s1 0
R1 s1 10 12e-2
VS2 9 s2 0
R2 s2 18 33e1
VS3 21 s3 0
R3 s3 22 18e2
VS4 8 s4 0
R4 s4 23 82e1
VS5 10 s5 0
R5 s5 24 10e1
VS6 3 s6 0
R6 s6 29 39e1
VS7 22 s7 0
R7 s7 25 68e0
VS8 9 s8 0
R8 s8 14 39e-2
VS9 16 s9 0
R9 s9 29 82e-1
VS10 28 s10 0
R10 s10 3 18e1
VS11 20 s11 0
R11 s11 16 22e0
VS12 22 s12 0
R12 s12 15 47e1
VS13 5 s13 0
R13 s13 8 10e-2
VS14 6 s14 0
R14 s14 11 27e2
VS15 5 s15 0
R15 s15 3 18e-2
VS16 9 s16 0
R16 s16 28 39e0
VS17 8 s17 0
V17 e17 s17 DC 33e1
RI17 e17 15 27e-3
VS18 9 s18 0
R18 s18 0 12e3
VS19 4 s19 0
R19 s19 20 18e3
VS20 27 s20 0
R20 s20 26 39e2
VS21 2 s21 0
V21 e21 s21 DC 47e1
RI21 e21 6 39e-2
VS22 2 s22 0
R22 s22 23 47e1
VS23 4 s23 0
R23 s23 0 39e-2
VS24 14 s24 0
R24 s24 12 27e3
VS25 7 s25 0
R25 s25 15 68e0
VS26 2 s26 0
R26 s26 22 56e3
VS27 22 s27 0
R27 s27 7 12e1
VS28 19 s28 0
R28 s28 8 10e-2
VS29 1 s29 0
R29 s29 17 39e0
VS30 11 s30 0
R30 s30 22 10e-2
VS31 8 s31 0
R31 s31 0 22e-1
VS32 16 s32 0
V32 e32 s32 DC 33e-1
RI32 e32 22 39e-1
VS33 27 s33 0
R33 s33 21 10e-1
VS34 23 s34 0
R34 s34 13 18e1
VS35 26 s35 0
R35 s35 22 82e1
VS36 22 s36 0
R36 s36 19 12e1
VS37 13 s37 0
R37 s37 12 18e0
VS38 24 s38 0
V38 e38 s38 DC 10e-1
RI38 e38 0 27e-1
VS39 18 s39 0
R39 s39 3 10e-2
VS40 21 s40 0
V40 e40 s40 DC 18e1
RI40 e40 1 82e-1
VS41 17 s41 0
R41 s41 15 12e1
.control
set numdgt=17
op
print v(1) v(2) v(3) v(4) v(5) v(6) v(7) v(8) v(9) v(10)
print v(11) v(12) v(13) v(14) v(15) v(16) v(17) v(18) v(19) v(20)
print v(21) v(22) v(23) v(24) v(25) v(26) v(27) v(28) v(29)
print i(vs0) i(vs1) i(vs2) i(vs3) i(vs4) i(vs5) i(vs6) i(vs7) i(vs8) i(vs9)
print i(vs10) i(vs11) i(vs12) i(vs13) i(vs14) i(vs15) i(vs16) i(vs17) i(vs18) i(vs19)
print i(vs20) i(vs21) i(vs22) i(vs23) i(vs24) i(vs25) i(vs26) i(vs27) i(vs28) i(vs29)
print i(vs30) i(vs31) i(vs32) i(vs33) i(vs34) i(vs35) i(vs36) i(vs37) i(vs38) i(vs39)
print i(vs40) i(vs41)
.endc
.end
