controls oracle dc-0192
* Generated (plan F2.7, ADR 0012): do not edit; regenerate with `pnpm sim oracle regen`. dc seed 20261030 index 192 nodes 11 elements 21
.options sparse gmin=1e-12 noopac
RG1 1 0 1000000000000
RG2 2 0 1000000000000
RG3 3 0 1000000000000
RG4 4 0 1000000000000
RG5 5 0 1000000000000
RG6 6 0 1000000000000
RG7 7 0 1000000000000
RG8 8 0 1000000000000
RG9 9 0 1000000000000
RG10 10 0 1000000000000
VS0 0 s0 0
V0 e0 s0 DC 10e1
RI0 e0 7 10e-2
VS1 1 s1 0
V1 e1 s1 DC 33e0
RI1 e1 5 39e-2
VS2 9 s2 0
R2 s2 3 39e1
VS3 3 s3 0
R3 s3 1 33e-1
VS4 6 s4 0
I4 s4 3 DC 56e-4
VS5 1 s5 0
I5 s5 7 DC 15e-1
VS6 0 s6 0
R6 s6 5 27e1
VS7 10 s7 0
R7 s7 4 15e3
VS8 2 s8 0
R8 s8 5 68e2
VS9 0 s9 0
R9 s9 2 10e0
VS10 10 s10 0
R10 s10 6 27e3
VS11 9 s11 0
V11 e11 s11 DC 22e-1
RI11 e11 7 18e-1
VS12 8 s12 0
R12 s12 2 22e-1
VS13 10 s13 0
R13 s13 8 82e0
VS14 5 s14 0
V14 e14 s14 DC 47e-1
RI14 e14 8 18e-1
VS15 8 s15 0
V15 e15 s15 DC 22e1
RI15 e15 2 10e-3
VS16 2 s16 0
R16 s16 3 82e1
VS17 5 s17 0
R17 s17 6 56e3
VS18 2 s18 0
V18 e18 s18 DC 82e-1
RI18 e18 5 56e-3
VS19 6 s19 0
R19 s19 4 56e2
VS20 5 s20 0
R20 s20 7 10e0
.control
set numdgt=17
op
print v(1) v(2) v(3) v(4) v(5) v(6) v(7) v(8) v(9) v(10)
print i(vs0) i(vs1) i(vs2) i(vs3) i(vs4) i(vs5) i(vs6) i(vs7) i(vs8) i(vs9)
print i(vs10) i(vs11) i(vs12) i(vs13) i(vs14) i(vs15) i(vs16) i(vs17) i(vs18) i(vs19)
print i(vs20)
.endc
.end
