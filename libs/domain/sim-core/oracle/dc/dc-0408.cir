controls oracle dc-0408
* Generated (plan F2.7, ADR 0012): do not edit; regenerate with `pnpm sim oracle regen`. dc seed 20261030 index 408 nodes 15 elements 24
.options sparse gmin=1e-12 noopac
RG1 1 0 1000000000000
RG2 2 0 1000000000000
RG3 3 0 1000000000000
RG4 4 0 1000000000000
RG5 5 0 1000000000000
RG6 6 0 1000000000000
RG7 7 0 1000000000000
RG8 8 0 1000000000000
RG9 9 0 1000000000000
RG10 10 0 1000000000000
RG11 11 0 1000000000000
RG12 12 0 1000000000000
RG13 13 0 1000000000000
RG14 14 0 1000000000000
VS0 7 s0 0
R0 s0 11 68e-2
VS1 8 s1 0
R1 s1 10 27e2
VS2 14 s2 0
R2 s2 8 47e2
VS3 0 s3 0
R3 s3 4 47e3
VS4 8 s4 0
R4 s4 6 68e-2
VS5 9 s5 0
I5 s5 6 DC 22e-3
VS6 2 s6 0
R6 s6 5 15e2
VS7 0 s7 0
V7 e7 s7 DC 15e1
RI7 e7 1 12e-2
VS8 11 s8 0
R8 s8 13 39e-2
VS9 2 s9 0
R9 s9 6 18e-2
VS10 3 s10 0
R10 s10 10 22e0
VS11 14 s11 0
I11 s11 2 DC 82e-4
VS12 4 s12 0
R12 s12 2 68e0
VS13 13 s13 0
R13 s13 9 47e3
VS14 13 s14 0
R14 s14 6 39e-1
VS15 8 s15 0
R15 s15 3 33e2
VS16 8 s16 0
V16 e16 s16 DC 56e0
RI16 e16 7 10e-2
VS17 1 s17 0
R17 s17 14 18e2
VS18 14 s18 0
I18 s18 2 DC 10e-2
VS19 12 s19 0
R19 s19 7 56e-2
VS20 3 s20 0
R20 s20 9 18e0
VS21 9 s21 0
V21 e21 s21 DC 39e0
RI21 e21 1 15e-3
VS22 9 s22 0
R22 s22 0 47e0
VS23 14 s23 0
R23 s23 10 68e-2
.control
set numdgt=17
op
print v(1) v(2) v(3) v(4) v(5) v(6) v(7) v(8) v(9) v(10)
print v(11) v(12) v(13) v(14)
print i(vs0) i(vs1) i(vs2) i(vs3) i(vs4) i(vs5) i(vs6) i(vs7) i(vs8) i(vs9)
print i(vs10) i(vs11) i(vs12) i(vs13) i(vs14) i(vs15) i(vs16) i(vs17) i(vs18) i(vs19)
print i(vs20) i(vs21) i(vs22) i(vs23)
.endc
.end
