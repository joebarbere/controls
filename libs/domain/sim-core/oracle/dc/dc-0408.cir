controls oracle dc-0408
* Generated (plan F2.7, ADR 0012): do not edit; regenerate with `pnpm sim oracle regen`. dc seed 20261030 index 408 nodes 15 elements 26
.options sparse gmin=1e-12 noopac
RG1 1 0 1000000000000
RG2 2 0 1000000000000
RG3 3 0 1000000000000
RG4 4 0 1000000000000
RG5 5 0 1000000000000
RG6 6 0 1000000000000
RG7 7 0 1000000000000
RG8 8 0 1000000000000
RG9 9 0 1000000000000
RG10 10 0 1000000000000
RG11 11 0 1000000000000
RG12 12 0 1000000000000
RG13 13 0 1000000000000
RG14 14 0 1000000000000
VS0 3 s0 0
R0 s0 9 18e0
VS1 12 s1 0
R1 s1 9 68e0
VS2 0 s2 0
V2 e2 s2 DC 56e0
RI2 e2 7 10e-2
VS3 1 s3 0
R3 s3 4 47e3
VS4 12 s4 0
R4 s4 7 56e-2
VS5 0 s5 0
R5 s5 10 27e2
VS6 11 s6 0
V6 e6 s6 DC 47e1
RI6 e6 5 33e-3
VS7 4 s7 0
R7 s7 2 68e0
VS8 0 s8 0
R8 s8 6 68e-2
VS9 14 s9 0
R9 s9 0 47e2
VS10 8 s10 0
R10 s10 14 18e2
VS11 9 s11 0
I11 s11 6 DC 22e-3
VS12 14 s12 0
I12 s12 2 DC 10e-2
VS13 2 s13 0
R13 s13 5 15e2
VS14 9 s14 0
V14 e14 s14 DC 39e0
RI14 e14 8 15e-3
VS15 2 s15 0
R15 s15 6 18e-2
VS16 14 s16 0
I16 s16 2 DC 82e-4
VS17 0 s17 0
R17 s17 3 33e2
VS18 13 s18 0
R18 s18 9 47e3
VS19 9 s19 0
R19 s19 1 47e0
VS20 11 s20 0
R20 s20 13 39e-2
VS21 1 s21 0
V21 e21 s21 DC 15e1
RI21 e21 8 12e-2
VS22 3 s22 0
R22 s22 10 22e0
VS23 13 s23 0
R23 s23 6 39e-1
VS24 7 s24 0
R24 s24 11 68e-2
VS25 14 s25 0
R25 s25 10 68e-2
.control
set numdgt=17
op
print v(1) v(2) v(3) v(4) v(5) v(6) v(7) v(8) v(9) v(10)
print v(11) v(12) v(13) v(14)
print i(vs0) i(vs1) i(vs2) i(vs3) i(vs4) i(vs5) i(vs6) i(vs7) i(vs8) i(vs9)
print i(vs10) i(vs11) i(vs12) i(vs13) i(vs14) i(vs15) i(vs16) i(vs17) i(vs18) i(vs19)
print i(vs20) i(vs21) i(vs22) i(vs23) i(vs24) i(vs25)
.endc
.end
