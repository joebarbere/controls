controls oracle dc-0032
* Generated (plan F2.7, ADR 0012): do not edit; regenerate with `pnpm sim oracle regen`. dc seed 20261030 index 32 nodes 19 elements 26
.options sparse gmin=1e-12 noopac
RG1 1 0 1000000000000
RG2 2 0 1000000000000
RG3 3 0 1000000000000
RG4 4 0 1000000000000
RG5 5 0 1000000000000
RG6 6 0 1000000000000
RG7 7 0 1000000000000
RG8 8 0 1000000000000
RG9 9 0 1000000000000
RG10 10 0 1000000000000
RG11 11 0 1000000000000
RG12 12 0 1000000000000
RG13 13 0 1000000000000
RG14 14 0 1000000000000
RG15 15 0 1000000000000
RG16 16 0 1000000000000
RG17 17 0 1000000000000
RG18 18 0 1000000000000
VS0 11 s0 0
R0 s0 2 15e0
VS1 18 s1 0
R1 s1 3 68e1
VS2 16 s2 0
R2 s2 11 33e0
VS3 0 s3 0
V3 e3 s3 DC 39e0
RI3 e3 10 10e-1
VS4 1 s4 0
R4 s4 18 56e-2
VS5 6 s5 0
V5 e5 s5 DC 27e-1
RI5 e5 12 18e-1
VS6 3 s6 0
R6 s6 0 39e2
VS7 16 s7 0
R7 s7 13 27e-1
VS8 12 s8 0
R8 s8 2 47e-2
VS9 9 s9 0
R9 s9 7 10e2
VS10 4 s10 0
V10 e10 s10 DC 82e-1
RI10 e10 12 82e-2
VS11 16 s11 0
R11 s11 14 15e3
VS12 8 s12 0
V12 e12 s12 DC 68e1
RI12 e12 11 56e-2
VS13 5 s13 0
R13 s13 8 56e-2
VS14 17 s14 0
R14 s14 15 10e3
VS15 8 s15 0
R15 s15 12 22e1
VS16 10 s16 0
R16 s16 13 18e0
VS17 6 s17 0
R17 s17 18 56e2
VS18 5 s18 0
R18 s18 7 68e2
VS19 4 s19 0
R19 s19 14 33e0
VS20 7 s20 0
R20 s20 17 10e-1
VS21 11 s21 0
R21 s21 9 18e3
VS22 15 s22 0
R22 s22 16 47e3
VS23 1 s23 0
R23 s23 14 18e-2
VS24 16 s24 0
R24 s24 10 47e2
VS25 14 s25 0
R25 s25 18 68e-1
.control
set numdgt=17
op
print v(1) v(2) v(3) v(4) v(5) v(6) v(7) v(8) v(9) v(10)
print v(11) v(12) v(13) v(14) v(15) v(16) v(17) v(18)
print i(vs0) i(vs1) i(vs2) i(vs3) i(vs4) i(vs5) i(vs6) i(vs7) i(vs8) i(vs9)
print i(vs10) i(vs11) i(vs12) i(vs13) i(vs14) i(vs15) i(vs16) i(vs17) i(vs18) i(vs19)
print i(vs20) i(vs21) i(vs22) i(vs23) i(vs24) i(vs25)
.endc
.end
