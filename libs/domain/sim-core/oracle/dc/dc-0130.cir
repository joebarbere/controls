controls oracle dc-0130
* Generated (plan F2.7, ADR 0012): do not edit; regenerate with `pnpm sim oracle regen`. dc seed 20261030 index 130 nodes 22 elements 39
.options sparse gmin=1e-12 noopac
RG1 1 0 1000000000000
RG2 2 0 1000000000000
RG3 3 0 1000000000000
RG4 4 0 1000000000000
RG5 5 0 1000000000000
RG6 6 0 1000000000000
RG7 7 0 1000000000000
RG8 8 0 1000000000000
RG9 9 0 1000000000000
RG10 10 0 1000000000000
RG11 11 0 1000000000000
RG12 12 0 1000000000000
RG13 13 0 1000000000000
RG14 14 0 1000000000000
RG15 15 0 1000000000000
RG16 16 0 1000000000000
RG17 17 0 1000000000000
RG18 18 0 1000000000000
RG19 19 0 1000000000000
RG20 20 0 1000000000000
RG21 21 0 1000000000000
VS0 9 s0 0
R0 s0 2 27e1
VS1 17 s1 0
R1 s1 19 10e2
VS2 20 s2 0
R2 s2 2 27e0
VS3 2 s3 0
R3 s3 5 12e1
VS4 0 s4 0
R4 s4 19 68e0
VS5 7 s5 0
I5 s5 21 DC 68e-1
VS6 17 s6 0
R6 s6 10 15e1
VS7 15 s7 0
R7 s7 4 39e2
VS8 1 s8 0
R8 s8 20 82e0
VS9 12 s9 0
R9 s9 18 56e-2
VS10 7 s10 0
R10 s10 9 47e2
VS11 21 s11 0
R11 s11 6 82e3
VS12 3 s12 0
R12 s12 14 10e2
VS13 13 s13 0
R13 s13 4 47e1
VS14 17 s14 0
I14 s14 2 DC 56e-1
VS15 0 s15 0
V15 e15 s15 DC 22e1
RI15 e15 9 22e-2
VS16 2 s16 0
V16 e16 s16 DC 22e1
RI16 e16 17 12e-3
VS17 14 s17 0
I17 s17 12 DC 15e-3
VS18 2 s18 0
R18 s18 12 68e1
VS19 14 s19 0
R19 s19 17 68e0
VS20 1 s20 0
R20 s20 3 33e3
VS21 8 s21 0
R21 s21 21 15e0
VS22 6 s22 0
V22 e22 s22 DC 12e1
RI22 e22 2 22e-2
VS23 19 s23 0
R23 s23 11 15e0
VS24 18 s24 0
R24 s24 0 68e-2
VS25 3 s25 0
R25 s25 17 56e1
VS26 18 s26 0
I26 s26 10 DC 68e-3
VS27 0 s27 0
I27 s27 4 DC 27e-1
VS28 8 s28 0
R28 s28 3 15e3
VS29 20 s29 0
R29 s29 13 10e3
VS30 15 s30 0
I30 s30 3 DC 33e-2
VS31 16 s31 0
R31 s31 8 68e0
VS32 4 s32 0
I32 s32 7 DC 12e-1
VS33 15 s33 0
I33 s33 0 DC 15e-1
VS34 7 s34 0
V34 e34 s34 DC 22e0
RI34 e34 2 22e-3
VS35 21 s35 0
R35 s35 9 10e1
VS36 3 s36 0
R36 s36 4 47e2
VS37 1 s37 0
I37 s37 12 DC 18e-4
VS38 8 s38 0
R38 s38 1 39e-1
.control
set numdgt=17
op
print v(1) v(2) v(3) v(4) v(5) v(6) v(7) v(8) v(9) v(10)
print v(11) v(12) v(13) v(14) v(15) v(16) v(17) v(18) v(19) v(20)
print v(21)
print i(vs0) i(vs1) i(vs2) i(vs3) i(vs4) i(vs5) i(vs6) i(vs7) i(vs8) i(vs9)
print i(vs10) i(vs11) i(vs12) i(vs13) i(vs14) i(vs15) i(vs16) i(vs17) i(vs18) i(vs19)
print i(vs20) i(vs21) i(vs22) i(vs23) i(vs24) i(vs25) i(vs26) i(vs27) i(vs28) i(vs29)
print i(vs30) i(vs31) i(vs32) i(vs33) i(vs34) i(vs35) i(vs36) i(vs37) i(vs38)
.endc
.end
