controls oracle dc-0215
* Generated (plan F2.7, ADR 0012): do not edit; regenerate with `pnpm sim oracle regen`. dc seed 20261030 index 215 nodes 22 elements 41
.options sparse gmin=1e-12 noopac
RG1 1 0 1000000000000
RG2 2 0 1000000000000
RG3 3 0 1000000000000
RG4 4 0 1000000000000
RG5 5 0 1000000000000
RG6 6 0 1000000000000
RG7 7 0 1000000000000
RG8 8 0 1000000000000
RG9 9 0 1000000000000
RG10 10 0 1000000000000
RG11 11 0 1000000000000
RG12 12 0 1000000000000
RG13 13 0 1000000000000
RG14 14 0 1000000000000
RG15 15 0 1000000000000
RG16 16 0 1000000000000
RG17 17 0 1000000000000
RG18 18 0 1000000000000
RG19 19 0 1000000000000
RG20 20 0 1000000000000
RG21 21 0 1000000000000
VS0 21 s0 0
R0 s0 17 22e1
VS1 0 s1 0
V1 e1 s1 DC 15e0
RI1 e1 19 22e-1
VS2 16 s2 0
V2 e2 s2 DC 47e1
RI2 e2 6 18e-2
VS3 2 s3 0
R3 s3 3 27e2
VS4 18 s4 0
V4 e4 s4 DC 12e-1
RI4 e4 20 68e-1
VS5 21 s5 0
R5 s5 13 15e1
VS6 16 s6 0
V6 e6 s6 DC 12e0
RI6 e6 19 22e-1
VS7 11 s7 0
I7 s7 21 DC 56e-4
VS8 8 s8 0
I8 s8 17 DC 22e-4
VS9 20 s9 0
R9 s9 0 15e-1
VS10 9 s10 0
V10 e10 s10 DC 22e1
RI10 e10 19 56e-2
VS11 2 s11 0
R11 s11 15 47e3
VS12 16 s12 0
V12 e12 s12 DC 12e0
RI12 e12 3 12e-3
VS13 3 s13 0
R13 s13 13 33e-2
VS14 4 s14 0
V14 e14 s14 DC 68e1
RI14 e14 18 33e-2
VS15 20 s15 0
I15 s15 2 DC 10e-3
VS16 11 s16 0
I16 s16 21 DC 47e-4
VS17 12 s17 0
V17 e17 s17 DC 10e-1
RI17 e17 15 33e-2
VS18 6 s18 0
R18 s18 7 82e1
VS19 6 s19 0
V19 e19 s19 DC 56e0
RI19 e19 17 56e-1
VS20 21 s20 0
I20 s20 14 DC 47e-1
VS21 7 s21 0
R21 s21 20 15e2
VS22 7 s22 0
R22 s22 0 47e-2
VS23 16 s23 0
R23 s23 1 68e3
VS24 1 s24 0
R24 s24 5 22e2
VS25 17 s25 0
V25 e25 s25 DC 15e1
RI25 e25 2 33e-3
VS26 3 s26 0
R26 s26 7 10e-2
VS27 9 s27 0
R27 s27 2 10e-2
VS28 6 s28 0
R28 s28 10 47e3
VS29 11 s29 0
R29 s29 19 18e1
VS30 8 s30 0
V30 e30 s30 DC 56e-1
RI30 e30 2 33e-1
VS31 3 s31 0
V31 e31 s31 DC 39e0
RI31 e31 14 47e-1
VS32 2 s32 0
R32 s32 9 12e-2
VS33 14 s33 0
R33 s33 15 68e-2
VS34 10 s34 0
R34 s34 15 22e1
VS35 17 s35 0
R35 s35 18 18e1
VS36 21 s36 0
R36 s36 4 56e-2
VS37 14 s37 0
I37 s37 2 DC 47e-2
VS38 12 s38 0
R38 s38 1 56e1
VS39 15 s39 0
I39 s39 20 DC 12e-2
VS40 4 s40 0
V40 e40 s40 DC 82e0
RI40 e40 10 22e-1
.control
set numdgt=17
op
print v(1) v(2) v(3) v(4) v(5) v(6) v(7) v(8) v(9) v(10)
print v(11) v(12) v(13) v(14) v(15) v(16) v(17) v(18) v(19) v(20)
print v(21)
print i(vs0) i(vs1) i(vs2) i(vs3) i(vs4) i(vs5) i(vs6) i(vs7) i(vs8) i(vs9)
print i(vs10) i(vs11) i(vs12) i(vs13) i(vs14) i(vs15) i(vs16) i(vs17) i(vs18) i(vs19)
print i(vs20) i(vs21) i(vs22) i(vs23) i(vs24) i(vs25) i(vs26) i(vs27) i(vs28) i(vs29)
print i(vs30) i(vs31) i(vs32) i(vs33) i(vs34) i(vs35) i(vs36) i(vs37) i(vs38) i(vs39)
print i(vs40)
.endc
.end
