controls oracle dc-0215
* Generated (plan F2.7, ADR 0012): do not edit; regenerate with `pnpm sim oracle regen`. dc seed 20261030 index 215 nodes 22 elements 44
.options sparse gmin=1e-12 noopac
RG1 1 0 1000000000000
RG2 2 0 1000000000000
RG3 3 0 1000000000000
RG4 4 0 1000000000000
RG5 5 0 1000000000000
RG6 6 0 1000000000000
RG7 7 0 1000000000000
RG8 8 0 1000000000000
RG9 9 0 1000000000000
RG10 10 0 1000000000000
RG11 11 0 1000000000000
RG12 12 0 1000000000000
RG13 13 0 1000000000000
RG14 14 0 1000000000000
RG15 15 0 1000000000000
RG16 16 0 1000000000000
RG17 17 0 1000000000000
RG18 18 0 1000000000000
RG19 19 0 1000000000000
RG20 20 0 1000000000000
RG21 21 0 1000000000000
VS0 3 s0 0
R0 s0 0 27e2
VS1 0 s1 0
V1 e1 s1 DC 18e0
RI1 e1 11 18e-3
VS2 12 s2 0
V2 e2 s2 DC 10e-1
RI2 e2 15 33e-2
VS3 6 s3 0
V3 e3 s3 DC 56e0
RI3 e3 17 56e-1
VS4 6 s4 0
R4 s4 10 47e3
VS5 21 s5 0
R5 s5 13 15e1
VS6 20 s6 0
R6 s6 2 15e-1
VS7 17 s7 0
V7 e7 s7 DC 15e1
RI7 e7 3 33e-3
VS8 18 s8 0
V8 e8 s8 DC 12e-1
RI8 e8 20 68e-1
VS9 11 s9 0
R9 s9 19 18e1
VS10 16 s10 0
V10 e10 s10 DC 12e0
RI10 e10 19 22e-1
VS11 3 s11 0
R11 s11 15 47e3
VS12 1 s12 0
R12 s12 5 22e2
VS13 0 s13 0
R13 s13 7 10e-2
VS14 8 s14 0
V14 e14 s14 DC 56e-1
RI14 e14 3 33e-1
VS15 15 s15 0
I15 s15 20 DC 12e-2
VS16 0 s16 0
R16 s16 13 33e-2
VS17 20 s17 0
I17 s17 3 DC 10e-3
VS18 14 s18 0
I18 s18 3 DC 47e-2
VS19 8 s19 0
I19 s19 17 DC 22e-4
VS20 2 s20 0
V20 e20 s20 DC 15e0
RI20 e20 19 22e-1
VS21 21 s21 0
I21 s21 14 DC 47e-1
VS22 7 s22 0
R22 s22 20 15e2
VS23 6 s23 0
R23 s23 7 82e1
VS24 9 s24 0
R24 s24 3 10e-2
VS25 7 s25 0
R25 s25 2 47e-2
VS26 3 s26 0
R26 s26 9 12e-2
VS27 11 s27 0
I27 s27 21 DC 47e-4
VS28 21 s28 0
R28 s28 17 22e1
VS29 0 s29 0
V29 e29 s29 DC 39e0
RI29 e29 14 47e-1
VS30 8 s30 0
V30 e30 s30 DC 82e0
RI30 e30 5 33e-3
VS31 11 s31 0
I31 s31 21 DC 56e-4
VS32 10 s32 0
R32 s32 15 22e1
VS33 5 s33 0
R33 s33 4 39e3
VS34 16 s34 0
R34 s34 1 68e3
VS35 12 s35 0
R35 s35 1 56e1
VS36 16 s36 0
V36 e36 s36 DC 12e0
RI36 e36 0 12e-3
VS37 4 s37 0
V37 e37 s37 DC 68e1
RI37 e37 18 33e-2
VS38 21 s38 0
R38 s38 4 56e-2
VS39 14 s39 0
R39 s39 15 68e-2
VS40 17 s40 0
R40 s40 18 18e1
VS41 16 s41 0
V41 e41 s41 DC 47e1
RI41 e41 6 18e-2
VS42 4 s42 0
V42 e42 s42 DC 82e0
RI42 e42 10 22e-1
VS43 9 s43 0
V43 e43 s43 DC 22e1
RI43 e43 19 56e-2
.control
set numdgt=17
op
print v(1) v(2) v(3) v(4) v(5) v(6) v(7) v(8) v(9) v(10)
print v(11) v(12) v(13) v(14) v(15) v(16) v(17) v(18) v(19) v(20)
print v(21)
print i(vs0) i(vs1) i(vs2) i(vs3) i(vs4) i(vs5) i(vs6) i(vs7) i(vs8) i(vs9)
print i(vs10) i(vs11) i(vs12) i(vs13) i(vs14) i(vs15) i(vs16) i(vs17) i(vs18) i(vs19)
print i(vs20) i(vs21) i(vs22) i(vs23) i(vs24) i(vs25) i(vs26) i(vs27) i(vs28) i(vs29)
print i(vs30) i(vs31) i(vs32) i(vs33) i(vs34) i(vs35) i(vs36) i(vs37) i(vs38) i(vs39)
print i(vs40) i(vs41) i(vs42) i(vs43)
.endc
.end
