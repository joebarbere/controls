controls oracle dc-0355
* Generated (plan F2.7, ADR 0012): do not edit; regenerate with `pnpm sim oracle regen`. dc seed 20261030 index 355 nodes 21 elements 30
.options sparse gmin=1e-12 noopac
RG1 1 0 1000000000000
RG2 2 0 1000000000000
RG3 3 0 1000000000000
RG4 4 0 1000000000000
RG5 5 0 1000000000000
RG6 6 0 1000000000000
RG7 7 0 1000000000000
RG8 8 0 1000000000000
RG9 9 0 1000000000000
RG10 10 0 1000000000000
RG11 11 0 1000000000000
RG12 12 0 1000000000000
RG13 13 0 1000000000000
RG14 14 0 1000000000000
RG15 15 0 1000000000000
RG16 16 0 1000000000000
RG17 17 0 1000000000000
RG18 18 0 1000000000000
RG19 19 0 1000000000000
RG20 20 0 1000000000000
VS0 17 s0 0
R0 s0 1 18e3
VS1 18 s1 0
R1 s1 11 18e-1
VS2 17 s2 0
R2 s2 15 22e-2
VS3 10 s3 0
R3 s3 5 56e3
VS4 0 s4 0
V4 e4 s4 DC 68e1
RI4 e4 3 39e-2
VS5 10 s5 0
R5 s5 1 82e-2
VS6 5 s6 0
R6 s6 4 22e3
VS7 6 s7 0
R7 s7 17 82e0
VS8 0 s8 0
R8 s8 20 12e0
VS9 13 s9 0
R9 s9 9 15e2
VS10 15 s10 0
R10 s10 2 47e-1
VS11 8 s11 0
R11 s11 19 15e2
VS12 12 s12 0
R12 s12 7 47e-2
VS13 5 s13 0
R13 s13 20 22e3
VS14 12 s14 0
V14 e14 s14 DC 12e1
RI14 e14 1 27e-3
VS15 6 s15 0
R15 s15 16 82e-1
VS16 15 s16 0
R16 s16 13 47e0
VS17 18 s17 0
V17 e17 s17 DC 82e-1
RI17 e17 3 22e-3
VS18 4 s18 0
V18 e18 s18 DC 82e1
RI18 e18 11 18e-1
VS19 19 s19 0
I19 s19 10 DC 10e-3
VS20 18 s20 0
R20 s20 16 18e3
VS21 19 s21 0
R21 s21 13 12e0
VS22 7 s22 0
R22 s22 10 33e-2
VS23 16 s23 0
R23 s23 17 56e0
VS24 1 s24 0
R24 s24 8 15e1
VS25 14 s25 0
V25 e25 s25 DC 47e1
RI25 e25 16 15e-1
VS26 19 s26 0
R26 s26 9 68e-1
VS27 5 s27 0
R27 s27 14 22e1
VS28 15 s28 0
R28 s28 1 10e2
VS29 2 s29 0
R29 s29 5 47e-1
.control
set numdgt=17
op
print v(1) v(2) v(3) v(4) v(5) v(6) v(7) v(8) v(9) v(10)
print v(11) v(12) v(13) v(14) v(15) v(16) v(17) v(18) v(19) v(20)
print i(vs0) i(vs1) i(vs2) i(vs3) i(vs4) i(vs5) i(vs6) i(vs7) i(vs8) i(vs9)
print i(vs10) i(vs11) i(vs12) i(vs13) i(vs14) i(vs15) i(vs16) i(vs17) i(vs18) i(vs19)
print i(vs20) i(vs21) i(vs22) i(vs23) i(vs24) i(vs25) i(vs26) i(vs27) i(vs28) i(vs29)
.endc
.end
