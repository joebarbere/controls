controls oracle dc-0355
* Generated (plan F2.7, ADR 0012): do not edit; regenerate with `pnpm sim oracle regen`. dc seed 20261030 index 355 nodes 21 elements 23
.options sparse gmin=1e-12 noopac
RG1 1 0 1000000000000
RG2 2 0 1000000000000
RG3 3 0 1000000000000
RG4 4 0 1000000000000
RG5 5 0 1000000000000
RG6 6 0 1000000000000
RG7 7 0 1000000000000
RG8 8 0 1000000000000
RG9 9 0 1000000000000
RG10 10 0 1000000000000
RG11 11 0 1000000000000
RG12 12 0 1000000000000
RG13 13 0 1000000000000
RG14 14 0 1000000000000
RG15 15 0 1000000000000
RG16 16 0 1000000000000
RG17 17 0 1000000000000
RG18 18 0 1000000000000
RG19 19 0 1000000000000
RG20 20 0 1000000000000
VS0 18 s0 0
R0 s0 4 18e3
VS1 2 s1 0
R1 s1 5 47e-1
VS2 18 s2 0
R2 s2 11 18e-1
VS3 19 s3 0
R3 s3 9 68e-1
VS4 1 s4 0
R4 s4 8 15e1
VS5 6 s5 0
R5 s5 17 82e0
VS6 13 s6 0
R6 s6 9 15e2
VS7 8 s7 0
R7 s7 19 15e2
VS8 17 s8 0
R8 s8 15 22e-2
VS9 19 s9 0
I9 s9 10 DC 10e-3
VS10 0 s10 0
V10 e10 s10 DC 82e1
RI10 e10 11 18e-1
VS11 7 s11 0
R11 s11 10 33e-2
VS12 5 s12 0
R12 s12 20 22e3
VS13 16 s13 0
R13 s13 20 12e0
VS14 12 s14 0
V14 e14 s14 DC 12e1
RI14 e14 1 27e-3
VS15 10 s15 0
R15 s15 1 82e-2
VS16 4 s16 0
R16 s16 17 56e0
VS17 19 s17 0
R17 s17 13 12e0
VS18 10 s18 0
R18 s18 5 56e3
VS19 17 s19 0
R19 s19 1 18e3
VS20 16 s20 0
V20 e20 s20 DC 68e1
RI20 e20 3 39e-2
VS21 5 s21 0
R21 s21 14 22e1
VS22 14 s22 0
V22 e22 s22 DC 47e1
RI22 e22 4 15e-1
.control
set numdgt=17
op
print v(1) v(2) v(3) v(4) v(5) v(6) v(7) v(8) v(9) v(10)
print v(11) v(12) v(13) v(14) v(15) v(16) v(17) v(18) v(19) v(20)
print i(vs0) i(vs1) i(vs2) i(vs3) i(vs4) i(vs5) i(vs6) i(vs7) i(vs8) i(vs9)
print i(vs10) i(vs11) i(vs12) i(vs13) i(vs14) i(vs15) i(vs16) i(vs17) i(vs18) i(vs19)
print i(vs20) i(vs21) i(vs22)
.endc
.end
