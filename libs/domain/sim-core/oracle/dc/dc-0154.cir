controls oracle dc-0154
* Generated (plan F2.7, ADR 0012): do not edit; regenerate with `pnpm sim oracle regen`. dc seed 20261030 index 154 nodes 2 elements 4
.options sparse gmin=1e-12 noopac
RG1 1 0 1000000000000
VS0 1 s0 0
R0 s0 0 22e3
VS1 1 s1 0
R1 s1 0 33e-1
VS2 1 s2 0
R2 s2 0 15e2
VS3 0 s3 0
V3 e3 s3 DC 10e0
RI3 e3 1 10e-3
.control
set numdgt=17
op
print v(1)
print i(vs0) i(vs1) i(vs2) i(vs3)
.endc
.end
