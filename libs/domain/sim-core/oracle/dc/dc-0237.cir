controls oracle dc-0237
* Generated (plan F2.7, ADR 0012): do not edit; regenerate with `pnpm sim oracle regen`. dc seed 20261030 index 237 nodes 23 elements 39
.options sparse gmin=1e-12 noopac
RG1 1 0 1000000000000
RG2 2 0 1000000000000
RG3 3 0 1000000000000
RG4 4 0 1000000000000
RG5 5 0 1000000000000
RG6 6 0 1000000000000
RG7 7 0 1000000000000
RG8 8 0 1000000000000
RG9 9 0 1000000000000
RG10 10 0 1000000000000
RG11 11 0 1000000000000
RG12 12 0 1000000000000
RG13 13 0 1000000000000
RG14 14 0 1000000000000
RG15 15 0 1000000000000
RG16 16 0 1000000000000
RG17 17 0 1000000000000
RG18 18 0 1000000000000
RG19 19 0 1000000000000
RG20 20 0 1000000000000
RG21 21 0 1000000000000
RG22 22 0 1000000000000
VS0 1 s0 0
R0 s0 2 18e0
VS1 0 s1 0
V1 e1 s1 DC 33e1
RI1 e1 5 15e-3
VS2 9 s2 0
R2 s2 15 56e0
VS3 13 s3 0
R3 s3 22 22e-1
VS4 12 s4 0
V4 e4 s4 DC 47e0
RI4 e4 10 39e-3
VS5 11 s5 0
I5 s5 6 DC 10e-2
VS6 3 s6 0
R6 s6 14 12e-1
VS7 9 s7 0
R7 s7 6 33e3
VS8 4 s8 0
R8 s8 12 18e-2
VS9 13 s9 0
I9 s9 12 DC 18e-3
VS10 20 s10 0
R10 s10 18 27e2
VS11 22 s11 0
R11 s11 15 10e0
VS12 11 s12 0
I12 s12 7 DC 22e-3
VS13 11 s13 0
V13 e13 s13 DC 10e0
RI13 e13 0 82e-3
VS14 21 s14 0
V14 e14 s14 DC 22e0
RI14 e14 20 56e-1
VS15 1 s15 0
I15 s15 10 DC 39e-2
VS16 22 s16 0
R16 s16 12 10e-2
VS17 0 s17 0
V17 e17 s17 DC 68e0
RI17 e17 16 68e-3
VS18 2 s18 0
R18 s18 20 39e-2
VS19 7 s19 0
R19 s19 15 27e-2
VS20 2 s20 0
R20 s20 20 68e0
VS21 6 s21 0
R21 s21 17 22e-2
VS22 20 s22 0
R22 s22 6 10e-1
VS23 22 s23 0
R23 s23 10 39e2
VS24 22 s24 0
R24 s24 21 33e3
VS25 7 s25 0
R25 s25 19 12e-1
VS26 12 s26 0
R26 s26 8 33e-2
VS27 10 s27 0
R27 s27 0 39e-2
VS28 19 s28 0
R28 s28 4 27e3
VS29 2 s29 0
R29 s29 5 10e0
VS30 2 s30 0
R30 s30 4 18e3
VS31 4 s31 0
R31 s31 8 22e3
VS32 14 s32 0
R32 s32 13 15e-2
VS33 16 s33 0
R33 s33 9 47e-1
VS34 15 s34 0
I34 s34 5 DC 12e-1
VS35 13 s35 0
R35 s35 16 47e0
VS36 6 s36 0
R36 s36 22 15e-2
VS37 15 s37 0
R37 s37 3 68e3
VS38 20 s38 0
R38 s38 10 68e3
.control
set numdgt=17
op
print v(1) v(2) v(3) v(4) v(5) v(6) v(7) v(8) v(9) v(10)
print v(11) v(12) v(13) v(14) v(15) v(16) v(17) v(18) v(19) v(20)
print v(21) v(22)
print i(vs0) i(vs1) i(vs2) i(vs3) i(vs4) i(vs5) i(vs6) i(vs7) i(vs8) i(vs9)
print i(vs10) i(vs11) i(vs12) i(vs13) i(vs14) i(vs15) i(vs16) i(vs17) i(vs18) i(vs19)
print i(vs20) i(vs21) i(vs22) i(vs23) i(vs24) i(vs25) i(vs26) i(vs27) i(vs28) i(vs29)
print i(vs30) i(vs31) i(vs32) i(vs33) i(vs34) i(vs35) i(vs36) i(vs37) i(vs38)
.endc
.end
