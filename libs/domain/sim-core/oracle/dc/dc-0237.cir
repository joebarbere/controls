controls oracle dc-0237
* Generated (plan F2.7, ADR 0012): do not edit; regenerate with `pnpm sim oracle regen`. dc seed 20261030 index 237 nodes 23 elements 43
.options sparse gmin=1e-12 noopac
RG1 1 0 1000000000000
RG2 2 0 1000000000000
RG3 3 0 1000000000000
RG4 4 0 1000000000000
RG5 5 0 1000000000000
RG6 6 0 1000000000000
RG7 7 0 1000000000000
RG8 8 0 1000000000000
RG9 9 0 1000000000000
RG10 10 0 1000000000000
RG11 11 0 1000000000000
RG12 12 0 1000000000000
RG13 13 0 1000000000000
RG14 14 0 1000000000000
RG15 15 0 1000000000000
RG16 16 0 1000000000000
RG17 17 0 1000000000000
RG18 18 0 1000000000000
RG19 19 0 1000000000000
RG20 20 0 1000000000000
RG21 21 0 1000000000000
RG22 22 0 1000000000000
VS0 20 s0 0
R0 s0 18 27e2
VS1 11 s1 0
I1 s1 6 DC 10e-2
VS2 15 s2 0
R2 s2 3 68e3
VS3 11 s3 0
I3 s3 7 DC 22e-3
VS4 22 s4 0
R4 s4 12 10e-2
VS5 7 s5 0
R5 s5 15 27e-2
VS6 20 s6 0
R6 s6 6 10e-1
VS7 14 s7 0
R7 s7 13 15e-2
VS8 0 s8 0
V8 e8 s8 DC 22e0
RI8 e8 20 56e-1
VS9 2 s9 0
V9 e9 s9 DC 33e1
RI9 e9 5 15e-3
VS10 9 s10 0
R10 s10 6 33e3
VS11 22 s11 0
R11 s11 0 33e3
VS12 22 s12 0
R12 s12 10 39e2
VS13 15 s13 0
R13 s13 18 56e2
VS14 2 s14 0
V14 e14 s14 DC 68e0
RI14 e14 16 68e-3
VS15 11 s15 0
R15 s15 14 12e-1
VS16 20 s16 0
R16 s16 10 68e3
VS17 17 s17 0
R17 s17 21 33e-2
VS18 12 s18 0
R18 s18 8 33e-2
VS19 4 s19 0
R19 s19 8 22e3
VS20 9 s20 0
R20 s20 15 56e0
VS21 21 s21 0
R21 s21 5 10e0
VS22 16 s22 0
R22 s22 9 47e-1
VS23 1 s23 0
R23 s23 8 10e0
VS24 19 s24 0
R24 s24 4 27e3
VS25 15 s25 0
I25 s25 5 DC 12e-1
VS26 1 s26 0
I26 s26 10 DC 39e-2
VS27 13 s27 0
I27 s27 12 DC 18e-3
VS28 6 s28 0
R28 s28 22 15e-2
VS29 21 s29 0
R29 s29 20 39e-2
VS30 21 s30 0
R30 s30 20 68e0
VS31 10 s31 0
R31 s31 2 39e-2
VS32 22 s32 0
R32 s32 15 10e0
VS33 13 s33 0
R33 s33 22 22e-1
VS34 11 s34 0
V34 e34 s34 DC 10e0
RI34 e34 2 82e-3
VS35 6 s35 0
R35 s35 17 22e-2
VS36 21 s36 0
R36 s36 4 18e3
VS37 7 s37 0
R37 s37 19 12e-1
VS38 1 s38 0
R38 s38 21 18e0
VS39 12 s39 0
V39 e39 s39 DC 47e0
RI39 e39 10 39e-3
VS40 13 s40 0
R40 s40 16 47e0
VS41 4 s41 0
R41 s41 12 18e-2
VS42 3 s42 0
R42 s42 14 12e-1
.control
set numdgt=17
op
print v(1) v(2) v(3) v(4) v(5) v(6) v(7) v(8) v(9) v(10)
print v(11) v(12) v(13) v(14) v(15) v(16) v(17) v(18) v(19) v(20)
print v(21) v(22)
print i(vs0) i(vs1) i(vs2) i(vs3) i(vs4) i(vs5) i(vs6) i(vs7) i(vs8) i(vs9)
print i(vs10) i(vs11) i(vs12) i(vs13) i(vs14) i(vs15) i(vs16) i(vs17) i(vs18) i(vs19)
print i(vs20) i(vs21) i(vs22) i(vs23) i(vs24) i(vs25) i(vs26) i(vs27) i(vs28) i(vs29)
print i(vs30) i(vs31) i(vs32) i(vs33) i(vs34) i(vs35) i(vs36) i(vs37) i(vs38) i(vs39)
print i(vs40) i(vs41) i(vs42)
.endc
.end
