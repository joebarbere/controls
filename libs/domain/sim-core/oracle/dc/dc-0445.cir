controls oracle dc-0445
* Generated (plan F2.7, ADR 0012): do not edit; regenerate with `pnpm sim oracle regen`. dc seed 20261030 index 445 nodes 25 elements 44
.options sparse gmin=1e-12 noopac
RG1 1 0 1000000000000
RG2 2 0 1000000000000
RG3 3 0 1000000000000
RG4 4 0 1000000000000
RG5 5 0 1000000000000
RG6 6 0 1000000000000
RG7 7 0 1000000000000
RG8 8 0 1000000000000
RG9 9 0 1000000000000
RG10 10 0 1000000000000
RG11 11 0 1000000000000
RG12 12 0 1000000000000
RG13 13 0 1000000000000
RG14 14 0 1000000000000
RG15 15 0 1000000000000
RG16 16 0 1000000000000
RG17 17 0 1000000000000
RG18 18 0 1000000000000
RG19 19 0 1000000000000
RG20 20 0 1000000000000
RG21 21 0 1000000000000
RG22 22 0 1000000000000
RG23 23 0 1000000000000
RG24 24 0 1000000000000
VS0 0 s0 0
V0 e0 s0 DC 56e-1
RI0 e0 12 18e-3
VS1 22 s1 0
R1 s1 24 68e0
VS2 16 s2 0
R2 s2 2 47e-1
VS3 21 s3 0
I3 s3 7 DC 39e-4
VS4 18 s4 0
V4 e4 s4 DC 22e1
RI4 e4 8 12e-3
VS5 19 s5 0
R5 s5 4 39e-2
VS6 10 s6 0
R6 s6 14 27e-1
VS7 20 s7 0
R7 s7 22 22e2
VS8 7 s8 0
R8 s8 6 10e3
VS9 11 s9 0
R9 s9 18 68e1
VS10 17 s10 0
R10 s10 21 18e0
VS11 5 s11 0
I11 s11 11 DC 56e-3
VS12 9 s12 0
R12 s12 12 27e-2
VS13 10 s13 0
V13 e13 s13 DC 15e-1
RI13 e13 19 18e-1
VS14 15 s14 0
R14 s14 22 22e0
VS15 15 s15 0
R15 s15 16 82e0
VS16 17 s16 0
R16 s16 13 47e-2
VS17 10 s17 0
R17 s17 3 18e3
VS18 14 s18 0
R18 s18 9 47e1
VS19 15 s19 0
R19 s19 0 10e0
VS20 23 s20 0
R20 s20 7 33e3
VS21 14 s21 0
I21 s21 7 DC 82e-1
VS22 8 s22 0
R22 s22 7 15e2
VS23 2 s23 0
V23 e23 s23 DC 12e-1
RI23 e23 23 27e-3
VS24 20 s24 0
R24 s24 17 15e1
VS25 21 s25 0
R25 s25 5 33e-1
VS26 17 s26 0
R26 s26 4 56e-2
VS27 20 s27 0
V27 e27 s27 DC 56e0
RI27 e27 11 12e-1
VS28 2 s28 0
V28 e28 s28 DC 15e1
RI28 e28 3 18e-2
VS29 10 s29 0
V29 e29 s29 DC 15e1
RI29 e29 7 10e-1
VS30 1 s30 0
V30 e30 s30 DC 27e0
RI30 e30 12 18e-2
VS31 23 s31 0
R31 s31 22 56e-1
VS32 18 s32 0
R32 s32 10 27e2
VS33 17 s33 0
R33 s33 22 15e1
VS34 16 s34 0
R34 s34 13 56e2
VS35 6 s35 0
R35 s35 10 39e1
VS36 0 s36 0
V36 e36 s36 DC 27e-1
RI36 e36 16 10e-3
VS37 21 s37 0
I37 s37 24 DC 10e-1
VS38 22 s38 0
I38 s38 18 DC 10e-3
VS39 12 s39 0
R39 s39 5 15e2
VS40 1 s40 0
R40 s40 22 56e2
VS41 14 s41 0
R41 s41 23 56e-2
VS42 24 s42 0
R42 s42 15 82e-1
VS43 19 s43 0
R43 s43 22 33e0
.control
set numdgt=17
op
print v(1) v(2) v(3) v(4) v(5) v(6) v(7) v(8) v(9) v(10)
print v(11) v(12) v(13) v(14) v(15) v(16) v(17) v(18) v(19) v(20)
print v(21) v(22) v(23) v(24)
print i(vs0) i(vs1) i(vs2) i(vs3) i(vs4) i(vs5) i(vs6) i(vs7) i(vs8) i(vs9)
print i(vs10) i(vs11) i(vs12) i(vs13) i(vs14) i(vs15) i(vs16) i(vs17) i(vs18) i(vs19)
print i(vs20) i(vs21) i(vs22) i(vs23) i(vs24) i(vs25) i(vs26) i(vs27) i(vs28) i(vs29)
print i(vs30) i(vs31) i(vs32) i(vs33) i(vs34) i(vs35) i(vs36) i(vs37) i(vs38) i(vs39)
print i(vs40) i(vs41) i(vs42) i(vs43)
.endc
.end
