controls oracle dc-0445
* Generated (plan F2.7, ADR 0012): do not edit; regenerate with `pnpm sim oracle regen`. dc seed 20261030 index 445 nodes 25 elements 39
.options sparse gmin=1e-12 noopac
RG1 1 0 1000000000000
RG2 2 0 1000000000000
RG3 3 0 1000000000000
RG4 4 0 1000000000000
RG5 5 0 1000000000000
RG6 6 0 1000000000000
RG7 7 0 1000000000000
RG8 8 0 1000000000000
RG9 9 0 1000000000000
RG10 10 0 1000000000000
RG11 11 0 1000000000000
RG12 12 0 1000000000000
RG13 13 0 1000000000000
RG14 14 0 1000000000000
RG15 15 0 1000000000000
RG16 16 0 1000000000000
RG17 17 0 1000000000000
RG18 18 0 1000000000000
RG19 19 0 1000000000000
RG20 20 0 1000000000000
RG21 21 0 1000000000000
RG22 22 0 1000000000000
RG23 23 0 1000000000000
RG24 24 0 1000000000000
VS0 15 s0 0
R0 s0 16 82e0
VS1 21 s1 0
R1 s1 5 33e-1
VS2 21 s2 0
I2 s2 7 DC 39e-4
VS3 9 s3 0
R3 s3 12 27e-2
VS4 16 s4 0
R4 s4 2 47e-1
VS5 15 s5 0
R5 s5 0 10e0
VS6 19 s6 0
R6 s6 22 33e0
VS7 0 s7 0
V7 e7 s7 DC 27e-1
RI7 e7 16 10e-3
VS8 10 s8 0
V8 e8 s8 DC 15e-1
RI8 e8 19 18e-1
VS9 21 s9 0
I9 s9 24 DC 10e-1
VS10 20 s10 0
V10 e10 s10 DC 56e0
RI10 e10 11 12e-1
VS11 18 s11 0
R11 s11 10 27e2
VS12 10 s12 0
V12 e12 s12 DC 15e1
RI12 e12 7 10e-1
VS13 20 s13 0
R13 s13 22 22e2
VS14 14 s14 0
R14 s14 23 56e-2
VS15 10 s15 0
R15 s15 3 18e3
VS16 17 s16 0
R16 s16 4 56e-2
VS17 17 s17 0
R17 s17 22 15e1
VS18 5 s18 0
I18 s18 11 DC 56e-3
VS19 17 s19 0
R19 s19 13 47e-2
VS20 16 s20 0
R20 s20 13 56e2
VS21 2 s21 0
V21 e21 s21 DC 15e1
RI21 e21 3 18e-2
VS22 2 s22 0
V22 e22 s22 DC 12e-1
RI22 e22 23 27e-3
VS23 14 s23 0
I23 s23 7 DC 82e-1
VS24 1 s24 0
V24 e24 s24 DC 27e0
RI24 e24 12 18e-2
VS25 24 s25 0
R25 s25 15 82e-1
VS26 23 s26 0
R26 s26 22 56e-1
VS27 8 s27 0
R27 s27 7 15e2
VS28 14 s28 0
R28 s28 9 47e1
VS29 22 s29 0
I29 s29 18 DC 10e-3
VS30 15 s30 0
R30 s30 22 22e0
VS31 23 s31 0
R31 s31 7 33e3
VS32 10 s32 0
R32 s32 14 27e-1
VS33 1 s33 0
R33 s33 22 56e2
VS34 12 s34 0
R34 s34 5 15e2
VS35 18 s35 0
V35 e35 s35 DC 22e1
RI35 e35 8 12e-3
VS36 17 s36 0
R36 s36 21 18e0
VS37 0 s37 0
V37 e37 s37 DC 56e-1
RI37 e37 12 18e-3
VS38 6 s38 0
R38 s38 10 39e1
.control
set numdgt=17
op
print v(1) v(2) v(3) v(4) v(5) v(6) v(7) v(8) v(9) v(10)
print v(11) v(12) v(13) v(14) v(15) v(16) v(17) v(18) v(19) v(20)
print v(21) v(22) v(23) v(24)
print i(vs0) i(vs1) i(vs2) i(vs3) i(vs4) i(vs5) i(vs6) i(vs7) i(vs8) i(vs9)
print i(vs10) i(vs11) i(vs12) i(vs13) i(vs14) i(vs15) i(vs16) i(vs17) i(vs18) i(vs19)
print i(vs20) i(vs21) i(vs22) i(vs23) i(vs24) i(vs25) i(vs26) i(vs27) i(vs28) i(vs29)
print i(vs30) i(vs31) i(vs32) i(vs33) i(vs34) i(vs35) i(vs36) i(vs37) i(vs38)
.endc
.end
