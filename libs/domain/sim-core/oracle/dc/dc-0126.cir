controls oracle dc-0126
* Generated (plan F2.7, ADR 0012): do not edit; regenerate with `pnpm sim oracle regen`. dc seed 20261030 index 126 nodes 3 elements 5
.options sparse gmin=1e-12 noopac
RG1 1 0 1000000000000
RG2 2 0 1000000000000
VS0 1 s0 0
R0 s0 2 82e2
VS1 2 s1 0
I1 s1 1 DC 68e-4
VS2 0 s2 0
R2 s2 1 56e-1
VS3 0 s3 0
V3 e3 s3 DC 27e0
RI3 e3 2 56e-2
VS4 1 s4 0
R4 s4 0 68e1
.control
set numdgt=17
op
print v(1) v(2)
print i(vs0) i(vs1) i(vs2) i(vs3) i(vs4)
.endc
.end
