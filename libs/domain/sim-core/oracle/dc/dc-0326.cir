controls oracle dc-0326
* Generated (plan F2.7, ADR 0012): do not edit; regenerate with `pnpm sim oracle regen`. dc seed 20261030 index 326 nodes 21 elements 30
.options sparse gmin=1e-12 noopac
RG1 1 0 1000000000000
RG2 2 0 1000000000000
RG3 3 0 1000000000000
RG4 4 0 1000000000000
RG5 5 0 1000000000000
RG6 6 0 1000000000000
RG7 7 0 1000000000000
RG8 8 0 1000000000000
RG9 9 0 1000000000000
RG10 10 0 1000000000000
RG11 11 0 1000000000000
RG12 12 0 1000000000000
RG13 13 0 1000000000000
RG14 14 0 1000000000000
RG15 15 0 1000000000000
RG16 16 0 1000000000000
RG17 17 0 1000000000000
RG18 18 0 1000000000000
RG19 19 0 1000000000000
RG20 20 0 1000000000000
VS0 5 s0 0
R0 s0 10 18e0
VS1 9 s1 0
R1 s1 10 47e-1
VS2 15 s2 0
R2 s2 2 82e2
VS3 4 s3 0
R3 s3 0 33e1
VS4 16 s4 0
R4 s4 3 22e3
VS5 10 s5 0
R5 s5 12 47e2
VS6 0 s6 0
V6 e6 s6 DC 15e0
RI6 e6 14 12e-3
VS7 0 s7 0
R7 s7 10 82e-1
VS8 17 s8 0
R8 s8 3 22e-1
VS9 3 s9 0
R9 s9 1 18e2
VS10 8 s10 0
R10 s10 19 56e0
VS11 2 s11 0
R11 s11 9 47e2
VS12 20 s12 0
R12 s12 14 56e1
VS13 9 s13 0
R13 s13 17 10e1
VS14 0 s14 0
R14 s14 13 15e0
VS15 6 s15 0
R15 s15 14 47e1
VS16 15 s16 0
R16 s16 13 68e1
VS17 8 s17 0
R17 s17 11 68e1
VS18 11 s18 0
R18 s18 7 47e-2
VS19 20 s19 0
R19 s19 8 27e-2
VS20 20 s20 0
R20 s20 6 56e0
VS21 5 s21 0
R21 s21 16 33e1
VS22 20 s22 0
R22 s22 1 27e3
VS23 7 s23 0
V23 e23 s23 DC 12e-1
RI23 e23 16 18e-3
VS24 19 s24 0
V24 e24 s24 DC 39e0
RI24 e24 3 22e-2
VS25 18 s25 0
R25 s25 5 33e-2
VS26 13 s26 0
R26 s26 12 12e-2
VS27 18 s27 0
R27 s27 0 15e-2
VS28 8 s28 0
R28 s28 4 56e2
VS29 4 s29 0
R29 s29 11 39e-1
.control
set numdgt=17
op
print v(1) v(2) v(3) v(4) v(5) v(6) v(7) v(8) v(9) v(10)
print v(11) v(12) v(13) v(14) v(15) v(16) v(17) v(18) v(19) v(20)
print i(vs0) i(vs1) i(vs2) i(vs3) i(vs4) i(vs5) i(vs6) i(vs7) i(vs8) i(vs9)
print i(vs10) i(vs11) i(vs12) i(vs13) i(vs14) i(vs15) i(vs16) i(vs17) i(vs18) i(vs19)
print i(vs20) i(vs21) i(vs22) i(vs23) i(vs24) i(vs25) i(vs26) i(vs27) i(vs28) i(vs29)
.endc
.end
