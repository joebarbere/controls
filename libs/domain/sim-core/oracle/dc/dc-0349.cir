controls oracle dc-0349
* Generated (plan F2.7, ADR 0012): do not edit; regenerate with `pnpm sim oracle regen`. dc seed 20261030 index 349 nodes 29 elements 41
.options sparse gmin=1e-12 noopac
RG1 1 0 1000000000000
RG2 2 0 1000000000000
RG3 3 0 1000000000000
RG4 4 0 1000000000000
RG5 5 0 1000000000000
RG6 6 0 1000000000000
RG7 7 0 1000000000000
RG8 8 0 1000000000000
RG9 9 0 1000000000000
RG10 10 0 1000000000000
RG11 11 0 1000000000000
RG12 12 0 1000000000000
RG13 13 0 1000000000000
RG14 14 0 1000000000000
RG15 15 0 1000000000000
RG16 16 0 1000000000000
RG17 17 0 1000000000000
RG18 18 0 1000000000000
RG19 19 0 1000000000000
RG20 20 0 1000000000000
RG21 21 0 1000000000000
RG22 22 0 1000000000000
RG23 23 0 1000000000000
RG24 24 0 1000000000000
RG25 25 0 1000000000000
RG26 26 0 1000000000000
RG27 27 0 1000000000000
RG28 28 0 1000000000000
VS0 0 s0 0
V0 e0 s0 DC 68e0
RI0 e0 21 68e-2
VS1 13 s1 0
R1 s1 22 15e-1
VS2 14 s2 0
V2 e2 s2 DC 27e1
RI2 e2 20 22e-2
VS3 3 s3 0
R3 s3 22 82e2
VS4 17 s4 0
R4 s4 2 27e-2
VS5 23 s5 0
R5 s5 0 18e1
VS6 14 s6 0
R6 s6 10 56e-2
VS7 18 s7 0
V7 e7 s7 DC 22e0
RI7 e7 3 47e-2
VS8 1 s8 0
R8 s8 5 27e3
VS9 12 s9 0
V9 e9 s9 DC 18e-1
RI9 e9 14 39e-3
VS10 15 s10 0
R10 s10 20 68e2
VS11 0 s11 0
V11 e11 s11 DC 10e0
RI11 e11 1 82e-1
VS12 2 s12 0
R12 s12 11 56e0
VS13 25 s13 0
R13 s13 20 22e3
VS14 17 s14 0
R14 s14 10 12e-1
VS15 7 s15 0
V15 e15 s15 DC 39e0
RI15 e15 22 18e-3
VS16 23 s16 0
R16 s16 18 47e2
VS17 9 s17 0
R17 s17 17 18e-1
VS18 3 s18 0
V18 e18 s18 DC 68e1
RI18 e18 4 39e-3
VS19 8 s19 0
R19 s19 24 39e3
VS20 27 s20 0
R20 s20 6 82e2
VS21 27 s21 0
R21 s21 28 27e3
VS22 22 s22 0
R22 s22 5 68e3
VS23 26 s23 0
R23 s23 7 10e-2
VS24 8 s24 0
R24 s24 13 56e-1
VS25 21 s25 0
R25 s25 7 22e0
VS26 22 s26 0
R26 s26 6 39e0
VS27 22 s27 0
R27 s27 16 15e-2
VS28 21 s28 0
R28 s28 14 27e0
VS29 9 s29 0
V29 e29 s29 DC 68e1
RI29 e29 4 18e-2
VS30 17 s30 0
R30 s30 12 39e1
VS31 7 s31 0
R31 s31 16 39e2
VS32 17 s32 0
V32 e32 s32 DC 33e1
RI32 e32 26 18e-1
VS33 21 s33 0
V33 e33 s33 DC 68e1
RI33 e33 28 22e-3
VS34 17 s34 0
R34 s34 19 27e0
VS35 8 s35 0
R35 s35 21 10e1
VS36 13 s36 0
V36 e36 s36 DC 12e0
RI36 e36 24 56e-3
VS37 19 s37 0
V37 e37 s37 DC 82e1
RI37 e37 20 12e-1
VS38 2 s38 0
R38 s38 28 10e2
VS39 11 s39 0
R39 s39 25 33e3
VS40 28 s40 0
R40 s40 15 22e-2
.control
set numdgt=17
op
print v(1) v(2) v(3) v(4) v(5) v(6) v(7) v(8) v(9) v(10)
print v(11) v(12) v(13) v(14) v(15) v(16) v(17) v(18) v(19) v(20)
print v(21) v(22) v(23) v(24) v(25) v(26) v(27) v(28)
print i(vs0) i(vs1) i(vs2) i(vs3) i(vs4) i(vs5) i(vs6) i(vs7) i(vs8) i(vs9)
print i(vs10) i(vs11) i(vs12) i(vs13) i(vs14) i(vs15) i(vs16) i(vs17) i(vs18) i(vs19)
print i(vs20) i(vs21) i(vs22) i(vs23) i(vs24) i(vs25) i(vs26) i(vs27) i(vs28) i(vs29)
print i(vs30) i(vs31) i(vs32) i(vs33) i(vs34) i(vs35) i(vs36) i(vs37) i(vs38) i(vs39)
print i(vs40)
.endc
.end
