controls oracle dc-0349
* Generated (plan F2.7, ADR 0012): do not edit; regenerate with `pnpm sim oracle regen`. dc seed 20261030 index 349 nodes 29 elements 29
.options sparse gmin=1e-12 noopac
RG1 1 0 1000000000000
RG2 2 0 1000000000000
RG3 3 0 1000000000000
RG4 4 0 1000000000000
RG5 5 0 1000000000000
RG6 6 0 1000000000000
RG7 7 0 1000000000000
RG8 8 0 1000000000000
RG9 9 0 1000000000000
RG10 10 0 1000000000000
RG11 11 0 1000000000000
RG12 12 0 1000000000000
RG13 13 0 1000000000000
RG14 14 0 1000000000000
RG15 15 0 1000000000000
RG16 16 0 1000000000000
RG17 17 0 1000000000000
RG18 18 0 1000000000000
RG19 19 0 1000000000000
RG20 20 0 1000000000000
RG21 21 0 1000000000000
RG22 22 0 1000000000000
RG23 23 0 1000000000000
RG24 24 0 1000000000000
RG25 25 0 1000000000000
RG26 26 0 1000000000000
RG27 27 0 1000000000000
RG28 28 0 1000000000000
VS0 0 s0 0
V0 e0 s0 DC 22e0
RI0 e0 3 47e-2
VS1 17 s1 0
R1 s1 10 12e-1
VS2 3 s2 0
V2 e2 s2 DC 68e1
RI2 e2 4 39e-3
VS3 17 s3 0
V3 e3 s3 DC 33e1
RI3 e3 26 18e-1
VS4 2 s4 0
R4 s4 11 56e0
VS5 13 s5 0
V5 e5 s5 DC 12e0
RI5 e5 24 56e-3
VS6 18 s6 0
R6 s6 14 27e0
VS7 9 s7 0
R7 s7 17 18e-1
VS8 18 s8 0
R8 s8 7 22e0
VS9 13 s9 0
R9 s9 22 15e-1
VS10 14 s10 0
V10 e10 s10 DC 27e1
RI10 e10 20 22e-2
VS11 21 s11 0
V11 e11 s11 DC 10e0
RI11 e11 1 82e-1
VS12 27 s12 0
R12 s12 28 27e3
VS13 22 s13 0
R13 s13 5 68e3
VS14 7 s14 0
V14 e14 s14 DC 39e0
RI14 e14 22 18e-3
VS15 15 s15 0
R15 s15 20 68e2
VS16 2 s16 0
R16 s16 28 10e2
VS17 21 s17 0
V17 e17 s17 DC 68e0
RI17 e17 18 68e-2
VS18 23 s18 0
R18 s18 0 47e2
VS19 25 s19 0
R19 s19 20 22e3
VS20 17 s20 0
R20 s20 19 27e0
VS21 8 s21 0
R21 s21 24 39e3
VS22 22 s22 0
R22 s22 16 15e-2
VS23 28 s23 0
R23 s23 18 47e-2
VS24 17 s24 0
R24 s24 12 39e1
VS25 22 s25 0
R25 s25 6 39e0
VS26 3 s26 0
R26 s26 22 82e2
VS27 18 s27 0
V27 e27 s27 DC 68e1
RI27 e27 28 22e-3
VS28 17 s28 0
R28 s28 2 27e-2
.control
set numdgt=17
op
print v(1) v(2) v(3) v(4) v(5) v(6) v(7) v(8) v(9) v(10)
print v(11) v(12) v(13) v(14) v(15) v(16) v(17) v(18) v(19) v(20)
print v(21) v(22) v(23) v(24) v(25) v(26) v(27) v(28)
print i(vs0) i(vs1) i(vs2) i(vs3) i(vs4) i(vs5) i(vs6) i(vs7) i(vs8) i(vs9)
print i(vs10) i(vs11) i(vs12) i(vs13) i(vs14) i(vs15) i(vs16) i(vs17) i(vs18) i(vs19)
print i(vs20) i(vs21) i(vs22) i(vs23) i(vs24) i(vs25) i(vs26) i(vs27) i(vs28)
.endc
.end
