controls oracle dc-0063
* Generated (plan F2.7, ADR 0012): do not edit; regenerate with `pnpm sim oracle regen`. dc seed 20261030 index 63 nodes 14 elements 28
.options sparse gmin=1e-12 noopac
RG1 1 0 1000000000000
RG2 2 0 1000000000000
RG3 3 0 1000000000000
RG4 4 0 1000000000000
RG5 5 0 1000000000000
RG6 6 0 1000000000000
RG7 7 0 1000000000000
RG8 8 0 1000000000000
RG9 9 0 1000000000000
RG10 10 0 1000000000000
RG11 11 0 1000000000000
RG12 12 0 1000000000000
RG13 13 0 1000000000000
VS0 11 s0 0
R0 s0 6 56e3
VS1 10 s1 0
R1 s1 7 22e0
VS2 0 s2 0
I2 s2 1 DC 27e-2
VS3 9 s3 0
R3 s3 12 27e0
VS4 7 s4 0
R4 s4 6 15e3
VS5 2 s5 0
R5 s5 3 22e-1
VS6 13 s6 0
R6 s6 8 82e-1
VS7 0 s7 0
V7 e7 s7 DC 33e-1
RI7 e7 4 22e-2
VS8 6 s8 0
R8 s8 13 33e1
VS9 6 s9 0
R9 s9 12 10e-2
VS10 0 s10 0
I10 s10 6 DC 68e-1
VS11 11 s11 0
V11 e11 s11 DC 18e0
RI11 e11 0 27e-1
VS12 7 s12 0
R12 s12 3 15e2
VS13 3 s13 0
R13 s13 11 39e-2
VS14 0 s14 0
R14 s14 7 47e-2
VS15 7 s15 0
V15 e15 s15 DC 18e0
RI15 e15 5 27e-1
VS16 8 s16 0
R16 s16 10 82e-2
VS17 5 s17 0
R17 s17 8 47e0
VS18 2 s18 0
R18 s18 9 56e-2
VS19 12 s19 0
V19 e19 s19 DC 68e-1
RI19 e19 10 82e-2
VS20 13 s20 0
R20 s20 11 39e3
VS21 8 s21 0
V21 e21 s21 DC 33e-1
RI21 e21 1 82e-2
VS22 12 s22 0
R22 s22 13 12e1
VS23 10 s23 0
I23 s23 3 DC 15e-4
VS24 10 s24 0
R24 s24 7 33e1
VS25 11 s25 0
R25 s25 9 39e3
VS26 4 s26 0
R26 s26 3 47e2
VS27 7 s27 0
R27 s27 1 47e1
.control
set numdgt=17
op
print v(1) v(2) v(3) v(4) v(5) v(6) v(7) v(8) v(9) v(10)
print v(11) v(12) v(13)
print i(vs0) i(vs1) i(vs2) i(vs3) i(vs4) i(vs5) i(vs6) i(vs7) i(vs8) i(vs9)
print i(vs10) i(vs11) i(vs12) i(vs13) i(vs14) i(vs15) i(vs16) i(vs17) i(vs18) i(vs19)
print i(vs20) i(vs21) i(vs22) i(vs23) i(vs24) i(vs25) i(vs26) i(vs27)
.endc
.end
