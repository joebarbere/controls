controls oracle dc-0063
* Generated (plan F2.7, ADR 0012): do not edit; regenerate with `pnpm sim oracle regen`. dc seed 20261030 index 63 nodes 14 elements 27
.options sparse gmin=1e-12 noopac
RG1 1 0 1000000000000
RG2 2 0 1000000000000
RG3 3 0 1000000000000
RG4 4 0 1000000000000
RG5 5 0 1000000000000
RG6 6 0 1000000000000
RG7 7 0 1000000000000
RG8 8 0 1000000000000
RG9 9 0 1000000000000
RG10 10 0 1000000000000
RG11 11 0 1000000000000
RG12 12 0 1000000000000
RG13 13 0 1000000000000
VS0 9 s0 0
R0 s0 12 27e0
VS1 7 s1 0
R1 s1 1 47e1
VS2 13 s2 0
R2 s2 11 39e3
VS3 10 s3 0
I3 s3 3 DC 15e-4
VS4 2 s4 0
R4 s4 9 56e-2
VS5 0 s5 0
V5 e5 s5 DC 33e-1
RI5 e5 1 82e-2
VS6 11 s6 0
R6 s6 9 39e3
VS7 8 s7 0
R7 s7 13 33e1
VS8 10 s8 0
R8 s8 7 22e0
VS9 0 s9 0
R9 s9 10 82e-2
VS10 6 s10 0
R10 s10 7 47e-2
VS11 13 s11 0
R11 s11 0 82e-1
VS12 3 s12 0
R12 s12 11 39e-2
VS13 7 s13 0
R13 s13 3 15e2
VS14 6 s14 0
I14 s14 8 DC 68e-1
VS15 12 s15 0
V15 e15 s15 DC 68e-1
RI15 e15 10 82e-2
VS16 11 s16 0
V16 e16 s16 DC 18e0
RI16 e16 6 27e-1
VS17 4 s17 0
R17 s17 3 47e2
VS18 11 s18 0
R18 s18 8 56e3
VS19 5 s19 0
R19 s19 0 47e0
VS20 7 s20 0
R20 s20 8 15e3
VS21 10 s21 0
R21 s21 7 33e1
VS22 8 s22 0
R22 s22 12 10e-2
VS23 6 s23 0
I23 s23 1 DC 27e-2
VS24 2 s24 0
R24 s24 3 22e-1
VS25 7 s25 0
V25 e25 s25 DC 18e0
RI25 e25 5 27e-1
VS26 12 s26 0
R26 s26 13 12e1
.control
set numdgt=17
op
print v(1) v(2) v(3) v(4) v(5) v(6) v(7) v(8) v(9) v(10)
print v(11) v(12) v(13)
print i(vs0) i(vs1) i(vs2) i(vs3) i(vs4) i(vs5) i(vs6) i(vs7) i(vs8) i(vs9)
print i(vs10) i(vs11) i(vs12) i(vs13) i(vs14) i(vs15) i(vs16) i(vs17) i(vs18) i(vs19)
print i(vs20) i(vs21) i(vs22) i(vs23) i(vs24) i(vs25) i(vs26)
.endc
.end
