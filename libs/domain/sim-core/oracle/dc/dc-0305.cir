controls oracle dc-0305
* Generated (plan F2.7, ADR 0012): do not edit; regenerate with `pnpm sim oracle regen`. dc seed 20261030 index 305 nodes 14 elements 25
.options sparse gmin=1e-12 noopac
RG1 1 0 1000000000000
RG2 2 0 1000000000000
RG3 3 0 1000000000000
RG4 4 0 1000000000000
RG5 5 0 1000000000000
RG6 6 0 1000000000000
RG7 7 0 1000000000000
RG8 8 0 1000000000000
RG9 9 0 1000000000000
RG10 10 0 1000000000000
RG11 11 0 1000000000000
RG12 12 0 1000000000000
RG13 13 0 1000000000000
VS0 11 s0 0
R0 s0 5 33e0
VS1 0 s1 0
V1 e1 s1 DC 15e-1
RI1 e1 10 27e-1
VS2 10 s2 0
R2 s2 4 12e1
VS3 0 s3 0
R3 s3 5 82e0
VS4 5 s4 0
V4 e4 s4 DC 82e0
RI4 e4 8 12e-2
VS5 7 s5 0
V5 e5 s5 DC 10e0
RI5 e5 13 10e-1
VS6 5 s6 0
I6 s6 10 DC 68e-2
VS7 2 s7 0
R7 s7 8 68e-1
VS8 7 s8 0
V8 e8 s8 DC 39e-1
RI8 e8 8 82e-1
VS9 9 s9 0
R9 s9 6 39e1
VS10 4 s10 0
I10 s10 0 DC 82e-1
VS11 9 s11 0
R11 s11 7 10e1
VS12 12 s12 0
V12 e12 s12 DC 33e1
RI12 e12 2 12e-2
VS13 3 s13 0
R13 s13 12 56e3
VS14 5 s14 0
V14 e14 s14 DC 15e-1
RI14 e14 13 68e-1
VS15 9 s15 0
R15 s15 6 47e1
VS16 6 s16 0
V16 e16 s16 DC 82e-1
RI16 e16 10 12e-3
VS17 9 s17 0
V17 e17 s17 DC 10e1
RI17 e17 3 47e-2
VS18 1 s18 0
R18 s18 11 27e2
VS19 12 s19 0
R19 s19 1 82e3
VS20 5 s20 0
R20 s20 3 33e3
VS21 1 s21 0
V21 e21 s21 DC 33e0
RI21 e21 4 82e-3
VS22 12 s22 0
R22 s22 1 12e0
VS23 2 s23 0
I23 s23 10 DC 68e-4
VS24 5 s24 0
R24 s24 3 15e1
.control
set numdgt=17
op
print v(1) v(2) v(3) v(4) v(5) v(6) v(7) v(8) v(9) v(10)
print v(11) v(12) v(13)
print i(vs0) i(vs1) i(vs2) i(vs3) i(vs4) i(vs5) i(vs6) i(vs7) i(vs8) i(vs9)
print i(vs10) i(vs11) i(vs12) i(vs13) i(vs14) i(vs15) i(vs16) i(vs17) i(vs18) i(vs19)
print i(vs20) i(vs21) i(vs22) i(vs23) i(vs24)
.endc
.end
