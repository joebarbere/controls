controls oracle dc-0305
* Generated (plan F2.7, ADR 0012): do not edit; regenerate with `pnpm sim oracle regen`. dc seed 20261030 index 305 nodes 14 elements 23
.options sparse gmin=1e-12 noopac
RG1 1 0 1000000000000
RG2 2 0 1000000000000
RG3 3 0 1000000000000
RG4 4 0 1000000000000
RG5 5 0 1000000000000
RG6 6 0 1000000000000
RG7 7 0 1000000000000
RG8 8 0 1000000000000
RG9 9 0 1000000000000
RG10 10 0 1000000000000
RG11 11 0 1000000000000
RG12 12 0 1000000000000
RG13 13 0 1000000000000
VS0 0 s0 0
R0 s0 7 10e1
VS1 5 s1 0
R1 s1 9 82e0
VS2 11 s2 0
R2 s2 9 33e0
VS3 0 s3 0
R3 s3 6 47e1
VS4 9 s4 0
R4 s4 3 15e1
VS5 0 s5 0
V5 e5 s5 DC 10e1
RI5 e5 3 47e-2
VS6 2 s6 0
I6 s6 10 DC 68e-4
VS7 9 s7 0
V7 e7 s7 DC 82e0
RI7 e7 8 12e-2
VS8 12 s8 0
R8 s8 1 12e0
VS9 2 s9 0
R9 s9 8 68e-1
VS10 9 s10 0
R10 s10 3 33e3
VS11 0 s11 0
R11 s11 6 39e1
VS12 4 s12 0
I12 s12 5 DC 82e-1
VS13 12 s13 0
V13 e13 s13 DC 33e1
RI13 e13 2 12e-2
VS14 3 s14 0
R14 s14 12 56e3
VS15 1 s15 0
V15 e15 s15 DC 33e0
RI15 e15 4 82e-3
VS16 12 s16 0
R16 s16 1 82e3
VS17 5 s17 0
V17 e17 s17 DC 15e-1
RI17 e17 10 27e-1
VS18 9 s18 0
V18 e18 s18 DC 15e-1
RI18 e18 13 68e-1
VS19 9 s19 0
I19 s19 10 DC 68e-2
VS20 7 s20 0
V20 e20 s20 DC 39e-1
RI20 e20 8 82e-1
VS21 7 s21 0
V21 e21 s21 DC 10e0
RI21 e21 13 10e-1
VS22 10 s22 0
R22 s22 4 12e1
.control
set numdgt=17
op
print v(1) v(2) v(3) v(4) v(5) v(6) v(7) v(8) v(9) v(10)
print v(11) v(12) v(13)
print i(vs0) i(vs1) i(vs2) i(vs3) i(vs4) i(vs5) i(vs6) i(vs7) i(vs8) i(vs9)
print i(vs10) i(vs11) i(vs12) i(vs13) i(vs14) i(vs15) i(vs16) i(vs17) i(vs18) i(vs19)
print i(vs20) i(vs21) i(vs22)
.endc
.end
