controls oracle dc-0494
* Generated (plan F2.7, ADR 0012): do not edit; regenerate with `pnpm sim oracle regen`. dc seed 20261030 index 494 nodes 15 elements 27
.options sparse gmin=1e-12 noopac
RG1 1 0 1000000000000
RG2 2 0 1000000000000
RG3 3 0 1000000000000
RG4 4 0 1000000000000
RG5 5 0 1000000000000
RG6 6 0 1000000000000
RG7 7 0 1000000000000
RG8 8 0 1000000000000
RG9 9 0 1000000000000
RG10 10 0 1000000000000
RG11 11 0 1000000000000
RG12 12 0 1000000000000
RG13 13 0 1000000000000
RG14 14 0 1000000000000
VS0 14 s0 0
R0 s0 10 27e-2
VS1 7 s1 0
R1 s1 6 56e-1
VS2 9 s2 0
R2 s2 11 47e-2
VS3 0 s3 0
R3 s3 9 27e2
VS4 10 s4 0
R4 s4 12 56e3
VS5 0 s5 0
V5 e5 s5 DC 12e-1
RI5 e5 9 10e-3
VS6 10 s6 0
R6 s6 3 68e0
VS7 14 s7 0
R7 s7 0 22e-2
VS8 13 s8 0
R8 s8 8 12e3
VS9 5 s9 0
R9 s9 0 82e2
VS10 14 s10 0
R10 s10 4 18e1
VS11 3 s11 0
R11 s11 9 18e0
VS12 12 s12 0
I12 s12 2 DC 47e-4
VS13 5 s13 0
V13 e13 s13 DC 12e0
RI13 e13 0 47e-3
VS14 3 s14 0
R14 s14 0 22e2
VS15 2 s15 0
R15 s15 3 15e-1
VS16 1 s16 0
R16 s16 4 18e2
VS17 13 s17 0
R17 s17 3 56e3
VS18 0 s18 0
R18 s18 7 12e3
VS19 11 s19 0
R19 s19 13 22e3
VS20 1 s20 0
R20 s20 10 15e1
VS21 14 s21 0
R21 s21 12 22e2
VS22 4 s22 0
I22 s22 10 DC 18e-3
VS23 8 s23 0
V23 e23 s23 DC 18e0
RI23 e23 11 33e-1
VS24 2 s24 0
V24 e24 s24 DC 12e-1
RI24 e24 0 39e-1
VS25 3 s25 0
R25 s25 2 82e-1
VS26 10 s26 0
I26 s26 12 DC 15e-3
.control
set numdgt=17
op
print v(1) v(2) v(3) v(4) v(5) v(6) v(7) v(8) v(9) v(10)
print v(11) v(12) v(13) v(14)
print i(vs0) i(vs1) i(vs2) i(vs3) i(vs4) i(vs5) i(vs6) i(vs7) i(vs8) i(vs9)
print i(vs10) i(vs11) i(vs12) i(vs13) i(vs14) i(vs15) i(vs16) i(vs17) i(vs18) i(vs19)
print i(vs20) i(vs21) i(vs22) i(vs23) i(vs24) i(vs25) i(vs26)
.endc
.end
