controls oracle dc-0494
* Generated (plan F2.7, ADR 0012): do not edit; regenerate with `pnpm sim oracle regen`. dc seed 20261030 index 494 nodes 15 elements 29
.options sparse gmin=1e-12 noopac
RG1 1 0 1000000000000
RG2 2 0 1000000000000
RG3 3 0 1000000000000
RG4 4 0 1000000000000
RG5 5 0 1000000000000
RG6 6 0 1000000000000
RG7 7 0 1000000000000
RG8 8 0 1000000000000
RG9 9 0 1000000000000
RG10 10 0 1000000000000
RG11 11 0 1000000000000
RG12 12 0 1000000000000
RG13 13 0 1000000000000
RG14 14 0 1000000000000
VS0 3 s0 0
R0 s0 2 82e-1
VS1 5 s1 0
R1 s1 12 56e3
VS2 12 s2 0
I2 s2 2 DC 47e-4
VS3 4 s3 0
I3 s3 5 DC 18e-3
VS4 14 s4 0
R4 s4 12 22e2
VS5 0 s5 0
V5 e5 s5 DC 12e0
RI5 e5 10 47e-3
VS6 13 s6 0
R6 s6 8 12e3
VS7 14 s7 0
R7 s7 5 27e-2
VS8 3 s8 0
R8 s8 9 18e0
VS9 10 s9 0
V9 e9 s9 DC 12e-1
RI9 e9 9 10e-3
VS10 9 s10 0
R10 s10 11 47e-2
VS11 1 s11 0
R11 s11 4 18e2
VS12 14 s12 0
R12 s12 10 22e-2
VS13 5 s13 0
R13 s13 3 68e0
VS14 8 s14 0
V14 e14 s14 DC 18e0
RI14 e14 11 33e-1
VS15 13 s15 0
R15 s15 3 56e3
VS16 11 s16 0
R16 s16 13 22e3
VS17 14 s17 0
R17 s17 0 68e3
VS18 6 s18 0
V18 e18 s18 DC 68e-1
RI18 e18 11 27e-3
VS19 2 s19 0
V19 e19 s19 DC 12e-1
RI19 e19 10 39e-1
VS20 14 s20 0
R20 s20 4 18e1
VS21 5 s21 0
I21 s21 12 DC 15e-3
VS22 1 s22 0
R22 s22 5 15e1
VS23 0 s23 0
R23 s23 10 82e2
VS24 2 s24 0
R24 s24 3 15e-1
VS25 7 s25 0
R25 s25 6 56e-1
VS26 10 s26 0
R26 s26 7 12e3
VS27 3 s27 0
R27 s27 10 22e2
VS28 10 s28 0
R28 s28 9 27e2
.control
set numdgt=17
op
print v(1) v(2) v(3) v(4) v(5) v(6) v(7) v(8) v(9) v(10)
print v(11) v(12) v(13) v(14)
print i(vs0) i(vs1) i(vs2) i(vs3) i(vs4) i(vs5) i(vs6) i(vs7) i(vs8) i(vs9)
print i(vs10) i(vs11) i(vs12) i(vs13) i(vs14) i(vs15) i(vs16) i(vs17) i(vs18) i(vs19)
print i(vs20) i(vs21) i(vs22) i(vs23) i(vs24) i(vs25) i(vs26) i(vs27) i(vs28)
.endc
.end
