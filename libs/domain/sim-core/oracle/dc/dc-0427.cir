controls oracle dc-0427
* Generated (plan F2.7, ADR 0012): do not edit; regenerate with `pnpm sim oracle regen`. dc seed 20261030 index 427 nodes 9 elements 13
.options sparse gmin=1e-12 noopac
RG1 1 0 1000000000000
RG2 2 0 1000000000000
RG3 3 0 1000000000000
RG4 4 0 1000000000000
RG5 5 0 1000000000000
RG6 6 0 1000000000000
RG7 7 0 1000000000000
RG8 8 0 1000000000000
VS0 7 s0 0
R0 s0 8 56e1
VS1 8 s1 0
R1 s1 6 18e3
VS2 8 s2 0
R2 s2 2 10e-2
VS3 4 s3 0
R3 s3 0 33e3
VS4 0 s4 0
V4 e4 s4 DC 82e-1
RI4 e4 5 47e-3
VS5 4 s5 0
R5 s5 6 12e-2
VS6 2 s6 0
R6 s6 5 15e0
VS7 1 s7 0
R7 s7 8 12e0
VS8 5 s8 0
R8 s8 1 56e-2
VS9 3 s9 0
R9 s9 4 12e1
VS10 7 s10 0
R10 s10 6 68e1
VS11 3 s11 0
R11 s11 8 15e3
VS12 8 s12 0
V12 e12 s12 DC 56e1
RI12 e12 2 47e-3
.control
set numdgt=17
op
print v(1) v(2) v(3) v(4) v(5) v(6) v(7) v(8)
print i(vs0) i(vs1) i(vs2) i(vs3) i(vs4) i(vs5) i(vs6) i(vs7) i(vs8) i(vs9)
print i(vs10) i(vs11) i(vs12)
.endc
.end
