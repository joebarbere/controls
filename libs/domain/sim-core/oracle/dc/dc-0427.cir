controls oracle dc-0427
* Generated (plan F2.7, ADR 0012): do not edit; regenerate with `pnpm sim oracle regen`. dc seed 20261030 index 427 nodes 9 elements 10
.options sparse gmin=1e-12 noopac
RG1 1 0 1000000000000
RG2 2 0 1000000000000
RG3 3 0 1000000000000
RG4 4 0 1000000000000
RG5 5 0 1000000000000
RG6 6 0 1000000000000
RG7 7 0 1000000000000
RG8 8 0 1000000000000
VS0 3 s0 0
R0 s0 4 12e1
VS1 0 s1 0
R1 s1 2 10e-2
VS2 4 s2 0
R2 s2 8 33e3
VS3 0 s3 0
V3 e3 s3 DC 56e1
RI3 e3 2 47e-3
VS4 7 s4 0
R4 s4 0 56e1
VS5 2 s5 0
R5 s5 5 15e0
VS6 8 s6 0
V6 e6 s6 DC 82e-1
RI6 e6 5 47e-3
VS7 4 s7 0
R7 s7 6 12e-2
VS8 5 s8 0
R8 s8 1 56e-2
VS9 0 s9 0
R9 s9 6 18e3
.control
set numdgt=17
op
print v(1) v(2) v(3) v(4) v(5) v(6) v(7) v(8)
print i(vs0) i(vs1) i(vs2) i(vs3) i(vs4) i(vs5) i(vs6) i(vs7) i(vs8) i(vs9)
.endc
.end
