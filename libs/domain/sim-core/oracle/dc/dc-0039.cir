controls oracle dc-0039
* Generated (plan F2.7, ADR 0012): do not edit; regenerate with `pnpm sim oracle regen`. dc seed 20261030 index 39 nodes 12 elements 15
.options sparse gmin=1e-12 noopac
RG1 1 0 1000000000000
RG2 2 0 1000000000000
RG3 3 0 1000000000000
RG4 4 0 1000000000000
RG5 5 0 1000000000000
RG6 6 0 1000000000000
RG7 7 0 1000000000000
RG8 8 0 1000000000000
RG9 9 0 1000000000000
RG10 10 0 1000000000000
RG11 11 0 1000000000000
VS0 0 s0 0
V0 e0 s0 DC 47e0
RI0 e0 11 22e-2
VS1 4 s1 0
R1 s1 8 27e3
VS2 5 s2 0
R2 s2 3 12e-1
VS3 0 s3 0
R3 s3 8 56e3
VS4 10 s4 0
R4 s4 4 82e3
VS5 6 s5 0
R5 s5 10 22e-2
VS6 3 s6 0
R6 s6 10 82e-2
VS7 3 s7 0
R7 s7 0 56e-2
VS8 10 s8 0
R8 s8 3 39e2
VS9 9 s9 0
R9 s9 5 18e3
VS10 2 s10 0
I10 s10 1 DC 39e-4
VS11 8 s11 0
R11 s11 2 15e0
VS12 1 s12 0
R12 s12 2 12e-1
VS13 11 s13 0
R13 s13 7 18e-1
VS14 3 s14 0
R14 s14 8 39e2
.control
set numdgt=17
op
print v(1) v(2) v(3) v(4) v(5) v(6) v(7) v(8) v(9) v(10)
print v(11)
print i(vs0) i(vs1) i(vs2) i(vs3) i(vs4) i(vs5) i(vs6) i(vs7) i(vs8) i(vs9)
print i(vs10) i(vs11) i(vs12) i(vs13) i(vs14)
.endc
.end
