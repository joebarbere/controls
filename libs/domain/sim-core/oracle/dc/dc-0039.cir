controls oracle dc-0039
* Generated (plan F2.7, ADR 0012): do not edit; regenerate with `pnpm sim oracle regen`. dc seed 20261030 index 39 nodes 12 elements 19
.options sparse gmin=1e-12 noopac
RG1 1 0 1000000000000
RG2 2 0 1000000000000
RG3 3 0 1000000000000
RG4 4 0 1000000000000
RG5 5 0 1000000000000
RG6 6 0 1000000000000
RG7 7 0 1000000000000
RG8 8 0 1000000000000
RG9 9 0 1000000000000
RG10 10 0 1000000000000
RG11 11 0 1000000000000
VS0 6 s0 0
R0 s0 11 12e-2
VS1 6 s1 0
R1 s1 7 56e0
VS2 3 s2 0
R2 s2 10 82e-2
VS3 3 s3 0
R3 s3 8 39e2
VS4 6 s4 0
R4 s4 1 56e-1
VS5 11 s5 0
R5 s5 7 18e-1
VS6 0 s6 0
R6 s6 8 56e3
VS7 1 s7 0
R7 s7 2 12e-1
VS8 10 s8 0
R8 s8 3 39e2
VS9 10 s9 0
R9 s9 4 82e3
VS10 3 s10 0
R10 s10 0 56e-2
VS11 5 s11 0
R11 s11 3 12e-1
VS12 8 s12 0
R12 s12 2 15e0
VS13 9 s13 0
R13 s13 5 18e3
VS14 9 s14 0
R14 s14 10 12e0
VS15 4 s15 0
R15 s15 8 27e3
VS16 2 s16 0
I16 s16 1 DC 39e-4
VS17 0 s17 0
V17 e17 s17 DC 47e0
RI17 e17 11 22e-2
VS18 6 s18 0
R18 s18 10 22e-2
.control
set numdgt=17
op
print v(1) v(2) v(3) v(4) v(5) v(6) v(7) v(8) v(9) v(10)
print v(11)
print i(vs0) i(vs1) i(vs2) i(vs3) i(vs4) i(vs5) i(vs6) i(vs7) i(vs8) i(vs9)
print i(vs10) i(vs11) i(vs12) i(vs13) i(vs14) i(vs15) i(vs16) i(vs17) i(vs18)
.endc
.end
