controls oracle dc-0285
* Generated (plan F2.7, ADR 0012): do not edit; regenerate with `pnpm sim oracle regen`. dc seed 20261030 index 285 nodes 9 elements 15
.options sparse gmin=1e-12 noopac
RG1 1 0 1000000000000
RG2 2 0 1000000000000
RG3 3 0 1000000000000
RG4 4 0 1000000000000
RG5 5 0 1000000000000
RG6 6 0 1000000000000
RG7 7 0 1000000000000
RG8 8 0 1000000000000
VS0 0 s0 0
V0 e0 s0 DC 39e0
RI0 e0 3 39e-3
VS1 3 s1 0
R1 s1 7 27e-1
VS2 8 s2 0
R2 s2 6 68e2
VS3 8 s3 0
R3 s3 1 39e1
VS4 8 s4 0
I4 s4 5 DC 22e-1
VS5 5 s5 0
R5 s5 4 27e-2
VS6 0 s6 0
R6 s6 1 15e1
VS7 8 s7 0
R7 s7 5 82e-2
VS8 3 s8 0
V8 e8 s8 DC 15e1
RI8 e8 0 68e-1
VS9 5 s9 0
R9 s9 3 47e1
VS10 4 s10 0
R10 s10 3 56e-2
VS11 6 s11 0
R11 s11 4 27e0
VS12 6 s12 0
I12 s12 4 DC 82e-4
VS13 2 s13 0
R13 s13 8 12e2
VS14 0 s14 0
R14 s14 4 68e1
.control
set numdgt=17
op
print v(1) v(2) v(3) v(4) v(5) v(6) v(7) v(8)
print i(vs0) i(vs1) i(vs2) i(vs3) i(vs4) i(vs5) i(vs6) i(vs7) i(vs8) i(vs9)
print i(vs10) i(vs11) i(vs12) i(vs13) i(vs14)
.endc
.end
