controls oracle dc-0285
* Generated (plan F2.7, ADR 0012): do not edit; regenerate with `pnpm sim oracle regen`. dc seed 20261030 index 285 nodes 9 elements 17
.options sparse gmin=1e-12 noopac
RG1 1 0 1000000000000
RG2 2 0 1000000000000
RG3 3 0 1000000000000
RG4 4 0 1000000000000
RG5 5 0 1000000000000
RG6 6 0 1000000000000
RG7 7 0 1000000000000
RG8 8 0 1000000000000
VS0 2 s0 0
R0 s0 8 12e2
VS1 0 s1 0
V1 e1 s1 DC 15e1
RI1 e1 5 68e-1
VS2 4 s2 0
R2 s2 0 56e-2
VS3 7 s3 0
V3 e3 s3 DC 12e0
RI3 e3 6 82e-2
VS4 6 s4 0
R4 s4 4 27e0
VS5 8 s5 0
I5 s5 3 DC 22e-1
VS6 0 s6 0
R6 s6 7 27e-1
VS7 2 s7 0
V7 e7 s7 DC 82e-1
RI7 e7 7 12e-1
VS8 5 s8 0
R8 s8 4 68e1
VS9 5 s9 0
R9 s9 1 15e1
VS10 5 s10 0
V10 e10 s10 DC 39e0
RI10 e10 0 39e-3
VS11 6 s11 0
I11 s11 4 DC 82e-4
VS12 3 s12 0
R12 s12 0 47e1
VS13 8 s13 0
R13 s13 6 68e2
VS14 8 s14 0
R14 s14 1 39e1
VS15 8 s15 0
R15 s15 3 82e-2
VS16 3 s16 0
R16 s16 4 27e-2
.control
set numdgt=17
op
print v(1) v(2) v(3) v(4) v(5) v(6) v(7) v(8)
print i(vs0) i(vs1) i(vs2) i(vs3) i(vs4) i(vs5) i(vs6) i(vs7) i(vs8) i(vs9)
print i(vs10) i(vs11) i(vs12) i(vs13) i(vs14) i(vs15) i(vs16)
.endc
.end
