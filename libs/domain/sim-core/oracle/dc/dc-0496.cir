controls oracle dc-0496
* Generated (plan F2.7, ADR 0012): do not edit; regenerate with `pnpm sim oracle regen`. dc seed 20261030 index 496 nodes 19 elements 28
.options sparse gmin=1e-12 noopac
RG1 1 0 1000000000000
RG2 2 0 1000000000000
RG3 3 0 1000000000000
RG4 4 0 1000000000000
RG5 5 0 1000000000000
RG6 6 0 1000000000000
RG7 7 0 1000000000000
RG8 8 0 1000000000000
RG9 9 0 1000000000000
RG10 10 0 1000000000000
RG11 11 0 1000000000000
RG12 12 0 1000000000000
RG13 13 0 1000000000000
RG14 14 0 1000000000000
RG15 15 0 1000000000000
RG16 16 0 1000000000000
RG17 17 0 1000000000000
RG18 18 0 1000000000000
VS0 9 s0 0
R0 s0 4 56e-2
VS1 4 s1 0
R1 s1 16 27e3
VS2 14 s2 0
R2 s2 0 10e1
VS3 0 s3 0
V3 e3 s3 DC 82e1
RI3 e3 3 15e-1
VS4 3 s4 0
R4 s4 13 10e2
VS5 3 s5 0
V5 e5 s5 DC 18e-1
RI5 e5 8 47e-2
VS6 13 s6 0
R6 s6 4 18e-1
VS7 4 s7 0
V7 e7 s7 DC 18e0
RI7 e7 1 56e-1
VS8 0 s8 0
R8 s8 16 39e0
VS9 9 s9 0
V9 e9 s9 DC 22e0
RI9 e9 6 82e-2
VS10 13 s10 0
R10 s10 15 39e2
VS11 1 s11 0
R11 s11 8 15e1
VS12 14 s12 0
R12 s12 2 10e1
VS13 11 s13 0
R13 s13 13 12e-2
VS14 10 s14 0
R14 s14 18 15e-2
VS15 7 s15 0
R15 s15 11 56e1
VS16 12 s16 0
V16 e16 s16 DC 10e-1
RI16 e16 10 68e-2
VS17 12 s17 0
R17 s17 4 33e-2
VS18 9 s18 0
V18 e18 s18 DC 27e0
RI18 e18 16 33e-3
VS19 5 s19 0
R19 s19 4 82e3
VS20 10 s20 0
R20 s20 0 47e1
VS21 17 s21 0
R21 s21 6 82e1
VS22 0 s22 0
R22 s22 16 82e0
VS23 17 s23 0
R23 s23 9 68e0
VS24 7 s24 0
R24 s24 10 56e2
VS25 8 s25 0
V25 e25 s25 DC 33e-1
RI25 e25 9 47e-1
VS26 9 s26 0
R26 s26 6 39e-2
VS27 4 s27 0
R27 s27 18 10e2
.control
set numdgt=17
op
print v(1) v(2) v(3) v(4) v(5) v(6) v(7) v(8) v(9) v(10)
print v(11) v(12) v(13) v(14) v(15) v(16) v(17) v(18)
print i(vs0) i(vs1) i(vs2) i(vs3) i(vs4) i(vs5) i(vs6) i(vs7) i(vs8) i(vs9)
print i(vs10) i(vs11) i(vs12) i(vs13) i(vs14) i(vs15) i(vs16) i(vs17) i(vs18) i(vs19)
print i(vs20) i(vs21) i(vs22) i(vs23) i(vs24) i(vs25) i(vs26) i(vs27)
.endc
.end
