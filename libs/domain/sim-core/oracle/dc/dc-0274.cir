controls oracle dc-0274
* Generated (plan F2.7, ADR 0012): do not edit; regenerate with `pnpm sim oracle regen`. dc seed 20261030 index 274 nodes 13 elements 23
.options sparse gmin=1e-12 noopac
RG1 1 0 1000000000000
RG2 2 0 1000000000000
RG3 3 0 1000000000000
RG4 4 0 1000000000000
RG5 5 0 1000000000000
RG6 6 0 1000000000000
RG7 7 0 1000000000000
RG8 8 0 1000000000000
RG9 9 0 1000000000000
RG10 10 0 1000000000000
RG11 11 0 1000000000000
RG12 12 0 1000000000000
VS0 11 s0 0
R0 s0 0 15e-2
VS1 4 s1 0
R1 s1 5 27e0
VS2 0 s2 0
R2 s2 10 56e-2
VS3 3 s3 0
R3 s3 12 68e0
VS4 3 s4 0
I4 s4 5 DC 39e-2
VS5 10 s5 0
R5 s5 9 56e-2
VS6 7 s6 0
I6 s6 0 DC 33e-2
VS7 6 s7 0
R7 s7 10 39e3
VS8 0 s8 0
R8 s8 9 15e2
VS9 2 s9 0
I9 s9 8 DC 68e-1
VS10 6 s10 0
I10 s10 7 DC 18e-4
VS11 10 s11 0
R11 s11 1 15e1
VS12 8 s12 0
R12 s12 9 27e3
VS13 0 s13 0
V13 e13 s13 DC 82e1
RI13 e13 12 39e-3
VS14 12 s14 0
R14 s14 7 27e-2
VS15 0 s15 0
R15 s15 1 12e1
VS16 12 s16 0
V16 e16 s16 DC 56e0
RI16 e16 2 82e-2
VS17 7 s17 0
R17 s17 5 33e2
VS18 2 s18 0
R18 s18 6 15e0
VS19 12 s19 0
V19 e19 s19 DC 47e-1
RI19 e19 10 15e-1
VS20 2 s20 0
R20 s20 1 47e3
VS21 8 s21 0
R21 s21 0 82e0
VS22 3 s22 0
R22 s22 4 10e-2
.control
set numdgt=17
op
print v(1) v(2) v(3) v(4) v(5) v(6) v(7) v(8) v(9) v(10)
print v(11) v(12)
print i(vs0) i(vs1) i(vs2) i(vs3) i(vs4) i(vs5) i(vs6) i(vs7) i(vs8) i(vs9)
print i(vs10) i(vs11) i(vs12) i(vs13) i(vs14) i(vs15) i(vs16) i(vs17) i(vs18) i(vs19)
print i(vs20) i(vs21) i(vs22)
.endc
.end
