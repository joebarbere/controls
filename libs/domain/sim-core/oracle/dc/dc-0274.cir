controls oracle dc-0274
* Generated (plan F2.7, ADR 0012): do not edit; regenerate with `pnpm sim oracle regen`. dc seed 20261030 index 274 nodes 13 elements 24
.options sparse gmin=1e-12 noopac
RG1 1 0 1000000000000
RG2 2 0 1000000000000
RG3 3 0 1000000000000
RG4 4 0 1000000000000
RG5 5 0 1000000000000
RG6 6 0 1000000000000
RG7 7 0 1000000000000
RG8 8 0 1000000000000
RG9 9 0 1000000000000
RG10 10 0 1000000000000
RG11 11 0 1000000000000
RG12 12 0 1000000000000
VS0 0 s0 0
R0 s0 12 15e-2
VS1 3 s1 0
R1 s1 11 68e0
VS2 0 s2 0
V2 e2 s2 DC 39e0
RI2 e2 7 56e-2
VS3 11 s3 0
V3 e3 s3 DC 56e0
RI3 e3 2 82e-2
VS4 3 s4 0
R4 s4 4 10e-2
VS5 10 s5 0
R5 s5 9 56e-2
VS6 7 s6 0
R6 s6 5 33e2
VS7 12 s7 0
V7 e7 s7 DC 82e1
RI7 e7 11 39e-3
VS8 4 s8 0
R8 s8 5 27e0
VS9 12 s9 0
R9 s9 1 12e1
VS10 2 s10 0
I10 s10 8 DC 68e-1
VS11 8 s11 0
R11 s11 12 82e0
VS12 3 s12 0
I12 s12 5 DC 39e-2
VS13 7 s13 0
I13 s13 12 DC 33e-2
VS14 8 s14 0
R14 s14 9 27e3
VS15 10 s15 0
R15 s15 1 15e1
VS16 12 s16 0
R16 s16 10 56e-2
VS17 6 s17 0
I17 s17 7 DC 18e-4
VS18 2 s18 0
R18 s18 1 47e3
VS19 12 s19 0
R19 s19 9 15e2
VS20 11 s20 0
V20 e20 s20 DC 47e-1
RI20 e20 10 15e-1
VS21 6 s21 0
R21 s21 10 39e3
VS22 2 s22 0
R22 s22 6 15e0
VS23 11 s23 0
R23 s23 7 27e-2
.control
set numdgt=17
op
print v(1) v(2) v(3) v(4) v(5) v(6) v(7) v(8) v(9) v(10)
print v(11) v(12)
print i(vs0) i(vs1) i(vs2) i(vs3) i(vs4) i(vs5) i(vs6) i(vs7) i(vs8) i(vs9)
print i(vs10) i(vs11) i(vs12) i(vs13) i(vs14) i(vs15) i(vs16) i(vs17) i(vs18) i(vs19)
print i(vs20) i(vs21) i(vs22) i(vs23)
.endc
.end
