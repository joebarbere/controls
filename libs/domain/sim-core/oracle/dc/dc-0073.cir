controls oracle dc-0073
* Generated (plan F2.7, ADR 0012): do not edit; regenerate with `pnpm sim oracle regen`. dc seed 20261030 index 73 nodes 9 elements 16
.options sparse gmin=1e-12 noopac
RG1 1 0 1000000000000
RG2 2 0 1000000000000
RG3 3 0 1000000000000
RG4 4 0 1000000000000
RG5 5 0 1000000000000
RG6 6 0 1000000000000
RG7 7 0 1000000000000
RG8 8 0 1000000000000
VS0 3 s0 0
R0 s0 7 22e2
VS1 5 s1 0
R1 s1 0 18e3
VS2 0 s2 0
R2 s2 8 39e-2
VS3 1 s3 0
R3 s3 7 82e0
VS4 8 s4 0
R4 s4 2 22e0
VS5 8 s5 0
R5 s5 0 82e0
VS6 0 s6 0
V6 e6 s6 DC 15e1
RI6 e6 4 15e-1
VS7 1 s7 0
I7 s7 8 DC 39e-3
VS8 1 s8 0
R8 s8 2 15e2
VS9 3 s9 0
R9 s9 4 56e1
VS10 2 s10 0
I10 s10 3 DC 12e-3
VS11 3 s11 0
R11 s11 5 10e2
VS12 6 s12 0
R12 s12 3 56e0
VS13 6 s13 0
R13 s13 1 15e-2
VS14 5 s14 0
R14 s14 7 82e-1
VS15 3 s15 0
R15 s15 8 18e0
.control
set numdgt=17
op
print v(1) v(2) v(3) v(4) v(5) v(6) v(7) v(8)
print i(vs0) i(vs1) i(vs2) i(vs3) i(vs4) i(vs5) i(vs6) i(vs7) i(vs8) i(vs9)
print i(vs10) i(vs11) i(vs12) i(vs13) i(vs14) i(vs15)
.endc
.end
