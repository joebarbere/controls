controls oracle dc-0073
* Generated (plan F2.7, ADR 0012): do not edit; regenerate with `pnpm sim oracle regen`. dc seed 20261030 index 73 nodes 9 elements 12
.options sparse gmin=1e-12 noopac
RG1 1 0 1000000000000
RG2 2 0 1000000000000
RG3 3 0 1000000000000
RG4 4 0 1000000000000
RG5 5 0 1000000000000
RG6 6 0 1000000000000
RG7 7 0 1000000000000
RG8 8 0 1000000000000
VS0 3 s0 0
R0 s0 5 10e2
VS1 3 s1 0
R1 s1 7 22e2
VS2 8 s2 0
R2 s2 0 82e0
VS3 1 s3 0
R3 s3 7 82e0
VS4 0 s4 0
R4 s4 8 39e-2
VS5 0 s5 0
V5 e5 s5 DC 15e1
RI5 e5 4 15e-1
VS6 8 s6 0
R6 s6 2 22e0
VS7 6 s7 0
R7 s7 1 15e-2
VS8 2 s8 0
I8 s8 3 DC 12e-3
VS9 3 s9 0
R9 s9 4 56e1
VS10 3 s10 0
R10 s10 8 18e0
VS11 1 s11 0
I11 s11 8 DC 39e-3
.control
set numdgt=17
op
print v(1) v(2) v(3) v(4) v(5) v(6) v(7) v(8)
print i(vs0) i(vs1) i(vs2) i(vs3) i(vs4) i(vs5) i(vs6) i(vs7) i(vs8) i(vs9)
print i(vs10) i(vs11)
.endc
.end
