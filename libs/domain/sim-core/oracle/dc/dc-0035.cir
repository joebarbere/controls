controls oracle dc-0035
* Generated (plan F2.7, ADR 0012): do not edit; regenerate with `pnpm sim oracle regen`. dc seed 20261030 index 35 nodes 25 elements 31
.options sparse gmin=1e-12 noopac
RG1 1 0 1000000000000
RG2 2 0 1000000000000
RG3 3 0 1000000000000
RG4 4 0 1000000000000
RG5 5 0 1000000000000
RG6 6 0 1000000000000
RG7 7 0 1000000000000
RG8 8 0 1000000000000
RG9 9 0 1000000000000
RG10 10 0 1000000000000
RG11 11 0 1000000000000
RG12 12 0 1000000000000
RG13 13 0 1000000000000
RG14 14 0 1000000000000
RG15 15 0 1000000000000
RG16 16 0 1000000000000
RG17 17 0 1000000000000
RG18 18 0 1000000000000
RG19 19 0 1000000000000
RG20 20 0 1000000000000
RG21 21 0 1000000000000
RG22 22 0 1000000000000
RG23 23 0 1000000000000
RG24 24 0 1000000000000
VS0 0 s0 0
V0 e0 s0 DC 56e0
RI0 e0 15 15e-3
VS1 22 s1 0
R1 s1 0 22e3
VS2 10 s2 0
R2 s2 24 22e0
VS3 8 s3 0
V3 e3 s3 DC 68e0
RI3 e3 14 27e-1
VS4 2 s4 0
R4 s4 19 12e0
VS5 6 s5 0
V5 e5 s5 DC 18e0
RI5 e5 15 10e-3
VS6 7 s6 0
R6 s6 16 12e-2
VS7 16 s7 0
V7 e7 s7 DC 10e0
RI7 e7 8 22e-3
VS8 8 s8 0
R8 s8 18 15e0
VS9 13 s9 0
R9 s9 14 10e1
VS10 16 s10 0
R10 s10 17 82e2
VS11 20 s11 0
R11 s11 8 33e2
VS12 10 s12 0
I12 s12 7 DC 18e-2
VS13 23 s13 0
R13 s13 14 68e-2
VS14 12 s14 0
V14 e14 s14 DC 12e1
RI14 e14 6 27e-3
VS15 5 s15 0
V15 e15 s15 DC 33e0
RI15 e15 10 82e-1
VS16 8 s16 0
R16 s16 7 56e2
VS17 15 s17 0
R17 s17 11 18e-1
VS18 4 s18 0
R18 s18 13 56e-2
VS19 11 s19 0
V19 e19 s19 DC 82e1
RI19 e19 21 68e-1
VS20 23 s20 0
R20 s20 12 39e0
VS21 5 s21 0
V21 e21 s21 DC 33e1
RI21 e21 22 47e-3
VS22 3 s22 0
R22 s22 1 22e-2
VS23 8 s23 0
R23 s23 14 27e-2
VS24 18 s24 0
R24 s24 9 47e3
VS25 10 s25 0
R25 s25 19 12e2
VS26 22 s26 0
R26 s26 1 18e3
VS27 3 s27 0
R27 s27 8 33e-1
VS28 17 s28 0
R28 s28 9 27e1
VS29 22 s29 0
R29 s29 6 56e3
VS30 4 s30 0
I30 s30 21 DC 15e-2
.control
set numdgt=17
op
print v(1) v(2) v(3) v(4) v(5) v(6) v(7) v(8) v(9) v(10)
print v(11) v(12) v(13) v(14) v(15) v(16) v(17) v(18) v(19) v(20)
print v(21) v(22) v(23) v(24)
print i(vs0) i(vs1) i(vs2) i(vs3) i(vs4) i(vs5) i(vs6) i(vs7) i(vs8) i(vs9)
print i(vs10) i(vs11) i(vs12) i(vs13) i(vs14) i(vs15) i(vs16) i(vs17) i(vs18) i(vs19)
print i(vs20) i(vs21) i(vs22) i(vs23) i(vs24) i(vs25) i(vs26) i(vs27) i(vs28) i(vs29)
print i(vs30)
.endc
.end
