controls oracle dc-0035
* Generated (plan F2.7, ADR 0012): do not edit; regenerate with `pnpm sim oracle regen`. dc seed 20261030 index 35 nodes 25 elements 36
.options sparse gmin=1e-12 noopac
RG1 1 0 1000000000000
RG2 2 0 1000000000000
RG3 3 0 1000000000000
RG4 4 0 1000000000000
RG5 5 0 1000000000000
RG6 6 0 1000000000000
RG7 7 0 1000000000000
RG8 8 0 1000000000000
RG9 9 0 1000000000000
RG10 10 0 1000000000000
RG11 11 0 1000000000000
RG12 12 0 1000000000000
RG13 13 0 1000000000000
RG14 14 0 1000000000000
RG15 15 0 1000000000000
RG16 16 0 1000000000000
RG17 17 0 1000000000000
RG18 18 0 1000000000000
RG19 19 0 1000000000000
RG20 20 0 1000000000000
RG21 21 0 1000000000000
RG22 22 0 1000000000000
RG23 23 0 1000000000000
RG24 24 0 1000000000000
VS0 3 s0 0
R0 s0 8 33e-1
VS1 20 s1 0
R1 s1 8 33e2
VS2 0 s2 0
V2 e2 s2 DC 10e0
RI2 e2 8 22e-3
VS3 22 s3 0
V3 e3 s3 DC 56e0
RI3 e3 15 15e-3
VS4 3 s4 0
R4 s4 1 22e-2
VS5 2 s5 0
R5 s5 19 12e0
VS6 21 s6 0
R6 s6 7 12e-2
VS7 17 s7 0
R7 s7 9 27e1
VS8 4 s8 0
R8 s8 13 56e-2
VS9 16 s9 0
R9 s9 6 56e3
VS10 18 s10 0
R10 s10 9 47e3
VS11 7 s11 0
R11 s11 0 12e-2
VS12 4 s12 0
I12 s12 21 DC 15e-2
VS13 10 s13 0
R13 s13 24 22e0
VS14 8 s14 0
V14 e14 s14 DC 68e0
RI14 e14 14 27e-1
VS15 10 s15 0
I15 s15 7 DC 18e-2
VS16 15 s16 0
R16 s16 11 18e-1
VS17 6 s17 0
V17 e17 s17 DC 18e0
RI17 e17 15 10e-3
VS18 11 s18 0
V18 e18 s18 DC 82e1
RI18 e18 21 68e-1
VS19 16 s19 0
R19 s19 1 18e3
VS20 13 s20 0
R20 s20 14 10e1
VS21 16 s21 0
R21 s21 22 22e3
VS22 0 s22 0
R22 s22 2 22e0
VS23 8 s23 0
R23 s23 7 56e2
VS24 5 s24 0
V24 e24 s24 DC 33e1
RI24 e24 16 47e-3
VS25 0 s25 0
R25 s25 17 82e2
VS26 10 s26 0
R26 s26 19 12e2
VS27 23 s27 0
R27 s27 14 68e-2
VS28 4 s28 0
R28 s28 7 47e2
VS29 5 s29 0
V29 e29 s29 DC 33e0
RI29 e29 10 82e-1
VS30 23 s30 0
R30 s30 12 39e0
VS31 12 s31 0
V31 e31 s31 DC 12e1
RI31 e31 6 27e-3
VS32 8 s32 0
R32 s32 14 27e-2
VS33 20 s33 0
R33 s33 3 33e-2
VS34 1 s34 0
V34 e34 s34 DC 47e-1
RI34 e34 24 39e-3
VS35 8 s35 0
R35 s35 18 15e0
.control
set numdgt=17
op
print v(1) v(2) v(3) v(4) v(5) v(6) v(7) v(8) v(9) v(10)
print v(11) v(12) v(13) v(14) v(15) v(16) v(17) v(18) v(19) v(20)
print v(21) v(22) v(23) v(24)
print i(vs0) i(vs1) i(vs2) i(vs3) i(vs4) i(vs5) i(vs6) i(vs7) i(vs8) i(vs9)
print i(vs10) i(vs11) i(vs12) i(vs13) i(vs14) i(vs15) i(vs16) i(vs17) i(vs18) i(vs19)
print i(vs20) i(vs21) i(vs22) i(vs23) i(vs24) i(vs25) i(vs26) i(vs27) i(vs28) i(vs29)
print i(vs30) i(vs31) i(vs32) i(vs33) i(vs34) i(vs35)
.endc
.end
