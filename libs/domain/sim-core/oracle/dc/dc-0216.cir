controls oracle dc-0216
* Generated (plan F2.7, ADR 0012): do not edit; regenerate with `pnpm sim oracle regen`. dc seed 20261030 index 216 nodes 24 elements 29
.options sparse gmin=1e-12 noopac
RG1 1 0 1000000000000
RG2 2 0 1000000000000
RG3 3 0 1000000000000
RG4 4 0 1000000000000
RG5 5 0 1000000000000
RG6 6 0 1000000000000
RG7 7 0 1000000000000
RG8 8 0 1000000000000
RG9 9 0 1000000000000
RG10 10 0 1000000000000
RG11 11 0 1000000000000
RG12 12 0 1000000000000
RG13 13 0 1000000000000
RG14 14 0 1000000000000
RG15 15 0 1000000000000
RG16 16 0 1000000000000
RG17 17 0 1000000000000
RG18 18 0 1000000000000
RG19 19 0 1000000000000
RG20 20 0 1000000000000
RG21 21 0 1000000000000
RG22 22 0 1000000000000
RG23 23 0 1000000000000
VS0 19 s0 0
R0 s0 21 15e1
VS1 16 s1 0
R1 s1 23 22e-2
VS2 12 s2 0
R2 s2 16 12e-1
VS3 8 s3 0
R3 s3 16 12e-1
VS4 2 s4 0
R4 s4 16 39e3
VS5 8 s5 0
R5 s5 22 12e3
VS6 14 s6 0
R6 s6 0 18e-2
VS7 3 s7 0
R7 s7 6 27e-1
VS8 9 s8 0
R8 s8 0 68e-2
VS9 18 s9 0
R9 s9 20 22e2
VS10 0 s10 0
V10 e10 s10 DC 47e-1
RI10 e10 10 82e-1
VS11 16 s11 0
I11 s11 0 DC 15e-4
VS12 13 s12 0
R12 s12 15 68e0
VS13 5 s13 0
V13 e13 s13 DC 39e1
RI13 e13 13 12e-2
VS14 13 s14 0
V14 e14 s14 DC 18e-1
RI14 e14 1 12e-2
VS15 6 s15 0
R15 s15 16 56e0
VS16 11 s16 0
V16 e16 s16 DC 33e1
RI16 e16 17 39e-2
VS17 16 s17 0
R17 s17 20 22e-2
VS18 0 s18 0
V18 e18 s18 DC 27e-1
RI18 e18 8 27e-3
VS19 21 s19 0
R19 s19 1 22e-2
VS20 20 s20 0
V20 e20 s20 DC 68e-1
RI20 e20 23 12e-2
VS21 22 s21 0
R21 s21 6 18e1
VS22 6 s22 0
R22 s22 19 12e3
VS23 16 s23 0
R23 s23 4 47e0
VS24 3 s24 0
R24 s24 7 15e3
VS25 21 s25 0
R25 s25 10 39e3
VS26 3 s26 0
R26 s26 8 68e-2
VS27 18 s27 0
R27 s27 1 82e2
VS28 17 s28 0
R28 s28 23 22e1
.control
set numdgt=17
op
print v(1) v(2) v(3) v(4) v(5) v(6) v(7) v(8) v(9) v(10)
print v(11) v(12) v(13) v(14) v(15) v(16) v(17) v(18) v(19) v(20)
print v(21) v(22) v(23)
print i(vs0) i(vs1) i(vs2) i(vs3) i(vs4) i(vs5) i(vs6) i(vs7) i(vs8) i(vs9)
print i(vs10) i(vs11) i(vs12) i(vs13) i(vs14) i(vs15) i(vs16) i(vs17) i(vs18) i(vs19)
print i(vs20) i(vs21) i(vs22) i(vs23) i(vs24) i(vs25) i(vs26) i(vs27) i(vs28)
.endc
.end
