controls oracle dc-0216
* Generated (plan F2.7, ADR 0012): do not edit; regenerate with `pnpm sim oracle regen`. dc seed 20261030 index 216 nodes 24 elements 37
.options sparse gmin=1e-12 noopac
RG1 1 0 1000000000000
RG2 2 0 1000000000000
RG3 3 0 1000000000000
RG4 4 0 1000000000000
RG5 5 0 1000000000000
RG6 6 0 1000000000000
RG7 7 0 1000000000000
RG8 8 0 1000000000000
RG9 9 0 1000000000000
RG10 10 0 1000000000000
RG11 11 0 1000000000000
RG12 12 0 1000000000000
RG13 13 0 1000000000000
RG14 14 0 1000000000000
RG15 15 0 1000000000000
RG16 16 0 1000000000000
RG17 17 0 1000000000000
RG18 18 0 1000000000000
RG19 19 0 1000000000000
RG20 20 0 1000000000000
RG21 21 0 1000000000000
RG22 22 0 1000000000000
RG23 23 0 1000000000000
VS0 9 s0 0
R0 s0 0 68e-2
VS1 3 s1 0
R1 s1 8 68e-2
VS2 0 s2 0
V2 e2 s2 DC 27e-1
RI2 e2 8 27e-3
VS3 11 s3 0
V3 e3 s3 DC 33e1
RI3 e3 17 39e-2
VS4 16 s4 0
R4 s4 23 22e-2
VS5 8 s5 0
R5 s5 22 12e3
VS6 5 s6 0
R6 s6 23 82e3
VS7 17 s7 0
R7 s7 23 22e1
VS8 6 s8 0
R8 s8 16 56e0
VS9 18 s9 0
R9 s9 20 22e2
VS10 19 s10 0
R10 s10 21 15e1
VS11 2 s11 0
R11 s11 19 39e1
VS12 14 s12 0
R12 s12 7 47e-2
VS13 16 s13 0
I13 s13 0 DC 15e-4
VS14 5 s14 0
V14 e14 s14 DC 39e1
RI14 e14 13 12e-2
VS15 3 s15 0
R15 s15 7 15e3
VS16 21 s16 0
R16 s16 1 22e-2
VS17 0 s17 0
V17 e17 s17 DC 47e-1
RI17 e17 10 82e-1
VS18 11 s18 0
R18 s18 12 39e-1
VS19 3 s19 0
R19 s19 6 27e-1
VS20 16 s20 0
R20 s20 4 47e0
VS21 14 s21 0
R21 s21 0 18e-2
VS22 16 s22 0
R22 s22 20 22e-2
VS23 20 s23 0
V23 e23 s23 DC 68e-1
RI23 e23 23 12e-2
VS24 19 s24 0
V24 e24 s24 DC 12e0
RI24 e24 14 39e-1
VS25 12 s25 0
R25 s25 16 12e-1
VS26 13 s26 0
V26 e26 s26 DC 18e-1
RI26 e26 1 12e-2
VS27 13 s27 0
R27 s27 15 68e0
VS28 15 s28 0
R28 s28 20 22e3
VS29 6 s29 0
R29 s29 19 12e3
VS30 2 s30 0
R30 s30 16 39e3
VS31 22 s31 0
R31 s31 6 18e1
VS32 18 s32 0
R32 s32 1 82e2
VS33 4 s33 0
R33 s33 8 18e2
VS34 6 s34 0
R34 s34 9 27e2
VS35 8 s35 0
R35 s35 16 12e-1
VS36 21 s36 0
R36 s36 10 39e3
.control
set numdgt=17
op
print v(1) v(2) v(3) v(4) v(5) v(6) v(7) v(8) v(9) v(10)
print v(11) v(12) v(13) v(14) v(15) v(16) v(17) v(18) v(19) v(20)
print v(21) v(22) v(23)
print i(vs0) i(vs1) i(vs2) i(vs3) i(vs4) i(vs5) i(vs6) i(vs7) i(vs8) i(vs9)
print i(vs10) i(vs11) i(vs12) i(vs13) i(vs14) i(vs15) i(vs16) i(vs17) i(vs18) i(vs19)
print i(vs20) i(vs21) i(vs22) i(vs23) i(vs24) i(vs25) i(vs26) i(vs27) i(vs28) i(vs29)
print i(vs30) i(vs31) i(vs32) i(vs33) i(vs34) i(vs35) i(vs36)
.endc
.end
