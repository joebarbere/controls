controls oracle dc-0110
* Generated (plan F2.7, ADR 0012): do not edit; regenerate with `pnpm sim oracle regen`. dc seed 20261030 index 110 nodes 17 elements 18
.options sparse gmin=1e-12 noopac
RG1 1 0 1000000000000
RG2 2 0 1000000000000
RG3 3 0 1000000000000
RG4 4 0 1000000000000
RG5 5 0 1000000000000
RG6 6 0 1000000000000
RG7 7 0 1000000000000
RG8 8 0 1000000000000
RG9 9 0 1000000000000
RG10 10 0 1000000000000
RG11 11 0 1000000000000
RG12 12 0 1000000000000
RG13 13 0 1000000000000
RG14 14 0 1000000000000
RG15 15 0 1000000000000
RG16 16 0 1000000000000
VS0 0 s0 0
V0 e0 s0 DC 56e-1
RI0 e0 2 18e-2
VS1 12 s1 0
R1 s1 8 10e-2
VS2 16 s2 0
R2 s2 14 39e0
VS3 9 s3 0
V3 e3 s3 DC 47e0
RI3 e3 14 39e-1
VS4 12 s4 0
R4 s4 10 82e2
VS5 3 s5 0
R5 s5 0 68e-1
VS6 1 s6 0
V6 e6 s6 DC 22e-1
RI6 e6 3 82e-2
VS7 14 s7 0
R7 s7 9 27e0
VS8 5 s8 0
R8 s8 13 12e2
VS9 7 s9 0
V9 e9 s9 DC 12e0
RI9 e9 8 68e-1
VS10 3 s10 0
R10 s10 11 10e3
VS11 13 s11 0
V11 e11 s11 DC 27e0
RI11 e11 1 15e-3
VS12 3 s12 0
R12 s12 4 82e2
VS13 3 s13 0
R13 s13 4 22e2
VS14 6 s14 0
R14 s14 3 56e-1
VS15 8 s15 0
V15 e15 s15 DC 27e0
RI15 e15 11 68e-2
VS16 3 s16 0
R16 s16 9 33e-1
VS17 15 s17 0
V17 e17 s17 DC 82e-1
RI17 e17 14 22e-1
.control
set numdgt=17
op
print v(1) v(2) v(3) v(4) v(5) v(6) v(7) v(8) v(9) v(10)
print v(11) v(12) v(13) v(14) v(15) v(16)
print i(vs0) i(vs1) i(vs2) i(vs3) i(vs4) i(vs5) i(vs6) i(vs7) i(vs8) i(vs9)
print i(vs10) i(vs11) i(vs12) i(vs13) i(vs14) i(vs15) i(vs16) i(vs17)
.endc
.end
