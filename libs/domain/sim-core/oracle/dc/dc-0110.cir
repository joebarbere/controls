controls oracle dc-0110
* Generated (plan F2.7, ADR 0012): do not edit; regenerate with `pnpm sim oracle regen`. dc seed 20261030 index 110 nodes 17 elements 24
.options sparse gmin=1e-12 noopac
RG1 1 0 1000000000000
RG2 2 0 1000000000000
RG3 3 0 1000000000000
RG4 4 0 1000000000000
RG5 5 0 1000000000000
RG6 6 0 1000000000000
RG7 7 0 1000000000000
RG8 8 0 1000000000000
RG9 9 0 1000000000000
RG10 10 0 1000000000000
RG11 11 0 1000000000000
RG12 12 0 1000000000000
RG13 13 0 1000000000000
RG14 14 0 1000000000000
RG15 15 0 1000000000000
RG16 16 0 1000000000000
VS0 3 s0 0
R0 s0 15 22e2
VS1 0 s1 0
V1 e1 s1 DC 82e-1
RI1 e1 14 22e-1
VS2 12 s2 0
R2 s2 10 82e2
VS3 2 s3 0
V3 e3 s3 DC 10e1
RI3 e3 0 22e-3
VS4 8 s4 0
V4 e4 s4 DC 27e0
RI4 e4 11 68e-2
VS5 5 s5 0
R5 s5 13 12e2
VS6 9 s6 0
V6 e6 s6 DC 47e0
RI6 e6 14 39e-1
VS7 6 s7 0
R7 s7 5 82e2
VS8 3 s8 0
R8 s8 11 10e3
VS9 6 s9 0
R9 s9 3 56e-1
VS10 7 s10 0
R10 s10 13 27e3
VS11 7 s11 0
V11 e11 s11 DC 12e0
RI11 e11 8 68e-1
VS12 14 s12 0
R12 s12 9 27e0
VS13 13 s13 0
V13 e13 s13 DC 27e0
RI13 e13 1 15e-3
VS14 15 s14 0
R14 s14 10 15e0
VS15 3 s15 0
R15 s15 9 33e-1
VS16 1 s16 0
V16 e16 s16 DC 22e-1
RI16 e16 3 82e-2
VS17 16 s17 0
R17 s17 14 39e0
VS18 0 s18 0
V18 e18 s18 DC 27e0
RI18 e18 10 27e-1
VS19 12 s19 0
R19 s19 8 10e-2
VS20 6 s20 0
R20 s20 16 56e1
VS21 3 s21 0
R21 s21 15 82e2
VS22 4 s22 0
V22 e22 s22 DC 56e-1
RI22 e22 2 18e-2
VS23 3 s23 0
R23 s23 4 68e-1
.control
set numdgt=17
op
print v(1) v(2) v(3) v(4) v(5) v(6) v(7) v(8) v(9) v(10)
print v(11) v(12) v(13) v(14) v(15) v(16)
print i(vs0) i(vs1) i(vs2) i(vs3) i(vs4) i(vs5) i(vs6) i(vs7) i(vs8) i(vs9)
print i(vs10) i(vs11) i(vs12) i(vs13) i(vs14) i(vs15) i(vs16) i(vs17) i(vs18) i(vs19)
print i(vs20) i(vs21) i(vs22) i(vs23)
.endc
.end
