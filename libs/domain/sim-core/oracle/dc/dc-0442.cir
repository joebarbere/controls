controls oracle dc-0442
* Generated (plan F2.7, ADR 0012): do not edit; regenerate with `pnpm sim oracle regen`. dc seed 20261030 index 442 nodes 21 elements 27
.options sparse gmin=1e-12 noopac
RG1 1 0 1000000000000
RG2 2 0 1000000000000
RG3 3 0 1000000000000
RG4 4 0 1000000000000
RG5 5 0 1000000000000
RG6 6 0 1000000000000
RG7 7 0 1000000000000
RG8 8 0 1000000000000
RG9 9 0 1000000000000
RG10 10 0 1000000000000
RG11 11 0 1000000000000
RG12 12 0 1000000000000
RG13 13 0 1000000000000
RG14 14 0 1000000000000
RG15 15 0 1000000000000
RG16 16 0 1000000000000
RG17 17 0 1000000000000
RG18 18 0 1000000000000
RG19 19 0 1000000000000
RG20 20 0 1000000000000
VS0 0 s0 0
V0 e0 s0 DC 15e0
RI0 e0 11 82e-3
VS1 3 s1 0
R1 s1 13 12e-2
VS2 2 s2 0
V2 e2 s2 DC 68e0
RI2 e2 11 68e-3
VS3 6 s3 0
R3 s3 10 82e2
VS4 6 s4 0
V4 e4 s4 DC 12e0
RI4 e4 17 33e-1
VS5 13 s5 0
R5 s5 5 12e0
VS6 10 s6 0
V6 e6 s6 DC 18e0
RI6 e6 4 39e-1
VS7 13 s7 0
R7 s7 18 82e-2
VS8 9 s8 0
R8 s8 8 82e-1
VS9 15 s9 0
V9 e9 s9 DC 39e0
RI9 e9 19 22e-2
VS10 20 s10 0
R10 s10 19 56e1
VS11 12 s11 0
R11 s11 0 33e-1
VS12 8 s12 0
V12 e12 s12 DC 22e0
RI12 e12 20 27e-1
VS13 4 s13 0
R13 s13 18 39e1
VS14 16 s14 0
V14 e14 s14 DC 82e1
RI14 e14 11 15e-1
VS15 18 s15 0
R15 s15 11 82e0
VS16 4 s16 0
R16 s16 19 39e1
VS17 7 s17 0
R17 s17 19 10e2
VS18 13 s18 0
R18 s18 9 68e0
VS19 12 s19 0
R19 s19 1 10e2
VS20 14 s20 0
R20 s20 16 27e0
VS21 7 s21 0
R21 s21 1 33e1
VS22 15 s22 0
R22 s22 5 12e2
VS23 10 s23 0
V23 e23 s23 DC 33e-1
RI23 e23 14 18e-1
VS24 2 s24 0
V24 e24 s24 DC 27e0
RI24 e24 3 15e-2
VS25 6 s25 0
R25 s25 8 27e0
VS26 17 s26 0
R26 s26 18 33e-2
.control
set numdgt=17
op
print v(1) v(2) v(3) v(4) v(5) v(6) v(7) v(8) v(9) v(10)
print v(11) v(12) v(13) v(14) v(15) v(16) v(17) v(18) v(19) v(20)
print i(vs0) i(vs1) i(vs2) i(vs3) i(vs4) i(vs5) i(vs6) i(vs7) i(vs8) i(vs9)
print i(vs10) i(vs11) i(vs12) i(vs13) i(vs14) i(vs15) i(vs16) i(vs17) i(vs18) i(vs19)
print i(vs20) i(vs21) i(vs22) i(vs23) i(vs24) i(vs25) i(vs26)
.endc
.end
