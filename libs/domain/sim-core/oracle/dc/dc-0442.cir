controls oracle dc-0442
* Generated (plan F2.7, ADR 0012): do not edit; regenerate with `pnpm sim oracle regen`. dc seed 20261030 index 442 nodes 21 elements 22
.options sparse gmin=1e-12 noopac
RG1 1 0 1000000000000
RG2 2 0 1000000000000
RG3 3 0 1000000000000
RG4 4 0 1000000000000
RG5 5 0 1000000000000
RG6 6 0 1000000000000
RG7 7 0 1000000000000
RG8 8 0 1000000000000
RG9 9 0 1000000000000
RG10 10 0 1000000000000
RG11 11 0 1000000000000
RG12 12 0 1000000000000
RG13 13 0 1000000000000
RG14 14 0 1000000000000
RG15 15 0 1000000000000
RG16 16 0 1000000000000
RG17 17 0 1000000000000
RG18 18 0 1000000000000
RG19 19 0 1000000000000
RG20 20 0 1000000000000
VS0 0 s0 0
V0 e0 s0 DC 33e-1
RI0 e0 14 18e-1
VS1 2 s1 0
V1 e1 s1 DC 27e0
RI1 e1 3 15e-2
VS2 19 s2 0
V2 e2 s2 DC 15e0
RI2 e2 11 82e-3
VS3 17 s3 0
R3 s3 18 33e-2
VS4 13 s4 0
R4 s4 9 68e0
VS5 3 s5 0
R5 s5 13 12e-2
VS6 14 s6 0
R6 s6 16 27e0
VS7 9 s7 0
R7 s7 8 82e-1
VS8 7 s8 0
R8 s8 10 10e2
VS9 4 s9 0
R9 s9 10 39e1
VS10 12 s10 0
R10 s10 19 33e-1
VS11 20 s11 0
R11 s11 10 56e1
VS12 6 s12 0
V12 e12 s12 DC 12e0
RI12 e12 17 33e-1
VS13 12 s13 0
R13 s13 1 10e2
VS14 6 s14 0
R14 s14 0 82e2
VS15 4 s15 0
R15 s15 18 39e1
VS16 15 s16 0
V16 e16 s16 DC 39e0
RI16 e16 10 22e-2
VS17 6 s17 0
R17 s17 8 27e0
VS18 0 s18 0
V18 e18 s18 DC 18e0
RI18 e18 4 39e-1
VS19 13 s19 0
R19 s19 18 82e-2
VS20 18 s20 0
R20 s20 11 82e0
VS21 13 s21 0
R21 s21 5 12e0
.control
set numdgt=17
op
print v(1) v(2) v(3) v(4) v(5) v(6) v(7) v(8) v(9) v(10)
print v(11) v(12) v(13) v(14) v(15) v(16) v(17) v(18) v(19) v(20)
print i(vs0) i(vs1) i(vs2) i(vs3) i(vs4) i(vs5) i(vs6) i(vs7) i(vs8) i(vs9)
print i(vs10) i(vs11) i(vs12) i(vs13) i(vs14) i(vs15) i(vs16) i(vs17) i(vs18) i(vs19)
print i(vs20) i(vs21)
.endc
.end
