controls oracle dc-0486
* Generated (plan F2.7, ADR 0012): do not edit; regenerate with `pnpm sim oracle regen`. dc seed 20261030 index 486 nodes 4 elements 7
.options sparse gmin=1e-12 noopac
RG1 1 0 1000000000000
RG2 2 0 1000000000000
RG3 3 0 1000000000000
VS0 3 s0 0
R0 s0 2 10e3
VS1 0 s1 0
V1 e1 s1 DC 56e-1
RI1 e1 2 56e-2
VS2 3 s2 0
R2 s2 1 22e-2
VS3 3 s3 0
I3 s3 1 DC 47e-2
VS4 1 s4 0
R4 s4 0 22e-1
VS5 2 s5 0
I5 s5 0 DC 56e-2
VS6 0 s6 0
I6 s6 1 DC 15e-3
.control
set numdgt=17
op
print v(1) v(2) v(3)
print i(vs0) i(vs1) i(vs2) i(vs3) i(vs4) i(vs5) i(vs6)
.endc
.end
