controls oracle dc-0101
* Generated (plan F2.7, ADR 0012): do not edit; regenerate with `pnpm sim oracle regen`. dc seed 20261030 index 101 nodes 10 elements 10
.options sparse gmin=1e-12 noopac
RG1 1 0 1000000000000
RG2 2 0 1000000000000
RG3 3 0 1000000000000
RG4 4 0 1000000000000
RG5 5 0 1000000000000
RG6 6 0 1000000000000
RG7 7 0 1000000000000
RG8 8 0 1000000000000
RG9 9 0 1000000000000
VS0 4 s0 0
R0 s0 1 27e3
VS1 0 s1 0
V1 e1 s1 DC 47e0
RI1 e1 5 27e-3
VS2 4 s2 0
R2 s2 6 10e1
VS3 8 s3 0
R3 s3 9 39e-2
VS4 0 s4 0
V4 e4 s4 DC 10e1
RI4 e4 8 18e-1
VS5 0 s5 0
R5 s5 3 15e0
VS6 4 s6 0
V6 e6 s6 DC 47e1
RI6 e6 3 22e-1
VS7 2 s7 0
R7 s7 7 10e1
VS8 8 s8 0
R8 s8 0 47e-2
VS9 7 s9 0
V9 e9 s9 DC 10e-1
RI9 e9 8 18e-1
.control
set numdgt=17
op
print v(1) v(2) v(3) v(4) v(5) v(6) v(7) v(8) v(9)
print i(vs0) i(vs1) i(vs2) i(vs3) i(vs4) i(vs5) i(vs6) i(vs7) i(vs8) i(vs9)
.endc
.end
