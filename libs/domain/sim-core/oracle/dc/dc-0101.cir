controls oracle dc-0101
* Generated (plan F2.7, ADR 0012): do not edit; regenerate with `pnpm sim oracle regen`. dc seed 20261030 index 101 nodes 10 elements 13
.options sparse gmin=1e-12 noopac
RG1 1 0 1000000000000
RG2 2 0 1000000000000
RG3 3 0 1000000000000
RG4 4 0 1000000000000
RG5 5 0 1000000000000
RG6 6 0 1000000000000
RG7 7 0 1000000000000
RG8 8 0 1000000000000
RG9 9 0 1000000000000
VS0 0 s0 0
V0 e0 s0 DC 47e1
RI0 e0 3 22e-1
VS1 0 s1 0
R1 s1 1 27e3
VS2 6 s2 0
R2 s2 5 15e3
VS3 0 s3 0
R3 s3 6 10e1
VS4 2 s4 0
R4 s4 7 10e1
VS5 8 s5 0
R5 s5 9 39e-2
VS6 9 s6 0
V6 e6 s6 DC 39e-1
RI6 e6 1 12e-2
VS7 4 s7 0
V7 e7 s7 DC 10e1
RI7 e7 6 22e-2
VS8 4 s8 0
V8 e8 s8 DC 47e0
RI8 e8 5 27e-3
VS9 2 s9 0
R9 s9 1 27e-2
VS10 4 s10 0
V10 e10 s10 DC 10e1
RI10 e10 8 18e-1
VS11 4 s11 0
R11 s11 3 15e0
VS12 7 s12 0
V12 e12 s12 DC 10e-1
RI12 e12 8 18e-1
.control
set numdgt=17
op
print v(1) v(2) v(3) v(4) v(5) v(6) v(7) v(8) v(9)
print i(vs0) i(vs1) i(vs2) i(vs3) i(vs4) i(vs5) i(vs6) i(vs7) i(vs8) i(vs9)
print i(vs10) i(vs11) i(vs12)
.endc
.end
