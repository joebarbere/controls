controls oracle dc-0411
* Generated (plan F2.7, ADR 0012): do not edit; regenerate with `pnpm sim oracle regen`. dc seed 20261030 index 411 nodes 22 elements 46
.options sparse gmin=1e-12 noopac
RG1 1 0 1000000000000
RG2 2 0 1000000000000
RG3 3 0 1000000000000
RG4 4 0 1000000000000
RG5 5 0 1000000000000
RG6 6 0 1000000000000
RG7 7 0 1000000000000
RG8 8 0 1000000000000
RG9 9 0 1000000000000
RG10 10 0 1000000000000
RG11 11 0 1000000000000
RG12 12 0 1000000000000
RG13 13 0 1000000000000
RG14 14 0 1000000000000
RG15 15 0 1000000000000
RG16 16 0 1000000000000
RG17 17 0 1000000000000
RG18 18 0 1000000000000
RG19 19 0 1000000000000
RG20 20 0 1000000000000
RG21 21 0 1000000000000
VS0 18 s0 0
R0 s0 1 12e-2
VS1 15 s1 0
I1 s1 1 DC 39e-4
VS2 16 s2 0
R2 s2 12 27e2
VS3 15 s3 0
R3 s3 8 47e1
VS4 12 s4 0
R4 s4 14 27e1
VS5 8 s5 0
R5 s5 19 12e0
VS6 0 s6 0
V6 e6 s6 DC 18e-1
RI6 e6 11 18e-2
VS7 14 s7 0
I7 s7 21 DC 27e-3
VS8 17 s8 0
R8 s8 8 47e1
VS9 2 s9 0
I9 s9 14 DC 39e-1
VS10 1 s10 0
V10 e10 s10 DC 82e1
RI10 e10 4 33e-2
VS11 3 s11 0
I11 s11 12 DC 22e-2
VS12 17 s12 0
V12 e12 s12 DC 33e0
RI12 e12 0 39e-3
VS13 0 s13 0
R13 s13 9 18e1
VS14 11 s14 0
R14 s14 9 68e2
VS15 5 s15 0
R15 s15 12 39e0
VS16 1 s16 0
R16 s16 7 33e0
VS17 7 s17 0
R17 s17 5 18e2
VS18 13 s18 0
V18 e18 s18 DC 12e0
RI18 e18 5 27e-3
VS19 17 s19 0
I19 s19 8 DC 10e-1
VS20 8 s20 0
R20 s20 14 33e-1
VS21 4 s21 0
R21 s21 11 33e0
VS22 3 s22 0
R22 s22 15 27e2
VS23 13 s23 0
R23 s23 0 10e-1
VS24 20 s24 0
R24 s24 13 68e-1
VS25 20 s25 0
R25 s25 3 15e-1
VS26 21 s26 0
R26 s26 13 47e2
VS27 2 s27 0
R27 s27 5 10e2
VS28 11 s28 0
R28 s28 5 33e2
VS29 1 s29 0
V29 e29 s29 DC 47e-1
RI29 e29 2 47e-2
VS30 5 s30 0
I30 s30 17 DC 10e-4
VS31 7 s31 0
R31 s31 9 18e-2
VS32 19 s32 0
R32 s32 11 18e3
VS33 10 s33 0
V33 e33 s33 DC 12e0
RI33 e33 5 12e-3
VS34 10 s34 0
R34 s34 8 22e-1
VS35 7 s35 0
R35 s35 13 39e2
VS36 21 s36 0
R36 s36 9 39e3
VS37 16 s37 0
R37 s37 7 12e3
VS38 7 s38 0
V38 e38 s38 DC 56e-1
RI38 e38 0 15e-2
VS39 21 s39 0
R39 s39 16 27e-2
VS40 18 s40 0
R40 s40 11 10e-1
VS41 16 s41 0
I41 s41 4 DC 82e-1
VS42 12 s42 0
R42 s42 16 56e1
VS43 5 s43 0
V43 e43 s43 DC 68e-1
RI43 e43 6 22e-2
VS44 13 s44 0
R44 s44 21 10e1
VS45 6 s45 0
R45 s45 12 47e3
.control
set numdgt=17
op
print v(1) v(2) v(3) v(4) v(5) v(6) v(7) v(8) v(9) v(10)
print v(11) v(12) v(13) v(14) v(15) v(16) v(17) v(18) v(19) v(20)
print v(21)
print i(vs0) i(vs1) i(vs2) i(vs3) i(vs4) i(vs5) i(vs6) i(vs7) i(vs8) i(vs9)
print i(vs10) i(vs11) i(vs12) i(vs13) i(vs14) i(vs15) i(vs16) i(vs17) i(vs18) i(vs19)
print i(vs20) i(vs21) i(vs22) i(vs23) i(vs24) i(vs25) i(vs26) i(vs27) i(vs28) i(vs29)
print i(vs30) i(vs31) i(vs32) i(vs33) i(vs34) i(vs35) i(vs36) i(vs37) i(vs38) i(vs39)
print i(vs40) i(vs41) i(vs42) i(vs43) i(vs44) i(vs45)
.endc
.end
