controls oracle dc-0411
* Generated (plan F2.7, ADR 0012): do not edit; regenerate with `pnpm sim oracle regen`. dc seed 20261030 index 411 nodes 22 elements 43
.options sparse gmin=1e-12 noopac
RG1 1 0 1000000000000
RG2 2 0 1000000000000
RG3 3 0 1000000000000
RG4 4 0 1000000000000
RG5 5 0 1000000000000
RG6 6 0 1000000000000
RG7 7 0 1000000000000
RG8 8 0 1000000000000
RG9 9 0 1000000000000
RG10 10 0 1000000000000
RG11 11 0 1000000000000
RG12 12 0 1000000000000
RG13 13 0 1000000000000
RG14 14 0 1000000000000
RG15 15 0 1000000000000
RG16 16 0 1000000000000
RG17 17 0 1000000000000
RG18 18 0 1000000000000
RG19 19 0 1000000000000
RG20 20 0 1000000000000
RG21 21 0 1000000000000
VS0 0 s0 0
V0 e0 s0 DC 56e-1
RI0 e0 5 15e-2
VS1 13 s1 0
R1 s1 21 10e1
VS2 7 s2 0
R2 s2 12 39e0
VS3 3 s3 0
I3 s3 12 DC 22e-2
VS4 10 s4 0
R4 s4 8 22e-1
VS5 11 s5 0
R5 s5 9 68e2
VS6 1 s6 0
V6 e6 s6 DC 47e-1
RI6 e6 2 47e-2
VS7 11 s7 0
R7 s7 7 33e2
VS8 8 s8 0
R8 s8 14 33e-1
VS9 2 s9 0
I9 s9 14 DC 39e-1
VS10 13 s10 0
R10 s10 5 10e-1
VS11 1 s11 0
V11 e11 s11 DC 82e1
RI11 e11 4 33e-2
VS12 6 s12 0
R12 s12 12 47e3
VS13 16 s13 0
R13 s13 0 12e3
VS14 12 s14 0
R14 s14 14 27e1
VS15 20 s15 0
R15 s15 3 15e-1
VS16 8 s16 0
R16 s16 19 12e0
VS17 7 s17 0
I17 s17 17 DC 10e-4
VS18 15 s18 0
R18 s18 8 47e1
VS19 19 s19 0
R19 s19 11 18e3
VS20 16 s20 0
R20 s20 12 27e2
VS21 2 s21 0
R21 s21 7 10e2
VS22 5 s22 0
R22 s22 9 18e1
VS23 0 s23 0
R23 s23 13 39e2
VS24 21 s24 0
R24 s24 9 39e3
VS25 21 s25 0
R25 s25 16 27e-2
VS26 17 s26 0
I26 s26 8 DC 10e-1
VS27 4 s27 0
R27 s27 11 33e0
VS28 0 s28 0
R28 s28 9 18e-2
VS29 14 s29 0
I29 s29 21 DC 27e-3
VS30 21 s30 0
R30 s30 13 47e2
VS31 17 s31 0
V31 e31 s31 DC 33e0
RI31 e31 5 39e-3
VS32 18 s32 0
R32 s32 11 10e-1
VS33 1 s33 0
R33 s33 0 33e0
VS34 15 s34 0
I34 s34 1 DC 39e-4
VS35 7 s35 0
V35 e35 s35 DC 68e-1
RI35 e35 6 22e-2
VS36 5 s36 0
V36 e36 s36 DC 18e-1
RI36 e36 11 18e-2
VS37 0 s37 0
R37 s37 7 18e2
VS38 16 s38 0
I38 s38 4 DC 82e-1
VS39 20 s39 0
R39 s39 13 68e-1
VS40 10 s40 0
V40 e40 s40 DC 12e0
RI40 e40 7 12e-3
VS41 12 s41 0
R41 s41 16 56e1
VS42 13 s42 0
V42 e42 s42 DC 12e0
RI42 e42 7 27e-3
.control
set numdgt=17
op
print v(1) v(2) v(3) v(4) v(5) v(6) v(7) v(8) v(9) v(10)
print v(11) v(12) v(13) v(14) v(15) v(16) v(17) v(18) v(19) v(20)
print v(21)
print i(vs0) i(vs1) i(vs2) i(vs3) i(vs4) i(vs5) i(vs6) i(vs7) i(vs8) i(vs9)
print i(vs10) i(vs11) i(vs12) i(vs13) i(vs14) i(vs15) i(vs16) i(vs17) i(vs18) i(vs19)
print i(vs20) i(vs21) i(vs22) i(vs23) i(vs24) i(vs25) i(vs26) i(vs27) i(vs28) i(vs29)
print i(vs30) i(vs31) i(vs32) i(vs33) i(vs34) i(vs35) i(vs36) i(vs37) i(vs38) i(vs39)
print i(vs40) i(vs41) i(vs42)
.endc
.end
