controls oracle dc-0200
* Generated (plan F2.7, ADR 0012): do not edit; regenerate with `pnpm sim oracle regen`. dc seed 20261030 index 200 nodes 16 elements 29
.options sparse gmin=1e-12 noopac
RG1 1 0 1000000000000
RG2 2 0 1000000000000
RG3 3 0 1000000000000
RG4 4 0 1000000000000
RG5 5 0 1000000000000
RG6 6 0 1000000000000
RG7 7 0 1000000000000
RG8 8 0 1000000000000
RG9 9 0 1000000000000
RG10 10 0 1000000000000
RG11 11 0 1000000000000
RG12 12 0 1000000000000
RG13 13 0 1000000000000
RG14 14 0 1000000000000
RG15 15 0 1000000000000
VS0 8 s0 0
R0 s0 7 82e2
VS1 11 s1 0
R1 s1 15 82e-1
VS2 15 s2 0
I2 s2 1 DC 47e-1
VS3 1 s3 0
I3 s3 4 DC 15e-1
VS4 4 s4 0
R4 s4 9 82e2
VS5 6 s5 0
R5 s5 9 10e-1
VS6 1 s6 0
R6 s6 9 15e-2
VS7 9 s7 0
R7 s7 5 12e3
VS8 14 s8 0
R8 s8 12 10e3
VS9 0 s9 0
V9 e9 s9 DC 10e0
RI9 e9 13 39e-1
VS10 10 s10 0
R10 s10 4 33e2
VS11 13 s11 0
R11 s11 9 82e2
VS12 9 s12 0
I12 s12 2 DC 22e-3
VS13 14 s13 0
R13 s13 0 68e1
VS14 10 s14 0
R14 s14 15 68e2
VS15 2 s15 0
R15 s15 8 15e-2
VS16 9 s16 0
R16 s16 11 18e0
VS17 13 s17 0
V17 e17 s17 DC 82e1
RI17 e17 8 15e-2
VS18 3 s18 0
V18 e18 s18 DC 18e1
RI18 e18 7 12e-2
VS19 7 s19 0
R19 s19 1 82e2
VS20 15 s20 0
R20 s20 10 15e0
VS21 5 s21 0
V21 e21 s21 DC 82e1
RI21 e21 8 22e-2
VS22 5 s22 0
R22 s22 4 15e3
VS23 1 s23 0
R23 s23 14 33e3
VS24 12 s24 0
R24 s24 3 82e-2
VS25 2 s25 0
V25 e25 s25 DC 82e-1
RI25 e25 9 33e-2
VS26 6 s26 0
R26 s26 13 68e-2
VS27 7 s27 0
R27 s27 12 10e0
VS28 5 s28 0
V28 e28 s28 DC 39e1
RI28 e28 6 82e-2
.control
set numdgt=17
op
print v(1) v(2) v(3) v(4) v(5) v(6) v(7) v(8) v(9) v(10)
print v(11) v(12) v(13) v(14) v(15)
print i(vs0) i(vs1) i(vs2) i(vs3) i(vs4) i(vs5) i(vs6) i(vs7) i(vs8) i(vs9)
print i(vs10) i(vs11) i(vs12) i(vs13) i(vs14) i(vs15) i(vs16) i(vs17) i(vs18) i(vs19)
print i(vs20) i(vs21) i(vs22) i(vs23) i(vs24) i(vs25) i(vs26) i(vs27) i(vs28)
.endc
.end
