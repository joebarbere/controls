controls oracle dc-0200
* Generated (plan F2.7, ADR 0012): do not edit; regenerate with `pnpm sim oracle regen`. dc seed 20261030 index 200 nodes 16 elements 27
.options sparse gmin=1e-12 noopac
RG1 1 0 1000000000000
RG2 2 0 1000000000000
RG3 3 0 1000000000000
RG4 4 0 1000000000000
RG5 5 0 1000000000000
RG6 6 0 1000000000000
RG7 7 0 1000000000000
RG8 8 0 1000000000000
RG9 9 0 1000000000000
RG10 10 0 1000000000000
RG11 11 0 1000000000000
RG12 12 0 1000000000000
RG13 13 0 1000000000000
RG14 14 0 1000000000000
RG15 15 0 1000000000000
VS0 1 s0 0
R0 s0 9 15e-2
VS1 9 s1 0
R1 s1 11 18e0
VS2 0 s2 0
V2 e2 s2 DC 82e-1
RI2 e2 9 33e-2
VS3 7 s3 0
R3 s3 1 82e2
VS4 14 s4 0
R4 s4 12 10e3
VS5 3 s5 0
V5 e5 s5 DC 18e1
RI5 e5 7 12e-2
VS6 4 s6 0
R6 s6 9 82e2
VS7 15 s7 0
R7 s7 10 15e0
VS8 0 s8 0
R8 s8 8 15e-2
VS9 6 s9 0
R9 s9 9 10e-1
VS10 1 s10 0
I10 s10 4 DC 15e-1
VS11 15 s11 0
I11 s11 1 DC 47e-1
VS12 11 s12 0
R12 s12 15 82e-1
VS13 2 s13 0
V13 e13 s13 DC 39e1
RI13 e13 6 82e-2
VS14 13 s14 0
V14 e14 s14 DC 82e1
RI14 e14 8 15e-2
VS15 7 s15 0
R15 s15 12 10e0
VS16 14 s16 0
R16 s16 5 68e1
VS17 2 s17 0
V17 e17 s17 DC 82e1
RI17 e17 8 22e-2
VS18 13 s18 0
R18 s18 9 82e2
VS19 9 s19 0
R19 s19 2 12e3
VS20 10 s20 0
R20 s20 4 33e2
VS21 9 s21 0
I21 s21 0 DC 22e-3
VS22 1 s22 0
R22 s22 14 33e3
VS23 10 s23 0
R23 s23 15 68e2
VS24 8 s24 0
R24 s24 7 82e2
VS25 2 s25 0
R25 s25 4 15e3
VS26 6 s26 0
R26 s26 13 68e-2
.control
set numdgt=17
op
print v(1) v(2) v(3) v(4) v(5) v(6) v(7) v(8) v(9) v(10)
print v(11) v(12) v(13) v(14) v(15)
print i(vs0) i(vs1) i(vs2) i(vs3) i(vs4) i(vs5) i(vs6) i(vs7) i(vs8) i(vs9)
print i(vs10) i(vs11) i(vs12) i(vs13) i(vs14) i(vs15) i(vs16) i(vs17) i(vs18) i(vs19)
print i(vs20) i(vs21) i(vs22) i(vs23) i(vs24) i(vs25) i(vs26)
.endc
.end
