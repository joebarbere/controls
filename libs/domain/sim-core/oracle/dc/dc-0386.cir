controls oracle dc-0386
* Generated (plan F2.7, ADR 0012): do not edit; regenerate with `pnpm sim oracle regen`. dc seed 20261030 index 386 nodes 21 elements 32
.options sparse gmin=1e-12 noopac
RG1 1 0 1000000000000
RG2 2 0 1000000000000
RG3 3 0 1000000000000
RG4 4 0 1000000000000
RG5 5 0 1000000000000
RG6 6 0 1000000000000
RG7 7 0 1000000000000
RG8 8 0 1000000000000
RG9 9 0 1000000000000
RG10 10 0 1000000000000
RG11 11 0 1000000000000
RG12 12 0 1000000000000
RG13 13 0 1000000000000
RG14 14 0 1000000000000
RG15 15 0 1000000000000
RG16 16 0 1000000000000
RG17 17 0 1000000000000
RG18 18 0 1000000000000
RG19 19 0 1000000000000
RG20 20 0 1000000000000
VS0 12 s0 0
R0 s0 1 68e-2
VS1 20 s1 0
R1 s1 19 27e-2
VS2 20 s2 0
R2 s2 1 22e-1
VS3 2 s3 0
R3 s3 15 15e0
VS4 3 s4 0
R4 s4 11 15e3
VS5 0 s5 0
V5 e5 s5 DC 56e1
RI5 e5 13 27e-2
VS6 17 s6 0
R6 s6 7 39e-2
VS7 2 s7 0
V7 e7 s7 DC 47e-1
RI7 e7 20 33e-1
VS8 18 s8 0
R8 s8 19 68e0
VS9 20 s9 0
R9 s9 6 15e1
VS10 10 s10 0
I10 s10 5 DC 18e-2
VS11 14 s11 0
R11 s11 5 10e-2
VS12 15 s12 0
R12 s12 10 15e-1
VS13 0 s13 0
R13 s13 16 39e-2
VS14 14 s14 0
V14 e14 s14 DC 12e1
RI14 e14 18 15e-2
VS15 3 s15 0
R15 s15 20 68e-2
VS16 20 s16 0
R16 s16 5 22e3
VS17 16 s17 0
R17 s17 6 82e-1
VS18 13 s18 0
R18 s18 20 82e2
VS19 5 s19 0
R19 s19 4 68e2
VS20 5 s20 0
R20 s20 0 22e2
VS21 11 s21 0
R21 s21 20 22e0
VS22 3 s22 0
R22 s22 13 56e3
VS23 8 s23 0
R23 s23 11 10e2
VS24 5 s24 0
R24 s24 10 18e2
VS25 9 s25 0
V25 e25 s25 DC 18e-1
RI25 e25 16 18e-2
VS26 5 s26 0
R26 s26 7 22e-1
VS27 8 s27 0
R27 s27 16 33e3
VS28 19 s28 0
R28 s28 15 22e0
VS29 4 s29 0
R29 s29 15 15e1
VS30 12 s30 0
V30 e30 s30 DC 22e1
RI30 e30 14 27e-3
VS31 17 s31 0
R31 s31 9 68e-2
.control
set numdgt=17
op
print v(1) v(2) v(3) v(4) v(5) v(6) v(7) v(8) v(9) v(10)
print v(11) v(12) v(13) v(14) v(15) v(16) v(17) v(18) v(19) v(20)
print i(vs0) i(vs1) i(vs2) i(vs3) i(vs4) i(vs5) i(vs6) i(vs7) i(vs8) i(vs9)
print i(vs10) i(vs11) i(vs12) i(vs13) i(vs14) i(vs15) i(vs16) i(vs17) i(vs18) i(vs19)
print i(vs20) i(vs21) i(vs22) i(vs23) i(vs24) i(vs25) i(vs26) i(vs27) i(vs28) i(vs29)
print i(vs30) i(vs31)
.endc
.end
