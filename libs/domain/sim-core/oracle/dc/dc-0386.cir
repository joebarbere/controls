controls oracle dc-0386
* Generated (plan F2.7, ADR 0012): do not edit; regenerate with `pnpm sim oracle regen`. dc seed 20261030 index 386 nodes 21 elements 25
.options sparse gmin=1e-12 noopac
RG1 1 0 1000000000000
RG2 2 0 1000000000000
RG3 3 0 1000000000000
RG4 4 0 1000000000000
RG5 5 0 1000000000000
RG6 6 0 1000000000000
RG7 7 0 1000000000000
RG8 8 0 1000000000000
RG9 9 0 1000000000000
RG10 10 0 1000000000000
RG11 11 0 1000000000000
RG12 12 0 1000000000000
RG13 13 0 1000000000000
RG14 14 0 1000000000000
RG15 15 0 1000000000000
RG16 16 0 1000000000000
RG17 17 0 1000000000000
RG18 18 0 1000000000000
RG19 19 0 1000000000000
RG20 20 0 1000000000000
VS0 15 s0 0
R0 s0 10 15e-1
VS1 16 s1 0
R1 s1 6 82e-1
VS2 5 s2 0
R2 s2 11 22e2
VS3 17 s3 0
R3 s3 7 39e-2
VS4 19 s4 0
R4 s4 15 22e0
VS5 3 s5 0
R5 s5 2 15e3
VS6 0 s6 0
R6 s6 15 15e0
VS7 8 s7 0
R7 s7 2 10e2
VS8 0 s8 0
V8 e8 s8 DC 47e-1
RI8 e8 20 33e-1
VS9 20 s9 0
R9 s9 1 22e-1
VS10 12 s10 0
V10 e10 s10 DC 22e1
RI10 e10 14 27e-3
VS11 20 s11 0
R11 s11 5 22e3
VS12 5 s12 0
R12 s12 10 18e2
VS13 14 s13 0
V13 e13 s13 DC 12e1
RI13 e13 18 15e-2
VS14 14 s14 0
R14 s14 5 10e-2
VS15 3 s15 0
R15 s15 20 68e-2
VS16 20 s16 0
R16 s16 6 15e1
VS17 11 s17 0
V17 e17 s17 DC 56e1
RI17 e17 13 27e-2
VS18 13 s18 0
R18 s18 20 82e2
VS19 17 s19 0
R19 s19 9 68e-2
VS20 11 s20 0
R20 s20 16 39e-2
VS21 2 s21 0
R21 s21 20 22e0
VS22 9 s22 0
V22 e22 s22 DC 18e-1
RI22 e22 16 18e-2
VS23 10 s23 0
I23 s23 5 DC 18e-2
VS24 4 s24 0
R24 s24 15 15e1
.control
set numdgt=17
op
print v(1) v(2) v(3) v(4) v(5) v(6) v(7) v(8) v(9) v(10)
print v(11) v(12) v(13) v(14) v(15) v(16) v(17) v(18) v(19) v(20)
print i(vs0) i(vs1) i(vs2) i(vs3) i(vs4) i(vs5) i(vs6) i(vs7) i(vs8) i(vs9)
print i(vs10) i(vs11) i(vs12) i(vs13) i(vs14) i(vs15) i(vs16) i(vs17) i(vs18) i(vs19)
print i(vs20) i(vs21) i(vs22) i(vs23) i(vs24)
.endc
.end
