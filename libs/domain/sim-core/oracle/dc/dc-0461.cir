controls oracle dc-0461
* Generated (plan F2.7, ADR 0012): do not edit; regenerate with `pnpm sim oracle regen`. dc seed 20261030 index 461 nodes 9 elements 16
.options sparse gmin=1e-12 noopac
RG1 1 0 1000000000000
RG2 2 0 1000000000000
RG3 3 0 1000000000000
RG4 4 0 1000000000000
RG5 5 0 1000000000000
RG6 6 0 1000000000000
RG7 7 0 1000000000000
RG8 8 0 1000000000000
VS0 4 s0 0
R0 s0 1 39e-2
VS1 7 s1 0
R1 s1 6 68e-1
VS2 1 s2 0
R2 s2 6 47e2
VS3 1 s3 0
R3 s3 5 56e0
VS4 3 s4 0
I4 s4 4 DC 33e-2
VS5 0 s5 0
V5 e5 s5 DC 12e1
RI5 e5 1 12e-3
VS6 4 s6 0
R6 s6 7 39e0
VS7 5 s7 0
R7 s7 1 47e-1
VS8 8 s8 0
R8 s8 5 56e-1
VS9 7 s9 0
R9 s9 6 10e-2
VS10 8 s10 0
R10 s10 2 10e3
VS11 0 s11 0
I11 s11 1 DC 47e-3
VS12 1 s12 0
R12 s12 7 82e2
VS13 2 s13 0
V13 e13 s13 DC 18e0
RI13 e13 3 47e-2
VS14 0 s14 0
I14 s14 8 DC 68e-4
VS15 7 s15 0
R15 s15 3 18e0
.control
set numdgt=17
op
print v(1) v(2) v(3) v(4) v(5) v(6) v(7) v(8)
print i(vs0) i(vs1) i(vs2) i(vs3) i(vs4) i(vs5) i(vs6) i(vs7) i(vs8) i(vs9)
print i(vs10) i(vs11) i(vs12) i(vs13) i(vs14) i(vs15)
.endc
.end
