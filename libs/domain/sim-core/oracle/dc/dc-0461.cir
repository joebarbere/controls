controls oracle dc-0461
* Generated (plan F2.7, ADR 0012): do not edit; regenerate with `pnpm sim oracle regen`. dc seed 20261030 index 461 nodes 9 elements 17
.options sparse gmin=1e-12 noopac
RG1 1 0 1000000000000
RG2 2 0 1000000000000
RG3 3 0 1000000000000
RG4 4 0 1000000000000
RG5 5 0 1000000000000
RG6 6 0 1000000000000
RG7 7 0 1000000000000
RG8 8 0 1000000000000
VS0 7 s0 0
I0 s0 8 DC 68e-4
VS1 8 s1 0
R1 s1 5 56e-1
VS2 1 s2 0
R2 s2 6 82e2
VS3 4 s3 0
R3 s3 1 39e-2
VS4 1 s4 0
R4 s4 0 47e2
VS5 0 s5 0
V5 e5 s5 DC 10e1
RI5 e5 7 10e-2
VS6 8 s6 0
R6 s6 2 10e3
VS7 1 s7 0
R7 s7 5 56e0
VS8 2 s8 0
V8 e8 s8 DC 18e0
RI8 e8 3 47e-2
VS9 4 s9 0
R9 s9 6 39e0
VS10 6 s10 0
R10 s10 3 18e0
VS11 6 s11 0
R11 s11 0 68e-1
VS12 6 s12 0
R12 s12 0 10e-2
VS13 3 s13 0
I13 s13 4 DC 33e-2
VS14 5 s14 0
R14 s14 1 47e-1
VS15 7 s15 0
V15 e15 s15 DC 12e1
RI15 e15 1 12e-3
VS16 7 s16 0
I16 s16 1 DC 47e-3
.control
set numdgt=17
op
print v(1) v(2) v(3) v(4) v(5) v(6) v(7) v(8)
print i(vs0) i(vs1) i(vs2) i(vs3) i(vs4) i(vs5) i(vs6) i(vs7) i(vs8) i(vs9)
print i(vs10) i(vs11) i(vs12) i(vs13) i(vs14) i(vs15) i(vs16)
.endc
.end
