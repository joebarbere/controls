controls oracle dc-0252
* Generated (plan F2.7, ADR 0012): do not edit; regenerate with `pnpm sim oracle regen`. dc seed 20261030 index 252 nodes 11 elements 19
.options sparse gmin=1e-12 noopac
RG1 1 0 1000000000000
RG2 2 0 1000000000000
RG3 3 0 1000000000000
RG4 4 0 1000000000000
RG5 5 0 1000000000000
RG6 6 0 1000000000000
RG7 7 0 1000000000000
RG8 8 0 1000000000000
RG9 9 0 1000000000000
RG10 10 0 1000000000000
VS0 1 s0 0
R0 s0 2 68e1
VS1 5 s1 0
R1 s1 4 39e-2
VS2 5 s2 0
R2 s2 8 10e1
VS3 1 s3 0
I3 s3 9 DC 18e-2
VS4 3 s4 0
I4 s4 4 DC 22e-1
VS5 8 s5 0
R5 s5 0 12e1
VS6 2 s6 0
I6 s6 8 DC 22e-1
VS7 0 s7 0
I7 s7 10 DC 39e-3
VS8 0 s8 0
V8 e8 s8 DC 39e-1
RI8 e8 3 47e-3
VS9 2 s9 0
R9 s9 4 33e3
VS10 9 s10 0
R10 s10 6 82e3
VS11 0 s11 0
I11 s11 4 DC 33e-3
VS12 10 s12 0
V12 e12 s12 DC 82e0
RI12 e12 9 15e-3
VS13 9 s13 0
R13 s13 4 22e3
VS14 8 s14 0
R14 s14 5 12e0
VS15 9 s15 0
R15 s15 3 68e-2
VS16 2 s16 0
R16 s16 7 22e-1
VS17 7 s17 0
R17 s17 10 27e-1
VS18 9 s18 0
R18 s18 7 22e1
.control
set numdgt=17
op
print v(1) v(2) v(3) v(4) v(5) v(6) v(7) v(8) v(9) v(10)
print i(vs0) i(vs1) i(vs2) i(vs3) i(vs4) i(vs5) i(vs6) i(vs7) i(vs8) i(vs9)
print i(vs10) i(vs11) i(vs12) i(vs13) i(vs14) i(vs15) i(vs16) i(vs17) i(vs18)
.endc
.end
