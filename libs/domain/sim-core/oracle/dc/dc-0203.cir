controls oracle dc-0203
* Generated (plan F2.7, ADR 0012): do not edit; regenerate with `pnpm sim oracle regen`. dc seed 20261030 index 203 nodes 4 elements 6
.options sparse gmin=1e-12 noopac
RG1 1 0 1000000000000
RG2 2 0 1000000000000
RG3 3 0 1000000000000
VS0 3 s0 0
R0 s0 2 12e2
VS1 3 s1 0
R1 s1 1 22e0
VS2 0 s2 0
R2 s2 3 47e-2
VS3 0 s3 0
V3 e3 s3 DC 12e1
RI3 e3 2 47e-3
VS4 0 s4 0
R4 s4 2 15e0
VS5 0 s5 0
R5 s5 1 56e1
.control
set numdgt=17
op
print v(1) v(2) v(3)
print i(vs0) i(vs1) i(vs2) i(vs3) i(vs4) i(vs5)
.endc
.end
