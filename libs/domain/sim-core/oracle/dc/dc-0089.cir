controls oracle dc-0089
* Generated (plan F2.7, ADR 0012): do not edit; regenerate with `pnpm sim oracle regen`. dc seed 20261030 index 89 nodes 19 elements 33
.options sparse gmin=1e-12 noopac
RG1 1 0 1000000000000
RG2 2 0 1000000000000
RG3 3 0 1000000000000
RG4 4 0 1000000000000
RG5 5 0 1000000000000
RG6 6 0 1000000000000
RG7 7 0 1000000000000
RG8 8 0 1000000000000
RG9 9 0 1000000000000
RG10 10 0 1000000000000
RG11 11 0 1000000000000
RG12 12 0 1000000000000
RG13 13 0 1000000000000
RG14 14 0 1000000000000
RG15 15 0 1000000000000
RG16 16 0 1000000000000
RG17 17 0 1000000000000
RG18 18 0 1000000000000
VS0 10 s0 0
R0 s0 16 22e-1
VS1 17 s1 0
R1 s1 14 15e0
VS2 5 s2 0
R2 s2 9 39e-2
VS3 11 s3 0
I3 s3 1 DC 15e-2
VS4 10 s4 0
R4 s4 17 82e3
VS5 0 s5 0
V5 e5 s5 DC 68e1
RI5 e5 15 22e-3
VS6 6 s6 0
R6 s6 16 15e0
VS7 12 s7 0
R7 s7 1 15e2
VS8 11 s8 0
R8 s8 4 12e-1
VS9 3 s9 0
I9 s9 15 DC 47e-3
VS10 9 s10 0
V10 e10 s10 DC 56e1
RI10 e10 5 15e-3
VS11 5 s11 0
R11 s11 6 10e1
VS12 2 s12 0
R12 s12 16 10e-1
VS13 7 s13 0
R13 s13 12 27e-1
VS14 4 s14 0
R14 s14 8 56e0
VS15 7 s15 0
I15 s15 9 DC 68e-3
VS16 9 s16 0
V16 e16 s16 DC 22e0
RI16 e16 12 27e-3
VS17 13 s17 0
R17 s17 12 68e-2
VS18 5 s18 0
V18 e18 s18 DC 47e-1
RI18 e18 14 56e-2
VS19 13 s19 0
R19 s19 1 15e-2
VS20 3 s20 0
R20 s20 11 12e0
VS21 6 s21 0
V21 e21 s21 DC 82e0
RI21 e21 15 12e-1
VS22 11 s22 0
V22 e22 s22 DC 15e1
RI22 e22 4 10e-1
VS23 10 s23 0
R23 s23 0 15e-1
VS24 5 s24 0
R24 s24 4 82e-2
VS25 9 s25 0
V25 e25 s25 DC 15e0
RI25 e25 16 56e-1
VS26 17 s26 0
R26 s26 13 56e3
VS27 16 s27 0
R27 s27 4 12e3
VS28 4 s28 0
R28 s28 15 56e1
VS29 11 s29 0
R29 s29 3 27e3
VS30 4 s30 0
R30 s30 13 10e-1
VS31 18 s31 0
R31 s31 16 39e-2
VS32 4 s32 0
I32 s32 1 DC 22e-2
.control
set numdgt=17
op
print v(1) v(2) v(3) v(4) v(5) v(6) v(7) v(8) v(9) v(10)
print v(11) v(12) v(13) v(14) v(15) v(16) v(17) v(18)
print i(vs0) i(vs1) i(vs2) i(vs3) i(vs4) i(vs5) i(vs6) i(vs7) i(vs8) i(vs9)
print i(vs10) i(vs11) i(vs12) i(vs13) i(vs14) i(vs15) i(vs16) i(vs17) i(vs18) i(vs19)
print i(vs20) i(vs21) i(vs22) i(vs23) i(vs24) i(vs25) i(vs26) i(vs27) i(vs28) i(vs29)
print i(vs30) i(vs31) i(vs32)
.endc
.end
