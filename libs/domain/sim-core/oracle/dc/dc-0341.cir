controls oracle dc-0341
* Generated (plan F2.7, ADR 0012): do not edit; regenerate with `pnpm sim oracle regen`. dc seed 20261030 index 341 nodes 18 elements 28
.options sparse gmin=1e-12 noopac
RG1 1 0 1000000000000
RG2 2 0 1000000000000
RG3 3 0 1000000000000
RG4 4 0 1000000000000
RG5 5 0 1000000000000
RG6 6 0 1000000000000
RG7 7 0 1000000000000
RG8 8 0 1000000000000
RG9 9 0 1000000000000
RG10 10 0 1000000000000
RG11 11 0 1000000000000
RG12 12 0 1000000000000
RG13 13 0 1000000000000
RG14 14 0 1000000000000
RG15 15 0 1000000000000
RG16 16 0 1000000000000
RG17 17 0 1000000000000
VS0 0 s0 0
V0 e0 s0 DC 39e0
RI0 e0 5 39e-2
VS1 10 s1 0
I1 s1 17 DC 39e-3
VS2 2 s2 0
V2 e2 s2 DC 82e0
RI2 e2 7 15e-2
VS3 9 s3 0
R3 s3 13 22e-2
VS4 2 s4 0
R4 s4 1 47e-2
VS5 4 s5 0
I5 s5 16 DC 15e-4
VS6 16 s6 0
I6 s6 15 DC 47e-1
VS7 15 s7 0
V7 e7 s7 DC 12e0
RI7 e7 4 68e-1
VS8 11 s8 0
R8 s8 9 22e-1
VS9 13 s9 0
R9 s9 6 10e-1
VS10 11 s10 0
R10 s10 12 27e2
VS11 12 s11 0
V11 e11 s11 DC 68e-1
RI11 e11 7 39e-1
VS12 16 s12 0
V12 e12 s12 DC 22e1
RI12 e12 14 47e-2
VS13 4 s13 0
R13 s13 17 10e-1
VS14 3 s14 0
R14 s14 13 18e0
VS15 13 s15 0
R15 s15 17 10e2
VS16 1 s16 0
R16 s16 0 15e-2
VS17 5 s17 0
R17 s17 13 82e0
VS18 14 s18 0
R18 s18 9 39e-1
VS19 10 s19 0
R19 s19 11 15e3
VS20 8 s20 0
R20 s20 4 33e1
VS21 6 s21 0
R21 s21 0 22e3
VS22 16 s22 0
R22 s22 8 22e-1
VS23 15 s23 0
V23 e23 s23 DC 22e0
RI23 e23 10 33e-2
VS24 6 s24 0
I24 s24 14 DC 10e-1
VS25 14 s25 0
V25 e25 s25 DC 10e0
RI25 e25 2 10e-2
VS26 3 s26 0
R26 s26 8 22e-1
VS27 8 s27 0
V27 e27 s27 DC 56e1
RI27 e27 11 68e-1
.control
set numdgt=17
op
print v(1) v(2) v(3) v(4) v(5) v(6) v(7) v(8) v(9) v(10)
print v(11) v(12) v(13) v(14) v(15) v(16) v(17)
print i(vs0) i(vs1) i(vs2) i(vs3) i(vs4) i(vs5) i(vs6) i(vs7) i(vs8) i(vs9)
print i(vs10) i(vs11) i(vs12) i(vs13) i(vs14) i(vs15) i(vs16) i(vs17) i(vs18) i(vs19)
print i(vs20) i(vs21) i(vs22) i(vs23) i(vs24) i(vs25) i(vs26) i(vs27)
.endc
.end
