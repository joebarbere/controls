controls oracle dc-0341
* Generated (plan F2.7, ADR 0012): do not edit; regenerate with `pnpm sim oracle regen`. dc seed 20261030 index 341 nodes 18 elements 22
.options sparse gmin=1e-12 noopac
RG1 1 0 1000000000000
RG2 2 0 1000000000000
RG3 3 0 1000000000000
RG4 4 0 1000000000000
RG5 5 0 1000000000000
RG6 6 0 1000000000000
RG7 7 0 1000000000000
RG8 8 0 1000000000000
RG9 9 0 1000000000000
RG10 10 0 1000000000000
RG11 11 0 1000000000000
RG12 12 0 1000000000000
RG13 13 0 1000000000000
RG14 14 0 1000000000000
RG15 15 0 1000000000000
RG16 16 0 1000000000000
RG17 17 0 1000000000000
VS0 13 s0 0
R0 s0 17 10e2
VS1 0 s1 0
V1 e1 s1 DC 82e0
RI1 e1 7 15e-2
VS2 6 s2 0
I2 s2 14 DC 10e-1
VS3 10 s3 0
I3 s3 17 DC 39e-3
VS4 16 s4 0
I4 s4 15 DC 47e-1
VS5 3 s5 0
R5 s5 13 18e0
VS6 14 s6 0
R6 s6 9 39e-1
VS7 10 s7 0
R7 s7 2 15e3
VS8 0 s8 0
R8 s8 1 47e-2
VS9 5 s9 0
R9 s9 13 82e0
VS10 2 s10 0
R10 s10 12 27e2
VS11 16 s11 0
R11 s11 8 22e-1
VS12 4 s12 0
I12 s12 16 DC 15e-4
VS13 9 s13 0
R13 s13 13 22e-2
VS14 13 s14 0
R14 s14 6 10e-1
VS15 12 s15 0
V15 e15 s15 DC 68e-1
RI15 e15 7 39e-1
VS16 1 s16 0
R16 s16 11 15e-2
VS17 6 s17 0
R17 s17 11 22e3
VS18 8 s18 0
R18 s18 4 33e1
VS19 2 s19 0
R19 s19 9 22e-1
VS20 15 s20 0
V20 e20 s20 DC 22e0
RI20 e20 10 33e-2
VS21 8 s21 0
V21 e21 s21 DC 56e1
RI21 e21 2 68e-1
.control
set numdgt=17
op
print v(1) v(2) v(3) v(4) v(5) v(6) v(7) v(8) v(9) v(10)
print v(11) v(12) v(13) v(14) v(15) v(16) v(17)
print i(vs0) i(vs1) i(vs2) i(vs3) i(vs4) i(vs5) i(vs6) i(vs7) i(vs8) i(vs9)
print i(vs10) i(vs11) i(vs12) i(vs13) i(vs14) i(vs15) i(vs16) i(vs17) i(vs18) i(vs19)
print i(vs20) i(vs21)
.endc
.end
