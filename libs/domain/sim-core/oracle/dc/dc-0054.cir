controls oracle dc-0054
* Generated (plan F2.7, ADR 0012): do not edit; regenerate with `pnpm sim oracle regen`. dc seed 20261030 index 54 nodes 28 elements 38
.options sparse gmin=1e-12 noopac
RG1 1 0 1000000000000
RG2 2 0 1000000000000
RG3 3 0 1000000000000
RG4 4 0 1000000000000
RG5 5 0 1000000000000
RG6 6 0 1000000000000
RG7 7 0 1000000000000
RG8 8 0 1000000000000
RG9 9 0 1000000000000
RG10 10 0 1000000000000
RG11 11 0 1000000000000
RG12 12 0 1000000000000
RG13 13 0 1000000000000
RG14 14 0 1000000000000
RG15 15 0 1000000000000
RG16 16 0 1000000000000
RG17 17 0 1000000000000
RG18 18 0 1000000000000
RG19 19 0 1000000000000
RG20 20 0 1000000000000
RG21 21 0 1000000000000
RG22 22 0 1000000000000
RG23 23 0 1000000000000
RG24 24 0 1000000000000
RG25 25 0 1000000000000
RG26 26 0 1000000000000
RG27 27 0 1000000000000
VS0 0 s0 0
V0 e0 s0 DC 18e0
RI0 e0 9 33e-1
VS1 11 s1 0
R1 s1 23 82e-1
VS2 12 s2 0
R2 s2 1 56e1
VS3 23 s3 0
R3 s3 3 12e-1
VS4 26 s4 0
R4 s4 2 56e1
VS5 0 s5 0
R5 s5 19 22e-2
VS6 27 s6 0
R6 s6 11 33e3
VS7 6 s7 0
R7 s7 16 68e1
VS8 26 s8 0
V8 e8 s8 DC 33e0
RI8 e8 7 18e-3
VS9 9 s9 0
R9 s9 5 15e2
VS10 19 s10 0
V10 e10 s10 DC 10e1
RI10 e10 10 47e-2
VS11 2 s11 0
V11 e11 s11 DC 47e0
RI11 e11 15 27e-1
VS12 16 s12 0
V12 e12 s12 DC 56e-1
RI12 e12 24 56e-3
VS13 8 s13 0
R13 s13 2 56e-2
VS14 17 s14 0
R14 s14 1 18e0
VS15 22 s15 0
R15 s15 21 68e-2
VS16 14 s16 0
R16 s16 3 15e2
VS17 0 s17 0
R17 s17 11 39e3
VS18 10 s18 0
R18 s18 23 22e-2
VS19 25 s19 0
I19 s19 23 DC 27e-4
VS20 22 s20 0
R20 s20 26 82e0
VS21 8 s21 0
R21 s21 1 56e0
VS22 22 s22 0
R22 s22 27 82e3
VS23 11 s23 0
V23 e23 s23 DC 56e-1
RI23 e23 25 22e-3
VS24 27 s24 0
R24 s24 10 68e-1
VS25 7 s25 0
V25 e25 s25 DC 33e1
RI25 e25 26 15e-3
VS26 11 s26 0
V26 e26 s26 DC 27e0
RI26 e26 19 39e-3
VS27 27 s27 0
R27 s27 4 33e2
VS28 23 s28 0
V28 e28 s28 DC 39e1
RI28 e28 4 56e-1
VS29 5 s29 0
R29 s29 1 68e2
VS30 13 s30 0
R30 s30 17 68e1
VS31 16 s31 0
R31 s31 10 27e0
VS32 19 s32 0
V32 e32 s32 DC 56e0
RI32 e32 2 68e-3
VS33 9 s33 0
R33 s33 26 18e1
VS34 23 s34 0
R34 s34 5 10e3
VS35 16 s35 0
R35 s35 18 39e0
VS36 22 s36 0
R36 s36 20 68e2
VS37 7 s37 0
R37 s37 14 10e-2
.control
set numdgt=17
op
print v(1) v(2) v(3) v(4) v(5) v(6) v(7) v(8) v(9) v(10)
print v(11) v(12) v(13) v(14) v(15) v(16) v(17) v(18) v(19) v(20)
print v(21) v(22) v(23) v(24) v(25) v(26) v(27)
print i(vs0) i(vs1) i(vs2) i(vs3) i(vs4) i(vs5) i(vs6) i(vs7) i(vs8) i(vs9)
print i(vs10) i(vs11) i(vs12) i(vs13) i(vs14) i(vs15) i(vs16) i(vs17) i(vs18) i(vs19)
print i(vs20) i(vs21) i(vs22) i(vs23) i(vs24) i(vs25) i(vs26) i(vs27) i(vs28) i(vs29)
print i(vs30) i(vs31) i(vs32) i(vs33) i(vs34) i(vs35) i(vs36) i(vs37)
.endc
.end
