controls oracle dc-0054
* Generated (plan F2.7, ADR 0012): do not edit; regenerate with `pnpm sim oracle regen`. dc seed 20261030 index 54 nodes 28 elements 44
.options sparse gmin=1e-12 noopac
RG1 1 0 1000000000000
RG2 2 0 1000000000000
RG3 3 0 1000000000000
RG4 4 0 1000000000000
RG5 5 0 1000000000000
RG6 6 0 1000000000000
RG7 7 0 1000000000000
RG8 8 0 1000000000000
RG9 9 0 1000000000000
RG10 10 0 1000000000000
RG11 11 0 1000000000000
RG12 12 0 1000000000000
RG13 13 0 1000000000000
RG14 14 0 1000000000000
RG15 15 0 1000000000000
RG16 16 0 1000000000000
RG17 17 0 1000000000000
RG18 18 0 1000000000000
RG19 19 0 1000000000000
RG20 20 0 1000000000000
RG21 21 0 1000000000000
RG22 22 0 1000000000000
RG23 23 0 1000000000000
RG24 24 0 1000000000000
RG25 25 0 1000000000000
RG26 26 0 1000000000000
RG27 27 0 1000000000000
VS0 0 s0 0
V0 e0 s0 DC 15e-1
RI0 e0 6 18e-2
VS1 22 s1 0
R1 s1 12 82e3
VS2 11 s2 0
V2 e2 s2 DC 27e0
RI2 e2 19 39e-3
VS3 27 s3 0
R3 s3 19 22e-2
VS4 14 s4 0
R4 s4 3 15e2
VS5 17 s5 0
R5 s5 1 18e0
VS6 16 s6 0
R6 s6 10 27e0
VS7 25 s7 0
I7 s7 23 DC 27e-4
VS8 0 s8 0
R8 s8 1 56e1
VS9 11 s9 0
R9 s9 23 82e-1
VS10 12 s10 0
R10 s10 11 33e3
VS11 9 s11 0
R11 s11 26 18e1
VS12 27 s12 0
R12 s12 11 39e3
VS13 7 s13 0
R13 s13 13 18e1
VS14 11 s14 0
V14 e14 s14 DC 56e-1
RI14 e14 25 22e-3
VS15 26 s15 0
R15 s15 2 56e1
VS16 10 s16 0
R16 s16 23 22e-2
VS17 23 s17 0
V17 e17 s17 DC 39e1
RI17 e17 4 56e-1
VS18 13 s18 0
R18 s18 17 68e1
VS19 9 s19 0
R19 s19 5 15e2
VS20 5 s20 0
R20 s20 1 68e2
VS21 12 s21 0
R21 s21 4 33e2
VS22 15 s22 0
V22 e22 s22 DC 12e0
RI22 e22 25 39e-1
VS23 22 s23 0
R23 s23 21 68e-2
VS24 23 s24 0
R24 s24 3 12e-1
VS25 26 s25 0
V25 e25 s25 DC 33e0
RI25 e25 7 18e-3
VS26 16 s26 0
V26 e26 s26 DC 56e-1
RI26 e26 24 56e-3
VS27 15 s27 0
R27 s27 24 18e-2
VS28 22 s28 0
R28 s28 26 82e0
VS29 12 s29 0
R29 s29 10 68e-1
VS30 27 s30 0
V30 e30 s30 DC 18e0
RI30 e30 9 33e-1
VS31 19 s31 0
V31 e31 s31 DC 10e1
RI31 e31 10 47e-2
VS32 22 s32 0
R32 s32 20 68e2
VS33 2 s33 0
V33 e33 s33 DC 47e0
RI33 e33 15 27e-1
VS34 8 s34 0
R34 s34 2 56e-2
VS35 6 s35 0
R35 s35 16 68e1
VS36 23 s36 0
R36 s36 5 10e3
VS37 16 s37 0
R37 s37 18 39e0
VS38 18 s38 0
V38 e38 s38 DC 15e0
RI38 e38 20 18e-3
VS39 19 s39 0
V39 e39 s39 DC 56e0
RI39 e39 2 68e-3
VS40 19 s40 0
R40 s40 21 68e0
VS41 7 s41 0
R41 s41 14 10e-2
VS42 8 s42 0
R42 s42 1 56e0
VS43 7 s43 0
V43 e43 s43 DC 33e1
RI43 e43 26 15e-3
.control
set numdgt=17
op
print v(1) v(2) v(3) v(4) v(5) v(6) v(7) v(8) v(9) v(10)
print v(11) v(12) v(13) v(14) v(15) v(16) v(17) v(18) v(19) v(20)
print v(21) v(22) v(23) v(24) v(25) v(26) v(27)
print i(vs0) i(vs1) i(vs2) i(vs3) i(vs4) i(vs5) i(vs6) i(vs7) i(vs8) i(vs9)
print i(vs10) i(vs11) i(vs12) i(vs13) i(vs14) i(vs15) i(vs16) i(vs17) i(vs18) i(vs19)
print i(vs20) i(vs21) i(vs22) i(vs23) i(vs24) i(vs25) i(vs26) i(vs27) i(vs28) i(vs29)
print i(vs30) i(vs31) i(vs32) i(vs33) i(vs34) i(vs35) i(vs36) i(vs37) i(vs38) i(vs39)
print i(vs40) i(vs41) i(vs42) i(vs43)
.endc
.end
