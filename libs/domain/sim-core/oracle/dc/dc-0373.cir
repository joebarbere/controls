controls oracle dc-0373
* Generated (plan F2.7, ADR 0012): do not edit; regenerate with `pnpm sim oracle regen`. dc seed 20261030 index 373 nodes 9 elements 17
.options sparse gmin=1e-12 noopac
RG1 1 0 1000000000000
RG2 2 0 1000000000000
RG3 3 0 1000000000000
RG4 4 0 1000000000000
RG5 5 0 1000000000000
RG6 6 0 1000000000000
RG7 7 0 1000000000000
RG8 8 0 1000000000000
VS0 0 s0 0
V0 e0 s0 DC 47e0
RI0 e0 5 15e-1
VS1 1 s1 0
R1 s1 4 68e-2
VS2 2 s2 0
R2 s2 8 12e2
VS3 3 s3 0
R3 s3 5 10e-1
VS4 0 s4 0
I4 s4 6 DC 18e-4
VS5 8 s5 0
R5 s5 3 47e-1
VS6 1 s6 0
R6 s6 0 15e2
VS7 3 s7 0
V7 e7 s7 DC 68e0
RI7 e7 1 27e-1
VS8 6 s8 0
I8 s8 8 DC 27e-4
VS9 7 s9 0
R9 s9 6 56e3
VS10 8 s10 0
I10 s10 4 DC 27e-1
VS11 5 s11 0
I11 s11 6 DC 68e-2
VS12 1 s12 0
V12 e12 s12 DC 39e-1
RI12 e12 6 27e-1
VS13 0 s13 0
I13 s13 3 DC 68e-3
VS14 1 s14 0
R14 s14 6 18e1
VS15 2 s15 0
V15 e15 s15 DC 18e1
RI15 e15 5 10e-3
VS16 5 s16 0
R16 s16 7 33e1
.control
set numdgt=17
op
print v(1) v(2) v(3) v(4) v(5) v(6) v(7) v(8)
print i(vs0) i(vs1) i(vs2) i(vs3) i(vs4) i(vs5) i(vs6) i(vs7) i(vs8) i(vs9)
print i(vs10) i(vs11) i(vs12) i(vs13) i(vs14) i(vs15) i(vs16)
.endc
.end
