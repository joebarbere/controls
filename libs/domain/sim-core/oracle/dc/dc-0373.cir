controls oracle dc-0373
* Generated (plan F2.7, ADR 0012): do not edit; regenerate with `pnpm sim oracle regen`. dc seed 20261030 index 373 nodes 9 elements 18
.options sparse gmin=1e-12 noopac
RG1 1 0 1000000000000
RG2 2 0 1000000000000
RG3 3 0 1000000000000
RG4 4 0 1000000000000
RG5 5 0 1000000000000
RG6 6 0 1000000000000
RG7 7 0 1000000000000
RG8 8 0 1000000000000
VS0 1 s0 0
R0 s0 4 68e-2
VS1 0 s1 0
V1 e1 s1 DC 47e0
RI1 e1 5 15e-1
VS2 4 s2 0
V2 e2 s2 DC 39e-1
RI2 e2 3 10e-3
VS3 5 s3 0
I3 s3 6 DC 68e-2
VS4 1 s4 0
R4 s4 6 18e1
VS5 5 s5 0
R5 s5 7 33e1
VS6 0 s6 0
I6 s6 6 DC 18e-4
VS7 8 s7 0
R7 s7 3 47e-1
VS8 0 s8 0
I8 s8 3 DC 68e-3
VS9 8 s9 0
I9 s9 4 DC 27e-1
VS10 1 s10 0
R10 s10 0 15e2
VS11 1 s11 0
V11 e11 s11 DC 39e-1
RI11 e11 6 27e-1
VS12 3 s12 0
V12 e12 s12 DC 68e0
RI12 e12 1 27e-1
VS13 3 s13 0
R13 s13 5 10e-1
VS14 2 s14 0
V14 e14 s14 DC 18e1
RI14 e14 5 10e-3
VS15 6 s15 0
I15 s15 8 DC 27e-4
VS16 2 s16 0
R16 s16 8 12e2
VS17 7 s17 0
R17 s17 6 56e3
.control
set numdgt=17
op
print v(1) v(2) v(3) v(4) v(5) v(6) v(7) v(8)
print i(vs0) i(vs1) i(vs2) i(vs3) i(vs4) i(vs5) i(vs6) i(vs7) i(vs8) i(vs9)
print i(vs10) i(vs11) i(vs12) i(vs13) i(vs14) i(vs15) i(vs16) i(vs17)
.endc
.end
