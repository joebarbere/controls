controls oracle dc-0176
* Generated (plan F2.7, ADR 0012): do not edit; regenerate with `pnpm sim oracle regen`. dc seed 20261030 index 176 nodes 17 elements 19
.options sparse gmin=1e-12 noopac
RG1 1 0 1000000000000
RG2 2 0 1000000000000
RG3 3 0 1000000000000
RG4 4 0 1000000000000
RG5 5 0 1000000000000
RG6 6 0 1000000000000
RG7 7 0 1000000000000
RG8 8 0 1000000000000
RG9 9 0 1000000000000
RG10 10 0 1000000000000
RG11 11 0 1000000000000
RG12 12 0 1000000000000
RG13 13 0 1000000000000
RG14 14 0 1000000000000
RG15 15 0 1000000000000
RG16 16 0 1000000000000
VS0 1 s0 0
R0 s0 15 27e-2
VS1 0 s1 0
V1 e1 s1 DC 56e1
RI1 e1 8 47e-2
VS2 6 s2 0
R2 s2 13 39e3
VS3 15 s3 0
R3 s3 16 18e2
VS4 4 s4 0
R4 s4 13 56e-2
VS5 14 s5 0
V5 e5 s5 DC 12e-1
RI5 e5 15 56e-2
VS6 8 s6 0
R6 s6 2 18e0
VS7 11 s7 0
R7 s7 5 33e2
VS8 15 s8 0
V8 e8 s8 DC 56e0
RI8 e8 5 68e-1
VS9 1 s9 0
V9 e9 s9 DC 82e0
RI9 e9 12 10e-1
VS10 16 s10 0
R10 s10 9 39e-1
VS11 13 s11 0
R11 s11 15 68e1
VS12 5 s12 0
V12 e12 s12 DC 56e-1
RI12 e12 7 12e-2
VS13 3 s13 0
R13 s13 15 47e2
VS14 5 s14 0
R14 s14 12 68e2
VS15 5 s15 0
R15 s15 1 18e3
VS16 13 s16 0
V16 e16 s16 DC 68e1
RI16 e16 10 68e-2
VS17 2 s17 0
R17 s17 14 82e-1
VS18 8 s18 0
I18 s18 6 DC 82e-3
.control
set numdgt=17
op
print v(1) v(2) v(3) v(4) v(5) v(6) v(7) v(8) v(9) v(10)
print v(11) v(12) v(13) v(14) v(15) v(16)
print i(vs0) i(vs1) i(vs2) i(vs3) i(vs4) i(vs5) i(vs6) i(vs7) i(vs8) i(vs9)
print i(vs10) i(vs11) i(vs12) i(vs13) i(vs14) i(vs15) i(vs16) i(vs17) i(vs18)
.endc
.end
