controls oracle dc-0366
* Generated (plan F2.7, ADR 0012): do not edit; regenerate with `pnpm sim oracle regen`. dc seed 20261030 index 366 nodes 29 elements 43
.options sparse gmin=1e-12 noopac
RG1 1 0 1000000000000
RG2 2 0 1000000000000
RG3 3 0 1000000000000
RG4 4 0 1000000000000
RG5 5 0 1000000000000
RG6 6 0 1000000000000
RG7 7 0 1000000000000
RG8 8 0 1000000000000
RG9 9 0 1000000000000
RG10 10 0 1000000000000
RG11 11 0 1000000000000
RG12 12 0 1000000000000
RG13 13 0 1000000000000
RG14 14 0 1000000000000
RG15 15 0 1000000000000
RG16 16 0 1000000000000
RG17 17 0 1000000000000
RG18 18 0 1000000000000
RG19 19 0 1000000000000
RG20 20 0 1000000000000
RG21 21 0 1000000000000
RG22 22 0 1000000000000
RG23 23 0 1000000000000
RG24 24 0 1000000000000
RG25 25 0 1000000000000
RG26 26 0 1000000000000
RG27 27 0 1000000000000
RG28 28 0 1000000000000
VS0 23 s0 0
R0 s0 7 68e1
VS1 9 s1 0
R1 s1 16 56e1
VS2 12 s2 0
R2 s2 23 10e0
VS3 19 s3 0
I3 s3 9 DC 33e-4
VS4 12 s4 0
R4 s4 18 33e3
VS5 15 s5 0
R5 s5 27 22e2
VS6 19 s6 0
R6 s6 1 18e2
VS7 24 s7 0
R7 s7 4 27e0
VS8 0 s8 0
V8 e8 s8 DC 82e0
RI8 e8 21 82e-3
VS9 5 s9 0
V9 e9 s9 DC 68e1
RI9 e9 12 12e-3
VS10 11 s10 0
R10 s10 15 68e-1
VS11 12 s11 0
R11 s11 27 33e3
VS12 15 s12 0
R12 s12 18 33e0
VS13 22 s13 0
R13 s13 9 27e0
VS14 20 s14 0
R14 s14 0 12e-2
VS15 23 s15 0
R15 s15 25 82e-2
VS16 28 s16 0
R16 s16 25 33e1
VS17 28 s17 0
I17 s17 15 DC 22e-2
VS18 1 s18 0
R18 s18 8 27e2
VS19 8 s19 0
R19 s19 7 68e2
VS20 27 s20 0
V20 e20 s20 DC 22e-1
RI20 e20 23 22e-1
VS21 21 s21 0
V21 e21 s21 DC 68e-1
RI21 e21 12 12e-1
VS22 4 s22 0
R22 s22 20 12e0
VS23 7 s23 0
R23 s23 9 10e-1
VS24 11 s24 0
R24 s24 8 10e0
VS25 4 s25 0
R25 s25 6 68e-2
VS26 26 s26 0
R26 s26 8 27e0
VS27 12 s27 0
R27 s27 2 33e3
VS28 19 s28 0
I28 s28 10 DC 15e-4
VS29 23 s29 0
R29 s29 27 82e2
VS30 8 s30 0
R30 s30 14 18e2
VS31 3 s31 0
R31 s31 27 22e0
VS32 10 s32 0
R32 s32 19 22e2
VS33 13 s33 0
R33 s33 7 82e-1
VS34 9 s34 0
V34 e34 s34 DC 12e-1
RI34 e34 10 15e-1
VS35 19 s35 0
R35 s35 8 39e-1
VS36 10 s36 0
R36 s36 9 33e1
VS37 12 s37 0
R37 s37 20 10e-1
VS38 24 s38 0
R38 s38 20 33e-1
VS39 4 s39 0
R39 s39 0 10e-2
VS40 28 s40 0
R40 s40 11 39e0
VS41 0 s41 0
V41 e41 s41 DC 39e-1
RI41 e41 13 82e-3
VS42 17 s42 0
R42 s42 4 22e3
.control
set numdgt=17
op
print v(1) v(2) v(3) v(4) v(5) v(6) v(7) v(8) v(9) v(10)
print v(11) v(12) v(13) v(14) v(15) v(16) v(17) v(18) v(19) v(20)
print v(21) v(22) v(23) v(24) v(25) v(26) v(27) v(28)
print i(vs0) i(vs1) i(vs2) i(vs3) i(vs4) i(vs5) i(vs6) i(vs7) i(vs8) i(vs9)
print i(vs10) i(vs11) i(vs12) i(vs13) i(vs14) i(vs15) i(vs16) i(vs17) i(vs18) i(vs19)
print i(vs20) i(vs21) i(vs22) i(vs23) i(vs24) i(vs25) i(vs26) i(vs27) i(vs28) i(vs29)
print i(vs30) i(vs31) i(vs32) i(vs33) i(vs34) i(vs35) i(vs36) i(vs37) i(vs38) i(vs39)
print i(vs40) i(vs41) i(vs42)
.endc
.end
