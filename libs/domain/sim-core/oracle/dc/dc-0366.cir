controls oracle dc-0366
* Generated (plan F2.7, ADR 0012): do not edit; regenerate with `pnpm sim oracle regen`. dc seed 20261030 index 366 nodes 29 elements 52
.options sparse gmin=1e-12 noopac
RG1 1 0 1000000000000
RG2 2 0 1000000000000
RG3 3 0 1000000000000
RG4 4 0 1000000000000
RG5 5 0 1000000000000
RG6 6 0 1000000000000
RG7 7 0 1000000000000
RG8 8 0 1000000000000
RG9 9 0 1000000000000
RG10 10 0 1000000000000
RG11 11 0 1000000000000
RG12 12 0 1000000000000
RG13 13 0 1000000000000
RG14 14 0 1000000000000
RG15 15 0 1000000000000
RG16 16 0 1000000000000
RG17 17 0 1000000000000
RG18 18 0 1000000000000
RG19 19 0 1000000000000
RG20 20 0 1000000000000
RG21 21 0 1000000000000
RG22 22 0 1000000000000
RG23 23 0 1000000000000
RG24 24 0 1000000000000
RG25 25 0 1000000000000
RG26 26 0 1000000000000
RG27 27 0 1000000000000
RG28 28 0 1000000000000
VS0 0 s0 0
V0 e0 s0 DC 12e-1
RI0 e0 10 15e-1
VS1 15 s1 0
R1 s1 14 22e2
VS2 9 s2 0
R2 s2 7 68e1
VS3 5 s3 0
V3 e3 s3 DC 68e1
RI3 e3 12 12e-3
VS4 24 s4 0
R4 s4 20 33e-1
VS5 5 s5 0
R5 s5 20 39e3
VS6 11 s6 0
R6 s6 8 10e0
VS7 19 s7 0
R7 s7 1 18e2
VS8 12 s8 0
R8 s8 9 10e0
VS9 15 s9 0
R9 s9 18 33e0
VS10 22 s10 0
R10 s10 0 27e0
VS11 17 s11 0
R11 s11 4 22e3
VS12 28 s12 0
R12 s12 11 39e0
VS13 12 s13 0
R13 s13 20 10e-1
VS14 19 s14 0
I14 s14 10 DC 15e-4
VS15 7 s15 0
R15 s15 0 10e-1
VS16 19 s16 0
R16 s16 8 39e-1
VS17 28 s17 0
R17 s17 25 33e1
VS18 26 s18 0
R18 s18 6 68e-1
VS19 3 s19 0
R19 s19 27 22e0
VS20 9 s20 0
R20 s20 27 82e2
VS21 13 s21 0
R21 s21 7 82e-1
VS22 26 s22 0
R22 s22 8 27e0
VS23 21 s23 0
V23 e23 s23 DC 68e-1
RI23 e23 12 12e-1
VS24 8 s24 0
R24 s24 7 68e2
VS25 12 s25 0
R25 s25 2 33e3
VS26 24 s26 0
R26 s26 4 27e0
VS27 9 s27 0
R27 s27 25 82e-2
VS28 23 s28 0
V28 e28 s28 DC 82e0
RI28 e28 21 82e-3
VS29 16 s29 0
R29 s29 10 15e2
VS30 23 s30 0
V30 e30 s30 DC 39e-1
RI30 e30 13 82e-3
VS31 12 s31 0
R31 s31 27 33e3
VS32 4 s32 0
R32 s32 20 12e0
VS33 19 s33 0
I33 s33 0 DC 33e-4
VS34 2 s34 0
V34 e34 s34 DC 27e-1
RI34 e34 10 12e-1
VS35 17 s35 0
R35 s35 11 39e3
VS36 10 s36 0
R36 s36 19 22e2
VS37 20 s37 0
R37 s37 23 12e-2
VS38 10 s38 0
R38 s38 0 33e1
VS39 4 s39 0
R39 s39 6 68e-2
VS40 28 s40 0
I40 s40 15 DC 22e-2
VS41 27 s41 0
V41 e41 s41 DC 22e-1
RI41 e41 9 22e-1
VS42 15 s42 0
R42 s42 27 22e2
VS43 0 s43 0
R43 s43 16 56e1
VS44 3 s44 0
R44 s44 9 47e2
VS45 12 s45 0
R45 s45 18 33e3
VS46 1 s46 0
R46 s46 8 27e2
VS47 8 s47 0
R47 s47 14 18e2
VS48 2 s48 0
R48 s48 22 39e-2
VS49 4 s49 0
R49 s49 23 10e-2
VS50 11 s50 0
R50 s50 15 68e-1
VS51 26 s51 0
V51 e51 s51 DC 12e-1
RI51 e51 28 10e-3
.control
set numdgt=17
op
print v(1) v(2) v(3) v(4) v(5) v(6) v(7) v(8) v(9) v(10)
print v(11) v(12) v(13) v(14) v(15) v(16) v(17) v(18) v(19) v(20)
print v(21) v(22) v(23) v(24) v(25) v(26) v(27) v(28)
print i(vs0) i(vs1) i(vs2) i(vs3) i(vs4) i(vs5) i(vs6) i(vs7) i(vs8) i(vs9)
print i(vs10) i(vs11) i(vs12) i(vs13) i(vs14) i(vs15) i(vs16) i(vs17) i(vs18) i(vs19)
print i(vs20) i(vs21) i(vs22) i(vs23) i(vs24) i(vs25) i(vs26) i(vs27) i(vs28) i(vs29)
print i(vs30) i(vs31) i(vs32) i(vs33) i(vs34) i(vs35) i(vs36) i(vs37) i(vs38) i(vs39)
print i(vs40) i(vs41) i(vs42) i(vs43) i(vs44) i(vs45) i(vs46) i(vs47) i(vs48) i(vs49)
print i(vs50) i(vs51)
.endc
.end
