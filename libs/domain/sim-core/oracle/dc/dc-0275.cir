controls oracle dc-0275
* Generated (plan F2.7, ADR 0012): do not edit; regenerate with `pnpm sim oracle regen`. dc seed 20261030 index 275 nodes 22 elements 25
.options sparse gmin=1e-12 noopac
RG1 1 0 1000000000000
RG2 2 0 1000000000000
RG3 3 0 1000000000000
RG4 4 0 1000000000000
RG5 5 0 1000000000000
RG6 6 0 1000000000000
RG7 7 0 1000000000000
RG8 8 0 1000000000000
RG9 9 0 1000000000000
RG10 10 0 1000000000000
RG11 11 0 1000000000000
RG12 12 0 1000000000000
RG13 13 0 1000000000000
RG14 14 0 1000000000000
RG15 15 0 1000000000000
RG16 16 0 1000000000000
RG17 17 0 1000000000000
RG18 18 0 1000000000000
RG19 19 0 1000000000000
RG20 20 0 1000000000000
RG21 21 0 1000000000000
VS0 21 s0 0
R0 s0 0 10e-1
VS1 18 s1 0
R1 s1 21 12e0
VS2 8 s2 0
R2 s2 0 82e1
VS3 9 s3 0
R3 s3 14 39e0
VS4 0 s4 0
V4 e4 s4 DC 56e-1
RI4 e4 6 10e-3
VS5 17 s5 0
R5 s5 12 39e3
VS6 8 s6 0
R6 s6 14 22e2
VS7 5 s7 0
R7 s7 4 27e0
VS8 15 s8 0
R8 s8 14 82e-1
VS9 8 s9 0
R9 s9 17 18e2
VS10 1 s10 0
R10 s10 7 27e-1
VS11 14 s11 0
R11 s11 1 33e0
VS12 20 s12 0
R12 s12 19 47e-1
VS13 8 s13 0
R13 s13 2 12e3
VS14 16 s14 0
R14 s14 18 22e-2
VS15 13 s15 0
R15 s15 12 33e-2
VS16 20 s16 0
R16 s16 8 22e-1
VS17 5 s17 0
R17 s17 8 68e0
VS18 15 s18 0
R18 s18 3 47e2
VS19 16 s19 0
I19 s19 9 DC 15e-3
VS20 10 s20 0
V20 e20 s20 DC 22e0
RI20 e20 14 12e-1
VS21 15 s21 0
I21 s21 4 DC 82e-2
VS22 13 s22 0
I22 s22 0 DC 27e-1
VS23 17 s23 0
R23 s23 11 47e2
VS24 18 s24 0
R24 s24 14 18e2
.control
set numdgt=17
op
print v(1) v(2) v(3) v(4) v(5) v(6) v(7) v(8) v(9) v(10)
print v(11) v(12) v(13) v(14) v(15) v(16) v(17) v(18) v(19) v(20)
print v(21)
print i(vs0) i(vs1) i(vs2) i(vs3) i(vs4) i(vs5) i(vs6) i(vs7) i(vs8) i(vs9)
print i(vs10) i(vs11) i(vs12) i(vs13) i(vs14) i(vs15) i(vs16) i(vs17) i(vs18) i(vs19)
print i(vs20) i(vs21) i(vs22) i(vs23) i(vs24)
.endc
.end
