controls oracle dc-0275
* Generated (plan F2.7, ADR 0012): do not edit; regenerate with `pnpm sim oracle regen`. dc seed 20261030 index 275 nodes 22 elements 34
.options sparse gmin=1e-12 noopac
RG1 1 0 1000000000000
RG2 2 0 1000000000000
RG3 3 0 1000000000000
RG4 4 0 1000000000000
RG5 5 0 1000000000000
RG6 6 0 1000000000000
RG7 7 0 1000000000000
RG8 8 0 1000000000000
RG9 9 0 1000000000000
RG10 10 0 1000000000000
RG11 11 0 1000000000000
RG12 12 0 1000000000000
RG13 13 0 1000000000000
RG14 14 0 1000000000000
RG15 15 0 1000000000000
RG16 16 0 1000000000000
RG17 17 0 1000000000000
RG18 18 0 1000000000000
RG19 19 0 1000000000000
RG20 20 0 1000000000000
RG21 21 0 1000000000000
VS0 16 s0 0
R0 s0 18 22e-2
VS1 5 s1 0
R1 s1 8 68e0
VS2 0 s2 0
V2 e2 s2 DC 56e-1
RI2 e2 6 10e-3
VS3 10 s3 0
V3 e3 s3 DC 22e0
RI3 e3 14 12e-1
VS4 17 s4 0
R4 s4 11 47e2
VS5 20 s5 0
R5 s5 19 47e-1
VS6 15 s6 0
R6 s6 3 47e2
VS7 16 s7 0
I7 s7 9 DC 15e-3
VS8 13 s8 0
I8 s8 0 DC 27e-1
VS9 8 s9 0
R9 s9 17 18e2
VS10 7 s10 0
V10 e10 s10 DC 22e0
RI10 e10 11 33e-2
VS11 9 s11 0
R11 s11 14 39e0
VS12 5 s12 0
R12 s12 4 27e0
VS13 13 s13 0
R13 s13 12 33e-2
VS14 8 s14 0
R14 s14 0 82e1
VS15 13 s15 0
R15 s15 15 82e3
VS16 14 s16 0
R16 s16 1 33e0
VS17 18 s17 0
R17 s17 14 18e2
VS18 20 s18 0
R18 s18 8 22e-1
VS19 15 s19 0
R19 s19 14 82e-1
VS20 11 s20 0
V20 e20 s20 DC 10e-1
RI20 e20 19 22e-2
VS21 8 s21 0
R21 s21 2 12e3
VS22 15 s22 0
I22 s22 4 DC 82e-2
VS23 21 s23 0
R23 s23 0 10e-1
VS24 1 s24 0
R24 s24 7 27e-1
VS25 10 s25 0
R25 s25 1 68e1
VS26 6 s26 0
V26 e26 s26 DC 68e1
RI26 e26 9 12e-1
VS27 2 s27 0
V27 e27 s27 DC 39e1
RI27 e27 17 47e-2
VS28 8 s28 0
R28 s28 14 22e2
VS29 17 s29 0
R29 s29 12 39e3
VS30 16 s30 0
R30 s30 12 12e3
VS31 7 s31 0
V31 e31 s31 DC 15e0
RI31 e31 14 12e-3
VS32 18 s32 0
R32 s32 21 12e0
VS33 4 s33 0
R33 s33 3 18e-2
.control
set numdgt=17
op
print v(1) v(2) v(3) v(4) v(5) v(6) v(7) v(8) v(9) v(10)
print v(11) v(12) v(13) v(14) v(15) v(16) v(17) v(18) v(19) v(20)
print v(21)
print i(vs0) i(vs1) i(vs2) i(vs3) i(vs4) i(vs5) i(vs6) i(vs7) i(vs8) i(vs9)
print i(vs10) i(vs11) i(vs12) i(vs13) i(vs14) i(vs15) i(vs16) i(vs17) i(vs18) i(vs19)
print i(vs20) i(vs21) i(vs22) i(vs23) i(vs24) i(vs25) i(vs26) i(vs27) i(vs28) i(vs29)
print i(vs30) i(vs31) i(vs32) i(vs33)
.endc
.end
