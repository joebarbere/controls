controls oracle dc-0114
* Generated (plan F2.7, ADR 0012): do not edit; regenerate with `pnpm sim oracle regen`. dc seed 20261030 index 114 nodes 7 elements 12
.options sparse gmin=1e-12 noopac
RG1 1 0 1000000000000
RG2 2 0 1000000000000
RG3 3 0 1000000000000
RG4 4 0 1000000000000
RG5 5 0 1000000000000
RG6 6 0 1000000000000
VS0 0 s0 0
V0 e0 s0 DC 82e1
RI0 e0 1 10e-2
VS1 3 s1 0
V1 e1 s1 DC 33e1
RI1 e1 4 56e-3
VS2 2 s2 0
R2 s2 3 27e0
VS3 0 s3 0
R3 s3 6 68e3
VS4 3 s4 0
V4 e4 s4 DC 68e0
RI4 e4 1 82e-1
VS5 4 s5 0
R5 s5 5 18e1
VS6 0 s6 0
R6 s6 4 27e2
VS7 6 s7 0
R7 s7 2 68e2
VS8 6 s8 0
R8 s8 0 12e2
VS9 2 s9 0
R9 s9 5 56e3
VS10 6 s10 0
R10 s10 5 47e1
VS11 1 s11 0
R11 s11 0 15e0
.control
set numdgt=17
op
print v(1) v(2) v(3) v(4) v(5) v(6)
print i(vs0) i(vs1) i(vs2) i(vs3) i(vs4) i(vs5) i(vs6) i(vs7) i(vs8) i(vs9)
print i(vs10) i(vs11)
.endc
.end
