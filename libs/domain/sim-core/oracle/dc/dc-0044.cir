controls oracle dc-0044
* Generated (plan F2.7, ADR 0012): do not edit; regenerate with `pnpm sim oracle regen`. dc seed 20261030 index 44 nodes 9 elements 17
.options sparse gmin=1e-12 noopac
RG1 1 0 1000000000000
RG2 2 0 1000000000000
RG3 3 0 1000000000000
RG4 4 0 1000000000000
RG5 5 0 1000000000000
RG6 6 0 1000000000000
RG7 7 0 1000000000000
RG8 8 0 1000000000000
VS0 6 s0 0
R0 s0 7 68e-1
VS1 8 s1 0
I1 s1 6 DC 47e-3
VS2 2 s2 0
R2 s2 8 15e-2
VS3 4 s3 0
I3 s3 3 DC 10e-2
VS4 2 s4 0
I4 s4 1 DC 33e-2
VS5 6 s5 0
R5 s5 3 33e-1
VS6 1 s6 0
R6 s6 4 82e-2
VS7 3 s7 0
R7 s7 1 12e1
VS8 7 s8 0
R8 s8 5 33e0
VS9 0 s9 0
R9 s9 5 18e3
VS10 3 s10 0
R10 s10 7 15e3
VS11 0 s11 0
V11 e11 s11 DC 27e0
RI11 e11 8 12e-3
VS12 4 s12 0
R12 s12 6 47e0
VS13 3 s13 0
R13 s13 0 39e3
VS14 3 s14 0
I14 s14 0 DC 82e-4
VS15 7 s15 0
R15 s15 2 18e2
VS16 3 s16 0
R16 s16 0 10e3
.control
set numdgt=17
op
print v(1) v(2) v(3) v(4) v(5) v(6) v(7) v(8)
print i(vs0) i(vs1) i(vs2) i(vs3) i(vs4) i(vs5) i(vs6) i(vs7) i(vs8) i(vs9)
print i(vs10) i(vs11) i(vs12) i(vs13) i(vs14) i(vs15) i(vs16)
.endc
.end
