controls oracle dc-0141
* Generated (plan F2.7, ADR 0012): do not edit; regenerate with `pnpm sim oracle regen`. dc seed 20261030 index 141 nodes 22 elements 39
.options sparse gmin=1e-12 noopac
RG1 1 0 1000000000000
RG2 2 0 1000000000000
RG3 3 0 1000000000000
RG4 4 0 1000000000000
RG5 5 0 1000000000000
RG6 6 0 1000000000000
RG7 7 0 1000000000000
RG8 8 0 1000000000000
RG9 9 0 1000000000000
RG10 10 0 1000000000000
RG11 11 0 1000000000000
RG12 12 0 1000000000000
RG13 13 0 1000000000000
RG14 14 0 1000000000000
RG15 15 0 1000000000000
RG16 16 0 1000000000000
RG17 17 0 1000000000000
RG18 18 0 1000000000000
RG19 19 0 1000000000000
RG20 20 0 1000000000000
RG21 21 0 1000000000000
VS0 0 s0 0
V0 e0 s0 DC 15e1
RI0 e0 4 22e-1
VS1 9 s1 0
V1 e1 s1 DC 18e0
RI1 e1 21 68e-2
VS2 3 s2 0
I2 s2 2 DC 82e-2
VS3 9 s3 0
V3 e3 s3 DC 10e1
RI3 e3 10 22e-1
VS4 4 s4 0
V4 e4 s4 DC 15e-1
RI4 e4 14 56e-1
VS5 2 s5 0
R5 s5 20 15e2
VS6 2 s6 0
R6 s6 20 56e-2
VS7 13 s7 0
V7 e7 s7 DC 22e0
RI7 e7 0 68e-1
VS8 2 s8 0
R8 s8 17 33e1
VS9 1 s9 0
R9 s9 15 12e3
VS10 12 s10 0
R10 s10 19 33e1
VS11 15 s11 0
R11 s11 6 15e-2
VS12 12 s12 0
R12 s12 8 68e0
VS13 8 s13 0
V13 e13 s13 DC 27e-1
RI13 e13 6 39e-2
VS14 18 s14 0
V14 e14 s14 DC 82e-1
RI14 e14 14 22e-3
VS15 19 s15 0
R15 s15 18 27e-2
VS16 16 s16 0
R16 s16 20 10e0
VS17 5 s17 0
R17 s17 9 12e1
VS18 7 s18 0
I18 s18 11 DC 39e-3
VS19 5 s19 0
R19 s19 13 56e-1
VS20 8 s20 0
V20 e20 s20 DC 82e0
RI20 e20 16 10e-1
VS21 4 s21 0
V21 e21 s21 DC 56e-1
RI21 e21 1 27e-2
VS22 10 s22 0
V22 e22 s22 DC 39e-1
RI22 e22 18 27e-2
VS23 17 s23 0
R23 s23 7 15e-2
VS24 19 s24 0
R24 s24 2 27e-1
VS25 9 s25 0
I25 s25 3 DC 18e-1
VS26 20 s26 0
V26 e26 s26 DC 22e0
RI26 e26 12 56e-2
VS27 4 s27 0
I27 s27 20 DC 12e-3
VS28 7 s28 0
V28 e28 s28 DC 39e1
RI28 e28 21 82e-3
VS29 19 s29 0
R29 s29 7 18e-2
VS30 19 s30 0
R30 s30 20 18e3
VS31 11 s31 0
R31 s31 9 47e-1
VS32 9 s32 0
R32 s32 3 27e3
VS33 4 s33 0
V33 e33 s33 DC 33e-1
RI33 e33 7 27e-1
VS34 12 s34 0
V34 e34 s34 DC 56e-1
RI34 e34 18 82e-3
VS35 13 s35 0
R35 s35 3 39e2
VS36 11 s36 0
I36 s36 18 DC 47e-1
VS37 20 s37 0
R37 s37 7 10e-1
VS38 11 s38 0
R38 s38 6 12e1
.control
set numdgt=17
op
print v(1) v(2) v(3) v(4) v(5) v(6) v(7) v(8) v(9) v(10)
print v(11) v(12) v(13) v(14) v(15) v(16) v(17) v(18) v(19) v(20)
print v(21)
print i(vs0) i(vs1) i(vs2) i(vs3) i(vs4) i(vs5) i(vs6) i(vs7) i(vs8) i(vs9)
print i(vs10) i(vs11) i(vs12) i(vs13) i(vs14) i(vs15) i(vs16) i(vs17) i(vs18) i(vs19)
print i(vs20) i(vs21) i(vs22) i(vs23) i(vs24) i(vs25) i(vs26) i(vs27) i(vs28) i(vs29)
print i(vs30) i(vs31) i(vs32) i(vs33) i(vs34) i(vs35) i(vs36) i(vs37) i(vs38)
.endc
.end
