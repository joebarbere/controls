controls oracle dc-0141
* Generated (plan F2.7, ADR 0012): do not edit; regenerate with `pnpm sim oracle regen`. dc seed 20261030 index 141 nodes 22 elements 31
.options sparse gmin=1e-12 noopac
RG1 1 0 1000000000000
RG2 2 0 1000000000000
RG3 3 0 1000000000000
RG4 4 0 1000000000000
RG5 5 0 1000000000000
RG6 6 0 1000000000000
RG7 7 0 1000000000000
RG8 8 0 1000000000000
RG9 9 0 1000000000000
RG10 10 0 1000000000000
RG11 11 0 1000000000000
RG12 12 0 1000000000000
RG13 13 0 1000000000000
RG14 14 0 1000000000000
RG15 15 0 1000000000000
RG16 16 0 1000000000000
RG17 17 0 1000000000000
RG18 18 0 1000000000000
RG19 19 0 1000000000000
RG20 20 0 1000000000000
RG21 21 0 1000000000000
VS0 0 s0 0
V0 e0 s0 DC 56e-1
RI0 e0 12 82e-3
VS1 3 s1 0
I1 s1 2 DC 82e-2
VS2 0 s2 0
R2 s2 8 68e0
VS3 0 s3 0
R3 s3 19 33e1
VS4 19 s4 0
R4 s4 20 18e3
VS5 9 s5 0
V5 e5 s5 DC 10e1
RI5 e5 10 22e-1
VS6 9 s6 0
R6 s6 3 27e3
VS7 9 s7 0
V7 e7 s7 DC 18e0
RI7 e7 21 68e-2
VS8 4 s8 0
I8 s8 20 DC 12e-3
VS9 13 s9 0
R9 s9 3 39e2
VS10 11 s10 0
I10 s10 12 DC 47e-1
VS11 19 s11 0
R11 s11 12 27e-2
VS12 5 s12 0
R12 s12 9 12e1
VS13 19 s13 0
R13 s13 7 18e-2
VS14 1 s14 0
R14 s14 15 12e3
VS15 20 s15 0
R15 s15 7 10e-1
VS16 10 s16 0
V16 e16 s16 DC 39e-1
RI16 e16 12 27e-2
VS17 11 s17 0
R17 s17 9 47e-1
VS18 4 s18 0
V18 e18 s18 DC 33e-1
RI18 e18 7 27e-1
VS19 19 s19 0
R19 s19 2 27e-1
VS20 7 s20 0
I20 s20 11 DC 39e-3
VS21 2 s21 0
R21 s21 17 33e1
VS22 2 s22 0
R22 s22 20 15e2
VS23 9 s23 0
I23 s23 3 DC 18e-1
VS24 4 s24 0
V24 e24 s24 DC 56e-1
RI24 e24 1 27e-2
VS25 20 s25 0
V25 e25 s25 DC 22e0
RI25 e25 0 56e-2
VS26 4 s26 0
V26 e26 s26 DC 15e-1
RI26 e26 14 56e-1
VS27 2 s27 0
R27 s27 20 56e-2
VS28 18 s28 0
V28 e28 s28 DC 15e1
RI28 e28 4 22e-1
VS29 16 s29 0
R29 s29 20 10e0
VS30 8 s30 0
V30 e30 s30 DC 27e-1
RI30 e30 6 39e-2
.control
set numdgt=17
op
print v(1) v(2) v(3) v(4) v(5) v(6) v(7) v(8) v(9) v(10)
print v(11) v(12) v(13) v(14) v(15) v(16) v(17) v(18) v(19) v(20)
print v(21)
print i(vs0) i(vs1) i(vs2) i(vs3) i(vs4) i(vs5) i(vs6) i(vs7) i(vs8) i(vs9)
print i(vs10) i(vs11) i(vs12) i(vs13) i(vs14) i(vs15) i(vs16) i(vs17) i(vs18) i(vs19)
print i(vs20) i(vs21) i(vs22) i(vs23) i(vs24) i(vs25) i(vs26) i(vs27) i(vs28) i(vs29)
print i(vs30)
.endc
.end
