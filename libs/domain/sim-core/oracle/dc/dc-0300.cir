controls oracle dc-0300
* Generated (plan F2.7, ADR 0012): do not edit; regenerate with `pnpm sim oracle regen`. dc seed 20261030 index 300 nodes 28 elements 30
.options sparse gmin=1e-12 noopac
RG1 1 0 1000000000000
RG2 2 0 1000000000000
RG3 3 0 1000000000000
RG4 4 0 1000000000000
RG5 5 0 1000000000000
RG6 6 0 1000000000000
RG7 7 0 1000000000000
RG8 8 0 1000000000000
RG9 9 0 1000000000000
RG10 10 0 1000000000000
RG11 11 0 1000000000000
RG12 12 0 1000000000000
RG13 13 0 1000000000000
RG14 14 0 1000000000000
RG15 15 0 1000000000000
RG16 16 0 1000000000000
RG17 17 0 1000000000000
RG18 18 0 1000000000000
RG19 19 0 1000000000000
RG20 20 0 1000000000000
RG21 21 0 1000000000000
RG22 22 0 1000000000000
RG23 23 0 1000000000000
RG24 24 0 1000000000000
RG25 25 0 1000000000000
RG26 26 0 1000000000000
RG27 27 0 1000000000000
VS0 17 s0 0
R0 s0 23 18e-1
VS1 9 s1 0
R1 s1 5 82e2
VS2 19 s2 0
R2 s2 3 15e0
VS3 22 s3 0
R3 s3 4 56e2
VS4 12 s4 0
R4 s4 5 18e-2
VS5 7 s5 0
R5 s5 15 12e2
VS6 5 s6 0
I6 s6 11 DC 56e-3
VS7 22 s7 0
I7 s7 18 DC 56e-3
VS8 0 s8 0
V8 e8 s8 DC 22e1
RI8 e8 11 56e-3
VS9 13 s9 0
R9 s9 12 68e-2
VS10 21 s10 0
R10 s10 18 22e-1
VS11 1 s11 0
V11 e11 s11 DC 33e1
RI11 e11 6 47e-1
VS12 8 s12 0
R12 s12 19 56e2
VS13 26 s13 0
R13 s13 7 56e1
VS14 0 s14 0
R14 s14 16 18e3
VS15 23 s15 0
R15 s15 1 18e2
VS16 3 s16 0
R16 s16 6 82e-1
VS17 10 s17 0
R17 s17 26 47e0
VS18 1 s18 0
R18 s18 0 27e-1
VS19 2 s19 0
R19 s19 4 22e-2
VS20 6 s20 0
R20 s20 24 18e1
VS21 14 s21 0
R21 s21 3 10e0
VS22 4 s22 0
V22 e22 s22 DC 56e0
RI22 e22 20 27e-1
VS23 1 s23 0
R23 s23 26 27e1
VS24 21 s24 0
R24 s24 26 15e2
VS25 1 s25 0
R25 s25 4 33e2
VS26 10 s26 0
R26 s26 19 68e-1
VS27 6 s27 0
R27 s27 13 56e2
VS28 8 s28 0
R28 s28 25 56e-1
VS29 17 s29 0
R29 s29 27 27e0
.control
set numdgt=17
op
print v(1) v(2) v(3) v(4) v(5) v(6) v(7) v(8) v(9) v(10)
print v(11) v(12) v(13) v(14) v(15) v(16) v(17) v(18) v(19) v(20)
print v(21) v(22) v(23) v(24) v(25) v(26) v(27)
print i(vs0) i(vs1) i(vs2) i(vs3) i(vs4) i(vs5) i(vs6) i(vs7) i(vs8) i(vs9)
print i(vs10) i(vs11) i(vs12) i(vs13) i(vs14) i(vs15) i(vs16) i(vs17) i(vs18) i(vs19)
print i(vs20) i(vs21) i(vs22) i(vs23) i(vs24) i(vs25) i(vs26) i(vs27) i(vs28) i(vs29)
.endc
.end
