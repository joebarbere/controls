controls oracle dc-0300
* Generated (plan F2.7, ADR 0012): do not edit; regenerate with `pnpm sim oracle regen`. dc seed 20261030 index 300 nodes 28 elements 41
.options sparse gmin=1e-12 noopac
RG1 1 0 1000000000000
RG2 2 0 1000000000000
RG3 3 0 1000000000000
RG4 4 0 1000000000000
RG5 5 0 1000000000000
RG6 6 0 1000000000000
RG7 7 0 1000000000000
RG8 8 0 1000000000000
RG9 9 0 1000000000000
RG10 10 0 1000000000000
RG11 11 0 1000000000000
RG12 12 0 1000000000000
RG13 13 0 1000000000000
RG14 14 0 1000000000000
RG15 15 0 1000000000000
RG16 16 0 1000000000000
RG17 17 0 1000000000000
RG18 18 0 1000000000000
RG19 19 0 1000000000000
RG20 20 0 1000000000000
RG21 21 0 1000000000000
RG22 22 0 1000000000000
RG23 23 0 1000000000000
RG24 24 0 1000000000000
RG25 25 0 1000000000000
RG26 26 0 1000000000000
RG27 27 0 1000000000000
VS0 8 s0 0
R0 s0 25 56e-1
VS1 0 s1 0
V1 e1 s1 DC 12e1
RI1 e1 15 27e-3
VS2 9 s2 0
R2 s2 5 82e2
VS3 6 s3 0
R3 s3 13 56e2
VS4 0 s4 0
R4 s4 3 10e0
VS5 22 s5 0
I5 s5 18 DC 56e-3
VS6 13 s6 0
R6 s6 24 33e-2
VS7 21 s7 0
R7 s7 18 22e-1
VS8 17 s8 0
R8 s8 27 27e0
VS9 23 s9 0
R9 s9 1 18e2
VS10 1 s10 0
R10 s10 26 27e-1
VS11 11 s11 0
R11 s11 27 22e-2
VS12 19 s12 0
R12 s12 3 15e0
VS13 22 s13 0
V13 e13 s13 DC 39e-1
RI13 e13 23 47e-1
VS14 16 s14 0
R14 s14 27 82e0
VS15 6 s15 0
R15 s15 24 18e1
VS16 17 s16 0
R16 s16 23 18e-1
VS17 3 s17 0
R17 s17 6 82e-1
VS18 21 s18 0
R18 s18 14 15e2
VS19 5 s19 0
I19 s19 11 DC 56e-3
VS20 17 s20 0
R20 s20 9 82e3
VS21 8 s21 0
R21 s21 19 56e2
VS22 12 s22 0
R22 s22 5 18e-2
VS23 17 s23 0
R23 s23 0 82e-1
VS24 27 s24 0
R24 s24 20 56e-2
VS25 2 s25 0
R25 s25 9 39e1
VS26 26 s26 0
R26 s26 16 18e3
VS27 1 s27 0
R27 s27 4 33e2
VS28 26 s28 0
V28 e28 s28 DC 22e1
RI28 e28 11 56e-3
VS29 14 s29 0
R29 s29 7 56e1
VS30 13 s30 0
R30 s30 12 68e-2
VS31 4 s31 0
V31 e31 s31 DC 56e0
RI31 e31 20 27e-1
VS32 2 s32 0
R32 s32 4 22e-2
VS33 25 s33 0
R33 s33 3 27e1
VS34 10 s34 0
R34 s34 19 68e-1
VS35 1 s35 0
R35 s35 14 27e1
VS36 22 s36 0
R36 s36 4 56e2
VS37 1 s37 0
V37 e37 s37 DC 33e1
RI37 e37 6 47e-1
VS38 7 s38 0
R38 s38 15 12e2
VS39 22 s39 0
R39 s39 18 18e2
VS40 10 s40 0
R40 s40 14 47e0
.control
set numdgt=17
op
print v(1) v(2) v(3) v(4) v(5) v(6) v(7) v(8) v(9) v(10)
print v(11) v(12) v(13) v(14) v(15) v(16) v(17) v(18) v(19) v(20)
print v(21) v(22) v(23) v(24) v(25) v(26) v(27)
print i(vs0) i(vs1) i(vs2) i(vs3) i(vs4) i(vs5) i(vs6) i(vs7) i(vs8) i(vs9)
print i(vs10) i(vs11) i(vs12) i(vs13) i(vs14) i(vs15) i(vs16) i(vs17) i(vs18) i(vs19)
print i(vs20) i(vs21) i(vs22) i(vs23) i(vs24) i(vs25) i(vs26) i(vs27) i(vs28) i(vs29)
print i(vs30) i(vs31) i(vs32) i(vs33) i(vs34) i(vs35) i(vs36) i(vs37) i(vs38) i(vs39)
print i(vs40)
.endc
.end
