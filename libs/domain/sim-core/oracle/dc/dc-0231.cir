controls oracle dc-0231
* Generated (plan F2.7, ADR 0012): do not edit; regenerate with `pnpm sim oracle regen`. dc seed 20261030 index 231 nodes 27 elements 34
.options sparse gmin=1e-12 noopac
RG1 1 0 1000000000000
RG2 2 0 1000000000000
RG3 3 0 1000000000000
RG4 4 0 1000000000000
RG5 5 0 1000000000000
RG6 6 0 1000000000000
RG7 7 0 1000000000000
RG8 8 0 1000000000000
RG9 9 0 1000000000000
RG10 10 0 1000000000000
RG11 11 0 1000000000000
RG12 12 0 1000000000000
RG13 13 0 1000000000000
RG14 14 0 1000000000000
RG15 15 0 1000000000000
RG16 16 0 1000000000000
RG17 17 0 1000000000000
RG18 18 0 1000000000000
RG19 19 0 1000000000000
RG20 20 0 1000000000000
RG21 21 0 1000000000000
RG22 22 0 1000000000000
RG23 23 0 1000000000000
RG24 24 0 1000000000000
RG25 25 0 1000000000000
RG26 26 0 1000000000000
VS0 0 s0 0
V0 e0 s0 DC 56e1
RI0 e0 18 82e-2
VS1 14 s1 0
I1 s1 16 DC 10e-1
VS2 20 s2 0
R2 s2 22 18e1
VS3 25 s3 0
V3 e3 s3 DC 10e0
RI3 e3 13 12e-1
VS4 26 s4 0
R4 s4 1 15e-1
VS5 23 s5 0
R5 s5 8 56e3
VS6 15 s6 0
R6 s6 25 18e-2
VS7 18 s7 0
R7 s7 5 10e0
VS8 25 s8 0
R8 s8 0 82e-2
VS9 5 s9 0
R9 s9 25 27e-1
VS10 9 s10 0
R10 s10 11 22e0
VS11 19 s11 0
R11 s11 25 12e0
VS12 12 s12 0
I12 s12 6 DC 56e-3
VS13 4 s13 0
R13 s13 25 47e0
VS14 23 s14 0
R14 s14 4 56e2
VS15 18 s15 0
R15 s15 10 12e1
VS16 15 s16 0
I16 s16 19 DC 27e-2
VS17 24 s17 0
I17 s17 13 DC 15e-1
VS18 7 s18 0
R18 s18 20 68e2
VS19 1 s19 0
R19 s19 7 27e-1
VS20 16 s20 0
R20 s20 7 33e-2
VS21 15 s21 0
V21 e21 s21 DC 68e-1
RI21 e21 17 27e-1
VS22 7 s22 0
V22 e22 s22 DC 12e-1
RI22 e22 4 68e-1
VS23 26 s23 0
R23 s23 5 27e2
VS24 6 s24 0
R24 s24 25 39e0
VS25 2 s25 0
V25 e25 s25 DC 56e1
RI25 e25 24 27e-2
VS26 10 s26 0
V26 e26 s26 DC 68e1
RI26 e26 21 39e-2
VS27 14 s27 0
R27 s27 8 18e0
VS28 13 s28 0
R28 s28 9 56e2
VS29 24 s29 0
R29 s29 17 39e0
VS30 17 s30 0
R30 s30 18 15e2
VS31 4 s31 0
V31 e31 s31 DC 68e0
RI31 e31 2 15e-3
VS32 4 s32 0
V32 e32 s32 DC 68e0
RI32 e32 3 27e-2
VS33 7 s33 0
V33 e33 s33 DC 27e1
RI33 e33 12 82e-2
.control
set numdgt=17
op
print v(1) v(2) v(3) v(4) v(5) v(6) v(7) v(8) v(9) v(10)
print v(11) v(12) v(13) v(14) v(15) v(16) v(17) v(18) v(19) v(20)
print v(21) v(22) v(23) v(24) v(25) v(26)
print i(vs0) i(vs1) i(vs2) i(vs3) i(vs4) i(vs5) i(vs6) i(vs7) i(vs8) i(vs9)
print i(vs10) i(vs11) i(vs12) i(vs13) i(vs14) i(vs15) i(vs16) i(vs17) i(vs18) i(vs19)
print i(vs20) i(vs21) i(vs22) i(vs23) i(vs24) i(vs25) i(vs26) i(vs27) i(vs28) i(vs29)
print i(vs30) i(vs31) i(vs32) i(vs33)
.endc
.end
