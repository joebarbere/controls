controls oracle dc-0231
* Generated (plan F2.7, ADR 0012): do not edit; regenerate with `pnpm sim oracle regen`. dc seed 20261030 index 231 nodes 27 elements 41
.options sparse gmin=1e-12 noopac
RG1 1 0 1000000000000
RG2 2 0 1000000000000
RG3 3 0 1000000000000
RG4 4 0 1000000000000
RG5 5 0 1000000000000
RG6 6 0 1000000000000
RG7 7 0 1000000000000
RG8 8 0 1000000000000
RG9 9 0 1000000000000
RG10 10 0 1000000000000
RG11 11 0 1000000000000
RG12 12 0 1000000000000
RG13 13 0 1000000000000
RG14 14 0 1000000000000
RG15 15 0 1000000000000
RG16 16 0 1000000000000
RG17 17 0 1000000000000
RG18 18 0 1000000000000
RG19 19 0 1000000000000
RG20 20 0 1000000000000
RG21 21 0 1000000000000
RG22 22 0 1000000000000
RG23 23 0 1000000000000
RG24 24 0 1000000000000
RG25 25 0 1000000000000
RG26 26 0 1000000000000
VS0 16 s0 0
R0 s0 19 27e3
VS1 24 s1 0
R1 s1 17 39e0
VS2 0 s2 0
V2 e2 s2 DC 68e0
RI2 e2 3 27e-2
VS3 6 s3 0
R3 s3 25 39e0
VS4 26 s4 0
R4 s4 5 27e2
VS5 25 s5 0
V5 e5 s5 DC 10e0
RI5 e5 13 12e-1
VS6 26 s6 0
R6 s6 1 15e-1
VS7 0 s7 0
V7 e7 s7 DC 68e0
RI7 e7 2 15e-3
VS8 4 s8 0
V8 e8 s8 DC 56e1
RI8 e8 18 82e-2
VS9 15 s9 0
R9 s9 25 18e-2
VS10 11 s10 0
R10 s10 15 82e1
VS11 7 s11 0
V11 e11 s11 DC 12e-1
RI11 e11 0 68e-1
VS12 19 s12 0
R12 s12 25 12e0
VS13 12 s13 0
I13 s13 6 DC 56e-3
VS14 14 s14 0
R14 s14 8 18e0
VS15 1 s15 0
R15 s15 7 27e-1
VS16 13 s16 0
R16 s16 9 56e2
VS17 23 s17 0
R17 s17 8 56e3
VS18 15 s18 0
V18 e18 s18 DC 68e-1
RI18 e18 17 27e-1
VS19 21 s19 0
R19 s19 22 39e-2
VS20 18 s20 0
R20 s20 10 12e1
VS21 9 s21 0
R21 s21 11 22e0
VS22 16 s22 0
R22 s22 7 33e-2
VS23 2 s23 0
V23 e23 s23 DC 56e1
RI23 e23 24 27e-2
VS24 17 s24 0
R24 s24 18 15e2
VS25 12 s25 0
V25 e25 s25 DC 39e-1
RI25 e25 14 68e-3
VS26 14 s26 0
I26 s26 16 DC 10e-1
VS27 24 s27 0
I27 s27 13 DC 15e-1
VS28 12 s28 0
V28 e28 s28 DC 18e-1
RI28 e28 0 33e-3
VS29 6 s29 0
V29 e29 s29 DC 82e-1
RI29 e29 19 33e-1
VS30 25 s30 0
R30 s30 4 82e-2
VS31 5 s31 0
R31 s31 25 27e-1
VS32 7 s32 0
R32 s32 20 68e2
VS33 0 s33 0
R33 s33 25 47e0
VS34 20 s34 0
R34 s34 22 18e1
VS35 10 s35 0
V35 e35 s35 DC 68e1
RI35 e35 21 39e-2
VS36 7 s36 0
V36 e36 s36 DC 27e1
RI36 e36 12 82e-2
VS37 18 s37 0
R37 s37 5 10e0
VS38 15 s38 0
I38 s38 19 DC 27e-2
VS39 3 s39 0
V39 e39 s39 DC 33e1
RI39 e39 2 12e-3
VS40 23 s40 0
R40 s40 0 56e2
.control
set numdgt=17
op
print v(1) v(2) v(3) v(4) v(5) v(6) v(7) v(8) v(9) v(10)
print v(11) v(12) v(13) v(14) v(15) v(16) v(17) v(18) v(19) v(20)
print v(21) v(22) v(23) v(24) v(25) v(26)
print i(vs0) i(vs1) i(vs2) i(vs3) i(vs4) i(vs5) i(vs6) i(vs7) i(vs8) i(vs9)
print i(vs10) i(vs11) i(vs12) i(vs13) i(vs14) i(vs15) i(vs16) i(vs17) i(vs18) i(vs19)
print i(vs20) i(vs21) i(vs22) i(vs23) i(vs24) i(vs25) i(vs26) i(vs27) i(vs28) i(vs29)
print i(vs30) i(vs31) i(vs32) i(vs33) i(vs34) i(vs35) i(vs36) i(vs37) i(vs38) i(vs39)
print i(vs40)
.endc
.end
