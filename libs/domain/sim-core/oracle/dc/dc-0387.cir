controls oracle dc-0387
* Generated (plan F2.7, ADR 0012): do not edit; regenerate with `pnpm sim oracle regen`. dc seed 20261030 index 387 nodes 29 elements 57
.options sparse gmin=1e-12 noopac
RG1 1 0 1000000000000
RG2 2 0 1000000000000
RG3 3 0 1000000000000
RG4 4 0 1000000000000
RG5 5 0 1000000000000
RG6 6 0 1000000000000
RG7 7 0 1000000000000
RG8 8 0 1000000000000
RG9 9 0 1000000000000
RG10 10 0 1000000000000
RG11 11 0 1000000000000
RG12 12 0 1000000000000
RG13 13 0 1000000000000
RG14 14 0 1000000000000
RG15 15 0 1000000000000
RG16 16 0 1000000000000
RG17 17 0 1000000000000
RG18 18 0 1000000000000
RG19 19 0 1000000000000
RG20 20 0 1000000000000
RG21 21 0 1000000000000
RG22 22 0 1000000000000
RG23 23 0 1000000000000
RG24 24 0 1000000000000
RG25 25 0 1000000000000
RG26 26 0 1000000000000
RG27 27 0 1000000000000
RG28 28 0 1000000000000
VS0 0 s0 0
R0 s0 14 18e1
VS1 2 s1 0
R1 s1 24 27e0
VS2 0 s2 0
V2 e2 s2 DC 12e1
RI2 e2 24 10e-3
VS3 22 s3 0
R3 s3 28 27e-1
VS4 26 s4 0
V4 e4 s4 DC 22e-1
RI4 e4 20 10e-3
VS5 16 s5 0
R5 s5 28 47e0
VS6 8 s6 0
I6 s6 24 DC 56e-4
VS7 10 s7 0
R7 s7 22 15e3
VS8 15 s8 0
R8 s8 24 47e0
VS9 24 s9 0
R9 s9 18 27e3
VS10 15 s10 0
R10 s10 1 27e2
VS11 10 s11 0
R11 s11 17 27e0
VS12 12 s12 0
R12 s12 20 39e1
VS13 5 s13 0
R13 s13 14 33e-1
VS14 6 s14 0
I14 s14 7 DC 18e-1
VS15 16 s15 0
R15 s15 27 47e0
VS16 24 s16 0
R16 s16 1 15e0
VS17 9 s17 0
R17 s17 26 27e-2
VS18 15 s18 0
R18 s18 12 15e2
VS19 1 s19 0
R19 s19 9 56e1
VS20 21 s20 0
V20 e20 s20 DC 47e1
RI20 e20 23 82e-1
VS21 20 s21 0
V21 e21 s21 DC 10e0
RI21 e21 3 12e-2
VS22 8 s22 0
R22 s22 6 18e1
VS23 9 s23 0
I23 s23 22 DC 56e-3
VS24 26 s24 0
R24 s24 18 68e2
VS25 1 s25 0
R25 s25 25 10e1
VS26 23 s26 0
R26 s26 0 56e0
VS27 19 s27 0
R27 s27 9 15e-2
VS28 24 s28 0
I28 s28 11 DC 27e-4
VS29 23 s29 0
V29 e29 s29 DC 22e1
RI29 e29 19 68e-2
VS30 7 s30 0
V30 e30 s30 DC 22e1
RI30 e30 13 68e-2
VS31 27 s31 0
R31 s31 17 15e1
VS32 12 s32 0
R32 s32 26 12e-2
VS33 4 s33 0
R33 s33 11 82e1
VS34 11 s34 0
R34 s34 28 39e2
VS35 10 s35 0
V35 e35 s35 DC 33e-1
RI35 e35 2 68e-2
VS36 13 s36 0
R36 s36 8 82e-1
VS37 7 s37 0
V37 e37 s37 DC 27e-1
RI37 e37 27 33e-2
VS38 24 s38 0
R38 s38 11 56e3
VS39 25 s39 0
V39 e39 s39 DC 68e-1
RI39 e39 15 33e-2
VS40 3 s40 0
R40 s40 26 39e1
VS41 23 s41 0
R41 s41 19 68e2
VS42 6 s42 0
V42 e42 s42 DC 82e-1
RI42 e42 28 10e-3
VS43 28 s43 0
V43 e43 s43 DC 22e-1
RI43 e43 14 15e-3
VS44 28 s44 0
R44 s44 21 12e-2
VS45 18 s45 0
I45 s45 23 DC 39e-1
VS46 5 s46 0
R46 s46 10 18e0
VS47 1 s47 0
R47 s47 13 39e-1
VS48 5 s48 0
R48 s48 10 15e3
VS49 13 s49 0
R49 s49 7 12e0
VS50 1 s50 0
I50 s50 2 DC 39e-1
VS51 4 s51 0
V51 e51 s51 DC 22e1
RI51 e51 14 82e-3
VS52 26 s52 0
R52 s52 14 27e2
VS53 8 s53 0
R53 s53 5 12e-1
VS54 25 s54 0
I54 s54 16 DC 12e-3
VS55 17 s55 0
I55 s55 5 DC 47e-2
VS56 14 s56 0
R56 s56 27 27e-2
.control
set numdgt=17
op
print v(1) v(2) v(3) v(4) v(5) v(6) v(7) v(8) v(9) v(10)
print v(11) v(12) v(13) v(14) v(15) v(16) v(17) v(18) v(19) v(20)
print v(21) v(22) v(23) v(24) v(25) v(26) v(27) v(28)
print i(vs0) i(vs1) i(vs2) i(vs3) i(vs4) i(vs5) i(vs6) i(vs7) i(vs8) i(vs9)
print i(vs10) i(vs11) i(vs12) i(vs13) i(vs14) i(vs15) i(vs16) i(vs17) i(vs18) i(vs19)
print i(vs20) i(vs21) i(vs22) i(vs23) i(vs24) i(vs25) i(vs26) i(vs27) i(vs28) i(vs29)
print i(vs30) i(vs31) i(vs32) i(vs33) i(vs34) i(vs35) i(vs36) i(vs37) i(vs38) i(vs39)
print i(vs40) i(vs41) i(vs42) i(vs43) i(vs44) i(vs45) i(vs46) i(vs47) i(vs48) i(vs49)
print i(vs50) i(vs51) i(vs52) i(vs53) i(vs54) i(vs55) i(vs56)
.endc
.end
