controls oracle dc-0387
* Generated (plan F2.7, ADR 0012): do not edit; regenerate with `pnpm sim oracle regen`. dc seed 20261030 index 387 nodes 29 elements 50
.options sparse gmin=1e-12 noopac
RG1 1 0 1000000000000
RG2 2 0 1000000000000
RG3 3 0 1000000000000
RG4 4 0 1000000000000
RG5 5 0 1000000000000
RG6 6 0 1000000000000
RG7 7 0 1000000000000
RG8 8 0 1000000000000
RG9 9 0 1000000000000
RG10 10 0 1000000000000
RG11 11 0 1000000000000
RG12 12 0 1000000000000
RG13 13 0 1000000000000
RG14 14 0 1000000000000
RG15 15 0 1000000000000
RG16 16 0 1000000000000
RG17 17 0 1000000000000
RG18 18 0 1000000000000
RG19 19 0 1000000000000
RG20 20 0 1000000000000
RG21 21 0 1000000000000
RG22 22 0 1000000000000
RG23 23 0 1000000000000
RG24 24 0 1000000000000
RG25 25 0 1000000000000
RG26 26 0 1000000000000
RG27 27 0 1000000000000
RG28 28 0 1000000000000
VS0 8 s0 0
I0 s0 24 DC 56e-4
VS1 0 s1 0
V1 e1 s1 DC 22e1
RI1 e1 14 82e-3
VS2 7 s2 0
V2 e2 s2 DC 22e1
RI2 e2 13 68e-2
VS3 27 s3 0
R3 s3 14 18e1
VS4 26 s4 0
R4 s4 14 27e2
VS5 6 s5 0
I5 s5 7 DC 18e-1
VS6 26 s6 0
R6 s6 18 68e2
VS7 1 s7 0
R7 s7 13 39e-1
VS8 1 s8 0
I8 s8 2 DC 39e-1
VS9 15 s9 0
R9 s9 24 47e0
VS10 5 s10 0
R10 s10 14 33e-1
VS11 23 s11 0
R11 s11 19 68e2
VS12 22 s12 0
R12 s12 28 27e-1
VS13 25 s13 0
V13 e13 s13 DC 68e-1
RI13 e13 15 33e-2
VS14 28 s14 0
V14 e14 s14 DC 22e-1
RI14 e14 14 15e-3
VS15 3 s15 0
R15 s15 26 39e1
VS16 24 s16 0
I16 s16 11 DC 27e-4
VS17 11 s17 0
R17 s17 28 39e2
VS18 2 s18 0
R18 s18 24 27e0
VS19 4 s19 0
R19 s19 17 15e1
VS20 7 s20 0
V20 e20 s20 DC 27e-1
RI20 e20 4 33e-2
VS21 16 s21 0
R21 s21 28 47e0
VS22 1 s22 0
R22 s22 25 10e1
VS23 18 s23 0
I23 s23 23 DC 39e-1
VS24 24 s24 0
R24 s24 11 56e3
VS25 12 s25 0
R25 s25 26 12e-2
VS26 24 s26 0
R26 s26 18 27e3
VS27 10 s27 0
V27 e27 s27 DC 33e-1
RI27 e27 2 68e-2
VS28 15 s28 0
R28 s28 1 27e2
VS29 23 s29 0
V29 e29 s29 DC 22e1
RI29 e29 19 68e-2
VS30 25 s30 0
I30 s30 16 DC 12e-3
VS31 21 s31 0
V31 e31 s31 DC 47e1
RI31 e31 23 82e-1
VS32 14 s32 0
R32 s32 4 27e-2
VS33 27 s33 0
V33 e33 s33 DC 12e1
RI33 e33 24 10e-3
VS34 10 s34 0
R34 s34 17 27e0
VS35 6 s35 0
V35 e35 s35 DC 82e-1
RI35 e35 28 10e-3
VS36 13 s36 0
R36 s36 8 82e-1
VS37 9 s37 0
R37 s37 26 27e-2
VS38 17 s38 0
I38 s38 5 DC 47e-2
VS39 15 s39 0
R39 s39 12 15e2
VS40 23 s40 0
R40 s40 27 56e0
VS41 10 s41 0
R41 s41 22 15e3
VS42 8 s42 0
R42 s42 6 18e1
VS43 9 s43 0
I43 s43 22 DC 56e-3
VS44 24 s44 0
R44 s44 1 15e0
VS45 5 s45 0
R45 s45 10 18e0
VS46 13 s46 0
R46 s46 7 12e0
VS47 8 s47 0
R47 s47 5 12e-1
VS48 26 s48 0
V48 e48 s48 DC 22e-1
RI48 e48 20 10e-3
VS49 5 s49 0
R49 s49 10 15e3
.control
set numdgt=17
op
print v(1) v(2) v(3) v(4) v(5) v(6) v(7) v(8) v(9) v(10)
print v(11) v(12) v(13) v(14) v(15) v(16) v(17) v(18) v(19) v(20)
print v(21) v(22) v(23) v(24) v(25) v(26) v(27) v(28)
print i(vs0) i(vs1) i(vs2) i(vs3) i(vs4) i(vs5) i(vs6) i(vs7) i(vs8) i(vs9)
print i(vs10) i(vs11) i(vs12) i(vs13) i(vs14) i(vs15) i(vs16) i(vs17) i(vs18) i(vs19)
print i(vs20) i(vs21) i(vs22) i(vs23) i(vs24) i(vs25) i(vs26) i(vs27) i(vs28) i(vs29)
print i(vs30) i(vs31) i(vs32) i(vs33) i(vs34) i(vs35) i(vs36) i(vs37) i(vs38) i(vs39)
print i(vs40) i(vs41) i(vs42) i(vs43) i(vs44) i(vs45) i(vs46) i(vs47) i(vs48) i(vs49)
.endc
.end
