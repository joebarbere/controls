controls oracle dc-0465
* Generated (plan F2.7, ADR 0012): do not edit; regenerate with `pnpm sim oracle regen`. dc seed 20261030 index 465 nodes 6 elements 12
.options sparse gmin=1e-12 noopac
RG1 1 0 1000000000000
RG2 2 0 1000000000000
RG3 3 0 1000000000000
RG4 4 0 1000000000000
RG5 5 0 1000000000000
VS0 3 s0 0
R0 s0 2 15e-2
VS1 3 s1 0
R1 s1 4 10e3
VS2 1 s2 0
R2 s2 3 47e-2
VS3 3 s3 0
I3 s3 2 DC 33e-4
VS4 0 s4 0
I4 s4 2 DC 82e-4
VS5 0 s5 0
V5 e5 s5 DC 22e-1
RI5 e5 5 22e-1
VS6 2 s6 0
R6 s6 4 22e-2
VS7 4 s7 0
I7 s7 2 DC 82e-3
VS8 5 s8 0
R8 s8 1 10e-1
VS9 4 s9 0
R9 s9 0 22e0
VS10 4 s10 0
R10 s10 1 27e1
VS11 3 s11 0
R11 s11 5 68e2
.control
set numdgt=17
op
print v(1) v(2) v(3) v(4) v(5)
print i(vs0) i(vs1) i(vs2) i(vs3) i(vs4) i(vs5) i(vs6) i(vs7) i(vs8) i(vs9)
print i(vs10) i(vs11)
.endc
.end
