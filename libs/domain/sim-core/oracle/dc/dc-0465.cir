controls oracle dc-0465
* Generated (plan F2.7, ADR 0012): do not edit; regenerate with `pnpm sim oracle regen`. dc seed 20261030 index 465 nodes 6 elements 9
.options sparse gmin=1e-12 noopac
RG1 1 0 1000000000000
RG2 2 0 1000000000000
RG3 3 0 1000000000000
RG4 4 0 1000000000000
RG5 5 0 1000000000000
VS0 0 s0 0
R0 s0 4 22e0
VS1 3 s1 0
R1 s1 0 10e3
VS2 3 s2 0
R2 s2 2 15e-2
VS3 5 s3 0
R3 s3 1 10e-1
VS4 4 s4 0
I4 s4 2 DC 82e-4
VS5 0 s5 0
I5 s5 2 DC 82e-3
VS6 1 s6 0
R6 s6 3 47e-2
VS7 0 s7 0
R7 s7 1 27e1
VS8 3 s8 0
I8 s8 2 DC 33e-4
.control
set numdgt=17
op
print v(1) v(2) v(3) v(4) v(5)
print i(vs0) i(vs1) i(vs2) i(vs3) i(vs4) i(vs5) i(vs6) i(vs7) i(vs8)
.endc
.end
