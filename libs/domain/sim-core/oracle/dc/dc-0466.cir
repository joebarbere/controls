controls oracle dc-0466
* Generated (plan F2.7, ADR 0012): do not edit; regenerate with `pnpm sim oracle regen`. dc seed 20261030 index 466 nodes 14 elements 26
.options sparse gmin=1e-12 noopac
RG1 1 0 1000000000000
RG2 2 0 1000000000000
RG3 3 0 1000000000000
RG4 4 0 1000000000000
RG5 5 0 1000000000000
RG6 6 0 1000000000000
RG7 7 0 1000000000000
RG8 8 0 1000000000000
RG9 9 0 1000000000000
RG10 10 0 1000000000000
RG11 11 0 1000000000000
RG12 12 0 1000000000000
RG13 13 0 1000000000000
VS0 9 s0 0
R0 s0 0 22e-2
VS1 10 s1 0
R1 s1 13 12e1
VS2 8 s2 0
R2 s2 10 22e2
VS3 0 s3 0
V3 e3 s3 DC 15e-1
RI3 e3 4 33e-3
VS4 10 s4 0
R4 s4 6 47e0
VS5 7 s5 0
R5 s5 4 47e2
VS6 11 s6 0
R6 s6 8 10e-1
VS7 9 s7 0
R7 s7 2 18e3
VS8 0 s8 0
I8 s8 8 DC 68e-4
VS9 11 s9 0
I9 s9 4 DC 68e-3
VS10 9 s10 0
R10 s10 4 10e0
VS11 11 s11 0
R11 s11 5 68e3
VS12 10 s12 0
R12 s12 5 10e0
VS13 5 s13 0
V13 e13 s13 DC 22e0
RI13 e13 1 56e-3
VS14 6 s14 0
R14 s14 1 22e-1
VS15 12 s15 0
R15 s15 9 33e1
VS16 12 s16 0
R16 s16 5 15e-2
VS17 0 s17 0
R17 s17 13 22e0
VS18 5 s18 0
R18 s18 9 33e-2
VS19 3 s19 0
R19 s19 2 15e2
VS20 4 s20 0
R20 s20 0 33e-2
VS21 7 s21 0
V21 e21 s21 DC 82e-1
RI21 e21 3 27e-1
VS22 6 s22 0
R22 s22 1 22e-1
VS23 12 s23 0
R23 s23 10 68e1
VS24 1 s24 0
R24 s24 4 12e-2
VS25 7 s25 0
V25 e25 s25 DC 27e1
RI25 e25 13 68e-1
.control
set numdgt=17
op
print v(1) v(2) v(3) v(4) v(5) v(6) v(7) v(8) v(9) v(10)
print v(11) v(12) v(13)
print i(vs0) i(vs1) i(vs2) i(vs3) i(vs4) i(vs5) i(vs6) i(vs7) i(vs8) i(vs9)
print i(vs10) i(vs11) i(vs12) i(vs13) i(vs14) i(vs15) i(vs16) i(vs17) i(vs18) i(vs19)
print i(vs20) i(vs21) i(vs22) i(vs23) i(vs24) i(vs25)
.endc
.end
