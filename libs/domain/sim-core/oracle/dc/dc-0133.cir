controls oracle dc-0133
* Generated (plan F2.7, ADR 0012): do not edit; regenerate with `pnpm sim oracle regen`. dc seed 20261030 index 133 nodes 13 elements 20
.options sparse gmin=1e-12 noopac
RG1 1 0 1000000000000
RG2 2 0 1000000000000
RG3 3 0 1000000000000
RG4 4 0 1000000000000
RG5 5 0 1000000000000
RG6 6 0 1000000000000
RG7 7 0 1000000000000
RG8 8 0 1000000000000
RG9 9 0 1000000000000
RG10 10 0 1000000000000
RG11 11 0 1000000000000
RG12 12 0 1000000000000
VS0 8 s0 0
R0 s0 4 33e-1
VS1 6 s1 0
R1 s1 9 47e0
VS2 8 s2 0
R2 s2 12 33e2
VS3 10 s3 0
I3 s3 6 DC 56e-1
VS4 3 s4 0
R4 s4 5 39e-2
VS5 6 s5 0
R5 s5 0 82e1
VS6 12 s6 0
R6 s6 1 47e1
VS7 12 s7 0
R7 s7 10 12e3
VS8 11 s8 0
R8 s8 6 39e2
VS9 3 s9 0
R9 s9 1 39e0
VS10 11 s10 0
I10 s10 3 DC 68e-2
VS11 5 s11 0
R11 s11 9 12e0
VS12 8 s12 0
R12 s12 5 82e3
VS13 0 s13 0
V13 e13 s13 DC 10e0
RI13 e13 7 15e-2
VS14 2 s14 0
V14 e14 s14 DC 12e-1
RI14 e14 5 39e-2
VS15 1 s15 0
I15 s15 4 DC 56e-1
VS16 5 s16 0
I16 s16 9 DC 15e-1
VS17 10 s17 0
R17 s17 6 12e-1
VS18 3 s18 0
R18 s18 0 39e2
VS19 9 s19 0
R19 s19 5 10e-1
.control
set numdgt=17
op
print v(1) v(2) v(3) v(4) v(5) v(6) v(7) v(8) v(9) v(10)
print v(11) v(12)
print i(vs0) i(vs1) i(vs2) i(vs3) i(vs4) i(vs5) i(vs6) i(vs7) i(vs8) i(vs9)
print i(vs10) i(vs11) i(vs12) i(vs13) i(vs14) i(vs15) i(vs16) i(vs17) i(vs18) i(vs19)
.endc
.end
