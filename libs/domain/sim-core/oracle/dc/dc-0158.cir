controls oracle dc-0158
* Generated (plan F2.7, ADR 0012): do not edit; regenerate with `pnpm sim oracle regen`. dc seed 20261030 index 158 nodes 13 elements 16
.options sparse gmin=1e-12 noopac
RG1 1 0 1000000000000
RG2 2 0 1000000000000
RG3 3 0 1000000000000
RG4 4 0 1000000000000
RG5 5 0 1000000000000
RG6 6 0 1000000000000
RG7 7 0 1000000000000
RG8 8 0 1000000000000
RG9 9 0 1000000000000
RG10 10 0 1000000000000
RG11 11 0 1000000000000
RG12 12 0 1000000000000
VS0 5 s0 0
R0 s0 6 12e-1
VS1 9 s1 0
I1 s1 0 DC 18e-1
VS2 0 s2 0
V2 e2 s2 DC 68e-1
RI2 e2 9 10e-3
VS3 2 s3 0
V3 e3 s3 DC 82e1
RI3 e3 6 27e-3
VS4 12 s4 0
R4 s4 6 12e1
VS5 0 s5 0
R5 s5 1 18e0
VS6 6 s6 0
R6 s6 1 56e3
VS7 2 s7 0
R7 s7 8 22e-1
VS8 8 s8 0
R8 s8 10 15e-1
VS9 4 s9 0
V9 e9 s9 DC 68e0
RI9 e9 1 12e-1
VS10 2 s10 0
V10 e10 s10 DC 56e1
RI10 e10 9 10e-1
VS11 0 s11 0
R11 s11 3 12e-1
VS12 8 s12 0
R12 s12 3 12e0
VS13 10 s13 0
R13 s13 5 47e1
VS14 8 s14 0
R14 s14 7 56e-1
VS15 8 s15 0
R15 s15 11 56e2
.control
set numdgt=17
op
print v(1) v(2) v(3) v(4) v(5) v(6) v(7) v(8) v(9) v(10)
print v(11) v(12)
print i(vs0) i(vs1) i(vs2) i(vs3) i(vs4) i(vs5) i(vs6) i(vs7) i(vs8) i(vs9)
print i(vs10) i(vs11) i(vs12) i(vs13) i(vs14) i(vs15)
.endc
.end
