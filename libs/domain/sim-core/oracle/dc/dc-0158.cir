controls oracle dc-0158
* Generated (plan F2.7, ADR 0012): do not edit; regenerate with `pnpm sim oracle regen`. dc seed 20261030 index 158 nodes 13 elements 19
.options sparse gmin=1e-12 noopac
RG1 1 0 1000000000000
RG2 2 0 1000000000000
RG3 3 0 1000000000000
RG4 4 0 1000000000000
RG5 5 0 1000000000000
RG6 6 0 1000000000000
RG7 7 0 1000000000000
RG8 8 0 1000000000000
RG9 9 0 1000000000000
RG10 10 0 1000000000000
RG11 11 0 1000000000000
RG12 12 0 1000000000000
VS0 8 s0 0
R0 s0 10 15e-1
VS1 4 s1 0
R1 s1 7 27e3
VS2 8 s2 0
R2 s2 7 56e-1
VS3 11 s3 0
R3 s3 0 47e2
VS4 12 s4 0
R4 s4 6 12e1
VS5 9 s5 0
I5 s5 2 DC 18e-1
VS6 10 s6 0
R6 s6 5 47e1
VS7 2 s7 0
R7 s7 1 18e0
VS8 6 s8 0
R8 s8 1 56e3
VS9 0 s9 0
V9 e9 s9 DC 82e1
RI9 e9 6 27e-3
VS10 8 s10 0
R10 s10 3 12e0
VS11 0 s11 0
V11 e11 s11 DC 56e1
RI11 e11 9 10e-1
VS12 2 s12 0
V12 e12 s12 DC 68e-1
RI12 e12 9 10e-3
VS13 5 s13 0
R13 s13 6 12e-1
VS14 4 s14 0
V14 e14 s14 DC 68e0
RI14 e14 1 12e-1
VS15 8 s15 0
R15 s15 11 56e2
VS16 2 s16 0
R16 s16 3 12e-1
VS17 2 s17 0
R17 s17 12 33e2
VS18 0 s18 0
R18 s18 8 22e-1
.control
set numdgt=17
op
print v(1) v(2) v(3) v(4) v(5) v(6) v(7) v(8) v(9) v(10)
print v(11) v(12)
print i(vs0) i(vs1) i(vs2) i(vs3) i(vs4) i(vs5) i(vs6) i(vs7) i(vs8) i(vs9)
print i(vs10) i(vs11) i(vs12) i(vs13) i(vs14) i(vs15) i(vs16) i(vs17) i(vs18)
.endc
.end
