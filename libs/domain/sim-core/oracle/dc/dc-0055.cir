controls oracle dc-0055
* Generated (plan F2.7, ADR 0012): do not edit; regenerate with `pnpm sim oracle regen`. dc seed 20261030 index 55 nodes 21 elements 42
.options sparse gmin=1e-12 noopac
RG1 1 0 1000000000000
RG2 2 0 1000000000000
RG3 3 0 1000000000000
RG4 4 0 1000000000000
RG5 5 0 1000000000000
RG6 6 0 1000000000000
RG7 7 0 1000000000000
RG8 8 0 1000000000000
RG9 9 0 1000000000000
RG10 10 0 1000000000000
RG11 11 0 1000000000000
RG12 12 0 1000000000000
RG13 13 0 1000000000000
RG14 14 0 1000000000000
RG15 15 0 1000000000000
RG16 16 0 1000000000000
RG17 17 0 1000000000000
RG18 18 0 1000000000000
RG19 19 0 1000000000000
RG20 20 0 1000000000000
VS0 3 s0 0
R0 s0 8 82e-2
VS1 9 s1 0
R1 s1 0 68e-2
VS2 8 s2 0
R2 s2 18 82e1
VS3 9 s3 0
R3 s3 3 12e-2
VS4 0 s4 0
R4 s4 2 33e-1
VS5 4 s5 0
R5 s5 20 82e3
VS6 4 s6 0
I6 s6 20 DC 22e-2
VS7 13 s7 0
R7 s7 12 15e-2
VS8 7 s8 0
I8 s8 18 DC 22e-1
VS9 5 s9 0
R9 s9 13 56e-1
VS10 19 s10 0
R10 s10 1 68e-2
VS11 6 s11 0
R11 s11 3 39e1
VS12 17 s12 0
R12 s12 13 56e0
VS13 19 s13 0
R13 s13 10 33e1
VS14 0 s14 0
V14 e14 s14 DC 82e1
RI14 e14 10 12e-2
VS15 14 s15 0
I15 s15 10 DC 15e-1
VS16 15 s16 0
R16 s16 9 27e1
VS17 4 s17 0
R17 s17 9 56e-2
VS18 12 s18 0
R18 s18 7 27e-2
VS19 16 s19 0
R19 s19 14 82e-2
VS20 12 s20 0
I20 s20 16 DC 10e-1
VS21 19 s21 0
R21 s21 12 56e2
VS22 17 s22 0
R22 s22 18 47e0
VS23 10 s23 0
R23 s23 9 56e0
VS24 15 s24 0
V24 e24 s24 DC 47e-1
RI24 e24 6 18e-2
VS25 5 s25 0
R25 s25 2 56e0
VS26 7 s26 0
I26 s26 5 DC 10e-2
VS27 11 s27 0
V27 e27 s27 DC 27e1
RI27 e27 17 56e-1
VS28 7 s28 0
R28 s28 2 82e3
VS29 16 s29 0
R29 s29 10 18e-1
VS30 20 s30 0
R30 s30 9 12e0
VS31 7 s31 0
V31 e31 s31 DC 56e0
RI31 e31 14 10e-3
VS32 20 s32 0
R32 s32 7 68e-1
VS33 9 s33 0
V33 e33 s33 DC 82e0
RI33 e33 14 27e-1
VS34 11 s34 0
I34 s34 4 DC 18e-1
VS35 1 s35 0
I35 s35 11 DC 56e-1
VS36 3 s36 0
R36 s36 11 15e1
VS37 13 s37 0
R37 s37 1 47e3
VS38 11 s38 0
R38 s38 0 15e-1
VS39 16 s39 0
R39 s39 19 12e1
VS40 16 s40 0
V40 e40 s40 DC 10e-1
RI40 e40 6 56e-1
VS41 1 s41 0
R41 s41 3 47e1
.control
set numdgt=17
op
print v(1) v(2) v(3) v(4) v(5) v(6) v(7) v(8) v(9) v(10)
print v(11) v(12) v(13) v(14) v(15) v(16) v(17) v(18) v(19) v(20)
print i(vs0) i(vs1) i(vs2) i(vs3) i(vs4) i(vs5) i(vs6) i(vs7) i(vs8) i(vs9)
print i(vs10) i(vs11) i(vs12) i(vs13) i(vs14) i(vs15) i(vs16) i(vs17) i(vs18) i(vs19)
print i(vs20) i(vs21) i(vs22) i(vs23) i(vs24) i(vs25) i(vs26) i(vs27) i(vs28) i(vs29)
print i(vs30) i(vs31) i(vs32) i(vs33) i(vs34) i(vs35) i(vs36) i(vs37) i(vs38) i(vs39)
print i(vs40) i(vs41)
.endc
.end
