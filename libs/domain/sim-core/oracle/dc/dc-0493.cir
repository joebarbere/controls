controls oracle dc-0493
* Generated (plan F2.7, ADR 0012): do not edit; regenerate with `pnpm sim oracle regen`. dc seed 20261030 index 493 nodes 18 elements 27
.options sparse gmin=1e-12 noopac
RG1 1 0 1000000000000
RG2 2 0 1000000000000
RG3 3 0 1000000000000
RG4 4 0 1000000000000
RG5 5 0 1000000000000
RG6 6 0 1000000000000
RG7 7 0 1000000000000
RG8 8 0 1000000000000
RG9 9 0 1000000000000
RG10 10 0 1000000000000
RG11 11 0 1000000000000
RG12 12 0 1000000000000
RG13 13 0 1000000000000
RG14 14 0 1000000000000
RG15 15 0 1000000000000
RG16 16 0 1000000000000
RG17 17 0 1000000000000
VS0 10 s0 0
R0 s0 9 47e1
VS1 0 s1 0
V1 e1 s1 DC 22e1
RI1 e1 5 18e-3
VS2 3 s2 0
R2 s2 0 10e-2
VS3 2 s3 0
R3 s3 10 47e-1
VS4 4 s4 0
R4 s4 13 68e1
VS5 11 s5 0
V5 e5 s5 DC 68e0
RI5 e5 15 33e-3
VS6 5 s6 0
R6 s6 1 82e-2
VS7 8 s7 0
R7 s7 13 12e0
VS8 13 s8 0
R8 s8 12 39e3
VS9 3 s9 0
V9 e9 s9 DC 15e0
RI9 e9 11 18e-2
VS10 6 s10 0
R10 s10 16 56e2
VS11 1 s11 0
R11 s11 8 82e-1
VS12 14 s12 0
R12 s12 7 27e-1
VS13 14 s13 0
R13 s13 11 27e3
VS14 15 s14 0
R14 s14 16 15e0
VS15 7 s15 0
R15 s15 12 47e1
VS16 2 s16 0
V16 e16 s16 DC 33e1
RI16 e16 13 15e-3
VS17 8 s17 0
R17 s17 10 10e-2
VS18 9 s18 0
R18 s18 6 56e1
VS19 1 s19 0
I19 s19 5 DC 27e-2
VS20 5 s20 0
R20 s20 4 47e-2
VS21 15 s21 0
V21 e21 s21 DC 47e0
RI21 e21 13 47e-2
VS22 17 s22 0
R22 s22 13 27e1
VS23 15 s23 0
R23 s23 4 39e0
VS24 6 s24 0
R24 s24 4 12e3
VS25 12 s25 0
R25 s25 17 47e3
VS26 17 s26 0
I26 s26 8 DC 47e-3
.control
set numdgt=17
op
print v(1) v(2) v(3) v(4) v(5) v(6) v(7) v(8) v(9) v(10)
print v(11) v(12) v(13) v(14) v(15) v(16) v(17)
print i(vs0) i(vs1) i(vs2) i(vs3) i(vs4) i(vs5) i(vs6) i(vs7) i(vs8) i(vs9)
print i(vs10) i(vs11) i(vs12) i(vs13) i(vs14) i(vs15) i(vs16) i(vs17) i(vs18) i(vs19)
print i(vs20) i(vs21) i(vs22) i(vs23) i(vs24) i(vs25) i(vs26)
.endc
.end
