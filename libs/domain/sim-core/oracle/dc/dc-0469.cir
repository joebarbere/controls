controls oracle dc-0469
* Generated (plan F2.7, ADR 0012): do not edit; regenerate with `pnpm sim oracle regen`. dc seed 20261030 index 469 nodes 26 elements 41
.options sparse gmin=1e-12 noopac
RG1 1 0 1000000000000
RG2 2 0 1000000000000
RG3 3 0 1000000000000
RG4 4 0 1000000000000
RG5 5 0 1000000000000
RG6 6 0 1000000000000
RG7 7 0 1000000000000
RG8 8 0 1000000000000
RG9 9 0 1000000000000
RG10 10 0 1000000000000
RG11 11 0 1000000000000
RG12 12 0 1000000000000
RG13 13 0 1000000000000
RG14 14 0 1000000000000
RG15 15 0 1000000000000
RG16 16 0 1000000000000
RG17 17 0 1000000000000
RG18 18 0 1000000000000
RG19 19 0 1000000000000
RG20 20 0 1000000000000
RG21 21 0 1000000000000
RG22 22 0 1000000000000
RG23 23 0 1000000000000
RG24 24 0 1000000000000
RG25 25 0 1000000000000
VS0 0 s0 0
R0 s0 6 33e1
VS1 2 s1 0
R1 s1 19 47e2
VS2 0 s2 0
V2 e2 s2 DC 56e0
RI2 e2 9 39e-3
VS3 0 s3 0
I3 s3 7 DC 82e-1
VS4 22 s4 0
I4 s4 9 DC 39e-1
VS5 15 s5 0
R5 s5 6 39e0
VS6 7 s6 0
R6 s6 8 39e3
VS7 22 s7 0
V7 e7 s7 DC 12e-1
RI7 e7 23 18e-1
VS8 13 s8 0
R8 s8 16 68e-1
VS9 14 s9 0
R9 s9 15 15e1
VS10 7 s10 0
R10 s10 21 82e1
VS11 10 s11 0
R11 s11 9 18e0
VS12 20 s12 0
R12 s12 13 18e-1
VS13 7 s13 0
R13 s13 18 82e1
VS14 21 s14 0
R14 s14 5 22e1
VS15 1 s15 0
V15 e15 s15 DC 22e1
RI15 e15 11 56e-2
VS16 8 s16 0
I16 s16 19 DC 56e-4
VS17 2 s17 0
I17 s17 10 DC 12e-4
VS18 15 s18 0
R18 s18 4 15e0
VS19 20 s19 0
V19 e19 s19 DC 39e1
RI19 e19 23 82e-3
VS20 4 s20 0
V20 e20 s20 DC 47e-1
RI20 e20 25 27e-1
VS21 9 s21 0
R21 s21 18 27e1
VS22 0 s22 0
I22 s22 6 DC 33e-3
VS23 2 s23 0
R23 s23 12 68e0
VS24 17 s24 0
R24 s24 25 56e0
VS25 9 s25 0
R25 s25 5 18e1
VS26 10 s26 0
R26 s26 16 18e1
VS27 18 s27 0
R27 s27 24 33e-1
VS28 19 s28 0
R28 s28 4 10e-2
VS29 0 s29 0
I29 s29 22 DC 10e-2
VS30 21 s30 0
R30 s30 11 39e2
VS31 1 s31 0
I31 s31 22 DC 22e-2
VS32 19 s32 0
V32 e32 s32 DC 12e1
RI32 e32 14 68e-1
VS33 6 s33 0
R33 s33 21 33e3
VS34 15 s34 0
R34 s34 9 15e1
VS35 16 s35 0
R35 s35 21 47e0
VS36 3 s36 0
R36 s36 18 68e2
VS37 11 s37 0
V37 e37 s37 DC 27e0
RI37 e37 25 56e-1
VS38 15 s38 0
R38 s38 6 39e-2
VS39 18 s39 0
R39 s39 20 56e0
VS40 4 s40 0
R40 s40 20 27e-2
.control
set numdgt=17
op
print v(1) v(2) v(3) v(4) v(5) v(6) v(7) v(8) v(9) v(10)
print v(11) v(12) v(13) v(14) v(15) v(16) v(17) v(18) v(19) v(20)
print v(21) v(22) v(23) v(24) v(25)
print i(vs0) i(vs1) i(vs2) i(vs3) i(vs4) i(vs5) i(vs6) i(vs7) i(vs8) i(vs9)
print i(vs10) i(vs11) i(vs12) i(vs13) i(vs14) i(vs15) i(vs16) i(vs17) i(vs18) i(vs19)
print i(vs20) i(vs21) i(vs22) i(vs23) i(vs24) i(vs25) i(vs26) i(vs27) i(vs28) i(vs29)
print i(vs30) i(vs31) i(vs32) i(vs33) i(vs34) i(vs35) i(vs36) i(vs37) i(vs38) i(vs39)
print i(vs40)
.endc
.end
