controls oracle dc-0457
* Generated (plan F2.7, ADR 0012): do not edit; regenerate with `pnpm sim oracle regen`. dc seed 20261030 index 457 nodes 11 elements 20
.options sparse gmin=1e-12 noopac
RG1 1 0 1000000000000
RG2 2 0 1000000000000
RG3 3 0 1000000000000
RG4 4 0 1000000000000
RG5 5 0 1000000000000
RG6 6 0 1000000000000
RG7 7 0 1000000000000
RG8 8 0 1000000000000
RG9 9 0 1000000000000
RG10 10 0 1000000000000
VS0 3 s0 0
R0 s0 0 27e2
VS1 9 s1 0
R1 s1 4 15e-1
VS2 0 s2 0
V2 e2 s2 DC 18e-1
RI2 e2 5 68e-1
VS3 10 s3 0
R3 s3 6 56e-1
VS4 8 s4 0
R4 s4 9 22e-2
VS5 6 s5 0
R5 s5 1 18e2
VS6 7 s6 0
V6 e6 s6 DC 22e-1
RI6 e6 8 68e-2
VS7 9 s7 0
R7 s7 10 82e0
VS8 6 s8 0
R8 s8 5 39e0
VS9 0 s9 0
R9 s9 10 27e-2
VS10 3 s10 0
I10 s10 1 DC 12e-2
VS11 10 s11 0
R11 s11 4 15e1
VS12 3 s12 0
R12 s12 6 18e-1
VS13 8 s13 0
R13 s13 1 56e3
VS14 10 s14 0
I14 s14 1 DC 68e-2
VS15 10 s15 0
R15 s15 2 18e3
VS16 7 s16 0
V16 e16 s16 DC 56e1
RI16 e16 10 47e-3
VS17 4 s17 0
I17 s17 7 DC 68e-3
VS18 7 s18 0
V18 e18 s18 DC 33e1
RI18 e18 10 82e-3
VS19 7 s19 0
R19 s19 3 47e3
.control
set numdgt=17
op
print v(1) v(2) v(3) v(4) v(5) v(6) v(7) v(8) v(9) v(10)
print i(vs0) i(vs1) i(vs2) i(vs3) i(vs4) i(vs5) i(vs6) i(vs7) i(vs8) i(vs9)
print i(vs10) i(vs11) i(vs12) i(vs13) i(vs14) i(vs15) i(vs16) i(vs17) i(vs18) i(vs19)
.endc
.end
