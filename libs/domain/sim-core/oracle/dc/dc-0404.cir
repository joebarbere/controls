controls oracle dc-0404
* Generated (plan F2.7, ADR 0012): do not edit; regenerate with `pnpm sim oracle regen`. dc seed 20261030 index 404 nodes 8 elements 16
.options sparse gmin=1e-12 noopac
RG1 1 0 1000000000000
RG2 2 0 1000000000000
RG3 3 0 1000000000000
RG4 4 0 1000000000000
RG5 5 0 1000000000000
RG6 6 0 1000000000000
RG7 7 0 1000000000000
VS0 0 s0 0
I0 s0 6 DC 18e-1
VS1 7 s1 0
I1 s1 2 DC 10e-1
VS2 2 s2 0
R2 s2 3 15e-2
VS3 0 s3 0
R3 s3 2 27e0
VS4 7 s4 0
R4 s4 3 22e2
VS5 5 s5 0
R5 s5 6 22e0
VS6 1 s6 0
R6 s6 5 22e0
VS7 5 s7 0
R7 s7 7 56e-2
VS8 1 s8 0
R8 s8 6 27e0
VS9 0 s9 0
V9 e9 s9 DC 56e1
RI9 e9 4 68e-1
VS10 7 s10 0
I10 s10 1 DC 33e-1
VS11 3 s11 0
R11 s11 7 82e2
VS12 5 s12 0
V12 e12 s12 DC 15e0
RI12 e12 7 39e-2
VS13 1 s13 0
R13 s13 4 82e1
VS14 0 s14 0
V14 e14 s14 DC 68e1
RI14 e14 5 56e-1
VS15 0 s15 0
V15 e15 s15 DC 68e0
RI15 e15 5 27e-1
.control
set numdgt=17
op
print v(1) v(2) v(3) v(4) v(5) v(6) v(7)
print i(vs0) i(vs1) i(vs2) i(vs3) i(vs4) i(vs5) i(vs6) i(vs7) i(vs8) i(vs9)
print i(vs10) i(vs11) i(vs12) i(vs13) i(vs14) i(vs15)
.endc
.end
