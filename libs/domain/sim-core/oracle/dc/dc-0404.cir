controls oracle dc-0404
* Generated (plan F2.7, ADR 0012): do not edit; regenerate with `pnpm sim oracle regen`. dc seed 20261030 index 404 nodes 8 elements 15
.options sparse gmin=1e-12 noopac
RG1 1 0 1000000000000
RG2 2 0 1000000000000
RG3 3 0 1000000000000
RG4 4 0 1000000000000
RG5 5 0 1000000000000
RG6 6 0 1000000000000
RG7 7 0 1000000000000
VS0 0 s0 0
V0 e0 s0 DC 68e0
RI0 e0 5 27e-1
VS1 0 s1 0
R1 s1 2 27e0
VS2 0 s2 0
I2 s2 6 DC 18e-1
VS3 5 s3 0
V3 e3 s3 DC 15e0
RI3 e3 7 39e-2
VS4 0 s4 0
V4 e4 s4 DC 68e1
RI4 e4 5 56e-1
VS5 1 s5 0
R5 s5 5 22e0
VS6 5 s6 0
R6 s6 7 56e-2
VS7 5 s7 0
R7 s7 6 22e0
VS8 2 s8 0
R8 s8 3 15e-2
VS9 1 s9 0
R9 s9 4 82e1
VS10 1 s10 0
R10 s10 6 27e0
VS11 7 s11 0
R11 s11 3 22e2
VS12 7 s12 0
I12 s12 1 DC 33e-1
VS13 3 s13 0
R13 s13 7 82e2
VS14 7 s14 0
I14 s14 2 DC 10e-1
.control
set numdgt=17
op
print v(1) v(2) v(3) v(4) v(5) v(6) v(7)
print i(vs0) i(vs1) i(vs2) i(vs3) i(vs4) i(vs5) i(vs6) i(vs7) i(vs8) i(vs9)
print i(vs10) i(vs11) i(vs12) i(vs13) i(vs14)
.endc
.end
