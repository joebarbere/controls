controls oracle dc-0379
* Generated (plan F2.7, ADR 0012): do not edit; regenerate with `pnpm sim oracle regen`. dc seed 20261030 index 379 nodes 3 elements 3
.options sparse gmin=1e-12 noopac
RG1 1 0 1000000000000
RG2 2 0 1000000000000
VS0 2 s0 0
R0 s0 1 10e-2
VS1 1 s1 0
R1 s1 0 47e2
VS2 0 s2 0
V2 e2 s2 DC 68e1
RI2 e2 2 47e-2
.control
set numdgt=17
op
print v(1) v(2)
print i(vs0) i(vs1) i(vs2)
.endc
.end
