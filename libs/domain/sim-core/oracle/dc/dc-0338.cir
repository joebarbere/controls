controls oracle dc-0338
* Generated (plan F2.7, ADR 0012): do not edit; regenerate with `pnpm sim oracle regen`. dc seed 20261030 index 338 nodes 25 elements 42
.options sparse gmin=1e-12 noopac
RG1 1 0 1000000000000
RG2 2 0 1000000000000
RG3 3 0 1000000000000
RG4 4 0 1000000000000
RG5 5 0 1000000000000
RG6 6 0 1000000000000
RG7 7 0 1000000000000
RG8 8 0 1000000000000
RG9 9 0 1000000000000
RG10 10 0 1000000000000
RG11 11 0 1000000000000
RG12 12 0 1000000000000
RG13 13 0 1000000000000
RG14 14 0 1000000000000
RG15 15 0 1000000000000
RG16 16 0 1000000000000
RG17 17 0 1000000000000
RG18 18 0 1000000000000
RG19 19 0 1000000000000
RG20 20 0 1000000000000
RG21 21 0 1000000000000
RG22 22 0 1000000000000
RG23 23 0 1000000000000
RG24 24 0 1000000000000
VS0 13 s0 0
R0 s0 3 22e2
VS1 23 s1 0
R1 s1 15 33e0
VS2 0 s2 0
R2 s2 15 82e1
VS3 4 s3 0
R3 s3 16 47e-2
VS4 16 s4 0
R4 s4 20 22e-2
VS5 13 s5 0
R5 s5 16 18e-1
VS6 18 s6 0
R6 s6 0 82e3
VS7 4 s7 0
R7 s7 13 27e2
VS8 16 s8 0
I8 s8 5 DC 33e-3
VS9 0 s9 0
V9 e9 s9 DC 39e-1
RI9 e9 6 47e-3
VS10 6 s10 0
R10 s10 21 39e-1
VS11 16 s11 0
R11 s11 12 27e2
VS12 11 s12 0
R12 s12 20 39e1
VS13 2 s13 0
R13 s13 14 10e1
VS14 19 s14 0
R14 s14 5 12e-2
VS15 17 s15 0
V15 e15 s15 DC 12e1
RI15 e15 24 18e-2
VS16 24 s16 0
V16 e16 s16 DC 12e-1
RI16 e16 11 15e-1
VS17 7 s17 0
R17 s17 13 47e1
VS18 3 s18 0
R18 s18 15 12e3
VS19 13 s19 0
R19 s19 21 39e-2
VS20 9 s20 0
R20 s20 18 47e-1
VS21 12 s21 0
R21 s21 8 10e-2
VS22 11 s22 0
R22 s22 1 12e0
VS23 10 s23 0
R23 s23 22 12e0
VS24 0 s24 0
R24 s24 6 12e-1
VS25 13 s25 0
R25 s25 24 33e2
VS26 24 s26 0
R26 s26 3 27e-2
VS27 9 s27 0
R27 s27 4 68e2
VS28 8 s28 0
R28 s28 12 15e3
VS29 3 s29 0
V29 e29 s29 DC 22e0
RI29 e29 19 33e-2
VS30 22 s30 0
R30 s30 24 18e1
VS31 18 s31 0
R31 s31 24 68e1
VS32 7 s32 0
V32 e32 s32 DC 47e0
RI32 e32 18 10e-1
VS33 13 s33 0
R33 s33 9 10e3
VS34 9 s34 0
V34 e34 s34 DC 18e0
RI34 e34 20 82e-1
VS35 3 s35 0
R35 s35 6 39e3
VS36 2 s36 0
I36 s36 23 DC 39e-3
VS37 7 s37 0
R37 s37 14 18e3
VS38 9 s38 0
I38 s38 0 DC 68e-1
VS39 11 s39 0
R39 s39 8 47e2
VS40 2 s40 0
R40 s40 10 39e-2
VS41 10 s41 0
V41 e41 s41 DC 27e1
RI41 e41 14 18e-2
.control
set numdgt=17
op
print v(1) v(2) v(3) v(4) v(5) v(6) v(7) v(8) v(9) v(10)
print v(11) v(12) v(13) v(14) v(15) v(16) v(17) v(18) v(19) v(20)
print v(21) v(22) v(23) v(24)
print i(vs0) i(vs1) i(vs2) i(vs3) i(vs4) i(vs5) i(vs6) i(vs7) i(vs8) i(vs9)
print i(vs10) i(vs11) i(vs12) i(vs13) i(vs14) i(vs15) i(vs16) i(vs17) i(vs18) i(vs19)
print i(vs20) i(vs21) i(vs22) i(vs23) i(vs24) i(vs25) i(vs26) i(vs27) i(vs28) i(vs29)
print i(vs30) i(vs31) i(vs32) i(vs33) i(vs34) i(vs35) i(vs36) i(vs37) i(vs38) i(vs39)
print i(vs40) i(vs41)
.endc
.end
