controls oracle dc-0338
* Generated (plan F2.7, ADR 0012): do not edit; regenerate with `pnpm sim oracle regen`. dc seed 20261030 index 338 nodes 25 elements 45
.options sparse gmin=1e-12 noopac
RG1 1 0 1000000000000
RG2 2 0 1000000000000
RG3 3 0 1000000000000
RG4 4 0 1000000000000
RG5 5 0 1000000000000
RG6 6 0 1000000000000
RG7 7 0 1000000000000
RG8 8 0 1000000000000
RG9 9 0 1000000000000
RG10 10 0 1000000000000
RG11 11 0 1000000000000
RG12 12 0 1000000000000
RG13 13 0 1000000000000
RG14 14 0 1000000000000
RG15 15 0 1000000000000
RG16 16 0 1000000000000
RG17 17 0 1000000000000
RG18 18 0 1000000000000
RG19 19 0 1000000000000
RG20 20 0 1000000000000
RG21 21 0 1000000000000
RG22 22 0 1000000000000
RG23 23 0 1000000000000
RG24 24 0 1000000000000
VS0 4 s0 0
R0 s0 16 47e-2
VS1 2 s1 0
I1 s1 23 DC 39e-3
VS2 0 s2 0
V2 e2 s2 DC 39e-1
RI2 e2 6 47e-3
VS3 7 s3 0
R3 s3 14 18e3
VS4 11 s4 0
R4 s4 8 47e2
VS5 7 s5 0
R5 s5 13 47e1
VS6 16 s6 0
R6 s6 12 27e2
VS7 23 s7 0
R7 s7 15 33e0
VS8 8 s8 0
R8 s8 12 15e3
VS9 9 s9 0
R9 s9 4 68e2
VS10 0 s10 0
R10 s10 15 82e1
VS11 18 s11 0
R11 s11 0 82e3
VS12 9 s12 0
I12 s12 0 DC 68e-1
VS13 13 s13 0
R13 s13 9 10e3
VS14 7 s14 0
V14 e14 s14 DC 47e0
RI14 e14 18 10e-1
VS15 10 s15 0
V15 e15 s15 DC 27e1
RI15 e15 14 18e-2
VS16 22 s16 0
R16 s16 24 18e1
VS17 9 s17 0
V17 e17 s17 DC 18e0
RI17 e17 20 82e-1
VS18 0 s18 0
R18 s18 6 12e-1
VS19 9 s19 0
R19 s19 18 47e-1
VS20 13 s20 0
R20 s20 21 39e-2
VS21 16 s21 0
I21 s21 5 DC 33e-3
VS22 19 s22 0
R22 s22 5 12e-2
VS23 2 s23 0
R23 s23 10 39e-2
VS24 18 s24 0
R24 s24 24 68e1
VS25 3 s25 0
R25 s25 6 39e3
VS26 16 s26 0
R26 s26 20 22e-2
VS27 13 s27 0
R27 s27 16 18e-1
VS28 13 s28 0
R28 s28 24 33e2
VS29 24 s29 0
R29 s29 3 27e-2
VS30 13 s30 0
R30 s30 3 22e2
VS31 3 s31 0
R31 s31 15 12e3
VS32 20 s32 0
R32 s32 1 82e-1
VS33 4 s33 0
R33 s33 13 27e2
VS34 5 s34 0
R34 s34 10 56e-2
VS35 3 s35 0
V35 e35 s35 DC 22e0
RI35 e35 19 33e-2
VS36 6 s36 0
R36 s36 21 39e-1
VS37 23 s37 0
V37 e37 s37 DC 15e0
RI37 e37 17 18e-1
VS38 24 s38 0
V38 e38 s38 DC 12e-1
RI38 e38 11 15e-1
VS39 2 s39 0
R39 s39 14 10e1
VS40 11 s40 0
R40 s40 20 39e1
VS41 12 s41 0
R41 s41 8 10e-2
VS42 10 s42 0
R42 s42 22 12e0
VS43 17 s43 0
V43 e43 s43 DC 12e1
RI43 e43 24 18e-2
VS44 11 s44 0
R44 s44 1 12e0
.control
set numdgt=17
op
print v(1) v(2) v(3) v(4) v(5) v(6) v(7) v(8) v(9) v(10)
print v(11) v(12) v(13) v(14) v(15) v(16) v(17) v(18) v(19) v(20)
print v(21) v(22) v(23) v(24)
print i(vs0) i(vs1) i(vs2) i(vs3) i(vs4) i(vs5) i(vs6) i(vs7) i(vs8) i(vs9)
print i(vs10) i(vs11) i(vs12) i(vs13) i(vs14) i(vs15) i(vs16) i(vs17) i(vs18) i(vs19)
print i(vs20) i(vs21) i(vs22) i(vs23) i(vs24) i(vs25) i(vs26) i(vs27) i(vs28) i(vs29)
print i(vs30) i(vs31) i(vs32) i(vs33) i(vs34) i(vs35) i(vs36) i(vs37) i(vs38) i(vs39)
print i(vs40) i(vs41) i(vs42) i(vs43) i(vs44)
.endc
.end
