controls oracle dc-0050
* Generated (plan F2.7, ADR 0012): do not edit; regenerate with `pnpm sim oracle regen`. dc seed 20261030 index 50 nodes 7 elements 14
.options sparse gmin=1e-12 noopac
RG1 1 0 1000000000000
RG2 2 0 1000000000000
RG3 3 0 1000000000000
RG4 4 0 1000000000000
RG5 5 0 1000000000000
RG6 6 0 1000000000000
VS0 4 s0 0
R0 s0 3 10e-2
VS1 0 s1 0
V1 e1 s1 DC 82e0
RI1 e1 6 39e-1
VS2 6 s2 0
V2 e2 s2 DC 47e0
RI2 e2 4 33e-3
VS3 3 s3 0
R3 s3 5 10e3
VS4 5 s4 0
R4 s4 1 39e0
VS5 2 s5 0
R5 s5 4 18e0
VS6 1 s6 0
R6 s6 0 39e0
VS7 0 s7 0
V7 e7 s7 DC 47e1
RI7 e7 6 68e-1
VS8 1 s8 0
R8 s8 2 18e-1
VS9 3 s9 0
V9 e9 s9 DC 12e0
RI9 e9 0 18e-2
VS10 1 s10 0
R10 s10 3 12e3
VS11 2 s11 0
R11 s11 4 27e1
VS12 5 s12 0
I12 s12 2 DC 10e-4
VS13 3 s13 0
R13 s13 4 56e1
.control
set numdgt=17
op
print v(1) v(2) v(3) v(4) v(5) v(6)
print i(vs0) i(vs1) i(vs2) i(vs3) i(vs4) i(vs5) i(vs6) i(vs7) i(vs8) i(vs9)
print i(vs10) i(vs11) i(vs12) i(vs13)
.endc
.end
