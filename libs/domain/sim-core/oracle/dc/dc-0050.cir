controls oracle dc-0050
* Generated (plan F2.7, ADR 0012): do not edit; regenerate with `pnpm sim oracle regen`. dc seed 20261030 index 50 nodes 7 elements 12
.options sparse gmin=1e-12 noopac
RG1 1 0 1000000000000
RG2 2 0 1000000000000
RG3 3 0 1000000000000
RG4 4 0 1000000000000
RG5 5 0 1000000000000
RG6 6 0 1000000000000
VS0 2 s0 0
R0 s0 4 18e0
VS1 2 s1 0
R1 s1 4 27e1
VS2 1 s2 0
R2 s2 0 12e3
VS3 1 s3 0
R3 s3 6 39e0
VS4 0 s4 0
V4 e4 s4 DC 12e0
RI4 e4 6 18e-2
VS5 6 s5 0
V5 e5 s5 DC 82e0
RI5 e5 3 39e-1
VS6 5 s6 0
I6 s6 2 DC 10e-4
VS7 4 s7 0
R7 s7 0 10e-2
VS8 3 s8 0
V8 e8 s8 DC 47e0
RI8 e8 4 33e-3
VS9 6 s9 0
V9 e9 s9 DC 47e1
RI9 e9 3 68e-1
VS10 0 s10 0
R10 s10 5 10e3
VS11 0 s11 0
R11 s11 4 56e1
.control
set numdgt=17
op
print v(1) v(2) v(3) v(4) v(5) v(6)
print i(vs0) i(vs1) i(vs2) i(vs3) i(vs4) i(vs5) i(vs6) i(vs7) i(vs8) i(vs9)
print i(vs10) i(vs11)
.endc
.end
