controls oracle dc-0155
* Generated (plan F2.7, ADR 0012): do not edit; regenerate with `pnpm sim oracle regen`. dc seed 20261030 index 155 nodes 8 elements 8
.options sparse gmin=1e-12 noopac
RG1 1 0 1000000000000
RG2 2 0 1000000000000
RG3 3 0 1000000000000
RG4 4 0 1000000000000
RG5 5 0 1000000000000
RG6 6 0 1000000000000
RG7 7 0 1000000000000
VS0 0 s0 0
V0 e0 s0 DC 10e-1
RI0 e0 3 82e-3
VS1 1 s1 0
R1 s1 2 47e1
VS2 5 s2 0
R2 s2 3 82e2
VS3 0 s3 0
R3 s3 6 47e3
VS4 2 s4 0
R4 s4 0 22e2
VS5 4 s5 0
R5 s5 0 27e-2
VS6 7 s6 0
R6 s6 3 22e0
VS7 2 s7 0
V7 e7 s7 DC 22e0
RI7 e7 0 39e-3
.control
set numdgt=17
op
print v(1) v(2) v(3) v(4) v(5) v(6) v(7)
print i(vs0) i(vs1) i(vs2) i(vs3) i(vs4) i(vs5) i(vs6) i(vs7)
.endc
.end
