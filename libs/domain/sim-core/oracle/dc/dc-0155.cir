controls oracle dc-0155
* Generated (plan F2.7, ADR 0012): do not edit; regenerate with `pnpm sim oracle regen`. dc seed 20261030 index 155 nodes 8 elements 12
.options sparse gmin=1e-12 noopac
RG1 1 0 1000000000000
RG2 2 0 1000000000000
RG3 3 0 1000000000000
RG4 4 0 1000000000000
RG5 5 0 1000000000000
RG6 6 0 1000000000000
RG7 7 0 1000000000000
VS0 1 s0 0
R0 s0 0 47e1
VS1 5 s1 0
R1 s1 7 15e2
VS2 2 s2 0
R2 s2 5 39e2
VS3 5 s3 0
R3 s3 3 82e2
VS4 4 s4 0
R4 s4 2 27e-2
VS5 0 s5 0
V5 e5 s5 DC 56e0
RI5 e5 6 82e-2
VS6 4 s6 0
R6 s6 5 27e1
VS7 2 s7 0
V7 e7 s7 DC 10e-1
RI7 e7 3 82e-3
VS8 0 s8 0
V8 e8 s8 DC 22e0
RI8 e8 2 39e-3
VS9 7 s9 0
R9 s9 3 22e0
VS10 4 s10 0
R10 s10 1 47e-1
VS11 2 s11 0
R11 s11 6 47e3
.control
set numdgt=17
op
print v(1) v(2) v(3) v(4) v(5) v(6) v(7)
print i(vs0) i(vs1) i(vs2) i(vs3) i(vs4) i(vs5) i(vs6) i(vs7) i(vs8) i(vs9)
print i(vs10) i(vs11)
.endc
.end
