controls oracle dc-0327
* Generated (plan F2.7, ADR 0012): do not edit; regenerate with `pnpm sim oracle regen`. dc seed 20261030 index 327 nodes 22 elements 33
.options sparse gmin=1e-12 noopac
RG1 1 0 1000000000000
RG2 2 0 1000000000000
RG3 3 0 1000000000000
RG4 4 0 1000000000000
RG5 5 0 1000000000000
RG6 6 0 1000000000000
RG7 7 0 1000000000000
RG8 8 0 1000000000000
RG9 9 0 1000000000000
RG10 10 0 1000000000000
RG11 11 0 1000000000000
RG12 12 0 1000000000000
RG13 13 0 1000000000000
RG14 14 0 1000000000000
RG15 15 0 1000000000000
RG16 16 0 1000000000000
RG17 17 0 1000000000000
RG18 18 0 1000000000000
RG19 19 0 1000000000000
RG20 20 0 1000000000000
RG21 21 0 1000000000000
VS0 0 s0 0
V0 e0 s0 DC 12e-1
RI0 e0 13 10e-3
VS1 6 s1 0
R1 s1 17 15e-2
VS2 11 s2 0
R2 s2 19 68e-2
VS3 19 s3 0
V3 e3 s3 DC 18e1
RI3 e3 17 27e-2
VS4 20 s4 0
R4 s4 3 22e1
VS5 2 s5 0
I5 s5 5 DC 18e-3
VS6 7 s6 0
R6 s6 12 10e-1
VS7 9 s7 0
R7 s7 0 33e2
VS8 3 s8 0
R8 s8 7 68e0
VS9 10 s9 0
R9 s9 5 15e1
VS10 15 s10 0
R10 s10 3 15e0
VS11 0 s11 0
V11 e11 s11 DC 47e1
RI11 e11 17 56e-3
VS12 18 s12 0
R12 s12 2 27e2
VS13 5 s13 0
R13 s13 4 39e-2
VS14 1 s14 0
I14 s14 2 DC 18e-2
VS15 3 s15 0
I15 s15 10 DC 47e-1
VS16 9 s16 0
R16 s16 6 22e0
VS17 5 s17 0
R17 s17 10 12e-1
VS18 16 s18 0
R18 s18 14 82e3
VS19 18 s19 0
R19 s19 0 33e-2
VS20 16 s20 0
I20 s20 5 DC 27e-2
VS21 14 s21 0
R21 s21 21 68e3
VS22 21 s22 0
V22 e22 s22 DC 22e1
RI22 e22 0 15e-2
VS23 18 s23 0
R23 s23 1 15e1
VS24 7 s24 0
R24 s24 14 22e-1
VS25 14 s25 0
R25 s25 11 56e0
VS26 4 s26 0
R26 s26 20 39e3
VS27 8 s27 0
R27 s27 3 10e2
VS28 9 s28 0
R28 s28 17 82e3
VS29 18 s29 0
R29 s29 15 12e1
VS30 21 s30 0
R30 s30 7 68e3
VS31 11 s31 0
V31 e31 s31 DC 22e0
RI31 e31 5 47e-2
VS32 7 s32 0
R32 s32 8 68e-1
.control
set numdgt=17
op
print v(1) v(2) v(3) v(4) v(5) v(6) v(7) v(8) v(9) v(10)
print v(11) v(12) v(13) v(14) v(15) v(16) v(17) v(18) v(19) v(20)
print v(21)
print i(vs0) i(vs1) i(vs2) i(vs3) i(vs4) i(vs5) i(vs6) i(vs7) i(vs8) i(vs9)
print i(vs10) i(vs11) i(vs12) i(vs13) i(vs14) i(vs15) i(vs16) i(vs17) i(vs18) i(vs19)
print i(vs20) i(vs21) i(vs22) i(vs23) i(vs24) i(vs25) i(vs26) i(vs27) i(vs28) i(vs29)
print i(vs30) i(vs31) i(vs32)
.endc
.end
