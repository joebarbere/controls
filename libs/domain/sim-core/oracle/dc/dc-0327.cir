controls oracle dc-0327
* Generated (plan F2.7, ADR 0012): do not edit; regenerate with `pnpm sim oracle regen`. dc seed 20261030 index 327 nodes 22 elements 38
.options sparse gmin=1e-12 noopac
RG1 1 0 1000000000000
RG2 2 0 1000000000000
RG3 3 0 1000000000000
RG4 4 0 1000000000000
RG5 5 0 1000000000000
RG6 6 0 1000000000000
RG7 7 0 1000000000000
RG8 8 0 1000000000000
RG9 9 0 1000000000000
RG10 10 0 1000000000000
RG11 11 0 1000000000000
RG12 12 0 1000000000000
RG13 13 0 1000000000000
RG14 14 0 1000000000000
RG15 15 0 1000000000000
RG16 16 0 1000000000000
RG17 17 0 1000000000000
RG18 18 0 1000000000000
RG19 19 0 1000000000000
RG20 20 0 1000000000000
RG21 21 0 1000000000000
VS0 1 s0 0
I0 s0 2 DC 18e-2
VS1 21 s1 0
R1 s1 7 68e3
VS2 0 s2 0
V2 e2 s2 DC 12e0
RI2 e2 12 15e-1
VS3 18 s3 0
R3 s3 2 27e2
VS4 16 s4 0
R4 s4 2 10e2
VS5 3 s5 0
R5 s5 7 68e0
VS6 21 s6 0
V6 e6 s6 DC 22e1
RI6 e6 0 15e-2
VS7 3 s7 0
I7 s7 10 DC 47e-1
VS8 5 s8 0
R8 s8 10 12e-1
VS9 14 s9 0
R9 s9 21 68e3
VS10 11 s10 0
R10 s10 19 68e-2
VS11 19 s11 0
V11 e11 s11 DC 18e1
RI11 e11 17 27e-2
VS12 16 s12 0
R12 s12 14 82e3
VS13 1 s13 0
R13 s13 20 82e-1
VS14 9 s14 0
R14 s14 17 82e3
VS15 4 s15 0
R15 s15 20 39e3
VS16 11 s16 0
V16 e16 s16 DC 22e0
RI16 e16 5 47e-2
VS17 7 s17 0
R17 s17 8 68e-1
VS18 8 s18 0
R18 s18 3 10e2
VS19 0 s19 0
V19 e19 s19 DC 12e-1
RI19 e19 13 10e-3
VS20 5 s20 0
R20 s20 4 39e-2
VS21 0 s21 0
V21 e21 s21 DC 47e1
RI21 e21 17 56e-3
VS22 10 s22 0
R22 s22 17 27e3
VS23 7 s23 0
R23 s23 14 22e-1
VS24 6 s24 0
R24 s24 17 15e-2
VS25 10 s25 0
R25 s25 5 15e1
VS26 9 s26 0
R26 s26 0 33e2
VS27 18 s27 0
R27 s27 1 15e1
VS28 16 s28 0
R28 s28 13 10e-1
VS29 9 s29 0
R29 s29 6 22e0
VS30 2 s30 0
I30 s30 5 DC 18e-3
VS31 18 s31 0
R31 s31 15 12e1
VS32 16 s32 0
I32 s32 5 DC 27e-2
VS33 7 s33 0
R33 s33 12 10e-1
VS34 15 s34 0
R34 s34 3 15e0
VS35 14 s35 0
R35 s35 11 56e0
VS36 20 s36 0
R36 s36 3 22e1
VS37 18 s37 0
R37 s37 0 33e-2
.control
set numdgt=17
op
print v(1) v(2) v(3) v(4) v(5) v(6) v(7) v(8) v(9) v(10)
print v(11) v(12) v(13) v(14) v(15) v(16) v(17) v(18) v(19) v(20)
print v(21)
print i(vs0) i(vs1) i(vs2) i(vs3) i(vs4) i(vs5) i(vs6) i(vs7) i(vs8) i(vs9)
print i(vs10) i(vs11) i(vs12) i(vs13) i(vs14) i(vs15) i(vs16) i(vs17) i(vs18) i(vs19)
print i(vs20) i(vs21) i(vs22) i(vs23) i(vs24) i(vs25) i(vs26) i(vs27) i(vs28) i(vs29)
print i(vs30) i(vs31) i(vs32) i(vs33) i(vs34) i(vs35) i(vs36) i(vs37)
.endc
.end
