controls oracle dc-0193
* Generated (plan F2.7, ADR 0012): do not edit; regenerate with `pnpm sim oracle regen`. dc seed 20261030 index 193 nodes 12 elements 15
.options sparse gmin=1e-12 noopac
RG1 1 0 1000000000000
RG2 2 0 1000000000000
RG3 3 0 1000000000000
RG4 4 0 1000000000000
RG5 5 0 1000000000000
RG6 6 0 1000000000000
RG7 7 0 1000000000000
RG8 8 0 1000000000000
RG9 9 0 1000000000000
RG10 10 0 1000000000000
RG11 11 0 1000000000000
VS0 7 s0 0
R0 s0 0 27e3
VS1 0 s1 0
V1 e1 s1 DC 10e1
RI1 e1 7 15e-3
VS2 3 s2 0
R2 s2 7 39e-2
VS3 10 s3 0
R3 s3 5 82e2
VS4 7 s4 0
R4 s4 11 12e0
VS5 10 s5 0
R5 s5 8 68e-2
VS6 2 s6 0
R6 s6 5 12e3
VS7 10 s7 0
R7 s7 6 56e-2
VS8 6 s8 0
R8 s8 9 27e-1
VS9 4 s9 0
R9 s9 2 68e-2
VS10 11 s10 0
R10 s10 9 47e3
VS11 10 s11 0
R11 s11 5 18e-2
VS12 6 s12 0
R12 s12 10 10e2
VS13 7 s13 0
R13 s13 9 47e-1
VS14 1 s14 0
R14 s14 9 68e3
.control
set numdgt=17
op
print v(1) v(2) v(3) v(4) v(5) v(6) v(7) v(8) v(9) v(10)
print v(11)
print i(vs0) i(vs1) i(vs2) i(vs3) i(vs4) i(vs5) i(vs6) i(vs7) i(vs8) i(vs9)
print i(vs10) i(vs11) i(vs12) i(vs13) i(vs14)
.endc
.end
