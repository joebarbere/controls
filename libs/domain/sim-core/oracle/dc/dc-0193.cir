controls oracle dc-0193
* Generated (plan F2.7, ADR 0012): do not edit; regenerate with `pnpm sim oracle regen`. dc seed 20261030 index 193 nodes 12 elements 18
.options sparse gmin=1e-12 noopac
RG1 1 0 1000000000000
RG2 2 0 1000000000000
RG3 3 0 1000000000000
RG4 4 0 1000000000000
RG5 5 0 1000000000000
RG6 6 0 1000000000000
RG7 7 0 1000000000000
RG8 8 0 1000000000000
RG9 9 0 1000000000000
RG10 10 0 1000000000000
RG11 11 0 1000000000000
VS0 11 s0 0
R0 s0 3 47e3
VS1 2 s1 0
R1 s1 5 12e3
VS2 9 s2 0
R2 s2 3 33e3
VS3 0 s3 0
V3 e3 s3 DC 47e-1
RI3 e3 4 47e-1
VS4 10 s4 0
R4 s4 8 68e-2
VS5 6 s5 0
R5 s5 3 27e-1
VS6 8 s6 0
R6 s6 0 12e1
VS7 6 s7 0
R7 s7 10 10e2
VS8 10 s8 0
R8 s8 5 82e2
VS9 7 s9 0
R9 s9 11 12e0
VS10 9 s10 0
V10 e10 s10 DC 10e1
RI10 e10 7 15e-3
VS11 4 s11 0
R11 s11 2 68e-2
VS12 7 s12 0
R12 s12 3 47e-1
VS13 0 s13 0
R13 s13 7 39e-2
VS14 1 s14 0
R14 s14 3 68e3
VS15 1 s15 0
R15 s15 7 56e0
VS16 10 s16 0
R16 s16 6 56e-2
VS17 10 s17 0
R17 s17 5 18e-2
.control
set numdgt=17
op
print v(1) v(2) v(3) v(4) v(5) v(6) v(7) v(8) v(9) v(10)
print v(11)
print i(vs0) i(vs1) i(vs2) i(vs3) i(vs4) i(vs5) i(vs6) i(vs7) i(vs8) i(vs9)
print i(vs10) i(vs11) i(vs12) i(vs13) i(vs14) i(vs15) i(vs16) i(vs17)
.endc
.end
