controls oracle dc-0115
* Generated (plan F2.7, ADR 0012): do not edit; regenerate with `pnpm sim oracle regen`. dc seed 20261030 index 115 nodes 17 elements 33
.options sparse gmin=1e-12 noopac
RG1 1 0 1000000000000
RG2 2 0 1000000000000
RG3 3 0 1000000000000
RG4 4 0 1000000000000
RG5 5 0 1000000000000
RG6 6 0 1000000000000
RG7 7 0 1000000000000
RG8 8 0 1000000000000
RG9 9 0 1000000000000
RG10 10 0 1000000000000
RG11 11 0 1000000000000
RG12 12 0 1000000000000
RG13 13 0 1000000000000
RG14 14 0 1000000000000
RG15 15 0 1000000000000
RG16 16 0 1000000000000
VS0 15 s0 0
R0 s0 11 10e-1
VS1 4 s1 0
R1 s1 10 18e-2
VS2 0 s2 0
R2 s2 14 15e2
VS3 8 s3 0
R3 s3 11 47e-1
VS4 0 s4 0
V4 e4 s4 DC 39e-1
RI4 e4 12 33e-3
VS5 5 s5 0
R5 s5 13 47e3
VS6 4 s6 0
R6 s6 3 47e3
VS7 0 s7 0
R7 s7 8 27e2
VS8 16 s8 0
I8 s8 6 DC 33e-3
VS9 3 s9 0
R9 s9 6 68e1
VS10 11 s10 0
R10 s10 2 82e0
VS11 2 s11 0
R11 s11 16 22e0
VS12 9 s12 0
V12 e12 s12 DC 27e0
RI12 e12 12 56e-3
VS13 1 s13 0
I13 s13 15 DC 47e-2
VS14 7 s14 0
R14 s14 13 22e-2
VS15 2 s15 0
R15 s15 14 39e2
VS16 10 s16 0
I16 s16 7 DC 15e-2
VS17 4 s17 0
V17 e17 s17 DC 12e0
RI17 e17 14 39e-1
VS18 8 s18 0
V18 e18 s18 DC 39e1
RI18 e18 5 68e-2
VS19 7 s19 0
R19 s19 9 47e-1
VS20 1 s20 0
R20 s20 7 56e3
VS21 1 s21 0
R21 s21 3 56e3
VS22 14 s22 0
I22 s22 0 DC 12e-2
VS23 7 s23 0
R23 s23 11 68e1
VS24 11 s24 0
R24 s24 5 27e1
VS25 13 s25 0
I25 s25 16 DC 39e-4
VS26 6 s26 0
V26 e26 s26 DC 68e-1
RI26 e26 7 12e-1
VS27 14 s27 0
V27 e27 s27 DC 15e1
RI27 e27 9 27e-2
VS28 2 s28 0
V28 e28 s28 DC 56e-1
RI28 e28 16 10e-3
VS29 2 s29 0
R29 s29 14 33e0
VS30 7 s30 0
V30 e30 s30 DC 82e0
RI30 e30 16 68e-1
VS31 10 s31 0
R31 s31 15 12e-2
VS32 16 s32 0
R32 s32 4 12e-2
.control
set numdgt=17
op
print v(1) v(2) v(3) v(4) v(5) v(6) v(7) v(8) v(9) v(10)
print v(11) v(12) v(13) v(14) v(15) v(16)
print i(vs0) i(vs1) i(vs2) i(vs3) i(vs4) i(vs5) i(vs6) i(vs7) i(vs8) i(vs9)
print i(vs10) i(vs11) i(vs12) i(vs13) i(vs14) i(vs15) i(vs16) i(vs17) i(vs18) i(vs19)
print i(vs20) i(vs21) i(vs22) i(vs23) i(vs24) i(vs25) i(vs26) i(vs27) i(vs28) i(vs29)
print i(vs30) i(vs31) i(vs32)
.endc
.end
