controls oracle dc-0115
* Generated (plan F2.7, ADR 0012): do not edit; regenerate with `pnpm sim oracle regen`. dc seed 20261030 index 115 nodes 17 elements 32
.options sparse gmin=1e-12 noopac
RG1 1 0 1000000000000
RG2 2 0 1000000000000
RG3 3 0 1000000000000
RG4 4 0 1000000000000
RG5 5 0 1000000000000
RG6 6 0 1000000000000
RG7 7 0 1000000000000
RG8 8 0 1000000000000
RG9 9 0 1000000000000
RG10 10 0 1000000000000
RG11 11 0 1000000000000
RG12 12 0 1000000000000
RG13 13 0 1000000000000
RG14 14 0 1000000000000
RG15 15 0 1000000000000
RG16 16 0 1000000000000
VS0 7 s0 0
R0 s0 2 82e0
VS1 8 s1 0
R1 s1 7 47e-1
VS2 5 s2 0
R2 s2 13 47e3
VS3 10 s3 0
I3 s3 0 DC 15e-2
VS4 0 s4 0
R4 s4 13 22e-2
VS5 1 s5 0
R5 s5 3 56e3
VS6 16 s6 0
I6 s6 6 DC 33e-3
VS7 0 s7 0
V7 e7 s7 DC 82e0
RI7 e7 16 68e-1
VS8 2 s8 0
R8 s8 16 22e0
VS9 2 s9 0
R9 s9 14 33e0
VS10 10 s10 0
R10 s10 15 12e-2
VS11 4 s11 0
R11 s11 3 47e3
VS12 1 s12 0
R12 s12 0 56e3
VS13 2 s13 0
V13 e13 s13 DC 56e-1
RI13 e13 16 10e-3
VS14 1 s14 0
I14 s14 15 DC 47e-2
VS15 0 s15 0
R15 s15 7 68e1
VS16 9 s16 0
V16 e16 s16 DC 27e0
RI16 e16 12 56e-3
VS17 14 s17 0
V17 e17 s17 DC 15e1
RI17 e17 9 27e-2
VS18 15 s18 0
R18 s18 7 10e-1
VS19 11 s19 0
R19 s19 14 15e2
VS20 14 s20 0
I20 s20 11 DC 12e-2
VS21 0 s21 0
R21 s21 9 47e-1
VS22 8 s22 0
V22 e22 s22 DC 39e1
RI22 e22 5 68e-2
VS23 2 s23 0
R23 s23 14 39e2
VS24 13 s24 0
I24 s24 16 DC 39e-4
VS25 16 s25 0
R25 s25 4 12e-2
VS26 4 s26 0
R26 s26 10 18e-2
VS27 11 s27 0
V27 e27 s27 DC 39e-1
RI27 e27 12 33e-3
VS28 7 s28 0
R28 s28 5 27e1
VS29 6 s29 0
V29 e29 s29 DC 68e-1
RI29 e29 0 12e-1
VS30 4 s30 0
V30 e30 s30 DC 12e0
RI30 e30 14 39e-1
VS31 11 s31 0
R31 s31 8 27e2
.control
set numdgt=17
op
print v(1) v(2) v(3) v(4) v(5) v(6) v(7) v(8) v(9) v(10)
print v(11) v(12) v(13) v(14) v(15) v(16)
print i(vs0) i(vs1) i(vs2) i(vs3) i(vs4) i(vs5) i(vs6) i(vs7) i(vs8) i(vs9)
print i(vs10) i(vs11) i(vs12) i(vs13) i(vs14) i(vs15) i(vs16) i(vs17) i(vs18) i(vs19)
print i(vs20) i(vs21) i(vs22) i(vs23) i(vs24) i(vs25) i(vs26) i(vs27) i(vs28) i(vs29)
print i(vs30) i(vs31)
.endc
.end
