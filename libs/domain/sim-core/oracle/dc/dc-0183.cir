controls oracle dc-0183
* Generated (plan F2.7, ADR 0012): do not edit; regenerate with `pnpm sim oracle regen`. dc seed 20261030 index 183 nodes 28 elements 31
.options sparse gmin=1e-12 noopac
RG1 1 0 1000000000000
RG2 2 0 1000000000000
RG3 3 0 1000000000000
RG4 4 0 1000000000000
RG5 5 0 1000000000000
RG6 6 0 1000000000000
RG7 7 0 1000000000000
RG8 8 0 1000000000000
RG9 9 0 1000000000000
RG10 10 0 1000000000000
RG11 11 0 1000000000000
RG12 12 0 1000000000000
RG13 13 0 1000000000000
RG14 14 0 1000000000000
RG15 15 0 1000000000000
RG16 16 0 1000000000000
RG17 17 0 1000000000000
RG18 18 0 1000000000000
RG19 19 0 1000000000000
RG20 20 0 1000000000000
RG21 21 0 1000000000000
RG22 22 0 1000000000000
RG23 23 0 1000000000000
RG24 24 0 1000000000000
RG25 25 0 1000000000000
RG26 26 0 1000000000000
RG27 27 0 1000000000000
VS0 27 s0 0
R0 s0 2 10e0
VS1 3 s1 0
R1 s1 4 47e1
VS2 25 s2 0
R2 s2 3 10e2
VS3 24 s3 0
R3 s3 3 33e2
VS4 7 s4 0
R4 s4 12 15e3
VS5 24 s5 0
R5 s5 10 56e-2
VS6 5 s6 0
R6 s6 6 18e-1
VS7 7 s7 0
R7 s7 21 56e-1
VS8 0 s8 0
V8 e8 s8 DC 33e1
RI8 e8 17 15e-1
VS9 8 s9 0
R9 s9 5 10e0
VS10 0 s10 0
R10 s10 11 33e-1
VS11 26 s11 0
R11 s11 25 27e-1
VS12 23 s12 0
R12 s12 0 18e2
VS13 2 s13 0
V13 e13 s13 DC 33e0
RI13 e13 11 12e-3
VS14 26 s14 0
R14 s14 13 12e-2
VS15 18 s15 0
R15 s15 26 22e3
VS16 4 s16 0
I16 s16 15 DC 27e-1
VS17 24 s17 0
V17 e17 s17 DC 27e0
RI17 e17 15 15e-1
VS18 3 s18 0
R18 s18 14 12e2
VS19 9 s19 0
V19 e19 s19 DC 39e0
RI19 e19 26 18e-1
VS20 6 s20 0
R20 s20 20 22e0
VS21 1 s21 0
R21 s21 20 56e-2
VS22 16 s22 0
R22 s22 10 56e0
VS23 3 s23 0
R23 s23 19 56e1
VS24 27 s24 0
R24 s24 12 15e-2
VS25 16 s25 0
R25 s25 1 27e1
VS26 7 s26 0
R26 s26 22 15e-2
VS27 20 s27 0
R27 s27 0 10e2
VS28 0 s28 0
I28 s28 21 DC 47e-2
VS29 26 s29 0
R29 s29 0 56e-2
VS30 7 s30 0
R30 s30 13 15e-1
.control
set numdgt=17
op
print v(1) v(2) v(3) v(4) v(5) v(6) v(7) v(8) v(9) v(10)
print v(11) v(12) v(13) v(14) v(15) v(16) v(17) v(18) v(19) v(20)
print v(21) v(22) v(23) v(24) v(25) v(26) v(27)
print i(vs0) i(vs1) i(vs2) i(vs3) i(vs4) i(vs5) i(vs6) i(vs7) i(vs8) i(vs9)
print i(vs10) i(vs11) i(vs12) i(vs13) i(vs14) i(vs15) i(vs16) i(vs17) i(vs18) i(vs19)
print i(vs20) i(vs21) i(vs22) i(vs23) i(vs24) i(vs25) i(vs26) i(vs27) i(vs28) i(vs29)
print i(vs30)
.endc
.end
