controls oracle dc-0006
* Generated (plan F2.7, ADR 0012): do not edit; regenerate with `pnpm sim oracle regen`. dc seed 20261030 index 6 nodes 26 elements 33
.options sparse gmin=1e-12 noopac
RG1 1 0 1000000000000
RG2 2 0 1000000000000
RG3 3 0 1000000000000
RG4 4 0 1000000000000
RG5 5 0 1000000000000
RG6 6 0 1000000000000
RG7 7 0 1000000000000
RG8 8 0 1000000000000
RG9 9 0 1000000000000
RG10 10 0 1000000000000
RG11 11 0 1000000000000
RG12 12 0 1000000000000
RG13 13 0 1000000000000
RG14 14 0 1000000000000
RG15 15 0 1000000000000
RG16 16 0 1000000000000
RG17 17 0 1000000000000
RG18 18 0 1000000000000
RG19 19 0 1000000000000
RG20 20 0 1000000000000
RG21 21 0 1000000000000
RG22 22 0 1000000000000
RG23 23 0 1000000000000
RG24 24 0 1000000000000
RG25 25 0 1000000000000
VS0 15 s0 0
R0 s0 0 10e-2
VS1 0 s1 0
V1 e1 s1 DC 15e0
RI1 e1 20 33e-3
VS2 25 s2 0
R2 s2 15 33e3
VS3 19 s3 0
R3 s3 21 10e2
VS4 12 s4 0
R4 s4 24 56e-2
VS5 3 s5 0
R5 s5 0 56e-1
VS6 14 s6 0
R6 s6 17 47e2
VS7 19 s7 0
R7 s7 8 68e-1
VS8 7 s8 0
R8 s8 11 82e-1
VS9 8 s9 0
R9 s9 18 39e3
VS10 0 s10 0
I10 s10 5 DC 27e-1
VS11 6 s11 0
R11 s11 5 82e1
VS12 6 s12 0
R12 s12 3 10e1
VS13 19 s13 0
R13 s13 12 10e3
VS14 20 s14 0
R14 s14 23 22e-2
VS15 13 s15 0
R15 s15 15 15e-2
VS16 20 s16 0
R16 s16 10 68e-2
VS17 11 s17 0
R17 s17 16 39e1
VS18 5 s18 0
R18 s18 22 47e3
VS19 25 s19 0
R19 s19 22 39e2
VS20 4 s20 0
R20 s20 0 27e3
VS21 25 s21 0
R21 s21 19 22e0
VS22 16 s22 0
I22 s22 0 DC 33e-4
VS23 9 s23 0
R23 s23 10 82e0
VS24 14 s24 0
R24 s24 24 27e-2
VS25 6 s25 0
R25 s25 1 33e-1
VS26 12 s26 0
R26 s26 6 15e3
VS27 8 s27 0
R27 s27 11 27e2
VS28 13 s28 0
R28 s28 7 18e-1
VS29 10 s29 0
R29 s29 6 22e-2
VS30 4 s30 0
R30 s30 6 68e1
VS31 18 s31 0
I31 s31 24 DC 68e-2
VS32 2 s32 0
V32 e32 s32 DC 68e0
RI32 e32 20 47e-3
.control
set numdgt=17
op
print v(1) v(2) v(3) v(4) v(5) v(6) v(7) v(8) v(9) v(10)
print v(11) v(12) v(13) v(14) v(15) v(16) v(17) v(18) v(19) v(20)
print v(21) v(22) v(23) v(24) v(25)
print i(vs0) i(vs1) i(vs2) i(vs3) i(vs4) i(vs5) i(vs6) i(vs7) i(vs8) i(vs9)
print i(vs10) i(vs11) i(vs12) i(vs13) i(vs14) i(vs15) i(vs16) i(vs17) i(vs18) i(vs19)
print i(vs20) i(vs21) i(vs22) i(vs23) i(vs24) i(vs25) i(vs26) i(vs27) i(vs28) i(vs29)
print i(vs30) i(vs31) i(vs32)
.endc
.end
