controls oracle dc-0112
* Generated (plan F2.7, ADR 0012): do not edit; regenerate with `pnpm sim oracle regen`. dc seed 20261030 index 112 nodes 16 elements 30
.options sparse gmin=1e-12 noopac
RG1 1 0 1000000000000
RG2 2 0 1000000000000
RG3 3 0 1000000000000
RG4 4 0 1000000000000
RG5 5 0 1000000000000
RG6 6 0 1000000000000
RG7 7 0 1000000000000
RG8 8 0 1000000000000
RG9 9 0 1000000000000
RG10 10 0 1000000000000
RG11 11 0 1000000000000
RG12 12 0 1000000000000
RG13 13 0 1000000000000
RG14 14 0 1000000000000
RG15 15 0 1000000000000
VS0 0 s0 0
V0 e0 s0 DC 68e1
RI0 e0 4 10e-3
VS1 4 s1 0
R1 s1 13 39e-1
VS2 6 s2 0
I2 s2 2 DC 68e-4
VS3 1 s3 0
R3 s3 13 27e3
VS4 3 s4 0
R4 s4 12 47e3
VS5 10 s5 0
R5 s5 2 82e2
VS6 11 s6 0
I6 s6 10 DC 82e-3
VS7 14 s7 0
R7 s7 15 12e0
VS8 8 s8 0
R8 s8 11 12e-1
VS9 9 s9 0
R9 s9 0 18e1
VS10 11 s10 0
R10 s10 13 33e2
VS11 12 s11 0
R11 s11 7 56e-1
VS12 6 s12 0
R12 s12 15 27e1
VS13 14 s13 0
R13 s13 1 27e3
VS14 14 s14 0
R14 s14 3 82e-1
VS15 4 s15 0
R15 s15 13 15e1
VS16 11 s16 0
R16 s16 14 68e3
VS17 7 s17 0
R17 s17 0 18e1
VS18 1 s18 0
R18 s18 0 56e0
VS19 14 s19 0
R19 s19 6 82e3
VS20 9 s20 0
R20 s20 3 18e-1
VS21 1 s21 0
R21 s21 4 82e-2
VS22 5 s22 0
V22 e22 s22 DC 82e0
RI22 e22 8 39e-2
VS23 9 s23 0
R23 s23 13 47e1
VS24 5 s24 0
R24 s24 14 22e-2
VS25 12 s25 0
R25 s25 6 12e-2
VS26 14 s26 0
R26 s26 9 68e-2
VS27 2 s27 0
R27 s27 1 15e-2
VS28 0 s28 0
I28 s28 10 DC 10e-3
VS29 4 s29 0
R29 s29 8 12e-2
.control
set numdgt=17
op
print v(1) v(2) v(3) v(4) v(5) v(6) v(7) v(8) v(9) v(10)
print v(11) v(12) v(13) v(14) v(15)
print i(vs0) i(vs1) i(vs2) i(vs3) i(vs4) i(vs5) i(vs6) i(vs7) i(vs8) i(vs9)
print i(vs10) i(vs11) i(vs12) i(vs13) i(vs14) i(vs15) i(vs16) i(vs17) i(vs18) i(vs19)
print i(vs20) i(vs21) i(vs22) i(vs23) i(vs24) i(vs25) i(vs26) i(vs27) i(vs28) i(vs29)
.endc
.end
