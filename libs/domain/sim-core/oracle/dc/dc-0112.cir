controls oracle dc-0112
* Generated (plan F2.7, ADR 0012): do not edit; regenerate with `pnpm sim oracle regen`. dc seed 20261030 index 112 nodes 16 elements 32
.options sparse gmin=1e-12 noopac
RG1 1 0 1000000000000
RG2 2 0 1000000000000
RG3 3 0 1000000000000
RG4 4 0 1000000000000
RG5 5 0 1000000000000
RG6 6 0 1000000000000
RG7 7 0 1000000000000
RG8 8 0 1000000000000
RG9 9 0 1000000000000
RG10 10 0 1000000000000
RG11 11 0 1000000000000
RG12 12 0 1000000000000
RG13 13 0 1000000000000
RG14 14 0 1000000000000
RG15 15 0 1000000000000
VS0 9 s0 0
R0 s0 3 18e-1
VS1 1 s1 0
R1 s1 5 27e3
VS2 3 s2 0
R2 s2 12 47e3
VS3 4 s3 0
R3 s3 5 15e1
VS4 11 s4 0
R4 s4 5 33e2
VS5 2 s5 0
R5 s5 1 15e-2
VS6 4 s6 0
R6 s6 2 12e2
VS7 0 s7 0
R7 s7 14 22e-2
VS8 13 s8 0
I8 s8 10 DC 10e-3
VS9 11 s9 0
I9 s9 10 DC 82e-3
VS10 11 s10 0
R10 s10 14 68e3
VS11 12 s11 0
R11 s11 6 12e-2
VS12 14 s12 0
R12 s12 15 12e0
VS13 14 s13 0
R13 s13 6 82e3
VS14 14 s14 0
R14 s14 3 82e-1
VS15 14 s15 0
R15 s15 1 27e3
VS16 9 s16 0
R16 s16 13 18e1
VS17 6 s17 0
I17 s17 2 DC 68e-4
VS18 4 s18 0
R18 s18 5 39e-1
VS19 9 s19 0
R19 s19 5 47e1
VS20 6 s20 0
R20 s20 15 27e1
VS21 1 s21 0
R21 s21 13 56e0
VS22 14 s22 0
R22 s22 9 68e-2
VS23 0 s23 0
V23 e23 s23 DC 82e0
RI23 e23 8 39e-2
VS24 10 s24 0
R24 s24 2 82e2
VS25 12 s25 0
R25 s25 7 56e-1
VS26 7 s26 0
R26 s26 13 18e1
VS27 4 s27 0
R27 s27 8 12e-2
VS28 1 s28 0
R28 s28 10 39e-2
VS29 1 s29 0
R29 s29 4 82e-2
VS30 13 s30 0
V30 e30 s30 DC 68e1
RI30 e30 4 10e-3
VS31 8 s31 0
R31 s31 11 12e-1
.control
set numdgt=17
op
print v(1) v(2) v(3) v(4) v(5) v(6) v(7) v(8) v(9) v(10)
print v(11) v(12) v(13) v(14) v(15)
print i(vs0) i(vs1) i(vs2) i(vs3) i(vs4) i(vs5) i(vs6) i(vs7) i(vs8) i(vs9)
print i(vs10) i(vs11) i(vs12) i(vs13) i(vs14) i(vs15) i(vs16) i(vs17) i(vs18) i(vs19)
print i(vs20) i(vs21) i(vs22) i(vs23) i(vs24) i(vs25) i(vs26) i(vs27) i(vs28) i(vs29)
print i(vs30) i(vs31)
.endc
.end
