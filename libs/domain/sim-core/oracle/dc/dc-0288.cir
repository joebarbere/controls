controls oracle dc-0288
* Generated (plan F2.7, ADR 0012): do not edit; regenerate with `pnpm sim oracle regen`. dc seed 20261030 index 288 nodes 24 elements 47
.options sparse gmin=1e-12 noopac
RG1 1 0 1000000000000
RG2 2 0 1000000000000
RG3 3 0 1000000000000
RG4 4 0 1000000000000
RG5 5 0 1000000000000
RG6 6 0 1000000000000
RG7 7 0 1000000000000
RG8 8 0 1000000000000
RG9 9 0 1000000000000
RG10 10 0 1000000000000
RG11 11 0 1000000000000
RG12 12 0 1000000000000
RG13 13 0 1000000000000
RG14 14 0 1000000000000
RG15 15 0 1000000000000
RG16 16 0 1000000000000
RG17 17 0 1000000000000
RG18 18 0 1000000000000
RG19 19 0 1000000000000
RG20 20 0 1000000000000
RG21 21 0 1000000000000
RG22 22 0 1000000000000
RG23 23 0 1000000000000
VS0 0 s0 0
V0 e0 s0 DC 39e0
RI0 e0 15 68e-1
VS1 23 s1 0
R1 s1 16 68e-1
VS2 15 s2 0
R2 s2 23 68e1
VS3 21 s3 0
V3 e3 s3 DC 82e0
RI3 e3 13 47e-2
VS4 21 s4 0
R4 s4 5 47e0
VS5 8 s5 0
V5 e5 s5 DC 12e-1
RI5 e5 10 82e-2
VS6 0 s6 0
R6 s6 9 39e0
VS7 14 s7 0
I7 s7 20 DC 15e-3
VS8 0 s8 0
R8 s8 21 56e0
VS9 19 s9 0
R9 s9 23 12e2
VS10 9 s10 0
R10 s10 21 27e-2
VS11 17 s11 0
R11 s11 16 47e2
VS12 23 s12 0
R12 s12 9 82e1
VS13 2 s13 0
R13 s13 13 39e3
VS14 7 s14 0
R14 s14 2 68e0
VS15 12 s15 0
R15 s15 15 27e1
VS16 22 s16 0
R16 s16 13 33e-2
VS17 11 s17 0
V17 e17 s17 DC 18e0
RI17 e17 3 15e-3
VS18 10 s18 0
I18 s18 13 DC 18e-1
VS19 10 s19 0
R19 s19 7 22e-2
VS20 4 s20 0
R20 s20 17 47e3
VS21 22 s21 0
R21 s21 6 82e0
VS22 7 s22 0
R22 s22 20 56e-2
VS23 16 s23 0
V23 e23 s23 DC 39e1
RI23 e23 11 27e-3
VS24 3 s24 0
V24 e24 s24 DC 56e-1
RI24 e24 21 15e-3
VS25 9 s25 0
R25 s25 18 33e3
VS26 11 s26 0
R26 s26 9 39e1
VS27 1 s27 0
I27 s27 20 DC 12e-3
VS28 18 s28 0
R28 s28 13 56e3
VS29 5 s29 0
R29 s29 9 68e-1
VS30 14 s30 0
R30 s30 16 68e3
VS31 12 s31 0
R31 s31 6 18e0
VS32 20 s32 0
I32 s32 8 DC 56e-2
VS33 2 s33 0
R33 s33 11 39e2
VS34 5 s34 0
R34 s34 19 12e3
VS35 6 s35 0
I35 s35 21 DC 68e-3
VS36 0 s36 0
V36 e36 s36 DC 82e0
RI36 e36 8 12e-1
VS37 1 s37 0
R37 s37 4 33e-2
VS38 5 s38 0
R38 s38 19 15e3
VS39 12 s39 0
R39 s39 2 68e3
VS40 4 s40 0
R40 s40 17 22e1
VS41 13 s41 0
V41 e41 s41 DC 56e-1
RI41 e41 17 10e-3
VS42 17 s42 0
R42 s42 9 56e0
VS43 16 s43 0
I43 s43 19 DC 47e-1
VS44 1 s44 0
R44 s44 20 15e3
VS45 15 s45 0
R45 s45 14 18e3
VS46 11 s46 0
V46 e46 s46 DC 56e1
RI46 e46 16 39e-2
.control
set numdgt=17
op
print v(1) v(2) v(3) v(4) v(5) v(6) v(7) v(8) v(9) v(10)
print v(11) v(12) v(13) v(14) v(15) v(16) v(17) v(18) v(19) v(20)
print v(21) v(22) v(23)
print i(vs0) i(vs1) i(vs2) i(vs3) i(vs4) i(vs5) i(vs6) i(vs7) i(vs8) i(vs9)
print i(vs10) i(vs11) i(vs12) i(vs13) i(vs14) i(vs15) i(vs16) i(vs17) i(vs18) i(vs19)
print i(vs20) i(vs21) i(vs22) i(vs23) i(vs24) i(vs25) i(vs26) i(vs27) i(vs28) i(vs29)
print i(vs30) i(vs31) i(vs32) i(vs33) i(vs34) i(vs35) i(vs36) i(vs37) i(vs38) i(vs39)
print i(vs40) i(vs41) i(vs42) i(vs43) i(vs44) i(vs45) i(vs46)
.endc
.end
