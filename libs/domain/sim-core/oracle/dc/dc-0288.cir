controls oracle dc-0288
* Generated (plan F2.7, ADR 0012): do not edit; regenerate with `pnpm sim oracle regen`. dc seed 20261030 index 288 nodes 24 elements 44
.options sparse gmin=1e-12 noopac
RG1 1 0 1000000000000
RG2 2 0 1000000000000
RG3 3 0 1000000000000
RG4 4 0 1000000000000
RG5 5 0 1000000000000
RG6 6 0 1000000000000
RG7 7 0 1000000000000
RG8 8 0 1000000000000
RG9 9 0 1000000000000
RG10 10 0 1000000000000
RG11 11 0 1000000000000
RG12 12 0 1000000000000
RG13 13 0 1000000000000
RG14 14 0 1000000000000
RG15 15 0 1000000000000
RG16 16 0 1000000000000
RG17 17 0 1000000000000
RG18 18 0 1000000000000
RG19 19 0 1000000000000
RG20 20 0 1000000000000
RG21 21 0 1000000000000
RG22 22 0 1000000000000
RG23 23 0 1000000000000
VS0 12 s0 0
R0 s0 6 18e0
VS1 23 s1 0
R1 s1 16 68e-1
VS2 6 s2 0
I2 s2 0 DC 68e-3
VS3 0 s3 0
V3 e3 s3 DC 82e0
RI3 e3 13 47e-2
VS4 7 s4 0
R4 s4 2 68e0
VS5 11 s5 0
R5 s5 21 39e1
VS6 9 s6 0
V6 e6 s6 DC 39e0
RI6 e6 15 68e-1
VS7 23 s7 0
R7 s7 21 82e1
VS8 4 s8 0
R8 s8 17 47e3
VS9 2 s9 0
R9 s9 13 39e3
VS10 11 s10 0
V10 e10 s10 DC 18e0
RI10 e10 3 15e-3
VS11 1 s11 0
R11 s11 20 15e3
VS12 12 s12 0
R12 s12 2 68e3
VS13 9 s13 0
R13 s13 21 39e0
VS14 14 s14 0
I14 s14 20 DC 15e-3
VS15 5 s15 0
R15 s15 19 15e3
VS16 7 s16 0
R16 s16 20 56e-2
VS17 18 s17 0
R17 s17 13 56e3
VS18 1 s18 0
I18 s18 20 DC 12e-3
VS19 19 s19 0
R19 s19 23 12e2
VS20 13 s20 0
V20 e20 s20 DC 56e-1
RI20 e20 17 10e-3
VS21 20 s21 0
I21 s21 8 DC 56e-2
VS22 10 s22 0
I22 s22 13 DC 18e-1
VS23 17 s23 0
R23 s23 21 56e0
VS24 3 s24 0
V24 e24 s24 DC 56e-1
RI24 e24 0 15e-3
VS25 2 s25 0
R25 s25 11 39e2
VS26 9 s26 0
R26 s26 0 56e0
VS27 5 s27 0
R27 s27 19 12e3
VS28 15 s28 0
R28 s28 14 18e3
VS29 0 s29 0
R29 s29 5 47e0
VS30 16 s30 0
V30 e30 s30 DC 39e1
RI30 e30 11 27e-3
VS31 14 s31 0
R31 s31 16 68e3
VS32 22 s32 0
R32 s32 13 33e-2
VS33 21 s33 0
R33 s33 18 33e3
VS34 15 s34 0
R34 s34 23 68e1
VS35 9 s35 0
V35 e35 s35 DC 82e0
RI35 e35 8 12e-1
VS36 21 s36 0
R36 s36 0 27e-2
VS37 16 s37 0
I37 s37 19 DC 47e-1
VS38 12 s38 0
R38 s38 15 27e1
VS39 8 s39 0
V39 e39 s39 DC 12e-1
RI39 e39 10 82e-2
VS40 17 s40 0
R40 s40 16 47e2
VS41 11 s41 0
V41 e41 s41 DC 56e1
RI41 e41 16 39e-2
VS42 5 s42 0
R42 s42 21 68e-1
VS43 4 s43 0
R43 s43 17 22e1
.control
set numdgt=17
op
print v(1) v(2) v(3) v(4) v(5) v(6) v(7) v(8) v(9) v(10)
print v(11) v(12) v(13) v(14) v(15) v(16) v(17) v(18) v(19) v(20)
print v(21) v(22) v(23)
print i(vs0) i(vs1) i(vs2) i(vs3) i(vs4) i(vs5) i(vs6) i(vs7) i(vs8) i(vs9)
print i(vs10) i(vs11) i(vs12) i(vs13) i(vs14) i(vs15) i(vs16) i(vs17) i(vs18) i(vs19)
print i(vs20) i(vs21) i(vs22) i(vs23) i(vs24) i(vs25) i(vs26) i(vs27) i(vs28) i(vs29)
print i(vs30) i(vs31) i(vs32) i(vs33) i(vs34) i(vs35) i(vs36) i(vs37) i(vs38) i(vs39)
print i(vs40) i(vs41) i(vs42) i(vs43)
.endc
.end
