controls oracle dc-0432
* Generated (plan F2.7, ADR 0012): do not edit; regenerate with `pnpm sim oracle regen`. dc seed 20261030 index 432 nodes 4 elements 6
.options sparse gmin=1e-12 noopac
RG1 1 0 1000000000000
RG2 2 0 1000000000000
RG3 3 0 1000000000000
VS0 3 s0 0
R0 s0 0 22e-2
VS1 0 s1 0
V1 e1 s1 DC 68e1
RI1 e1 1 68e-1
VS2 1 s2 0
R2 s2 0 33e-1
VS3 1 s3 0
R3 s3 2 33e0
VS4 2 s4 0
R4 s4 0 12e0
VS5 3 s5 0
R5 s5 1 39e1
.control
set numdgt=17
op
print v(1) v(2) v(3)
print i(vs0) i(vs1) i(vs2) i(vs3) i(vs4) i(vs5)
.endc
.end
