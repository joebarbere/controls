controls oracle dc-0178
* Generated (plan F2.7, ADR 0012): do not edit; regenerate with `pnpm sim oracle regen`. dc seed 20261030 index 178 nodes 14 elements 22
.options sparse gmin=1e-12 noopac
RG1 1 0 1000000000000
RG2 2 0 1000000000000
RG3 3 0 1000000000000
RG4 4 0 1000000000000
RG5 5 0 1000000000000
RG6 6 0 1000000000000
RG7 7 0 1000000000000
RG8 8 0 1000000000000
RG9 9 0 1000000000000
RG10 10 0 1000000000000
RG11 11 0 1000000000000
RG12 12 0 1000000000000
RG13 13 0 1000000000000
VS0 0 s0 0
R0 s0 2 56e1
VS1 8 s1 0
R1 s1 9 10e2
VS2 4 s2 0
R2 s2 9 39e2
VS3 7 s3 0
R3 s3 5 68e0
VS4 0 s4 0
I4 s4 7 DC 39e-2
VS5 0 s5 0
V5 e5 s5 DC 33e1
RI5 e5 13 22e-3
VS6 3 s6 0
I6 s6 4 DC 68e-4
VS7 7 s7 0
R7 s7 11 18e2
VS8 4 s8 0
R8 s8 8 39e-1
VS9 7 s9 0
R9 s9 2 82e3
VS10 10 s10 0
R10 s10 12 22e-1
VS11 8 s11 0
V11 e11 s11 DC 82e0
RI11 e11 11 15e-3
VS12 9 s12 0
R12 s12 12 68e-1
VS13 13 s13 0
R13 s13 11 22e-2
VS14 2 s14 0
R14 s14 1 10e-2
VS15 5 s15 0
R15 s15 11 12e-1
VS16 9 s16 0
V16 e16 s16 DC 56e1
RI16 e16 2 68e-1
VS17 8 s17 0
V17 e17 s17 DC 22e1
RI17 e17 5 68e-3
VS18 3 s18 0
R18 s18 0 18e1
VS19 12 s19 0
R19 s19 3 15e0
VS20 12 s20 0
I20 s20 5 DC 22e-1
VS21 2 s21 0
R21 s21 6 39e2
.control
set numdgt=17
op
print v(1) v(2) v(3) v(4) v(5) v(6) v(7) v(8) v(9) v(10)
print v(11) v(12) v(13)
print i(vs0) i(vs1) i(vs2) i(vs3) i(vs4) i(vs5) i(vs6) i(vs7) i(vs8) i(vs9)
print i(vs10) i(vs11) i(vs12) i(vs13) i(vs14) i(vs15) i(vs16) i(vs17) i(vs18) i(vs19)
print i(vs20) i(vs21)
.endc
.end
