controls oracle dc-0178
* Generated (plan F2.7, ADR 0012): do not edit; regenerate with `pnpm sim oracle regen`. dc seed 20261030 index 178 nodes 14 elements 24
.options sparse gmin=1e-12 noopac
RG1 1 0 1000000000000
RG2 2 0 1000000000000
RG3 3 0 1000000000000
RG4 4 0 1000000000000
RG5 5 0 1000000000000
RG6 6 0 1000000000000
RG7 7 0 1000000000000
RG8 8 0 1000000000000
RG9 9 0 1000000000000
RG10 10 0 1000000000000
RG11 11 0 1000000000000
RG12 12 0 1000000000000
RG13 13 0 1000000000000
VS0 0 s0 0
V0 e0 s0 DC 33e1
RI0 e0 13 22e-3
VS1 8 s1 0
V1 e1 s1 DC 82e0
RI1 e1 11 15e-3
VS2 9 s2 0
V2 e2 s2 DC 56e1
RI2 e2 2 68e-1
VS3 12 s3 0
R3 s3 3 15e0
VS4 4 s4 0
R4 s4 9 39e2
VS5 8 s5 0
V5 e5 s5 DC 22e1
RI5 e5 5 68e-3
VS6 8 s6 0
R6 s6 9 10e2
VS7 0 s7 0
I7 s7 7 DC 39e-2
VS8 7 s8 0
R8 s8 2 82e3
VS9 2 s9 0
R9 s9 6 39e2
VS10 3 s10 0
R10 s10 0 18e1
VS11 7 s11 0
R11 s11 5 68e0
VS12 10 s12 0
V12 e12 s12 DC 82e-1
RI12 e12 1 56e-3
VS13 7 s13 0
R13 s13 11 18e2
VS14 5 s14 0
R14 s14 11 12e-1
VS15 9 s15 0
R15 s15 12 68e-1
VS16 12 s16 0
I16 s16 5 DC 22e-1
VS17 2 s17 0
R17 s17 1 10e-2
VS18 0 s18 0
R18 s18 2 56e1
VS19 10 s19 0
R19 s19 6 56e-2
VS20 4 s20 0
R20 s20 8 39e-1
VS21 13 s21 0
R21 s21 11 22e-2
VS22 10 s22 0
R22 s22 12 22e-1
VS23 3 s23 0
I23 s23 4 DC 68e-4
.control
set numdgt=17
op
print v(1) v(2) v(3) v(4) v(5) v(6) v(7) v(8) v(9) v(10)
print v(11) v(12) v(13)
print i(vs0) i(vs1) i(vs2) i(vs3) i(vs4) i(vs5) i(vs6) i(vs7) i(vs8) i(vs9)
print i(vs10) i(vs11) i(vs12) i(vs13) i(vs14) i(vs15) i(vs16) i(vs17) i(vs18) i(vs19)
print i(vs20) i(vs21) i(vs22) i(vs23)
.endc
.end
