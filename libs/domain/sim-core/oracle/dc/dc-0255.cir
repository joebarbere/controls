controls oracle dc-0255
* Generated (plan F2.7, ADR 0012): do not edit; regenerate with `pnpm sim oracle regen`. dc seed 20261030 index 255 nodes 16 elements 30
.options sparse gmin=1e-12 noopac
RG1 1 0 1000000000000
RG2 2 0 1000000000000
RG3 3 0 1000000000000
RG4 4 0 1000000000000
RG5 5 0 1000000000000
RG6 6 0 1000000000000
RG7 7 0 1000000000000
RG8 8 0 1000000000000
RG9 9 0 1000000000000
RG10 10 0 1000000000000
RG11 11 0 1000000000000
RG12 12 0 1000000000000
RG13 13 0 1000000000000
RG14 14 0 1000000000000
RG15 15 0 1000000000000
VS0 0 s0 0
I0 s0 12 DC 18e-4
VS1 0 s1 0
V1 e1 s1 DC 82e0
RI1 e1 4 47e-1
VS2 0 s2 0
R2 s2 3 82e-1
VS3 3 s3 0
V3 e3 s3 DC 56e-1
RI3 e3 1 10e-2
VS4 11 s4 0
V4 e4 s4 DC 47e0
RI4 e4 5 18e-2
VS5 2 s5 0
R5 s5 14 27e-1
VS6 5 s6 0
R6 s6 11 33e1
VS7 12 s7 0
R7 s7 10 22e-2
VS8 7 s8 0
R8 s8 8 47e2
VS9 10 s9 0
R9 s9 14 39e2
VS10 10 s10 0
R10 s10 9 15e-2
VS11 15 s11 0
V11 e11 s11 DC 22e0
RI11 e11 4 82e-1
VS12 12 s12 0
I12 s12 9 DC 39e-4
VS13 14 s13 0
I13 s13 1 DC 22e-3
VS14 13 s14 0
V14 e14 s14 DC 82e1
RI14 e14 1 56e-3
VS15 3 s15 0
R15 s15 1 27e1
VS16 5 s16 0
V16 e16 s16 DC 68e1
RI16 e16 3 33e-2
VS17 11 s17 0
R17 s17 5 47e1
VS18 11 s18 0
R18 s18 12 33e-1
VS19 15 s19 0
R19 s19 12 68e1
VS20 6 s20 0
R20 s20 9 39e0
VS21 9 s21 0
V21 e21 s21 DC 15e-1
RI21 e21 8 39e-1
VS22 5 s22 0
R22 s22 4 39e0
VS23 8 s23 0
R23 s23 10 39e-1
VS24 12 s24 0
R24 s24 6 18e0
VS25 12 s25 0
I25 s25 5 DC 18e-3
VS26 7 s26 0
V26 e26 s26 DC 68e-1
RI26 e26 8 68e-1
VS27 7 s27 0
V27 e27 s27 DC 22e0
RI27 e27 2 22e-1
VS28 7 s28 0
R28 s28 0 27e3
VS29 13 s29 0
I29 s29 7 DC 33e-3
.control
set numdgt=17
op
print v(1) v(2) v(3) v(4) v(5) v(6) v(7) v(8) v(9) v(10)
print v(11) v(12) v(13) v(14) v(15)
print i(vs0) i(vs1) i(vs2) i(vs3) i(vs4) i(vs5) i(vs6) i(vs7) i(vs8) i(vs9)
print i(vs10) i(vs11) i(vs12) i(vs13) i(vs14) i(vs15) i(vs16) i(vs17) i(vs18) i(vs19)
print i(vs20) i(vs21) i(vs22) i(vs23) i(vs24) i(vs25) i(vs26) i(vs27) i(vs28) i(vs29)
.endc
.end
