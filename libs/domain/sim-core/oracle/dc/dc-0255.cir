controls oracle dc-0255
* Generated (plan F2.7, ADR 0012): do not edit; regenerate with `pnpm sim oracle regen`. dc seed 20261030 index 255 nodes 16 elements 32
.options sparse gmin=1e-12 noopac
RG1 1 0 1000000000000
RG2 2 0 1000000000000
RG3 3 0 1000000000000
RG4 4 0 1000000000000
RG5 5 0 1000000000000
RG6 6 0 1000000000000
RG7 7 0 1000000000000
RG8 8 0 1000000000000
RG9 9 0 1000000000000
RG10 10 0 1000000000000
RG11 11 0 1000000000000
RG12 12 0 1000000000000
RG13 13 0 1000000000000
RG14 14 0 1000000000000
RG15 15 0 1000000000000
VS0 0 s0 0
V0 e0 s0 DC 68e1
RI0 e0 3 33e-2
VS1 9 s1 0
V1 e1 s1 DC 15e-1
RI1 e1 8 39e-1
VS2 7 s2 0
R2 s2 1 27e3
VS3 3 s3 0
R3 s3 5 27e1
VS4 7 s4 0
R4 s4 8 47e2
VS5 13 s5 0
V5 e5 s5 DC 82e1
RI5 e5 5 56e-3
VS6 12 s6 0
I6 s6 0 DC 18e-3
VS7 8 s7 0
R7 s7 10 39e-1
VS8 6 s8 0
R8 s8 9 39e0
VS9 11 s9 0
R9 s9 5 47e-1
VS10 7 s10 0
V10 e10 s10 DC 22e0
RI10 e10 2 22e-1
VS11 2 s11 0
R11 s11 14 27e-1
VS12 11 s12 0
R12 s12 12 33e-1
VS13 10 s13 0
R13 s13 9 15e-2
VS14 11 s14 0
R14 s14 0 47e1
VS15 12 s15 0
R15 s15 10 22e-2
VS16 0 s16 0
R16 s16 11 33e1
VS17 0 s17 0
R17 s17 4 39e0
VS18 11 s18 0
V18 e18 s18 DC 47e0
RI18 e18 0 18e-2
VS19 14 s19 0
I19 s19 5 DC 22e-3
VS20 9 s20 0
R20 s20 13 15e-1
VS21 3 s21 0
V21 e21 s21 DC 56e-1
RI21 e21 5 10e-2
VS22 1 s22 0
R22 s22 3 82e-1
VS23 15 s23 0
R23 s23 12 68e1
VS24 1 s24 0
I24 s24 12 DC 18e-4
VS25 13 s25 0
I25 s25 7 DC 33e-3
VS26 1 s26 0
V26 e26 s26 DC 82e0
RI26 e26 4 47e-1
VS27 10 s27 0
R27 s27 14 39e2
VS28 12 s28 0
R28 s28 6 18e0
VS29 7 s29 0
V29 e29 s29 DC 68e-1
RI29 e29 8 68e-1
VS30 15 s30 0
V30 e30 s30 DC 22e0
RI30 e30 4 82e-1
VS31 12 s31 0
I31 s31 9 DC 39e-4
.control
set numdgt=17
op
print v(1) v(2) v(3) v(4) v(5) v(6) v(7) v(8) v(9) v(10)
print v(11) v(12) v(13) v(14) v(15)
print i(vs0) i(vs1) i(vs2) i(vs3) i(vs4) i(vs5) i(vs6) i(vs7) i(vs8) i(vs9)
print i(vs10) i(vs11) i(vs12) i(vs13) i(vs14) i(vs15) i(vs16) i(vs17) i(vs18) i(vs19)
print i(vs20) i(vs21) i(vs22) i(vs23) i(vs24) i(vs25) i(vs26) i(vs27) i(vs28) i(vs29)
print i(vs30) i(vs31)
.endc
.end
