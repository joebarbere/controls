controls oracle dc-0168
* Generated (plan F2.7, ADR 0012): do not edit; regenerate with `pnpm sim oracle regen`. dc seed 20261030 index 168 nodes 25 elements 41
.options sparse gmin=1e-12 noopac
RG1 1 0 1000000000000
RG2 2 0 1000000000000
RG3 3 0 1000000000000
RG4 4 0 1000000000000
RG5 5 0 1000000000000
RG6 6 0 1000000000000
RG7 7 0 1000000000000
RG8 8 0 1000000000000
RG9 9 0 1000000000000
RG10 10 0 1000000000000
RG11 11 0 1000000000000
RG12 12 0 1000000000000
RG13 13 0 1000000000000
RG14 14 0 1000000000000
RG15 15 0 1000000000000
RG16 16 0 1000000000000
RG17 17 0 1000000000000
RG18 18 0 1000000000000
RG19 19 0 1000000000000
RG20 20 0 1000000000000
RG21 21 0 1000000000000
RG22 22 0 1000000000000
RG23 23 0 1000000000000
RG24 24 0 1000000000000
VS0 15 s0 0
R0 s0 19 22e1
VS1 0 s1 0
R1 s1 10 56e1
VS2 9 s2 0
R2 s2 6 10e1
VS3 23 s3 0
R3 s3 14 12e2
VS4 14 s4 0
R4 s4 21 56e2
VS5 18 s5 0
R5 s5 9 56e3
VS6 9 s6 0
R6 s6 21 56e-1
VS7 23 s7 0
R7 s7 19 10e0
VS8 21 s8 0
R8 s8 2 22e-2
VS9 0 s9 0
R9 s9 14 56e1
VS10 16 s10 0
R10 s10 21 27e0
VS11 23 s11 0
R11 s11 17 47e1
VS12 0 s12 0
V12 e12 s12 DC 22e0
RI12 e12 7 39e-1
VS13 10 s13 0
R13 s13 12 68e0
VS14 2 s14 0
V14 e14 s14 DC 33e1
RI14 e14 19 39e-2
VS15 21 s15 0
V15 e15 s15 DC 68e-1
RI15 e15 23 33e-3
VS16 7 s16 0
R16 s16 22 15e0
VS17 13 s17 0
V17 e17 s17 DC 68e-1
RI17 e17 9 27e-2
VS18 11 s18 0
V18 e18 s18 DC 22e1
RI18 e18 20 33e-2
VS19 20 s19 0
R19 s19 5 12e-1
VS20 17 s20 0
R20 s20 19 15e-2
VS21 12 s21 0
I21 s21 14 DC 68e-1
VS22 22 s22 0
R22 s22 12 56e0
VS23 13 s23 0
R23 s23 17 47e-2
VS24 1 s24 0
R24 s24 2 15e-1
VS25 17 s25 0
I25 s25 3 DC 68e-3
VS26 7 s26 0
R26 s26 5 47e-2
VS27 8 s27 0
R27 s27 14 27e-1
VS28 18 s28 0
R28 s28 16 33e3
VS29 6 s29 0
R29 s29 1 33e2
VS30 21 s30 0
R30 s30 11 56e-2
VS31 4 s31 0
R31 s31 11 39e-2
VS32 10 s32 0
R32 s32 3 82e1
VS33 19 s33 0
R33 s33 9 22e0
VS34 24 s34 0
V34 e34 s34 DC 12e-1
RI34 e34 1 82e-2
VS35 1 s35 0
R35 s35 18 56e1
VS36 8 s36 0
R36 s36 23 47e1
VS37 8 s37 0
R37 s37 3 68e3
VS38 9 s38 0
R38 s38 15 47e-2
VS39 23 s39 0
R39 s39 4 12e-2
VS40 24 s40 0
R40 s40 23 47e1
.control
set numdgt=17
op
print v(1) v(2) v(3) v(4) v(5) v(6) v(7) v(8) v(9) v(10)
print v(11) v(12) v(13) v(14) v(15) v(16) v(17) v(18) v(19) v(20)
print v(21) v(22) v(23) v(24)
print i(vs0) i(vs1) i(vs2) i(vs3) i(vs4) i(vs5) i(vs6) i(vs7) i(vs8) i(vs9)
print i(vs10) i(vs11) i(vs12) i(vs13) i(vs14) i(vs15) i(vs16) i(vs17) i(vs18) i(vs19)
print i(vs20) i(vs21) i(vs22) i(vs23) i(vs24) i(vs25) i(vs26) i(vs27) i(vs28) i(vs29)
print i(vs30) i(vs31) i(vs32) i(vs33) i(vs34) i(vs35) i(vs36) i(vs37) i(vs38) i(vs39)
print i(vs40)
.endc
.end
