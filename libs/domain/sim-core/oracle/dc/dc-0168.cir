controls oracle dc-0168
* Generated (plan F2.7, ADR 0012): do not edit; regenerate with `pnpm sim oracle regen`. dc seed 20261030 index 168 nodes 25 elements 36
.options sparse gmin=1e-12 noopac
RG1 1 0 1000000000000
RG2 2 0 1000000000000
RG3 3 0 1000000000000
RG4 4 0 1000000000000
RG5 5 0 1000000000000
RG6 6 0 1000000000000
RG7 7 0 1000000000000
RG8 8 0 1000000000000
RG9 9 0 1000000000000
RG10 10 0 1000000000000
RG11 11 0 1000000000000
RG12 12 0 1000000000000
RG13 13 0 1000000000000
RG14 14 0 1000000000000
RG15 15 0 1000000000000
RG16 16 0 1000000000000
RG17 17 0 1000000000000
RG18 18 0 1000000000000
RG19 19 0 1000000000000
RG20 20 0 1000000000000
RG21 21 0 1000000000000
RG22 22 0 1000000000000
RG23 23 0 1000000000000
RG24 24 0 1000000000000
VS0 9 s0 0
R0 s0 11 56e-1
VS1 21 s1 0
R1 s1 10 56e1
VS2 4 s2 0
R2 s2 0 39e-2
VS3 0 s3 0
V3 e3 s3 DC 22e1
RI3 e3 20 33e-2
VS4 14 s4 0
R4 s4 11 56e2
VS5 15 s5 0
R5 s5 19 22e1
VS6 12 s6 0
I6 s6 14 DC 68e-1
VS7 21 s7 0
R7 s7 14 56e1
VS8 18 s8 0
R8 s8 9 56e3
VS9 23 s9 0
R9 s9 19 10e0
VS10 24 s10 0
R10 s10 23 47e1
VS11 1 s11 0
R11 s11 2 15e-1
VS12 13 s12 0
R12 s12 17 47e-2
VS13 2 s13 0
V13 e13 s13 DC 33e1
RI13 e13 19 39e-2
VS14 8 s14 0
R14 s14 23 47e1
VS15 23 s15 0
R15 s15 4 12e-2
VS16 11 s16 0
V16 e16 s16 DC 68e-1
RI16 e16 23 33e-3
VS17 11 s17 0
R17 s17 0 56e-2
VS18 17 s18 0
I18 s18 3 DC 68e-3
VS19 6 s19 0
R19 s19 1 33e2
VS20 10 s20 0
R20 s20 3 82e1
VS21 20 s21 0
R21 s21 5 12e-1
VS22 21 s22 0
V22 e22 s22 DC 22e0
RI22 e22 7 39e-1
VS23 7 s23 0
R23 s23 22 15e0
VS24 11 s24 0
R24 s24 2 22e-2
VS25 7 s25 0
R25 s25 5 47e-2
VS26 13 s26 0
V26 e26 s26 DC 68e-1
RI26 e26 9 27e-2
VS27 9 s27 0
R27 s27 6 10e1
VS28 23 s28 0
R28 s28 17 47e1
VS29 17 s29 0
R29 s29 19 15e-2
VS30 19 s30 0
R30 s30 9 22e0
VS31 1 s31 0
R31 s31 18 56e1
VS32 23 s32 0
R32 s32 14 12e2
VS33 16 s33 0
R33 s33 11 27e0
VS34 8 s34 0
R34 s34 14 27e-1
VS35 10 s35 0
R35 s35 12 68e0
.control
set numdgt=17
op
print v(1) v(2) v(3) v(4) v(5) v(6) v(7) v(8) v(9) v(10)
print v(11) v(12) v(13) v(14) v(15) v(16) v(17) v(18) v(19) v(20)
print v(21) v(22) v(23) v(24)
print i(vs0) i(vs1) i(vs2) i(vs3) i(vs4) i(vs5) i(vs6) i(vs7) i(vs8) i(vs9)
print i(vs10) i(vs11) i(vs12) i(vs13) i(vs14) i(vs15) i(vs16) i(vs17) i(vs18) i(vs19)
print i(vs20) i(vs21) i(vs22) i(vs23) i(vs24) i(vs25) i(vs26) i(vs27) i(vs28) i(vs29)
print i(vs30) i(vs31) i(vs32) i(vs33) i(vs34) i(vs35)
.endc
.end
