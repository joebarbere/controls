controls oracle dc-0277
* Generated (plan F2.7, ADR 0012): do not edit; regenerate with `pnpm sim oracle regen`. dc seed 20261030 index 277 nodes 15 elements 23
.options sparse gmin=1e-12 noopac
RG1 1 0 1000000000000
RG2 2 0 1000000000000
RG3 3 0 1000000000000
RG4 4 0 1000000000000
RG5 5 0 1000000000000
RG6 6 0 1000000000000
RG7 7 0 1000000000000
RG8 8 0 1000000000000
RG9 9 0 1000000000000
RG10 10 0 1000000000000
RG11 11 0 1000000000000
RG12 12 0 1000000000000
RG13 13 0 1000000000000
RG14 14 0 1000000000000
VS0 10 s0 0
R0 s0 4 27e2
VS1 1 s1 0
R1 s1 2 56e2
VS2 4 s2 0
R2 s2 3 33e2
VS3 12 s3 0
R3 s3 8 56e0
VS4 11 s4 0
R4 s4 7 18e1
VS5 8 s5 0
R5 s5 14 82e3
VS6 7 s6 0
R6 s6 10 39e-1
VS7 2 s7 0
R7 s7 8 47e0
VS8 9 s8 0
R8 s8 0 68e-1
VS9 3 s9 0
R9 s9 6 10e1
VS10 4 s10 0
R10 s10 5 33e1
VS11 10 s11 0
I11 s11 8 DC 68e-2
VS12 3 s12 0
R12 s12 0 10e3
VS13 11 s13 0
R13 s13 1 56e3
VS14 1 s14 0
R14 s14 3 39e0
VS15 0 s15 0
V15 e15 s15 DC 15e0
RI15 e15 11 47e-1
VS16 14 s16 0
R16 s16 5 22e0
VS17 14 s17 0
R17 s17 11 22e-2
VS18 12 s18 0
R18 s18 2 10e-1
VS19 13 s19 0
R19 s19 5 12e-2
VS20 9 s20 0
V20 e20 s20 DC 15e0
RI20 e20 10 68e-2
VS21 12 s21 0
R21 s21 5 15e3
VS22 6 s22 0
V22 e22 s22 DC 12e-1
RI22 e22 11 47e-1
.control
set numdgt=17
op
print v(1) v(2) v(3) v(4) v(5) v(6) v(7) v(8) v(9) v(10)
print v(11) v(12) v(13) v(14)
print i(vs0) i(vs1) i(vs2) i(vs3) i(vs4) i(vs5) i(vs6) i(vs7) i(vs8) i(vs9)
print i(vs10) i(vs11) i(vs12) i(vs13) i(vs14) i(vs15) i(vs16) i(vs17) i(vs18) i(vs19)
print i(vs20) i(vs21) i(vs22)
.endc
.end
