controls oracle dc-0280
* Generated (plan F2.7, ADR 0012): do not edit; regenerate with `pnpm sim oracle regen`. dc seed 20261030 index 280 nodes 21 elements 43
.options sparse gmin=1e-12 noopac
RG1 1 0 1000000000000
RG2 2 0 1000000000000
RG3 3 0 1000000000000
RG4 4 0 1000000000000
RG5 5 0 1000000000000
RG6 6 0 1000000000000
RG7 7 0 1000000000000
RG8 8 0 1000000000000
RG9 9 0 1000000000000
RG10 10 0 1000000000000
RG11 11 0 1000000000000
RG12 12 0 1000000000000
RG13 13 0 1000000000000
RG14 14 0 1000000000000
RG15 15 0 1000000000000
RG16 16 0 1000000000000
RG17 17 0 1000000000000
RG18 18 0 1000000000000
RG19 19 0 1000000000000
RG20 20 0 1000000000000
VS0 0 s0 0
V0 e0 s0 DC 47e0
RI0 e0 7 22e-3
VS1 4 s1 0
R1 s1 6 10e2
VS2 2 s2 0
R2 s2 11 15e3
VS3 7 s3 0
R3 s3 11 82e2
VS4 12 s4 0
V4 e4 s4 DC 56e-1
RI4 e4 18 68e-3
VS5 0 s5 0
V5 e5 s5 DC 27e-1
RI5 e5 16 39e-3
VS6 3 s6 0
R6 s6 16 27e-2
VS7 18 s7 0
R7 s7 6 18e3
VS8 6 s8 0
V8 e8 s8 DC 39e1
RI8 e8 7 33e-1
VS9 4 s9 0
V9 e9 s9 DC 39e1
RI9 e9 19 56e-2
VS10 4 s10 0
V10 e10 s10 DC 68e1
RI10 e10 20 33e-2
VS11 6 s11 0
V11 e11 s11 DC 15e1
RI11 e11 16 56e-1
VS12 13 s12 0
R12 s12 2 33e1
VS13 5 s13 0
R13 s13 17 82e-1
VS14 10 s14 0
V14 e14 s14 DC 33e0
RI14 e14 4 39e-3
VS15 10 s15 0
R15 s15 12 15e-1
VS16 6 s16 0
R16 s16 8 22e3
VS17 5 s17 0
V17 e17 s17 DC 15e0
RI17 e17 6 68e-1
VS18 2 s18 0
R18 s18 16 22e0
VS19 19 s19 0
R19 s19 6 68e3
VS20 19 s20 0
I20 s20 16 DC 18e-3
VS21 15 s21 0
R21 s21 2 56e3
VS22 12 s22 0
R22 s22 2 18e2
VS23 11 s23 0
I23 s23 7 DC 47e-1
VS24 2 s24 0
R24 s24 0 18e0
VS25 1 s25 0
V25 e25 s25 DC 12e0
RI25 e25 5 18e-1
VS26 4 s26 0
R26 s26 1 39e3
VS27 0 s27 0
R27 s27 15 27e2
VS28 7 s28 0
R28 s28 13 18e2
VS29 16 s29 0
I29 s29 13 DC 27e-1
VS30 8 s30 0
V30 e30 s30 DC 39e1
RI30 e30 14 10e-1
VS31 6 s31 0
I31 s31 5 DC 82e-3
VS32 8 s32 0
R32 s32 20 22e2
VS33 10 s33 0
R33 s33 5 27e3
VS34 6 s34 0
R34 s34 0 10e-2
VS35 13 s35 0
I35 s35 14 DC 82e-2
VS36 17 s36 0
R36 s36 9 68e-1
VS37 14 s37 0
R37 s37 0 27e-1
VS38 1 s38 0
R38 s38 8 82e0
VS39 10 s39 0
R39 s39 17 10e0
VS40 9 s40 0
V40 e40 s40 DC 10e1
RI40 e40 19 68e-2
VS41 20 s41 0
V41 e41 s41 DC 12e-1
RI41 e41 3 18e-2
VS42 8 s42 0
I42 s42 7 DC 22e-4
.control
set numdgt=17
op
print v(1) v(2) v(3) v(4) v(5) v(6) v(7) v(8) v(9) v(10)
print v(11) v(12) v(13) v(14) v(15) v(16) v(17) v(18) v(19) v(20)
print i(vs0) i(vs1) i(vs2) i(vs3) i(vs4) i(vs5) i(vs6) i(vs7) i(vs8) i(vs9)
print i(vs10) i(vs11) i(vs12) i(vs13) i(vs14) i(vs15) i(vs16) i(vs17) i(vs18) i(vs19)
print i(vs20) i(vs21) i(vs22) i(vs23) i(vs24) i(vs25) i(vs26) i(vs27) i(vs28) i(vs29)
print i(vs30) i(vs31) i(vs32) i(vs33) i(vs34) i(vs35) i(vs36) i(vs37) i(vs38) i(vs39)
print i(vs40) i(vs41) i(vs42)
.endc
.end
