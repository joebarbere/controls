controls oracle dc-0280
* Generated (plan F2.7, ADR 0012): do not edit; regenerate with `pnpm sim oracle regen`. dc seed 20261030 index 280 nodes 21 elements 37
.options sparse gmin=1e-12 noopac
RG1 1 0 1000000000000
RG2 2 0 1000000000000
RG3 3 0 1000000000000
RG4 4 0 1000000000000
RG5 5 0 1000000000000
RG6 6 0 1000000000000
RG7 7 0 1000000000000
RG8 8 0 1000000000000
RG9 9 0 1000000000000
RG10 10 0 1000000000000
RG11 11 0 1000000000000
RG12 12 0 1000000000000
RG13 13 0 1000000000000
RG14 14 0 1000000000000
RG15 15 0 1000000000000
RG16 16 0 1000000000000
RG17 17 0 1000000000000
RG18 18 0 1000000000000
RG19 19 0 1000000000000
RG20 20 0 1000000000000
VS0 13 s0 0
I0 s0 14 DC 82e-2
VS1 8 s1 0
R1 s1 20 22e2
VS2 11 s2 0
I2 s2 7 DC 47e-1
VS3 4 s3 0
R3 s3 6 10e2
VS4 5 s4 0
R4 s4 17 82e-1
VS5 13 s5 0
R5 s5 1 33e1
VS6 0 s6 0
V6 e6 s6 DC 12e0
RI6 e6 5 18e-1
VS7 19 s7 0
R7 s7 6 68e3
VS8 10 s8 0
R8 s8 5 27e3
VS9 0 s9 0
R9 s9 8 82e0
VS10 2 s10 0
R10 s10 15 27e2
VS11 2 s11 0
V11 e11 s11 DC 47e0
RI11 e11 7 22e-3
VS12 8 s12 0
V12 e12 s12 DC 39e1
RI12 e12 14 10e-1
VS13 16 s13 0
I13 s13 13 DC 27e-1
VS14 4 s14 0
V14 e14 s14 DC 68e1
RI14 e14 20 33e-2
VS15 4 s15 0
R15 s15 0 39e3
VS16 17 s16 0
R16 s16 9 68e-1
VS17 4 s17 0
V17 e17 s17 DC 39e1
RI17 e17 19 56e-2
VS18 5 s18 0
V18 e18 s18 DC 15e0
RI18 e18 6 68e-1
VS19 6 s19 0
I19 s19 5 DC 82e-3
VS20 6 s20 0
R20 s20 8 22e3
VS21 10 s21 0
R21 s21 17 10e0
VS22 1 s22 0
R22 s22 2 18e0
VS23 19 s23 0
I23 s23 16 DC 18e-3
VS24 10 s24 0
V24 e24 s24 DC 33e0
RI24 e24 4 39e-3
VS25 6 s25 0
R25 s25 2 10e-2
VS26 10 s26 0
R26 s26 12 15e-1
VS27 18 s27 0
R27 s27 6 18e3
VS28 2 s28 0
V28 e28 s28 DC 27e-1
RI28 e28 16 39e-3
VS29 8 s29 0
I29 s29 7 DC 22e-4
VS30 7 s30 0
R30 s30 11 82e2
VS31 9 s31 0
V31 e31 s31 DC 10e1
RI31 e31 19 68e-2
VS32 1 s32 0
R32 s32 16 22e0
VS33 6 s33 0
V33 e33 s33 DC 39e1
RI33 e33 7 33e-1
VS34 6 s34 0
V34 e34 s34 DC 15e1
RI34 e34 16 56e-1
VS35 15 s35 0
R35 s35 1 56e3
VS36 3 s36 0
R36 s36 16 27e-2
.control
set numdgt=17
op
print v(1) v(2) v(3) v(4) v(5) v(6) v(7) v(8) v(9) v(10)
print v(11) v(12) v(13) v(14) v(15) v(16) v(17) v(18) v(19) v(20)
print i(vs0) i(vs1) i(vs2) i(vs3) i(vs4) i(vs5) i(vs6) i(vs7) i(vs8) i(vs9)
print i(vs10) i(vs11) i(vs12) i(vs13) i(vs14) i(vs15) i(vs16) i(vs17) i(vs18) i(vs19)
print i(vs20) i(vs21) i(vs22) i(vs23) i(vs24) i(vs25) i(vs26) i(vs27) i(vs28) i(vs29)
print i(vs30) i(vs31) i(vs32) i(vs33) i(vs34) i(vs35) i(vs36)
.endc
.end
