controls oracle dc-0094
* Generated (plan F2.7, ADR 0012): do not edit; regenerate with `pnpm sim oracle regen`. dc seed 20261030 index 94 nodes 13 elements 26
.options sparse gmin=1e-12 noopac
RG1 1 0 1000000000000
RG2 2 0 1000000000000
RG3 3 0 1000000000000
RG4 4 0 1000000000000
RG5 5 0 1000000000000
RG6 6 0 1000000000000
RG7 7 0 1000000000000
RG8 8 0 1000000000000
RG9 9 0 1000000000000
RG10 10 0 1000000000000
RG11 11 0 1000000000000
RG12 12 0 1000000000000
VS0 0 s0 0
V0 e0 s0 DC 22e1
RI0 e0 10 22e-2
VS1 9 s1 0
V1 e1 s1 DC 47e0
RI1 e1 2 68e-3
VS2 8 s2 0
I2 s2 2 DC 68e-4
VS3 7 s3 0
R3 s3 9 33e3
VS4 4 s4 0
I4 s4 10 DC 33e-1
VS5 4 s5 0
R5 s5 5 12e3
VS6 7 s6 0
R6 s6 5 68e1
VS7 5 s7 0
R7 s7 3 22e-2
VS8 6 s8 0
R8 s8 11 68e-1
VS9 8 s9 0
R9 s9 1 18e0
VS10 8 s10 0
R10 s10 9 39e3
VS11 0 s11 0
R11 s11 3 12e1
VS12 6 s12 0
R12 s12 5 33e1
VS13 2 s13 0
R13 s13 7 39e2
VS14 11 s14 0
R14 s14 8 15e3
VS15 0 s15 0
I15 s15 8 DC 18e-1
VS16 10 s16 0
R16 s16 4 82e-2
VS17 12 s17 0
V17 e17 s17 DC 18e0
RI17 e17 3 56e-3
VS18 6 s18 0
R18 s18 9 56e-2
VS19 4 s19 0
R19 s19 3 18e0
VS20 9 s20 0
R20 s20 12 12e-1
VS21 5 s21 0
R21 s21 1 18e-1
VS22 7 s22 0
R22 s22 0 10e2
VS23 5 s23 0
R23 s23 3 47e-2
VS24 8 s24 0
R24 s24 4 22e0
VS25 6 s25 0
I25 s25 3 DC 82e-1
.control
set numdgt=17
op
print v(1) v(2) v(3) v(4) v(5) v(6) v(7) v(8) v(9) v(10)
print v(11) v(12)
print i(vs0) i(vs1) i(vs2) i(vs3) i(vs4) i(vs5) i(vs6) i(vs7) i(vs8) i(vs9)
print i(vs10) i(vs11) i(vs12) i(vs13) i(vs14) i(vs15) i(vs16) i(vs17) i(vs18) i(vs19)
print i(vs20) i(vs21) i(vs22) i(vs23) i(vs24) i(vs25)
.endc
.end
