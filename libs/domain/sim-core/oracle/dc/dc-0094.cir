controls oracle dc-0094
* Generated (plan F2.7, ADR 0012): do not edit; regenerate with `pnpm sim oracle regen`. dc seed 20261030 index 94 nodes 13 elements 25
.options sparse gmin=1e-12 noopac
RG1 1 0 1000000000000
RG2 2 0 1000000000000
RG3 3 0 1000000000000
RG4 4 0 1000000000000
RG5 5 0 1000000000000
RG6 6 0 1000000000000
RG7 7 0 1000000000000
RG8 8 0 1000000000000
RG9 9 0 1000000000000
RG10 10 0 1000000000000
RG11 11 0 1000000000000
RG12 12 0 1000000000000
VS0 9 s0 0
R0 s0 0 12e-1
VS1 8 s1 0
I1 s1 2 DC 68e-4
VS2 7 s2 0
R2 s2 9 33e3
VS3 5 s3 0
R3 s3 3 22e-2
VS4 4 s4 0
R4 s4 3 18e0
VS5 8 s5 0
R5 s5 4 22e0
VS6 10 s6 0
R6 s6 4 82e-2
VS7 0 s7 0
V7 e7 s7 DC 18e0
RI7 e7 3 56e-3
VS8 12 s8 0
I8 s8 3 DC 82e-1
VS9 7 s9 0
R9 s9 6 10e2
VS10 12 s10 0
R10 s10 9 56e-2
VS11 6 s11 0
R11 s11 3 12e1
VS12 8 s12 0
R12 s12 9 39e3
VS13 9 s13 0
V13 e13 s13 DC 47e0
RI13 e13 2 68e-3
VS14 4 s14 0
R14 s14 5 12e3
VS15 5 s15 0
R15 s15 3 47e-2
VS16 8 s16 0
R16 s16 1 18e0
VS17 7 s17 0
R17 s17 5 68e1
VS18 11 s18 0
R18 s18 8 15e3
VS19 5 s19 0
R19 s19 1 18e-1
VS20 12 s20 0
R20 s20 5 33e1
VS21 6 s21 0
V21 e21 s21 DC 22e1
RI21 e21 10 22e-2
VS22 2 s22 0
R22 s22 7 39e2
VS23 4 s23 0
I23 s23 10 DC 33e-1
VS24 6 s24 0
I24 s24 8 DC 18e-1
.control
set numdgt=17
op
print v(1) v(2) v(3) v(4) v(5) v(6) v(7) v(8) v(9) v(10)
print v(11) v(12)
print i(vs0) i(vs1) i(vs2) i(vs3) i(vs4) i(vs5) i(vs6) i(vs7) i(vs8) i(vs9)
print i(vs10) i(vs11) i(vs12) i(vs13) i(vs14) i(vs15) i(vs16) i(vs17) i(vs18) i(vs19)
print i(vs20) i(vs21) i(vs22) i(vs23) i(vs24)
.endc
.end
