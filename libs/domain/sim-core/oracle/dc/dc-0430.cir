controls oracle dc-0430
* Generated (plan F2.7, ADR 0012): do not edit; regenerate with `pnpm sim oracle regen`. dc seed 20261030 index 430 nodes 9 elements 17
.options sparse gmin=1e-12 noopac
RG1 1 0 1000000000000
RG2 2 0 1000000000000
RG3 3 0 1000000000000
RG4 4 0 1000000000000
RG5 5 0 1000000000000
RG6 6 0 1000000000000
RG7 7 0 1000000000000
RG8 8 0 1000000000000
VS0 1 s0 0
I0 s0 0 DC 39e-3
VS1 7 s1 0
R1 s1 8 27e1
VS2 8 s2 0
R2 s2 5 27e2
VS3 1 s3 0
R3 s3 5 12e2
VS4 0 s4 0
I4 s4 6 DC 33e-3
VS5 7 s5 0
R5 s5 8 68e-2
VS6 3 s6 0
I6 s6 7 DC 47e-1
VS7 5 s7 0
R7 s7 3 12e1
VS8 8 s8 0
R8 s8 2 39e1
VS9 0 s9 0
V9 e9 s9 DC 47e-1
RI9 e9 4 22e-1
VS10 3 s10 0
V10 e10 s10 DC 22e-1
RI10 e10 0 27e-1
VS11 4 s11 0
V11 e11 s11 DC 12e0
RI11 e11 7 68e-3
VS12 6 s12 0
R12 s12 4 12e-1
VS13 6 s13 0
R13 s13 0 10e1
VS14 0 s14 0
R14 s14 2 27e0
VS15 1 s15 0
R15 s15 0 27e3
VS16 8 s16 0
V16 e16 s16 DC 47e1
RI16 e16 5 18e-3
.control
set numdgt=17
op
print v(1) v(2) v(3) v(4) v(5) v(6) v(7) v(8)
print i(vs0) i(vs1) i(vs2) i(vs3) i(vs4) i(vs5) i(vs6) i(vs7) i(vs8) i(vs9)
print i(vs10) i(vs11) i(vs12) i(vs13) i(vs14) i(vs15) i(vs16)
.endc
.end
