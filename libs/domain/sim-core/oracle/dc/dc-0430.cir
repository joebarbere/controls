controls oracle dc-0430
* Generated (plan F2.7, ADR 0012): do not edit; regenerate with `pnpm sim oracle regen`. dc seed 20261030 index 430 nodes 9 elements 15
.options sparse gmin=1e-12 noopac
RG1 1 0 1000000000000
RG2 2 0 1000000000000
RG3 3 0 1000000000000
RG4 4 0 1000000000000
RG5 5 0 1000000000000
RG6 6 0 1000000000000
RG7 7 0 1000000000000
RG8 8 0 1000000000000
VS0 0 s0 0
I0 s0 6 DC 33e-3
VS1 3 s1 0
I1 s1 7 DC 47e-1
VS2 7 s2 0
R2 s2 8 68e-2
VS3 0 s3 0
V3 e3 s3 DC 47e-1
RI3 e3 4 22e-1
VS4 8 s4 0
R4 s4 5 27e2
VS5 0 s5 0
R5 s5 2 27e0
VS6 6 s6 0
R6 s6 4 12e-1
VS7 7 s7 0
R7 s7 8 27e1
VS8 6 s8 0
R8 s8 0 10e1
VS9 3 s9 0
V9 e9 s9 DC 22e-1
RI9 e9 0 27e-1
VS10 4 s10 0
V10 e10 s10 DC 12e0
RI10 e10 7 68e-3
VS11 5 s11 0
R11 s11 3 12e1
VS12 1 s12 0
R12 s12 0 27e3
VS13 8 s13 0
V13 e13 s13 DC 47e1
RI13 e13 5 18e-3
VS14 1 s14 0
I14 s14 0 DC 39e-3
.control
set numdgt=17
op
print v(1) v(2) v(3) v(4) v(5) v(6) v(7) v(8)
print i(vs0) i(vs1) i(vs2) i(vs3) i(vs4) i(vs5) i(vs6) i(vs7) i(vs8) i(vs9)
print i(vs10) i(vs11) i(vs12) i(vs13) i(vs14)
.endc
.end
