controls oracle dc-0477
* Generated (plan F2.7, ADR 0012): do not edit; regenerate with `pnpm sim oracle regen`. dc seed 20261030 index 477 nodes 17 elements 23
.options sparse gmin=1e-12 noopac
RG1 1 0 1000000000000
RG2 2 0 1000000000000
RG3 3 0 1000000000000
RG4 4 0 1000000000000
RG5 5 0 1000000000000
RG6 6 0 1000000000000
RG7 7 0 1000000000000
RG8 8 0 1000000000000
RG9 9 0 1000000000000
RG10 10 0 1000000000000
RG11 11 0 1000000000000
RG12 12 0 1000000000000
RG13 13 0 1000000000000
RG14 14 0 1000000000000
RG15 15 0 1000000000000
RG16 16 0 1000000000000
VS0 0 s0 0
V0 e0 s0 DC 12e-1
RI0 e0 14 10e-2
VS1 0 s1 0
I1 s1 3 DC 82e-1
VS2 16 s2 0
R2 s2 4 10e0
VS3 13 s3 0
R3 s3 12 39e1
VS4 8 s4 0
I4 s4 2 DC 68e-1
VS5 10 s5 0
R5 s5 2 56e1
VS6 16 s6 0
V6 e6 s6 DC 15e0
RI6 e6 3 47e-3
VS7 3 s7 0
R7 s7 13 22e3
VS8 6 s8 0
R8 s8 9 56e3
VS9 13 s9 0
R9 s9 11 33e3
VS10 0 s10 0
I10 s10 15 DC 33e-3
VS11 14 s11 0
V11 e11 s11 DC 10e-1
RI11 e11 1 82e-3
VS12 13 s12 0
I12 s12 16 DC 47e-1
VS13 15 s13 0
R13 s13 14 56e-2
VS14 8 s14 0
R14 s14 2 15e1
VS15 14 s15 0
R15 s15 3 33e3
VS16 14 s16 0
R16 s16 9 68e3
VS17 14 s17 0
R17 s17 9 15e2
VS18 11 s18 0
I18 s18 10 DC 56e-3
VS19 2 s19 0
R19 s19 9 10e3
VS20 2 s20 0
I20 s20 8 DC 18e-3
VS21 3 s21 0
R21 s21 5 56e-2
VS22 9 s22 0
R22 s22 7 18e0
.control
set numdgt=17
op
print v(1) v(2) v(3) v(4) v(5) v(6) v(7) v(8) v(9) v(10)
print v(11) v(12) v(13) v(14) v(15) v(16)
print i(vs0) i(vs1) i(vs2) i(vs3) i(vs4) i(vs5) i(vs6) i(vs7) i(vs8) i(vs9)
print i(vs10) i(vs11) i(vs12) i(vs13) i(vs14) i(vs15) i(vs16) i(vs17) i(vs18) i(vs19)
print i(vs20) i(vs21) i(vs22)
.endc
.end
