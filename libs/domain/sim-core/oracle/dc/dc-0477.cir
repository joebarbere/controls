controls oracle dc-0477
* Generated (plan F2.7, ADR 0012): do not edit; regenerate with `pnpm sim oracle regen`. dc seed 20261030 index 477 nodes 17 elements 31
.options sparse gmin=1e-12 noopac
RG1 1 0 1000000000000
RG2 2 0 1000000000000
RG3 3 0 1000000000000
RG4 4 0 1000000000000
RG5 5 0 1000000000000
RG6 6 0 1000000000000
RG7 7 0 1000000000000
RG8 8 0 1000000000000
RG9 9 0 1000000000000
RG10 10 0 1000000000000
RG11 11 0 1000000000000
RG12 12 0 1000000000000
RG13 13 0 1000000000000
RG14 14 0 1000000000000
RG15 15 0 1000000000000
RG16 16 0 1000000000000
VS0 14 s0 0
R0 s0 13 22e3
VS1 14 s1 0
R1 s1 5 56e-2
VS2 0 s2 0
R2 s2 9 15e2
VS3 0 s3 0
V3 e3 s3 DC 10e-1
RI3 e3 1 82e-3
VS4 8 s4 0
R4 s4 2 15e1
VS5 2 s5 0
I5 s5 8 DC 18e-3
VS6 6 s6 0
R6 s6 7 39e-1
VS7 16 s7 0
R7 s7 4 10e0
VS8 15 s8 0
R8 s8 14 68e3
VS9 16 s9 0
V9 e9 s9 DC 15e0
RI9 e9 14 47e-3
VS10 4 s10 0
V10 e10 s10 DC 33e-1
RI10 e10 3 33e-2
VS11 13 s11 0
R11 s11 12 39e1
VS12 9 s12 0
R12 s12 7 18e0
VS13 12 s13 0
R13 s13 3 22e1
VS14 3 s14 0
I14 s14 15 DC 33e-3
VS15 13 s15 0
R15 s15 11 33e3
VS16 0 s16 0
R16 s16 9 68e3
VS17 2 s17 0
R17 s17 9 10e3
VS18 15 s18 0
R18 s18 0 56e-2
VS19 13 s19 0
I19 s19 16 DC 47e-1
VS20 1 s20 0
R20 s20 6 22e2
VS21 8 s21 0
I21 s21 2 DC 68e-1
VS22 8 s22 0
R22 s22 5 68e-2
VS23 3 s23 0
R23 s23 11 39e1
VS24 3 s24 0
I24 s24 14 DC 82e-1
VS25 6 s25 0
R25 s25 9 56e3
VS26 10 s26 0
R26 s26 2 56e1
VS27 11 s27 0
I27 s27 10 DC 56e-3
VS28 0 s28 0
R28 s28 14 33e3
VS29 3 s29 0
V29 e29 s29 DC 12e-1
RI29 e29 0 10e-2
VS30 10 s30 0
R30 s30 9 18e-1
.control
set numdgt=17
op
print v(1) v(2) v(3) v(4) v(5) v(6) v(7) v(8) v(9) v(10)
print v(11) v(12) v(13) v(14) v(15) v(16)
print i(vs0) i(vs1) i(vs2) i(vs3) i(vs4) i(vs5) i(vs6) i(vs7) i(vs8) i(vs9)
print i(vs10) i(vs11) i(vs12) i(vs13) i(vs14) i(vs15) i(vs16) i(vs17) i(vs18) i(vs19)
print i(vs20) i(vs21) i(vs22) i(vs23) i(vs24) i(vs25) i(vs26) i(vs27) i(vs28) i(vs29)
print i(vs30)
.endc
.end
