controls oracle dc-0384
* Generated (plan F2.7, ADR 0012): do not edit; regenerate with `pnpm sim oracle regen`. dc seed 20261030 index 384 nodes 26 elements 45
.options sparse gmin=1e-12 noopac
RG1 1 0 1000000000000
RG2 2 0 1000000000000
RG3 3 0 1000000000000
RG4 4 0 1000000000000
RG5 5 0 1000000000000
RG6 6 0 1000000000000
RG7 7 0 1000000000000
RG8 8 0 1000000000000
RG9 9 0 1000000000000
RG10 10 0 1000000000000
RG11 11 0 1000000000000
RG12 12 0 1000000000000
RG13 13 0 1000000000000
RG14 14 0 1000000000000
RG15 15 0 1000000000000
RG16 16 0 1000000000000
RG17 17 0 1000000000000
RG18 18 0 1000000000000
RG19 19 0 1000000000000
RG20 20 0 1000000000000
RG21 21 0 1000000000000
RG22 22 0 1000000000000
RG23 23 0 1000000000000
RG24 24 0 1000000000000
RG25 25 0 1000000000000
VS0 0 s0 0
V0 e0 s0 DC 47e-1
RI0 e0 3 27e-2
VS1 3 s1 0
R1 s1 17 22e3
VS2 10 s2 0
R2 s2 0 12e1
VS3 6 s3 0
V3 e3 s3 DC 15e0
RI3 e3 16 10e-2
VS4 2 s4 0
R4 s4 1 18e1
VS5 7 s5 0
V5 e5 s5 DC 27e-1
RI5 e5 21 10e-3
VS6 19 s6 0
R6 s6 22 27e-2
VS7 7 s7 0
V7 e7 s7 DC 18e0
RI7 e7 5 22e-2
VS8 21 s8 0
R8 s8 24 27e-1
VS9 22 s9 0
I9 s9 6 DC 12e-2
VS10 6 s10 0
R10 s10 25 18e-1
VS11 1 s11 0
R11 s11 16 47e1
VS12 9 s12 0
V12 e12 s12 DC 47e-1
RI12 e12 11 18e-2
VS13 22 s13 0
R13 s13 5 47e-1
VS14 20 s14 0
R14 s14 3 47e-1
VS15 9 s15 0
R15 s15 3 68e1
VS16 1 s16 0
R16 s16 16 15e0
VS17 17 s17 0
R17 s17 23 82e2
VS18 1 s18 0
R18 s18 15 27e-1
VS19 15 s19 0
R19 s19 18 10e2
VS20 22 s20 0
R20 s20 10 47e-2
VS21 14 s21 0
V21 e21 s21 DC 10e0
RI21 e21 15 27e-2
VS22 4 s22 0
R22 s22 24 39e-1
VS23 7 s23 0
R23 s23 20 12e1
VS24 25 s24 0
R24 s24 21 12e1
VS25 10 s25 0
R25 s25 23 15e-2
VS26 16 s26 0
R26 s26 12 27e1
VS27 11 s27 0
R27 s27 9 68e3
VS28 11 s28 0
R28 s28 13 56e2
VS29 3 s29 0
V29 e29 s29 DC 27e1
RI29 e29 22 18e-1
VS30 23 s30 0
I30 s30 17 DC 82e-3
VS31 11 s31 0
I31 s31 7 DC 39e-2
VS32 9 s32 0
R32 s32 8 33e2
VS33 2 s33 0
I33 s33 18 DC 47e-2
VS34 4 s34 0
V34 e34 s34 DC 18e-1
RI34 e34 25 22e-1
VS35 21 s35 0
R35 s35 4 22e3
VS36 23 s36 0
I36 s36 22 DC 18e-1
VS37 9 s37 0
V37 e37 s37 DC 82e0
RI37 e37 24 12e-2
VS38 12 s38 0
V38 e38 s38 DC 18e0
RI38 e38 18 39e-1
VS39 22 s39 0
V39 e39 s39 DC 33e-1
RI39 e39 2 10e-1
VS40 14 s40 0
R40 s40 4 39e0
VS41 18 s41 0
R41 s41 8 22e2
VS42 2 s42 0
R42 s42 13 68e0
VS43 12 s43 0
V43 e43 s43 DC 22e0
RI43 e43 19 10e-1
VS44 9 s44 0
V44 e44 s44 DC 27e-1
RI44 e44 25 18e-3
.control
set numdgt=17
op
print v(1) v(2) v(3) v(4) v(5) v(6) v(7) v(8) v(9) v(10)
print v(11) v(12) v(13) v(14) v(15) v(16) v(17) v(18) v(19) v(20)
print v(21) v(22) v(23) v(24) v(25)
print i(vs0) i(vs1) i(vs2) i(vs3) i(vs4) i(vs5) i(vs6) i(vs7) i(vs8) i(vs9)
print i(vs10) i(vs11) i(vs12) i(vs13) i(vs14) i(vs15) i(vs16) i(vs17) i(vs18) i(vs19)
print i(vs20) i(vs21) i(vs22) i(vs23) i(vs24) i(vs25) i(vs26) i(vs27) i(vs28) i(vs29)
print i(vs30) i(vs31) i(vs32) i(vs33) i(vs34) i(vs35) i(vs36) i(vs37) i(vs38) i(vs39)
print i(vs40) i(vs41) i(vs42) i(vs43) i(vs44)
.endc
.end
