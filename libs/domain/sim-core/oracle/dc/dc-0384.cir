controls oracle dc-0384
* Generated (plan F2.7, ADR 0012): do not edit; regenerate with `pnpm sim oracle regen`. dc seed 20261030 index 384 nodes 26 elements 38
.options sparse gmin=1e-12 noopac
RG1 1 0 1000000000000
RG2 2 0 1000000000000
RG3 3 0 1000000000000
RG4 4 0 1000000000000
RG5 5 0 1000000000000
RG6 6 0 1000000000000
RG7 7 0 1000000000000
RG8 8 0 1000000000000
RG9 9 0 1000000000000
RG10 10 0 1000000000000
RG11 11 0 1000000000000
RG12 12 0 1000000000000
RG13 13 0 1000000000000
RG14 14 0 1000000000000
RG15 15 0 1000000000000
RG16 16 0 1000000000000
RG17 17 0 1000000000000
RG18 18 0 1000000000000
RG19 19 0 1000000000000
RG20 20 0 1000000000000
RG21 21 0 1000000000000
RG22 22 0 1000000000000
RG23 23 0 1000000000000
RG24 24 0 1000000000000
RG25 25 0 1000000000000
VS0 0 s0 0
V0 e0 s0 DC 18e0
RI0 e0 5 22e-2
VS1 21 s1 0
R1 s1 4 22e3
VS2 4 s2 0
R2 s2 24 39e-1
VS3 25 s3 0
R3 s3 21 12e1
VS4 9 s4 0
V4 e4 s4 DC 27e-1
RI4 e4 25 18e-3
VS5 7 s5 0
R5 s5 17 22e3
VS6 22 s6 0
V6 e6 s6 DC 33e-1
RI6 e6 2 10e-1
VS7 11 s7 0
R7 s7 13 56e2
VS8 2 s8 0
R8 s8 1 18e1
VS9 11 s9 0
R9 s9 9 68e3
VS10 18 s10 0
R10 s10 8 22e2
VS11 17 s11 0
R11 s11 23 82e2
VS12 9 s12 0
R12 s12 8 33e2
VS13 19 s13 0
R13 s13 22 27e-2
VS14 6 s14 0
R14 s14 25 18e-1
VS15 0 s15 0
R15 s15 20 12e1
VS16 7 s16 0
V16 e16 s16 DC 27e1
RI16 e16 22 18e-1
VS17 15 s17 0
R17 s17 18 10e2
VS18 4 s18 0
V18 e18 s18 DC 18e-1
RI18 e18 25 22e-1
VS19 16 s19 0
R19 s19 12 27e1
VS20 1 s20 0
R20 s20 15 27e-1
VS21 1 s21 0
R21 s21 16 15e0
VS22 9 s22 0
R22 s22 7 68e1
VS23 11 s23 0
I23 s23 0 DC 39e-2
VS24 2 s24 0
I24 s24 18 DC 47e-2
VS25 14 s25 0
R25 s25 4 39e0
VS26 22 s26 0
I26 s26 6 DC 12e-2
VS27 22 s27 0
R27 s27 10 47e-2
VS28 10 s28 0
R28 s28 3 12e1
VS29 9 s29 0
V29 e29 s29 DC 47e-1
RI29 e29 11 18e-2
VS30 2 s30 0
R30 s30 13 68e0
VS31 0 s31 0
V31 e31 s31 DC 27e-1
RI31 e31 21 10e-3
VS32 1 s32 0
R32 s32 16 47e1
VS33 20 s33 0
R33 s33 7 47e-1
VS34 23 s34 0
I34 s34 22 DC 18e-1
VS35 9 s35 0
V35 e35 s35 DC 82e0
RI35 e35 24 12e-2
VS36 21 s36 0
R36 s36 24 27e-1
VS37 23 s37 0
I37 s37 17 DC 82e-3
.control
set numdgt=17
op
print v(1) v(2) v(3) v(4) v(5) v(6) v(7) v(8) v(9) v(10)
print v(11) v(12) v(13) v(14) v(15) v(16) v(17) v(18) v(19) v(20)
print v(21) v(22) v(23) v(24) v(25)
print i(vs0) i(vs1) i(vs2) i(vs3) i(vs4) i(vs5) i(vs6) i(vs7) i(vs8) i(vs9)
print i(vs10) i(vs11) i(vs12) i(vs13) i(vs14) i(vs15) i(vs16) i(vs17) i(vs18) i(vs19)
print i(vs20) i(vs21) i(vs22) i(vs23) i(vs24) i(vs25) i(vs26) i(vs27) i(vs28) i(vs29)
print i(vs30) i(vs31) i(vs32) i(vs33) i(vs34) i(vs35) i(vs36) i(vs37)
.endc
.end
