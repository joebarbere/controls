controls oracle dc-0383
* Generated (plan F2.7, ADR 0012): do not edit; regenerate with `pnpm sim oracle regen`. dc seed 20261030 index 383 nodes 8 elements 12
.options sparse gmin=1e-12 noopac
RG1 1 0 1000000000000
RG2 2 0 1000000000000
RG3 3 0 1000000000000
RG4 4 0 1000000000000
RG5 5 0 1000000000000
RG6 6 0 1000000000000
RG7 7 0 1000000000000
VS0 3 s0 0
R0 s0 7 27e1
VS1 6 s1 0
R1 s1 3 33e1
VS2 7 s2 0
R2 s2 0 10e0
VS3 1 s3 0
R3 s3 4 33e-2
VS4 4 s4 0
R4 s4 6 22e1
VS5 0 s5 0
V5 e5 s5 DC 27e0
RI5 e5 2 22e-3
VS6 2 s6 0
R6 s6 5 27e-1
VS7 7 s7 0
I7 s7 5 DC 18e-1
VS8 0 s8 0
V8 e8 s8 DC 15e0
RI8 e8 6 22e-3
VS9 1 s9 0
R9 s9 3 15e-1
VS10 3 s10 0
R10 s10 5 33e2
VS11 4 s11 0
I11 s11 5 DC 22e-2
.control
set numdgt=17
op
print v(1) v(2) v(3) v(4) v(5) v(6) v(7)
print i(vs0) i(vs1) i(vs2) i(vs3) i(vs4) i(vs5) i(vs6) i(vs7) i(vs8) i(vs9)
print i(vs10) i(vs11)
.endc
.end
