controls oracle dc-0383
* Generated (plan F2.7, ADR 0012): do not edit; regenerate with `pnpm sim oracle regen`. dc seed 20261030 index 383 nodes 8 elements 9
.options sparse gmin=1e-12 noopac
RG1 1 0 1000000000000
RG2 2 0 1000000000000
RG3 3 0 1000000000000
RG4 4 0 1000000000000
RG5 5 0 1000000000000
RG6 6 0 1000000000000
RG7 7 0 1000000000000
VS0 7 s0 0
R0 s0 0 10e0
VS1 1 s1 0
R1 s1 4 33e-2
VS2 4 s2 0
I2 s2 5 DC 22e-2
VS3 0 s3 0
V3 e3 s3 DC 27e0
RI3 e3 2 22e-3
VS4 6 s4 0
R4 s4 3 33e1
VS5 4 s5 0
R5 s5 6 22e1
VS6 0 s6 0
V6 e6 s6 DC 15e0
RI6 e6 6 22e-3
VS7 2 s7 0
R7 s7 5 27e-1
VS8 7 s8 0
I8 s8 5 DC 18e-1
.control
set numdgt=17
op
print v(1) v(2) v(3) v(4) v(5) v(6) v(7)
print i(vs0) i(vs1) i(vs2) i(vs3) i(vs4) i(vs5) i(vs6) i(vs7) i(vs8)
.endc
.end
