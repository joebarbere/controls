controls oracle dc-0446
* Generated (plan F2.7, ADR 0012): do not edit; regenerate with `pnpm sim oracle regen`. dc seed 20261030 index 446 nodes 12 elements 17
.options sparse gmin=1e-12 noopac
RG1 1 0 1000000000000
RG2 2 0 1000000000000
RG3 3 0 1000000000000
RG4 4 0 1000000000000
RG5 5 0 1000000000000
RG6 6 0 1000000000000
RG7 7 0 1000000000000
RG8 8 0 1000000000000
RG9 9 0 1000000000000
RG10 10 0 1000000000000
RG11 11 0 1000000000000
VS0 0 s0 0
R0 s0 5 27e-1
VS1 0 s1 0
V1 e1 s1 DC 39e0
RI1 e1 3 27e-2
VS2 6 s2 0
R2 s2 11 47e0
VS3 10 s3 0
V3 e3 s3 DC 39e1
RI3 e3 11 15e-2
VS4 8 s4 0
R4 s4 10 56e3
VS5 5 s5 0
R5 s5 11 18e0
VS6 3 s6 0
R6 s6 1 68e1
VS7 6 s7 0
V7 e7 s7 DC 33e0
RI7 e7 9 56e-2
VS8 4 s8 0
R8 s8 7 39e2
VS9 10 s9 0
R9 s9 2 82e2
VS10 9 s10 0
R10 s10 10 33e3
VS11 1 s11 0
R11 s11 11 56e1
VS12 0 s12 0
R12 s12 1 82e-2
VS13 9 s13 0
R13 s13 7 56e-1
VS14 0 s14 0
V14 e14 s14 DC 10e0
RI14 e14 4 27e-2
VS15 2 s15 0
R15 s15 4 18e1
VS16 8 s16 0
R16 s16 1 27e2
.control
set numdgt=17
op
print v(1) v(2) v(3) v(4) v(5) v(6) v(7) v(8) v(9) v(10)
print v(11)
print i(vs0) i(vs1) i(vs2) i(vs3) i(vs4) i(vs5) i(vs6) i(vs7) i(vs8) i(vs9)
print i(vs10) i(vs11) i(vs12) i(vs13) i(vs14) i(vs15) i(vs16)
.endc
.end
