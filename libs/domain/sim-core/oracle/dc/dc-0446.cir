controls oracle dc-0446
* Generated (plan F2.7, ADR 0012): do not edit; regenerate with `pnpm sim oracle regen`. dc seed 20261030 index 446 nodes 12 elements 12
.options sparse gmin=1e-12 noopac
RG1 1 0 1000000000000
RG2 2 0 1000000000000
RG3 3 0 1000000000000
RG4 4 0 1000000000000
RG5 5 0 1000000000000
RG6 6 0 1000000000000
RG7 7 0 1000000000000
RG8 8 0 1000000000000
RG9 9 0 1000000000000
RG10 10 0 1000000000000
RG11 11 0 1000000000000
VS0 2 s0 0
R0 s0 4 18e1
VS1 6 s1 0
R1 s1 11 47e0
VS2 10 s2 0
R2 s2 11 47e0
VS3 0 s3 0
R3 s3 1 82e-2
VS4 9 s4 0
R4 s4 10 33e3
VS5 4 s5 0
R5 s5 7 39e2
VS6 0 s6 0
V6 e6 s6 DC 39e0
RI6 e6 3 27e-2
VS7 10 s7 0
V7 e7 s7 DC 39e1
RI7 e7 11 15e-2
VS8 8 s8 0
R8 s8 10 56e3
VS9 1 s9 0
R9 s9 11 56e1
VS10 5 s10 0
R10 s10 11 18e0
VS11 0 s11 0
V11 e11 s11 DC 10e0
RI11 e11 4 27e-2
.control
set numdgt=17
op
print v(1) v(2) v(3) v(4) v(5) v(6) v(7) v(8) v(9) v(10)
print v(11)
print i(vs0) i(vs1) i(vs2) i(vs3) i(vs4) i(vs5) i(vs6) i(vs7) i(vs8) i(vs9)
print i(vs10) i(vs11)
.endc
.end
