controls oracle dc-0046
* Generated (plan F2.7, ADR 0012): do not edit; regenerate with `pnpm sim oracle regen`. dc seed 20261030 index 46 nodes 30 elements 56
.options sparse gmin=1e-12 noopac
RG1 1 0 1000000000000
RG2 2 0 1000000000000
RG3 3 0 1000000000000
RG4 4 0 1000000000000
RG5 5 0 1000000000000
RG6 6 0 1000000000000
RG7 7 0 1000000000000
RG8 8 0 1000000000000
RG9 9 0 1000000000000
RG10 10 0 1000000000000
RG11 11 0 1000000000000
RG12 12 0 1000000000000
RG13 13 0 1000000000000
RG14 14 0 1000000000000
RG15 15 0 1000000000000
RG16 16 0 1000000000000
RG17 17 0 1000000000000
RG18 18 0 1000000000000
RG19 19 0 1000000000000
RG20 20 0 1000000000000
RG21 21 0 1000000000000
RG22 22 0 1000000000000
RG23 23 0 1000000000000
RG24 24 0 1000000000000
RG25 25 0 1000000000000
RG26 26 0 1000000000000
RG27 27 0 1000000000000
RG28 28 0 1000000000000
RG29 29 0 1000000000000
VS0 8 s0 0
R0 s0 16 39e1
VS1 0 s1 0
I1 s1 29 DC 68e-1
VS2 9 s2 0
R2 s2 4 39e0
VS3 0 s3 0
V3 e3 s3 DC 22e-1
RI3 e3 26 39e-1
VS4 12 s4 0
V4 e4 s4 DC 33e1
RI4 e4 5 56e-3
VS5 7 s5 0
R5 s5 13 33e3
VS6 16 s6 0
R6 s6 13 12e3
VS7 13 s7 0
R7 s7 10 18e0
VS8 2 s8 0
V8 e8 s8 DC 10e-1
RI8 e8 28 68e-2
VS9 4 s9 0
V9 e9 s9 DC 15e0
RI9 e9 23 12e-1
VS10 21 s10 0
R10 s10 12 68e3
VS11 12 s11 0
R11 s11 13 47e2
VS12 6 s12 0
R12 s12 21 15e-1
VS13 18 s13 0
V13 e13 s13 DC 10e-1
RI13 e13 11 33e-2
VS14 12 s14 0
R14 s14 2 18e-1
VS15 22 s15 0
R15 s15 6 18e1
VS16 1 s16 0
R16 s16 7 68e-1
VS17 29 s17 0
R17 s17 15 56e2
VS18 26 s18 0
I18 s18 11 DC 68e-3
VS19 0 s19 0
R19 s19 4 68e1
VS20 23 s20 0
R20 s20 24 33e1
VS21 19 s21 0
R21 s21 15 47e-2
VS22 9 s22 0
V22 e22 s22 DC 22e1
RI22 e22 24 68e-3
VS23 23 s23 0
R23 s23 8 12e2
VS24 19 s24 0
I24 s24 12 DC 68e-3
VS25 16 s25 0
R25 s25 20 27e1
VS26 16 s26 0
V26 e26 s26 DC 82e1
RI26 e26 26 82e-1
VS27 26 s27 0
R27 s27 20 47e0
VS28 13 s28 0
R28 s28 23 27e0
VS29 17 s29 0
R29 s29 14 56e-1
VS30 6 s30 0
R30 s30 26 33e-2
VS31 7 s31 0
R31 s31 18 39e0
VS32 27 s32 0
R32 s32 8 68e3
VS33 19 s33 0
R33 s33 11 56e2
VS34 0 s34 0
I34 s34 8 DC 39e-3
VS35 23 s35 0
V35 e35 s35 DC 33e0
RI35 e35 25 33e-2
VS36 16 s36 0
R36 s36 5 22e3
VS37 13 s37 0
R37 s37 3 47e3
VS38 27 s38 0
R38 s38 16 12e-2
VS39 2 s39 0
R39 s39 3 39e-2
VS40 6 s40 0
I40 s40 25 DC 68e-4
VS41 25 s41 0
R41 s41 20 47e2
VS42 17 s42 0
R42 s42 19 15e-2
VS43 26 s43 0
R43 s43 10 82e2
VS44 2 s44 0
V44 e44 s44 DC 27e-1
RI44 e44 13 47e-2
VS45 26 s45 0
I45 s45 13 DC 10e-2
VS46 1 s46 0
R46 s46 10 39e0
VS47 19 s47 0
R47 s47 29 56e3
VS48 28 s48 0
R48 s48 22 33e-2
VS49 3 s49 0
R49 s49 28 82e0
VS50 4 s50 0
I50 s50 29 DC 33e-4
VS51 26 s51 0
V51 e51 s51 DC 47e0
RI51 e51 14 10e-3
VS52 1 s52 0
R52 s52 8 10e0
VS53 29 s53 0
R53 s53 24 39e2
VS54 2 s54 0
V54 e54 s54 DC 27e-1
RI54 e54 22 18e-2
VS55 20 s55 0
I55 s55 3 DC 68e-4
.control
set numdgt=17
op
print v(1) v(2) v(3) v(4) v(5) v(6) v(7) v(8) v(9) v(10)
print v(11) v(12) v(13) v(14) v(15) v(16) v(17) v(18) v(19) v(20)
print v(21) v(22) v(23) v(24) v(25) v(26) v(27) v(28) v(29)
print i(vs0) i(vs1) i(vs2) i(vs3) i(vs4) i(vs5) i(vs6) i(vs7) i(vs8) i(vs9)
print i(vs10) i(vs11) i(vs12) i(vs13) i(vs14) i(vs15) i(vs16) i(vs17) i(vs18) i(vs19)
print i(vs20) i(vs21) i(vs22) i(vs23) i(vs24) i(vs25) i(vs26) i(vs27) i(vs28) i(vs29)
print i(vs30) i(vs31) i(vs32) i(vs33) i(vs34) i(vs35) i(vs36) i(vs37) i(vs38) i(vs39)
print i(vs40) i(vs41) i(vs42) i(vs43) i(vs44) i(vs45) i(vs46) i(vs47) i(vs48) i(vs49)
print i(vs50) i(vs51) i(vs52) i(vs53) i(vs54) i(vs55)
.endc
.end
