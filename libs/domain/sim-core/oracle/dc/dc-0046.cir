controls oracle dc-0046
* Generated (plan F2.7, ADR 0012): do not edit; regenerate with `pnpm sim oracle regen`. dc seed 20261030 index 46 nodes 30 elements 52
.options sparse gmin=1e-12 noopac
RG1 1 0 1000000000000
RG2 2 0 1000000000000
RG3 3 0 1000000000000
RG4 4 0 1000000000000
RG5 5 0 1000000000000
RG6 6 0 1000000000000
RG7 7 0 1000000000000
RG8 8 0 1000000000000
RG9 9 0 1000000000000
RG10 10 0 1000000000000
RG11 11 0 1000000000000
RG12 12 0 1000000000000
RG13 13 0 1000000000000
RG14 14 0 1000000000000
RG15 15 0 1000000000000
RG16 16 0 1000000000000
RG17 17 0 1000000000000
RG18 18 0 1000000000000
RG19 19 0 1000000000000
RG20 20 0 1000000000000
RG21 21 0 1000000000000
RG22 22 0 1000000000000
RG23 23 0 1000000000000
RG24 24 0 1000000000000
RG25 25 0 1000000000000
RG26 26 0 1000000000000
RG27 27 0 1000000000000
RG28 28 0 1000000000000
RG29 29 0 1000000000000
VS0 19 s0 0
R0 s0 11 56e2
VS1 19 s1 0
R1 s1 15 47e-2
VS2 19 s2 0
R2 s2 29 56e3
VS3 22 s3 0
R3 s3 6 18e1
VS4 23 s4 0
R4 s4 8 12e2
VS5 0 s5 0
V5 e5 s5 DC 27e-1
RI5 e5 22 18e-2
VS6 25 s6 0
R6 s6 20 47e2
VS7 1 s7 0
R7 s7 10 39e0
VS8 7 s8 0
R8 s8 13 33e3
VS9 16 s9 0
I9 s9 29 DC 68e-1
VS10 0 s10 0
R10 s10 3 39e-2
VS11 4 s11 0
I11 s11 29 DC 33e-4
VS12 26 s12 0
R12 s12 20 47e0
VS13 1 s13 0
R13 s13 8 10e0
VS14 0 s14 0
V14 e14 s14 DC 27e-1
RI14 e14 13 47e-2
VS15 16 s15 0
R15 s15 4 68e1
VS16 9 s16 0
V16 e16 s16 DC 22e1
RI16 e16 24 68e-3
VS17 12 s17 0
R17 s17 13 47e2
VS18 23 s18 0
R18 s18 24 33e1
VS19 2 s19 0
R19 s19 20 27e1
VS20 6 s20 0
R20 s20 21 15e-1
VS21 23 s21 0
V21 e21 s21 DC 33e0
RI21 e21 25 33e-2
VS22 26 s22 0
I22 s22 13 DC 10e-2
VS23 28 s23 0
R23 s23 22 33e-2
VS24 2 s24 0
R24 s24 5 22e3
VS25 16 s25 0
V25 e25 s25 DC 22e-1
RI25 e25 26 39e-1
VS26 13 s26 0
R26 s26 10 18e0
VS27 17 s27 0
R27 s27 19 15e-2
VS28 13 s28 0
R28 s28 23 27e0
VS29 0 s29 0
V29 e29 s29 DC 10e-1
RI29 e29 28 68e-2
VS30 19 s30 0
I30 s30 12 DC 68e-3
VS31 2 s31 0
R31 s31 13 12e3
VS32 17 s32 0
R32 s32 14 56e-1
VS33 16 s33 0
I33 s33 8 DC 39e-3
VS34 3 s34 0
R34 s34 28 82e0
VS35 7 s35 0
R35 s35 18 39e0
VS36 6 s36 0
R36 s36 26 33e-2
VS37 26 s37 0
R37 s37 10 82e2
VS38 12 s38 0
V38 e38 s38 DC 33e1
RI38 e38 5 56e-3
VS39 26 s39 0
I39 s39 11 DC 68e-3
VS40 26 s40 0
V40 e40 s40 DC 47e0
RI40 e40 14 10e-3
VS41 29 s41 0
R41 s41 24 39e2
VS42 12 s42 0
R42 s42 0 18e-1
VS43 2 s43 0
V43 e43 s43 DC 82e1
RI43 e43 26 82e-1
VS44 4 s44 0
V44 e44 s44 DC 15e0
RI44 e44 23 12e-1
VS45 6 s45 0
I45 s45 25 DC 68e-4
VS46 1 s46 0
R46 s46 7 68e-1
VS47 20 s47 0
I47 s47 3 DC 68e-4
VS48 27 s48 0
R48 s48 8 68e3
VS49 21 s49 0
R49 s49 12 68e3
VS50 13 s50 0
R50 s50 3 47e3
VS51 8 s51 0
R51 s51 2 39e1
.control
set numdgt=17
op
print v(1) v(2) v(3) v(4) v(5) v(6) v(7) v(8) v(9) v(10)
print v(11) v(12) v(13) v(14) v(15) v(16) v(17) v(18) v(19) v(20)
print v(21) v(22) v(23) v(24) v(25) v(26) v(27) v(28) v(29)
print i(vs0) i(vs1) i(vs2) i(vs3) i(vs4) i(vs5) i(vs6) i(vs7) i(vs8) i(vs9)
print i(vs10) i(vs11) i(vs12) i(vs13) i(vs14) i(vs15) i(vs16) i(vs17) i(vs18) i(vs19)
print i(vs20) i(vs21) i(vs22) i(vs23) i(vs24) i(vs25) i(vs26) i(vs27) i(vs28) i(vs29)
print i(vs30) i(vs31) i(vs32) i(vs33) i(vs34) i(vs35) i(vs36) i(vs37) i(vs38) i(vs39)
print i(vs40) i(vs41) i(vs42) i(vs43) i(vs44) i(vs45) i(vs46) i(vs47) i(vs48) i(vs49)
print i(vs50) i(vs51)
.endc
.end
