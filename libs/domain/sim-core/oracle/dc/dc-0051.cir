controls oracle dc-0051
* Generated (plan F2.7, ADR 0012): do not edit; regenerate with `pnpm sim oracle regen`. dc seed 20261030 index 51 nodes 20 elements 41
.options sparse gmin=1e-12 noopac
RG1 1 0 1000000000000
RG2 2 0 1000000000000
RG3 3 0 1000000000000
RG4 4 0 1000000000000
RG5 5 0 1000000000000
RG6 6 0 1000000000000
RG7 7 0 1000000000000
RG8 8 0 1000000000000
RG9 9 0 1000000000000
RG10 10 0 1000000000000
RG11 11 0 1000000000000
RG12 12 0 1000000000000
RG13 13 0 1000000000000
RG14 14 0 1000000000000
RG15 15 0 1000000000000
RG16 16 0 1000000000000
RG17 17 0 1000000000000
RG18 18 0 1000000000000
RG19 19 0 1000000000000
VS0 16 s0 0
R0 s0 5 33e-1
VS1 11 s1 0
R1 s1 5 82e2
VS2 17 s2 0
R2 s2 10 15e1
VS3 17 s3 0
R3 s3 11 22e2
VS4 9 s4 0
R4 s4 7 10e2
VS5 17 s5 0
R5 s5 6 56e3
VS6 13 s6 0
R6 s6 16 27e-2
VS7 15 s7 0
R7 s7 12 22e0
VS8 6 s8 0
R8 s8 3 27e1
VS9 6 s9 0
R9 s9 4 56e1
VS10 4 s10 0
R10 s10 11 47e-1
VS11 15 s11 0
I11 s11 18 DC 82e-4
VS12 15 s12 0
R12 s12 7 22e0
VS13 8 s13 0
R13 s13 4 10e1
VS14 6 s14 0
R14 s14 4 15e-2
VS15 1 s15 0
I15 s15 13 DC 33e-1
VS16 11 s16 0
I16 s16 18 DC 15e-3
VS17 11 s17 0
R17 s17 6 68e1
VS18 16 s18 0
I18 s18 11 DC 68e-2
VS19 0 s19 0
V19 e19 s19 DC 56e1
RI19 e19 2 68e-1
VS20 5 s20 0
R20 s20 2 68e1
VS21 14 s21 0
R21 s21 12 82e3
VS22 11 s22 0
R22 s22 15 10e0
VS23 11 s23 0
R23 s23 19 33e-1
VS24 3 s24 0
R24 s24 0 68e-1
VS25 10 s25 0
R25 s25 9 12e-2
VS26 1 s26 0
R26 s26 6 27e3
VS27 6 s27 0
V27 e27 s27 DC 22e1
RI27 e27 18 18e-2
VS28 7 s28 0
R28 s28 2 12e-1
VS29 18 s29 0
I29 s29 3 DC 12e-4
VS30 6 s30 0
R30 s30 7 27e-2
VS31 13 s31 0
V31 e31 s31 DC 39e1
RI31 e31 7 22e-3
VS32 8 s32 0
R32 s32 3 22e-2
VS33 9 s33 0
R33 s33 1 68e2
VS34 0 s34 0
V34 e34 s34 DC 33e0
RI34 e34 16 56e-3
VS35 14 s35 0
R35 s35 18 39e-1
VS36 11 s36 0
R36 s36 7 56e-1
VS37 4 s37 0
R37 s37 17 12e-2
VS38 6 s38 0
I38 s38 17 DC 15e-4
VS39 0 s39 0
R39 s39 14 12e3
VS40 15 s40 0
R40 s40 19 27e-2
.control
set numdgt=17
op
print v(1) v(2) v(3) v(4) v(5) v(6) v(7) v(8) v(9) v(10)
print v(11) v(12) v(13) v(14) v(15) v(16) v(17) v(18) v(19)
print i(vs0) i(vs1) i(vs2) i(vs3) i(vs4) i(vs5) i(vs6) i(vs7) i(vs8) i(vs9)
print i(vs10) i(vs11) i(vs12) i(vs13) i(vs14) i(vs15) i(vs16) i(vs17) i(vs18) i(vs19)
print i(vs20) i(vs21) i(vs22) i(vs23) i(vs24) i(vs25) i(vs26) i(vs27) i(vs28) i(vs29)
print i(vs30) i(vs31) i(vs32) i(vs33) i(vs34) i(vs35) i(vs36) i(vs37) i(vs38) i(vs39)
print i(vs40)
.endc
.end
