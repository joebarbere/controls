controls oracle dc-0070
* Generated (plan F2.7, ADR 0012): do not edit; regenerate with `pnpm sim oracle regen`. dc seed 20261030 index 70 nodes 23 elements 41
.options sparse gmin=1e-12 noopac
RG1 1 0 1000000000000
RG2 2 0 1000000000000
RG3 3 0 1000000000000
RG4 4 0 1000000000000
RG5 5 0 1000000000000
RG6 6 0 1000000000000
RG7 7 0 1000000000000
RG8 8 0 1000000000000
RG9 9 0 1000000000000
RG10 10 0 1000000000000
RG11 11 0 1000000000000
RG12 12 0 1000000000000
RG13 13 0 1000000000000
RG14 14 0 1000000000000
RG15 15 0 1000000000000
RG16 16 0 1000000000000
RG17 17 0 1000000000000
RG18 18 0 1000000000000
RG19 19 0 1000000000000
RG20 20 0 1000000000000
RG21 21 0 1000000000000
RG22 22 0 1000000000000
VS0 15 s0 0
I0 s0 3 DC 33e-4
VS1 21 s1 0
R1 s1 18 22e-2
VS2 0 s2 0
V2 e2 s2 DC 33e1
RI2 e2 21 47e-3
VS3 18 s3 0
V3 e3 s3 DC 27e-1
RI3 e3 15 22e-3
VS4 12 s4 0
R4 s4 2 33e1
VS5 4 s5 0
V5 e5 s5 DC 12e0
RI5 e5 20 33e-2
VS6 20 s6 0
R6 s6 22 47e-1
VS7 1 s7 0
R7 s7 2 15e-2
VS8 16 s8 0
R8 s8 14 39e3
VS9 10 s9 0
I9 s9 1 DC 56e-1
VS10 9 s10 0
R10 s10 19 39e2
VS11 10 s11 0
R11 s11 3 18e0
VS12 2 s12 0
V12 e12 s12 DC 12e0
RI12 e12 15 27e-2
VS13 5 s13 0
R13 s13 19 10e2
VS14 13 s14 0
V14 e14 s14 DC 10e1
RI14 e14 19 39e-2
VS15 5 s15 0
I15 s15 3 DC 47e-4
VS16 16 s16 0
R16 s16 19 82e-2
VS17 0 s17 0
I17 s17 1 DC 10e-2
VS18 5 s18 0
R18 s18 6 27e3
VS19 11 s19 0
I19 s19 2 DC 10e-1
VS20 1 s20 0
R20 s20 14 39e0
VS21 1 s21 0
I21 s21 20 DC 47e-1
VS22 14 s22 0
I22 s22 1 DC 27e-4
VS23 10 s23 0
R23 s23 6 22e1
VS24 4 s24 0
R24 s24 7 27e-2
VS25 22 s25 0
V25 e25 s25 DC 56e0
RI25 e25 13 22e-2
VS26 13 s26 0
V26 e26 s26 DC 47e-1
RI26 e26 12 33e-1
VS27 7 s27 0
R27 s27 1 68e-1
VS28 7 s28 0
R28 s28 10 15e-2
VS29 4 s29 0
R29 s29 1 33e-1
VS30 19 s30 0
V30 e30 s30 DC 15e-1
RI30 e30 8 27e-3
VS31 3 s31 0
I31 s31 11 DC 33e-3
VS32 16 s32 0
R32 s32 0 56e0
VS33 17 s33 0
V33 e33 s33 DC 33e-1
RI33 e33 18 12e-2
VS34 3 s34 0
V34 e34 s34 DC 15e1
RI34 e34 12 82e-1
VS35 11 s35 0
R35 s35 16 56e0
VS36 0 s36 0
R36 s36 17 27e2
VS37 9 s37 0
R37 s37 6 68e3
VS38 15 s38 0
R38 s38 19 56e1
VS39 4 s39 0
R39 s39 8 18e2
VS40 3 s40 0
R40 s40 11 82e0
.control
set numdgt=17
op
print v(1) v(2) v(3) v(4) v(5) v(6) v(7) v(8) v(9) v(10)
print v(11) v(12) v(13) v(14) v(15) v(16) v(17) v(18) v(19) v(20)
print v(21) v(22)
print i(vs0) i(vs1) i(vs2) i(vs3) i(vs4) i(vs5) i(vs6) i(vs7) i(vs8) i(vs9)
print i(vs10) i(vs11) i(vs12) i(vs13) i(vs14) i(vs15) i(vs16) i(vs17) i(vs18) i(vs19)
print i(vs20) i(vs21) i(vs22) i(vs23) i(vs24) i(vs25) i(vs26) i(vs27) i(vs28) i(vs29)
print i(vs30) i(vs31) i(vs32) i(vs33) i(vs34) i(vs35) i(vs36) i(vs37) i(vs38) i(vs39)
print i(vs40)
.endc
.end
