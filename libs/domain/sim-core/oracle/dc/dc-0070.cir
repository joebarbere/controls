controls oracle dc-0070
* Generated (plan F2.7, ADR 0012): do not edit; regenerate with `pnpm sim oracle regen`. dc seed 20261030 index 70 nodes 23 elements 38
.options sparse gmin=1e-12 noopac
RG1 1 0 1000000000000
RG2 2 0 1000000000000
RG3 3 0 1000000000000
RG4 4 0 1000000000000
RG5 5 0 1000000000000
RG6 6 0 1000000000000
RG7 7 0 1000000000000
RG8 8 0 1000000000000
RG9 9 0 1000000000000
RG10 10 0 1000000000000
RG11 11 0 1000000000000
RG12 12 0 1000000000000
RG13 13 0 1000000000000
RG14 14 0 1000000000000
RG15 15 0 1000000000000
RG16 16 0 1000000000000
RG17 17 0 1000000000000
RG18 18 0 1000000000000
RG19 19 0 1000000000000
RG20 20 0 1000000000000
RG21 21 0 1000000000000
RG22 22 0 1000000000000
VS0 0 s0 0
V0 e0 s0 DC 12e0
RI0 e0 15 27e-2
VS1 4 s1 0
R1 s1 7 27e-2
VS2 15 s2 0
R2 s2 19 56e1
VS3 14 s3 0
I3 s3 1 DC 27e-4
VS4 9 s4 0
R4 s4 19 39e2
VS5 20 s5 0
R5 s5 2 47e-1
VS6 17 s6 0
V6 e6 s6 DC 33e-1
RI6 e6 18 12e-2
VS7 16 s7 0
R7 s7 22 56e0
VS8 10 s8 0
I8 s8 1 DC 56e-1
VS9 21 s9 0
R9 s9 18 22e-2
VS10 7 s10 0
R10 s10 1 68e-1
VS11 7 s11 0
R11 s11 10 15e-2
VS12 22 s12 0
V12 e12 s12 DC 33e1
RI12 e12 21 47e-3
VS13 16 s13 0
R13 s13 19 82e-2
VS14 5 s14 0
R14 s14 6 27e3
VS15 12 s15 0
R15 s15 0 33e1
VS16 1 s16 0
R16 s16 0 15e-2
VS17 16 s17 0
R17 s17 14 39e3
VS18 11 s18 0
I18 s18 0 DC 10e-1
VS19 22 s19 0
I19 s19 1 DC 10e-2
VS20 1 s20 0
R20 s20 14 39e0
VS21 18 s21 0
V21 e21 s21 DC 27e-1
RI21 e21 15 22e-3
VS22 5 s22 0
R22 s22 19 10e2
VS23 10 s23 0
R23 s23 3 18e0
VS24 15 s24 0
I24 s24 3 DC 33e-4
VS25 3 s25 0
I25 s25 11 DC 33e-3
VS26 3 s26 0
V26 e26 s26 DC 15e1
RI26 e26 12 82e-1
VS27 11 s27 0
R27 s27 16 56e0
VS28 13 s28 0
V28 e28 s28 DC 47e-1
RI28 e28 12 33e-1
VS29 2 s29 0
V29 e29 s29 DC 56e0
RI29 e29 13 22e-2
VS30 3 s30 0
R30 s30 11 82e0
VS31 19 s31 0
V31 e31 s31 DC 15e-1
RI31 e31 8 27e-3
VS32 5 s32 0
I32 s32 3 DC 47e-4
VS33 10 s33 0
R33 s33 6 22e1
VS34 4 s34 0
V34 e34 s34 DC 12e0
RI34 e34 20 33e-2
VS35 13 s35 0
V35 e35 s35 DC 10e1
RI35 e35 19 39e-2
VS36 4 s36 0
R36 s36 1 33e-1
VS37 1 s37 0
I37 s37 20 DC 47e-1
.control
set numdgt=17
op
print v(1) v(2) v(3) v(4) v(5) v(6) v(7) v(8) v(9) v(10)
print v(11) v(12) v(13) v(14) v(15) v(16) v(17) v(18) v(19) v(20)
print v(21) v(22)
print i(vs0) i(vs1) i(vs2) i(vs3) i(vs4) i(vs5) i(vs6) i(vs7) i(vs8) i(vs9)
print i(vs10) i(vs11) i(vs12) i(vs13) i(vs14) i(vs15) i(vs16) i(vs17) i(vs18) i(vs19)
print i(vs20) i(vs21) i(vs22) i(vs23) i(vs24) i(vs25) i(vs26) i(vs27) i(vs28) i(vs29)
print i(vs30) i(vs31) i(vs32) i(vs33) i(vs34) i(vs35) i(vs36) i(vs37)
.endc
.end
