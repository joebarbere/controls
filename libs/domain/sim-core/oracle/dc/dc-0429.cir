controls oracle dc-0429
* Generated (plan F2.7, ADR 0012): do not edit; regenerate with `pnpm sim oracle regen`. dc seed 20261030 index 429 nodes 10 elements 11
.options sparse gmin=1e-12 noopac
RG1 1 0 1000000000000
RG2 2 0 1000000000000
RG3 3 0 1000000000000
RG4 4 0 1000000000000
RG5 5 0 1000000000000
RG6 6 0 1000000000000
RG7 7 0 1000000000000
RG8 8 0 1000000000000
RG9 9 0 1000000000000
VS0 6 s0 0
R0 s0 9 56e-2
VS1 6 s1 0
R1 s1 5 10e0
VS2 4 s2 0
R2 s2 7 82e0
VS3 9 s3 0
R3 s3 2 68e-1
VS4 0 s4 0
R4 s4 3 56e-2
VS5 3 s5 0
R5 s5 4 15e-1
VS6 0 s6 0
V6 e6 s6 DC 12e0
RI6 e6 6 68e-2
VS7 1 s7 0
R7 s7 0 56e3
VS8 2 s8 0
I8 s8 6 DC 10e-1
VS9 3 s9 0
R9 s9 8 56e1
VS10 2 s10 0
R10 s10 4 82e3
.control
set numdgt=17
op
print v(1) v(2) v(3) v(4) v(5) v(6) v(7) v(8) v(9)
print i(vs0) i(vs1) i(vs2) i(vs3) i(vs4) i(vs5) i(vs6) i(vs7) i(vs8) i(vs9)
print i(vs10)
.endc
.end
