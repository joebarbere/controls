controls oracle dc-0429
* Generated (plan F2.7, ADR 0012): do not edit; regenerate with `pnpm sim oracle regen`. dc seed 20261030 index 429 nodes 10 elements 14
.options sparse gmin=1e-12 noopac
RG1 1 0 1000000000000
RG2 2 0 1000000000000
RG3 3 0 1000000000000
RG4 4 0 1000000000000
RG5 5 0 1000000000000
RG6 6 0 1000000000000
RG7 7 0 1000000000000
RG8 8 0 1000000000000
RG9 9 0 1000000000000
VS0 9 s0 0
R0 s0 2 68e-1
VS1 0 s1 0
R1 s1 8 10e1
VS2 6 s2 0
R2 s2 5 10e0
VS3 3 s3 0
R3 s3 8 56e1
VS4 0 s4 0
V4 e4 s4 DC 12e0
RI4 e4 6 68e-2
VS5 3 s5 0
R5 s5 4 15e-1
VS6 2 s6 0
R6 s6 4 82e3
VS7 4 s7 0
R7 s7 7 82e0
VS8 2 s8 0
I8 s8 6 DC 10e-1
VS9 0 s9 0
R9 s9 3 56e-2
VS10 7 s10 0
R10 s10 1 15e-1
VS11 6 s11 0
R11 s11 9 56e-2
VS12 1 s12 0
R12 s12 0 56e3
VS13 9 s13 0
R13 s13 5 18e-1
.control
set numdgt=17
op
print v(1) v(2) v(3) v(4) v(5) v(6) v(7) v(8) v(9)
print i(vs0) i(vs1) i(vs2) i(vs3) i(vs4) i(vs5) i(vs6) i(vs7) i(vs8) i(vs9)
print i(vs10) i(vs11) i(vs12) i(vs13)
.endc
.end
