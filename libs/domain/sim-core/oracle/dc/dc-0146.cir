controls oracle dc-0146
* Generated (plan F2.7, ADR 0012): do not edit; regenerate with `pnpm sim oracle regen`. dc seed 20261030 index 146 nodes 2 elements 2
.options sparse gmin=1e-12 noopac
RG1 1 0 1000000000000
VS0 1 s0 0
R0 s0 0 18e-2
VS1 1 s1 0
I1 s1 0 DC 82e-3
.control
set numdgt=17
op
print v(1)
print i(vs0) i(vs1)
.endc
.end
