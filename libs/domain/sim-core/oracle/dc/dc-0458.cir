controls oracle dc-0458
* Generated (plan F2.7, ADR 0012): do not edit; regenerate with `pnpm sim oracle regen`. dc seed 20261030 index 458 nodes 7 elements 7
.options sparse gmin=1e-12 noopac
RG1 1 0 1000000000000
RG2 2 0 1000000000000
RG3 3 0 1000000000000
RG4 4 0 1000000000000
RG5 5 0 1000000000000
RG6 6 0 1000000000000
VS0 1 s0 0
R0 s0 3 33e2
VS1 0 s1 0
V1 e1 s1 DC 33e0
RI1 e1 1 39e-1
VS2 5 s2 0
R2 s2 1 56e3
VS3 0 s3 0
I3 s3 4 DC 68e-4
VS4 6 s4 0
R4 s4 2 56e-2
VS5 4 s5 0
R5 s5 0 56e3
VS6 0 s6 0
V6 e6 s6 DC 27e0
RI6 e6 6 27e-1
.control
set numdgt=17
op
print v(1) v(2) v(3) v(4) v(5) v(6)
print i(vs0) i(vs1) i(vs2) i(vs3) i(vs4) i(vs5) i(vs6)
.endc
.end
