controls oracle dc-0458
* Generated (plan F2.7, ADR 0012): do not edit; regenerate with `pnpm sim oracle regen`. dc seed 20261030 index 458 nodes 7 elements 11
.options sparse gmin=1e-12 noopac
RG1 1 0 1000000000000
RG2 2 0 1000000000000
RG3 3 0 1000000000000
RG4 4 0 1000000000000
RG5 5 0 1000000000000
RG6 6 0 1000000000000
VS0 4 s0 0
R0 s0 0 56e3
VS1 5 s1 0
R1 s1 1 56e3
VS2 4 s2 0
R2 s2 2 27e2
VS3 0 s3 0
I3 s3 4 DC 68e-4
VS4 0 s4 0
V4 e4 s4 DC 27e0
RI4 e4 6 27e-1
VS5 0 s5 0
V5 e5 s5 DC 33e0
RI5 e5 1 39e-1
VS6 6 s6 0
R6 s6 2 56e-2
VS7 2 s7 0
V7 e7 s7 DC 22e-1
RI7 e7 5 10e-3
VS8 2 s8 0
V8 e8 s8 DC 82e0
RI8 e8 3 22e-1
VS9 6 s9 0
R9 s9 1 18e0
VS10 1 s10 0
R10 s10 3 33e2
.control
set numdgt=17
op
print v(1) v(2) v(3) v(4) v(5) v(6)
print i(vs0) i(vs1) i(vs2) i(vs3) i(vs4) i(vs5) i(vs6) i(vs7) i(vs8) i(vs9)
print i(vs10)
.endc
.end
