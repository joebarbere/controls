controls oracle dc-0219
* Generated (plan F2.7, ADR 0012): do not edit; regenerate with `pnpm sim oracle regen`. dc seed 20261030 index 219 nodes 17 elements 19
.options sparse gmin=1e-12 noopac
RG1 1 0 1000000000000
RG2 2 0 1000000000000
RG3 3 0 1000000000000
RG4 4 0 1000000000000
RG5 5 0 1000000000000
RG6 6 0 1000000000000
RG7 7 0 1000000000000
RG8 8 0 1000000000000
RG9 9 0 1000000000000
RG10 10 0 1000000000000
RG11 11 0 1000000000000
RG12 12 0 1000000000000
RG13 13 0 1000000000000
RG14 14 0 1000000000000
RG15 15 0 1000000000000
RG16 16 0 1000000000000
VS0 0 s0 0
V0 e0 s0 DC 22e-1
RI0 e0 4 68e-2
VS1 2 s1 0
V1 e1 s1 DC 12e-1
RI1 e1 8 15e-1
VS2 0 s2 0
R2 s2 2 82e-2
VS3 14 s3 0
I3 s3 0 DC 27e-2
VS4 1 s4 0
R4 s4 11 10e3
VS5 14 s5 0
R5 s5 8 68e2
VS6 10 s6 0
R6 s6 2 12e1
VS7 15 s7 0
R7 s7 0 33e0
VS8 12 s8 0
I8 s8 1 DC 68e-1
VS9 14 s9 0
R9 s9 5 15e0
VS10 2 s10 0
V10 e10 s10 DC 10e1
RI10 e10 13 68e-2
VS11 12 s11 0
R11 s11 2 12e1
VS12 1 s12 0
V12 e12 s12 DC 39e0
RI12 e12 13 68e-1
VS13 9 s13 0
R13 s13 7 15e2
VS14 11 s14 0
R14 s14 9 56e1
VS15 6 s15 0
R15 s15 12 39e2
VS16 3 s16 0
R16 s16 4 33e3
VS17 1 s17 0
R17 s17 0 18e-1
VS18 16 s18 0
R18 s18 12 15e1
.control
set numdgt=17
op
print v(1) v(2) v(3) v(4) v(5) v(6) v(7) v(8) v(9) v(10)
print v(11) v(12) v(13) v(14) v(15) v(16)
print i(vs0) i(vs1) i(vs2) i(vs3) i(vs4) i(vs5) i(vs6) i(vs7) i(vs8) i(vs9)
print i(vs10) i(vs11) i(vs12) i(vs13) i(vs14) i(vs15) i(vs16) i(vs17) i(vs18)
.endc
.end
