controls oracle dc-0198
* Generated (plan F2.7, ADR 0012): do not edit; regenerate with `pnpm sim oracle regen`. dc seed 20261030 index 198 nodes 29 elements 35
.options sparse gmin=1e-12 noopac
RG1 1 0 1000000000000
RG2 2 0 1000000000000
RG3 3 0 1000000000000
RG4 4 0 1000000000000
RG5 5 0 1000000000000
RG6 6 0 1000000000000
RG7 7 0 1000000000000
RG8 8 0 1000000000000
RG9 9 0 1000000000000
RG10 10 0 1000000000000
RG11 11 0 1000000000000
RG12 12 0 1000000000000
RG13 13 0 1000000000000
RG14 14 0 1000000000000
RG15 15 0 1000000000000
RG16 16 0 1000000000000
RG17 17 0 1000000000000
RG18 18 0 1000000000000
RG19 19 0 1000000000000
RG20 20 0 1000000000000
RG21 21 0 1000000000000
RG22 22 0 1000000000000
RG23 23 0 1000000000000
RG24 24 0 1000000000000
RG25 25 0 1000000000000
RG26 26 0 1000000000000
RG27 27 0 1000000000000
RG28 28 0 1000000000000
VS0 25 s0 0
R0 s0 12 18e2
VS1 20 s1 0
R1 s1 28 82e1
VS2 5 s2 0
R2 s2 15 12e-1
VS3 14 s3 0
R3 s3 5 68e2
VS4 26 s4 0
R4 s4 11 22e-2
VS5 13 s5 0
R5 s5 27 68e2
VS6 3 s6 0
R6 s6 1 18e-1
VS7 5 s7 0
R7 s7 12 68e1
VS8 0 s8 0
V8 e8 s8 DC 18e-1
RI8 e8 3 12e-2
VS9 10 s9 0
R9 s9 25 56e1
VS10 6 s10 0
R10 s10 23 27e-2
VS11 8 s11 0
R11 s11 6 27e-2
VS12 1 s12 0
R12 s12 25 68e-2
VS13 16 s13 0
R13 s13 22 27e2
VS14 26 s14 0
R14 s14 27 18e2
VS15 16 s15 0
R15 s15 7 39e3
VS16 18 s16 0
I16 s16 5 DC 56e-3
VS17 20 s17 0
V17 e17 s17 DC 33e1
RI17 e17 3 15e-2
VS18 24 s18 0
R18 s18 3 27e1
VS19 24 s19 0
I19 s19 0 DC 39e-3
VS20 9 s20 0
R20 s20 3 18e0
VS21 14 s21 0
R21 s21 6 12e1
VS22 15 s22 0
R22 s22 10 47e1
VS23 21 s23 0
R23 s23 3 33e0
VS24 19 s24 0
I24 s24 4 DC 27e-2
VS25 1 s25 0
V25 e25 s25 DC 10e0
RI25 e25 26 22e-2
VS26 23 s26 0
R26 s26 1 10e3
VS27 18 s27 0
R27 s27 25 10e2
VS28 16 s28 0
V28 e28 s28 DC 82e1
RI28 e28 2 12e-2
VS29 23 s29 0
V29 e29 s29 DC 27e1
RI29 e29 20 22e-2
VS30 4 s30 0
R30 s30 13 39e1
VS31 16 s31 0
R31 s31 3 27e3
VS32 4 s32 0
R32 s32 10 10e-1
VS33 25 s33 0
V33 e33 s33 DC 10e-1
RI33 e33 19 22e-3
VS34 17 s34 0
R34 s34 28 10e-2
.control
set numdgt=17
op
print v(1) v(2) v(3) v(4) v(5) v(6) v(7) v(8) v(9) v(10)
print v(11) v(12) v(13) v(14) v(15) v(16) v(17) v(18) v(19) v(20)
print v(21) v(22) v(23) v(24) v(25) v(26) v(27) v(28)
print i(vs0) i(vs1) i(vs2) i(vs3) i(vs4) i(vs5) i(vs6) i(vs7) i(vs8) i(vs9)
print i(vs10) i(vs11) i(vs12) i(vs13) i(vs14) i(vs15) i(vs16) i(vs17) i(vs18) i(vs19)
print i(vs20) i(vs21) i(vs22) i(vs23) i(vs24) i(vs25) i(vs26) i(vs27) i(vs28) i(vs29)
print i(vs30) i(vs31) i(vs32) i(vs33) i(vs34)
.endc
.end
