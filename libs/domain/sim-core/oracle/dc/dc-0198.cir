controls oracle dc-0198
* Generated (plan F2.7, ADR 0012): do not edit; regenerate with `pnpm sim oracle regen`. dc seed 20261030 index 198 nodes 29 elements 44
.options sparse gmin=1e-12 noopac
RG1 1 0 1000000000000
RG2 2 0 1000000000000
RG3 3 0 1000000000000
RG4 4 0 1000000000000
RG5 5 0 1000000000000
RG6 6 0 1000000000000
RG7 7 0 1000000000000
RG8 8 0 1000000000000
RG9 9 0 1000000000000
RG10 10 0 1000000000000
RG11 11 0 1000000000000
RG12 12 0 1000000000000
RG13 13 0 1000000000000
RG14 14 0 1000000000000
RG15 15 0 1000000000000
RG16 16 0 1000000000000
RG17 17 0 1000000000000
RG18 18 0 1000000000000
RG19 19 0 1000000000000
RG20 20 0 1000000000000
RG21 21 0 1000000000000
RG22 22 0 1000000000000
RG23 23 0 1000000000000
RG24 24 0 1000000000000
RG25 25 0 1000000000000
RG26 26 0 1000000000000
RG27 27 0 1000000000000
RG28 28 0 1000000000000
VS0 21 s0 0
R0 s0 3 33e0
VS1 24 s1 0
I1 s1 1 DC 39e-3
VS2 24 s2 0
R2 s2 3 27e1
VS3 10 s3 0
R3 s3 25 56e1
VS4 0 s4 0
V4 e4 s4 DC 39e0
RI4 e4 9 68e-3
VS5 19 s5 0
I5 s5 4 DC 27e-2
VS6 14 s6 0
R6 s6 5 68e2
VS7 16 s7 0
R7 s7 22 27e2
VS8 17 s8 0
R8 s8 28 10e-2
VS9 14 s9 0
R9 s9 6 12e1
VS10 8 s10 0
R10 s10 25 68e-2
VS11 26 s11 0
R11 s11 11 22e-2
VS12 21 s12 0
R12 s12 19 33e-1
VS13 3 s13 0
R13 s13 8 18e-1
VS14 4 s14 0
R14 s14 13 39e1
VS15 2 s15 0
R15 s15 11 15e3
VS16 20 s16 0
R16 s16 28 82e1
VS17 18 s17 0
I17 s17 5 DC 56e-3
VS18 15 s18 0
R18 s18 10 47e1
VS19 20 s19 0
V19 e19 s19 DC 33e1
RI19 e19 3 15e-2
VS20 13 s20 0
R20 s20 27 68e2
VS21 26 s21 0
R21 s21 27 18e2
VS22 25 s22 0
R22 s22 12 18e2
VS23 5 s23 0
R23 s23 15 12e-1
VS24 17 s24 0
V24 e24 s24 DC 10e1
RI24 e24 8 33e-3
VS25 4 s25 0
R25 s25 10 10e-1
VS26 6 s26 0
R26 s26 24 82e-1
VS27 23 s27 0
R27 s27 8 10e3
VS28 19 s28 0
R28 s28 1 27e3
VS29 18 s29 0
R29 s29 25 10e2
VS30 0 s30 0
R30 s30 6 27e-2
VS31 18 s31 0
R31 s31 7 68e0
VS32 5 s32 0
R32 s32 12 68e1
VS33 6 s33 0
R33 s33 23 27e-2
VS34 1 s34 0
V34 e34 s34 DC 18e-1
RI34 e34 3 12e-2
VS35 10 s35 0
R35 s35 19 22e0
VS36 22 s36 0
R36 s36 0 27e2
VS37 23 s37 0
V37 e37 s37 DC 27e1
RI37 e37 20 22e-2
VS38 8 s38 0
V38 e38 s38 DC 10e0
RI38 e38 26 22e-2
VS39 9 s39 0
R39 s39 3 18e0
VS40 16 s40 0
R40 s40 7 39e3
VS41 25 s41 0
V41 e41 s41 DC 10e-1
RI41 e41 19 22e-3
VS42 16 s42 0
R42 s42 3 27e3
VS43 16 s43 0
V43 e43 s43 DC 82e1
RI43 e43 2 12e-2
.control
set numdgt=17
op
print v(1) v(2) v(3) v(4) v(5) v(6) v(7) v(8) v(9) v(10)
print v(11) v(12) v(13) v(14) v(15) v(16) v(17) v(18) v(19) v(20)
print v(21) v(22) v(23) v(24) v(25) v(26) v(27) v(28)
print i(vs0) i(vs1) i(vs2) i(vs3) i(vs4) i(vs5) i(vs6) i(vs7) i(vs8) i(vs9)
print i(vs10) i(vs11) i(vs12) i(vs13) i(vs14) i(vs15) i(vs16) i(vs17) i(vs18) i(vs19)
print i(vs20) i(vs21) i(vs22) i(vs23) i(vs24) i(vs25) i(vs26) i(vs27) i(vs28) i(vs29)
print i(vs30) i(vs31) i(vs32) i(vs33) i(vs34) i(vs35) i(vs36) i(vs37) i(vs38) i(vs39)
print i(vs40) i(vs41) i(vs42) i(vs43)
.endc
.end
