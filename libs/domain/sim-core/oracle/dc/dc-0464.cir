controls oracle dc-0464
* Generated (plan F2.7, ADR 0012): do not edit; regenerate with `pnpm sim oracle regen`. dc seed 20261030 index 464 nodes 4 elements 5
.options sparse gmin=1e-12 noopac
RG1 1 0 1000000000000
RG2 2 0 1000000000000
RG3 3 0 1000000000000
VS0 0 s0 0
R0 s0 2 39e-2
VS1 2 s1 0
R1 s1 1 33e2
VS2 0 s2 0
R2 s2 1 22e3
VS3 1 s3 0
R3 s3 3 82e-2
VS4 0 s4 0
V4 e4 s4 DC 33e1
RI4 e4 3 15e-1
.control
set numdgt=17
op
print v(1) v(2) v(3)
print i(vs0) i(vs1) i(vs2) i(vs3) i(vs4)
.endc
.end
