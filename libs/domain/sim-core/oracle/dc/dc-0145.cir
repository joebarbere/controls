controls oracle dc-0145
* Generated (plan F2.7, ADR 0012): do not edit; regenerate with `pnpm sim oracle regen`. dc seed 20261030 index 145 nodes 16 elements 25
.options sparse gmin=1e-12 noopac
RG1 1 0 1000000000000
RG2 2 0 1000000000000
RG3 3 0 1000000000000
RG4 4 0 1000000000000
RG5 5 0 1000000000000
RG6 6 0 1000000000000
RG7 7 0 1000000000000
RG8 8 0 1000000000000
RG9 9 0 1000000000000
RG10 10 0 1000000000000
RG11 11 0 1000000000000
RG12 12 0 1000000000000
RG13 13 0 1000000000000
RG14 14 0 1000000000000
RG15 15 0 1000000000000
VS0 1 s0 0
R0 s0 4 56e3
VS1 15 s1 0
R1 s1 2 56e-1
VS2 0 s2 0
V2 e2 s2 DC 68e-1
RI2 e2 2 47e-2
VS3 8 s3 0
V3 e3 s3 DC 47e-1
RI3 e3 7 12e-3
VS4 7 s4 0
I4 s4 5 DC 18e-4
VS5 6 s5 0
R5 s5 9 39e1
VS6 10 s6 0
R6 s6 7 82e0
VS7 13 s7 0
R7 s7 12 33e2
VS8 1 s8 0
R8 s8 6 12e1
VS9 11 s9 0
R9 s9 13 47e-1
VS10 6 s10 0
R10 s10 14 27e1
VS11 0 s11 0
V11 e11 s11 DC 68e0
RI11 e11 6 82e-3
VS12 12 s12 0
R12 s12 5 39e-1
VS13 5 s13 0
R13 s13 10 12e-1
VS14 0 s14 0
V14 e14 s14 DC 39e1
RI14 e14 15 82e-2
VS15 12 s15 0
R15 s15 8 27e-2
VS16 1 s16 0
R16 s16 9 15e0
VS17 4 s17 0
R17 s17 5 15e-2
VS18 11 s18 0
R18 s18 3 47e2
VS19 4 s19 0
R19 s19 6 47e1
VS20 7 s20 0
R20 s20 4 18e3
VS21 11 s21 0
R21 s21 5 18e-1
VS22 12 s22 0
R22 s22 14 39e3
VS23 0 s23 0
V23 e23 s23 DC 12e0
RI23 e23 3 68e-2
VS24 5 s24 0
R24 s24 15 12e-2
.control
set numdgt=17
op
print v(1) v(2) v(3) v(4) v(5) v(6) v(7) v(8) v(9) v(10)
print v(11) v(12) v(13) v(14) v(15)
print i(vs0) i(vs1) i(vs2) i(vs3) i(vs4) i(vs5) i(vs6) i(vs7) i(vs8) i(vs9)
print i(vs10) i(vs11) i(vs12) i(vs13) i(vs14) i(vs15) i(vs16) i(vs17) i(vs18) i(vs19)
print i(vs20) i(vs21) i(vs22) i(vs23) i(vs24)
.endc
.end
