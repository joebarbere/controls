controls oracle dc-0145
* Generated (plan F2.7, ADR 0012): do not edit; regenerate with `pnpm sim oracle regen`. dc seed 20261030 index 145 nodes 16 elements 24
.options sparse gmin=1e-12 noopac
RG1 1 0 1000000000000
RG2 2 0 1000000000000
RG3 3 0 1000000000000
RG4 4 0 1000000000000
RG5 5 0 1000000000000
RG6 6 0 1000000000000
RG7 7 0 1000000000000
RG8 8 0 1000000000000
RG9 9 0 1000000000000
RG10 10 0 1000000000000
RG11 11 0 1000000000000
RG12 12 0 1000000000000
RG13 13 0 1000000000000
RG14 14 0 1000000000000
RG15 15 0 1000000000000
VS0 12 s0 0
R0 s0 8 27e-2
VS1 12 s1 0
R1 s1 5 39e-1
VS2 4 s2 0
R2 s2 5 15e-2
VS3 5 s3 0
R3 s3 15 12e-2
VS4 0 s4 0
V4 e4 s4 DC 12e0
RI4 e4 3 68e-2
VS5 8 s5 0
V5 e5 s5 DC 47e-1
RI5 e5 7 12e-3
VS6 11 s6 0
R6 s6 13 47e-1
VS7 1 s7 0
R7 s7 6 12e1
VS8 10 s8 0
R8 s8 7 82e0
VS9 5 s9 0
R9 s9 10 12e-1
VS10 0 s10 0
V10 e10 s10 DC 68e-1
RI10 e10 2 47e-2
VS11 1 s11 0
R11 s11 4 56e3
VS12 1 s12 0
R12 s12 9 15e0
VS13 7 s13 0
R13 s13 4 18e3
VS14 11 s14 0
R14 s14 5 18e-1
VS15 0 s15 0
V15 e15 s15 DC 68e0
RI15 e15 6 82e-3
VS16 6 s16 0
R16 s16 14 27e1
VS17 0 s17 0
V17 e17 s17 DC 39e1
RI17 e17 15 82e-2
VS18 15 s18 0
R18 s18 2 56e-1
VS19 13 s19 0
R19 s19 12 33e2
VS20 4 s20 0
R20 s20 6 47e1
VS21 11 s21 0
R21 s21 3 47e2
VS22 7 s22 0
I22 s22 5 DC 18e-4
VS23 6 s23 0
R23 s23 9 39e1
.control
set numdgt=17
op
print v(1) v(2) v(3) v(4) v(5) v(6) v(7) v(8) v(9) v(10)
print v(11) v(12) v(13) v(14) v(15)
print i(vs0) i(vs1) i(vs2) i(vs3) i(vs4) i(vs5) i(vs6) i(vs7) i(vs8) i(vs9)
print i(vs10) i(vs11) i(vs12) i(vs13) i(vs14) i(vs15) i(vs16) i(vs17) i(vs18) i(vs19)
print i(vs20) i(vs21) i(vs22) i(vs23)
.endc
.end
