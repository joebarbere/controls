controls oracle dc-0223
* Generated (plan F2.7, ADR 0012): do not edit; regenerate with `pnpm sim oracle regen`. dc seed 20261030 index 223 nodes 12 elements 24
.options sparse gmin=1e-12 noopac
RG1 1 0 1000000000000
RG2 2 0 1000000000000
RG3 3 0 1000000000000
RG4 4 0 1000000000000
RG5 5 0 1000000000000
RG6 6 0 1000000000000
RG7 7 0 1000000000000
RG8 8 0 1000000000000
RG9 9 0 1000000000000
RG10 10 0 1000000000000
RG11 11 0 1000000000000
VS0 5 s0 0
I0 s0 11 DC 12e-1
VS1 3 s1 0
R1 s1 1 47e3
VS2 8 s2 0
R2 s2 4 33e0
VS3 11 s3 0
I3 s3 1 DC 15e-3
VS4 2 s4 0
I4 s4 4 DC 15e-4
VS5 2 s5 0
I5 s5 9 DC 18e-2
VS6 1 s6 0
R6 s6 0 22e3
VS7 7 s7 0
R7 s7 11 22e2
VS8 4 s8 0
R8 s8 11 82e1
VS9 6 s9 0
R9 s9 3 68e0
VS10 6 s10 0
R10 s10 5 27e2
VS11 1 s11 0
R11 s11 10 47e3
VS12 3 s12 0
R12 s12 4 33e1
VS13 11 s13 0
R13 s13 4 15e0
VS14 6 s14 0
R14 s14 2 33e-2
VS15 3 s15 0
R15 s15 2 68e1
VS16 0 s16 0
V16 e16 s16 DC 10e0
RI16 e16 7 15e-3
VS17 2 s17 0
I17 s17 7 DC 22e-2
VS18 5 s18 0
V18 e18 s18 DC 10e0
RI18 e18 10 82e-3
VS19 8 s19 0
R19 s19 0 56e-1
VS20 5 s20 0
R20 s20 3 18e-1
VS21 3 s21 0
R21 s21 9 47e0
VS22 1 s22 0
R22 s22 0 10e1
VS23 4 s23 0
R23 s23 9 47e3
.control
set numdgt=17
op
print v(1) v(2) v(3) v(4) v(5) v(6) v(7) v(8) v(9) v(10)
print v(11)
print i(vs0) i(vs1) i(vs2) i(vs3) i(vs4) i(vs5) i(vs6) i(vs7) i(vs8) i(vs9)
print i(vs10) i(vs11) i(vs12) i(vs13) i(vs14) i(vs15) i(vs16) i(vs17) i(vs18) i(vs19)
print i(vs20) i(vs21) i(vs22) i(vs23)
.endc
.end
