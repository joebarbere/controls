controls oracle dc-0230
* Generated (plan F2.7, ADR 0012): do not edit; regenerate with `pnpm sim oracle regen`. dc seed 20261030 index 230 nodes 2 elements 4
.options sparse gmin=1e-12 noopac
RG1 1 0 1000000000000
VS0 0 s0 0
R0 s0 1 27e-2
VS1 0 s1 0
V1 e1 s1 DC 27e0
RI1 e1 1 18e-3
VS2 1 s2 0
R2 s2 0 22e2
VS3 1 s3 0
R3 s3 0 18e-2
.control
set numdgt=17
op
print v(1)
print i(vs0) i(vs1) i(vs2) i(vs3)
.endc
.end
