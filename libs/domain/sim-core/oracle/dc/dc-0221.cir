controls oracle dc-0221
* Generated (plan F2.7, ADR 0012): do not edit; regenerate with `pnpm sim oracle regen`. dc seed 20261030 index 221 nodes 15 elements 23
.options sparse gmin=1e-12 noopac
RG1 1 0 1000000000000
RG2 2 0 1000000000000
RG3 3 0 1000000000000
RG4 4 0 1000000000000
RG5 5 0 1000000000000
RG6 6 0 1000000000000
RG7 7 0 1000000000000
RG8 8 0 1000000000000
RG9 9 0 1000000000000
RG10 10 0 1000000000000
RG11 11 0 1000000000000
RG12 12 0 1000000000000
RG13 13 0 1000000000000
RG14 14 0 1000000000000
VS0 3 s0 0
R0 s0 11 22e-1
VS1 13 s1 0
R1 s1 1 12e0
VS2 4 s2 0
R2 s2 8 39e2
VS3 0 s3 0
V3 e3 s3 DC 27e1
RI3 e3 9 22e-3
VS4 8 s4 0
R4 s4 13 12e0
VS5 9 s5 0
V5 e5 s5 DC 27e1
RI5 e5 14 12e-3
VS6 5 s6 0
R6 s6 11 39e1
VS7 8 s7 0
R7 s7 3 22e-1
VS8 10 s8 0
R8 s8 13 10e-1
VS9 14 s9 0
R9 s9 8 27e0
VS10 0 s10 0
V10 e10 s10 DC 12e1
RI10 e10 1 12e-2
VS11 6 s11 0
V11 e11 s11 DC 22e0
RI11 e11 8 15e-3
VS12 6 s12 0
R12 s12 10 68e0
VS13 13 s13 0
R13 s13 7 39e-1
VS14 12 s14 0
R14 s14 10 12e-1
VS15 3 s15 0
R15 s15 6 10e-2
VS16 0 s16 0
R16 s16 4 10e2
VS17 12 s17 0
R17 s17 4 56e-2
VS18 13 s18 0
V18 e18 s18 DC 68e-1
RI18 e18 2 33e-1
VS19 7 s19 0
V19 e19 s19 DC 27e0
RI19 e19 0 22e-3
VS20 5 s20 0
V20 e20 s20 DC 39e1
RI20 e20 14 39e-3
VS21 14 s21 0
R21 s21 5 56e2
VS22 2 s22 0
R22 s22 1 33e3
.control
set numdgt=17
op
print v(1) v(2) v(3) v(4) v(5) v(6) v(7) v(8) v(9) v(10)
print v(11) v(12) v(13) v(14)
print i(vs0) i(vs1) i(vs2) i(vs3) i(vs4) i(vs5) i(vs6) i(vs7) i(vs8) i(vs9)
print i(vs10) i(vs11) i(vs12) i(vs13) i(vs14) i(vs15) i(vs16) i(vs17) i(vs18) i(vs19)
print i(vs20) i(vs21) i(vs22)
.endc
.end
