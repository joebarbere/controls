controls oracle dc-0221
* Generated (plan F2.7, ADR 0012): do not edit; regenerate with `pnpm sim oracle regen`. dc seed 20261030 index 221 nodes 15 elements 15
.options sparse gmin=1e-12 noopac
RG1 1 0 1000000000000
RG2 2 0 1000000000000
RG3 3 0 1000000000000
RG4 4 0 1000000000000
RG5 5 0 1000000000000
RG6 6 0 1000000000000
RG7 7 0 1000000000000
RG8 8 0 1000000000000
RG9 9 0 1000000000000
RG10 10 0 1000000000000
RG11 11 0 1000000000000
RG12 12 0 1000000000000
RG13 13 0 1000000000000
RG14 14 0 1000000000000
VS0 14 s0 0
R0 s0 8 27e0
VS1 4 s1 0
R1 s1 8 39e2
VS2 10 s2 0
R2 s2 13 10e-1
VS3 0 s3 0
V3 e3 s3 DC 27e1
RI3 e3 14 12e-3
VS4 8 s4 0
R4 s4 9 22e-1
VS5 8 s5 0
R5 s5 13 12e0
VS6 5 s6 0
R6 s6 11 39e1
VS7 13 s7 0
V7 e7 s7 DC 68e-1
RI7 e7 2 33e-1
VS8 6 s8 0
R8 s8 10 68e0
VS9 2 s9 0
R9 s9 1 33e3
VS10 5 s10 0
V10 e10 s10 DC 39e1
RI10 e10 14 39e-3
VS11 3 s11 0
R11 s11 4 10e2
VS12 13 s12 0
R12 s12 7 39e-1
VS13 12 s13 0
R13 s13 10 12e-1
VS14 14 s14 0
R14 s14 5 56e2
.control
set numdgt=17
op
print v(1) v(2) v(3) v(4) v(5) v(6) v(7) v(8) v(9) v(10)
print v(11) v(12) v(13) v(14)
print i(vs0) i(vs1) i(vs2) i(vs3) i(vs4) i(vs5) i(vs6) i(vs7) i(vs8) i(vs9)
print i(vs10) i(vs11) i(vs12) i(vs13) i(vs14)
.endc
.end
