controls oracle dc-0416
* Generated (plan F2.7, ADR 0012): do not edit; regenerate with `pnpm sim oracle regen`. dc seed 20261030 index 416 nodes 14 elements 21
.options sparse gmin=1e-12 noopac
RG1 1 0 1000000000000
RG2 2 0 1000000000000
RG3 3 0 1000000000000
RG4 4 0 1000000000000
RG5 5 0 1000000000000
RG6 6 0 1000000000000
RG7 7 0 1000000000000
RG8 8 0 1000000000000
RG9 9 0 1000000000000
RG10 10 0 1000000000000
RG11 11 0 1000000000000
RG12 12 0 1000000000000
RG13 13 0 1000000000000
VS0 0 s0 0
V0 e0 s0 DC 82e0
RI0 e0 5 18e-3
VS1 2 s1 0
R1 s1 0 27e2
VS2 2 s2 0
R2 s2 11 12e3
VS3 11 s3 0
R3 s3 5 82e3
VS4 12 s4 0
R4 s4 10 47e-1
VS5 2 s5 0
V5 e5 s5 DC 15e0
RI5 e5 10 27e-1
VS6 6 s6 0
R6 s6 1 10e0
VS7 7 s7 0
R7 s7 0 68e-2
VS8 9 s8 0
R8 s8 1 33e-1
VS9 3 s9 0
R9 s9 9 33e0
VS10 7 s10 0
R10 s10 3 27e2
VS11 10 s11 0
I11 s11 7 DC 56e-4
VS12 11 s12 0
R12 s12 13 12e-2
VS13 9 s13 0
R13 s13 2 12e0
VS14 12 s14 0
R14 s14 6 82e3
VS15 1 s15 0
R15 s15 8 15e2
VS16 6 s16 0
R16 s16 1 47e-1
VS17 2 s17 0
R17 s17 1 33e-1
VS18 9 s18 0
R18 s18 4 10e2
VS19 11 s19 0
R19 s19 12 39e2
VS20 2 s20 0
V20 e20 s20 DC 68e0
RI20 e20 8 56e-1
.control
set numdgt=17
op
print v(1) v(2) v(3) v(4) v(5) v(6) v(7) v(8) v(9) v(10)
print v(11) v(12) v(13)
print i(vs0) i(vs1) i(vs2) i(vs3) i(vs4) i(vs5) i(vs6) i(vs7) i(vs8) i(vs9)
print i(vs10) i(vs11) i(vs12) i(vs13) i(vs14) i(vs15) i(vs16) i(vs17) i(vs18) i(vs19)
print i(vs20)
.endc
.end
