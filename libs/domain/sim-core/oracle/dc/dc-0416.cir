controls oracle dc-0416
* Generated (plan F2.7, ADR 0012): do not edit; regenerate with `pnpm sim oracle regen`. dc seed 20261030 index 416 nodes 14 elements 23
.options sparse gmin=1e-12 noopac
RG1 1 0 1000000000000
RG2 2 0 1000000000000
RG3 3 0 1000000000000
RG4 4 0 1000000000000
RG5 5 0 1000000000000
RG6 6 0 1000000000000
RG7 7 0 1000000000000
RG8 8 0 1000000000000
RG9 9 0 1000000000000
RG10 10 0 1000000000000
RG11 11 0 1000000000000
RG12 12 0 1000000000000
RG13 13 0 1000000000000
VS0 2 s0 0
R0 s0 1 33e-1
VS1 1 s1 0
R1 s1 8 15e2
VS2 12 s2 0
R2 s2 6 82e3
VS3 10 s3 0
I3 s3 7 DC 56e-4
VS4 11 s4 0
R4 s4 12 39e2
VS5 9 s5 0
R5 s5 2 12e0
VS6 9 s6 0
R6 s6 1 33e-1
VS7 2 s7 0
R7 s7 11 12e3
VS8 13 s8 0
R8 s8 1 15e2
VS9 0 s9 0
V9 e9 s9 DC 82e0
RI9 e9 5 18e-3
VS10 7 s10 0
R10 s10 3 27e2
VS11 6 s11 0
R11 s11 1 47e-1
VS12 8 s12 0
R12 s12 4 10e0
VS13 11 s13 0
R13 s13 5 82e3
VS14 11 s14 0
R14 s14 13 12e-2
VS15 2 s15 0
R15 s15 0 27e2
VS16 3 s16 0
R16 s16 9 33e0
VS17 9 s17 0
R17 s17 4 10e2
VS18 2 s18 0
V18 e18 s18 DC 15e0
RI18 e18 10 27e-1
VS19 7 s19 0
R19 s19 0 68e-2
VS20 6 s20 0
R20 s20 1 10e0
VS21 2 s21 0
V21 e21 s21 DC 68e0
RI21 e21 8 56e-1
VS22 12 s22 0
R22 s22 10 47e-1
.control
set numdgt=17
op
print v(1) v(2) v(3) v(4) v(5) v(6) v(7) v(8) v(9) v(10)
print v(11) v(12) v(13)
print i(vs0) i(vs1) i(vs2) i(vs3) i(vs4) i(vs5) i(vs6) i(vs7) i(vs8) i(vs9)
print i(vs10) i(vs11) i(vs12) i(vs13) i(vs14) i(vs15) i(vs16) i(vs17) i(vs18) i(vs19)
print i(vs20) i(vs21) i(vs22)
.endc
.end
