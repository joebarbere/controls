controls oracle dc-0312
* Generated (plan F2.7, ADR 0012): do not edit; regenerate with `pnpm sim oracle regen`. dc seed 20261030 index 312 nodes 15 elements 21
.options sparse gmin=1e-12 noopac
RG1 1 0 1000000000000
RG2 2 0 1000000000000
RG3 3 0 1000000000000
RG4 4 0 1000000000000
RG5 5 0 1000000000000
RG6 6 0 1000000000000
RG7 7 0 1000000000000
RG8 8 0 1000000000000
RG9 9 0 1000000000000
RG10 10 0 1000000000000
RG11 11 0 1000000000000
RG12 12 0 1000000000000
RG13 13 0 1000000000000
RG14 14 0 1000000000000
VS0 8 s0 0
I0 s0 6 DC 18e-4
VS1 0 s1 0
V1 e1 s1 DC 10e0
RI1 e1 13 68e-1
VS2 3 s2 0
R2 s2 12 39e3
VS3 0 s3 0
I3 s3 7 DC 27e-3
VS4 1 s4 0
R4 s4 6 27e-2
VS5 10 s5 0
R5 s5 13 27e1
VS6 5 s6 0
I6 s6 12 DC 56e-3
VS7 8 s7 0
V7 e7 s7 DC 56e-1
RI7 e7 4 39e-3
VS8 5 s8 0
R8 s8 11 39e0
VS9 8 s9 0
R9 s9 4 56e2
VS10 9 s10 0
R10 s10 1 27e-2
VS11 12 s11 0
R11 s11 13 82e-2
VS12 12 s12 0
R12 s12 14 56e2
VS13 7 s13 0
R13 s13 6 33e0
VS14 8 s14 0
V14 e14 s14 DC 47e-1
RI14 e14 11 68e-1
VS15 11 s15 0
R15 s15 3 22e1
VS16 12 s16 0
I16 s16 8 DC 39e-2
VS17 14 s17 0
V17 e17 s17 DC 39e-1
RI17 e17 13 68e-2
VS18 12 s18 0
R18 s18 8 39e-2
VS19 12 s19 0
R19 s19 1 22e0
VS20 2 s20 0
R20 s20 8 27e3
.control
set numdgt=17
op
print v(1) v(2) v(3) v(4) v(5) v(6) v(7) v(8) v(9) v(10)
print v(11) v(12) v(13) v(14)
print i(vs0) i(vs1) i(vs2) i(vs3) i(vs4) i(vs5) i(vs6) i(vs7) i(vs8) i(vs9)
print i(vs10) i(vs11) i(vs12) i(vs13) i(vs14) i(vs15) i(vs16) i(vs17) i(vs18) i(vs19)
print i(vs20)
.endc
.end
