controls oracle dc-0312
* Generated (plan F2.7, ADR 0012): do not edit; regenerate with `pnpm sim oracle regen`. dc seed 20261030 index 312 nodes 15 elements 27
.options sparse gmin=1e-12 noopac
RG1 1 0 1000000000000
RG2 2 0 1000000000000
RG3 3 0 1000000000000
RG4 4 0 1000000000000
RG5 5 0 1000000000000
RG6 6 0 1000000000000
RG7 7 0 1000000000000
RG8 8 0 1000000000000
RG9 9 0 1000000000000
RG10 10 0 1000000000000
RG11 11 0 1000000000000
RG12 12 0 1000000000000
RG13 13 0 1000000000000
RG14 14 0 1000000000000
VS0 14 s0 0
R0 s0 13 27e1
VS1 8 s1 0
I1 s1 6 DC 18e-4
VS2 12 s2 0
I2 s2 8 DC 39e-2
VS3 7 s3 0
R3 s3 6 33e0
VS4 10 s4 0
R4 s4 5 22e-1
VS5 11 s5 0
R5 s5 9 82e0
VS6 5 s6 0
I6 s6 12 DC 56e-3
VS7 4 s7 0
R7 s7 12 56e2
VS8 0 s8 0
V8 e8 s8 DC 39e-1
RI8 e8 13 68e-2
VS9 8 s9 0
R9 s9 4 56e2
VS10 12 s10 0
R10 s10 8 39e-2
VS11 3 s11 0
R11 s11 12 39e3
VS12 8 s12 0
V12 e12 s12 DC 47e-1
RI12 e12 11 68e-1
VS13 8 s13 0
V13 e13 s13 DC 56e-1
RI13 e13 4 39e-3
VS14 0 s14 0
V14 e14 s14 DC 33e-1
RI14 e14 7 15e-1
VS15 5 s15 0
R15 s15 11 39e0
VS16 10 s16 0
V16 e16 s16 DC 10e0
RI16 e16 13 68e-1
VS17 6 s17 0
R17 s17 2 56e3
VS18 12 s18 0
R18 s18 14 10e2
VS19 12 s19 0
R19 s19 0 56e2
VS20 10 s20 0
I20 s20 7 DC 27e-3
VS21 12 s21 0
R21 s21 13 82e-2
VS22 12 s22 0
R22 s22 1 22e0
VS23 11 s23 0
R23 s23 3 22e1
VS24 1 s24 0
R24 s24 6 27e-2
VS25 9 s25 0
R25 s25 1 27e-2
VS26 2 s26 0
R26 s26 8 27e3
.control
set numdgt=17
op
print v(1) v(2) v(3) v(4) v(5) v(6) v(7) v(8) v(9) v(10)
print v(11) v(12) v(13) v(14)
print i(vs0) i(vs1) i(vs2) i(vs3) i(vs4) i(vs5) i(vs6) i(vs7) i(vs8) i(vs9)
print i(vs10) i(vs11) i(vs12) i(vs13) i(vs14) i(vs15) i(vs16) i(vs17) i(vs18) i(vs19)
print i(vs20) i(vs21) i(vs22) i(vs23) i(vs24) i(vs25) i(vs26)
.endc
.end
