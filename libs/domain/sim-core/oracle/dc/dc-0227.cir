controls oracle dc-0227
* Generated (plan F2.7, ADR 0012): do not edit; regenerate with `pnpm sim oracle regen`. dc seed 20261030 index 227 nodes 9 elements 12
.options sparse gmin=1e-12 noopac
RG1 1 0 1000000000000
RG2 2 0 1000000000000
RG3 3 0 1000000000000
RG4 4 0 1000000000000
RG5 5 0 1000000000000
RG6 6 0 1000000000000
RG7 7 0 1000000000000
RG8 8 0 1000000000000
VS0 0 s0 0
V0 e0 s0 DC 18e0
RI0 e0 2 39e-1
VS1 8 s1 0
V1 e1 s1 DC 27e-1
RI1 e1 0 18e-3
VS2 2 s2 0
R2 s2 7 12e2
VS3 6 s3 0
R3 s3 2 18e-2
VS4 5 s4 0
V4 e4 s4 DC 56e1
RI4 e4 4 15e-2
VS5 2 s5 0
V5 e5 s5 DC 39e0
RI5 e5 1 56e-2
VS6 6 s6 0
R6 s6 7 82e-2
VS7 4 s7 0
R7 s7 1 33e-1
VS8 5 s8 0
R8 s8 8 12e2
VS9 6 s9 0
R9 s9 3 68e3
VS10 0 s10 0
R10 s10 3 27e-1
VS11 4 s11 0
R11 s11 6 10e-2
.control
set numdgt=17
op
print v(1) v(2) v(3) v(4) v(5) v(6) v(7) v(8)
print i(vs0) i(vs1) i(vs2) i(vs3) i(vs4) i(vs5) i(vs6) i(vs7) i(vs8) i(vs9)
print i(vs10) i(vs11)
.endc
.end
