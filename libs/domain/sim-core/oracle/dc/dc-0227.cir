controls oracle dc-0227
* Generated (plan F2.7, ADR 0012): do not edit; regenerate with `pnpm sim oracle regen`. dc seed 20261030 index 227 nodes 9 elements 9
.options sparse gmin=1e-12 noopac
RG1 1 0 1000000000000
RG2 2 0 1000000000000
RG3 3 0 1000000000000
RG4 4 0 1000000000000
RG5 5 0 1000000000000
RG6 6 0 1000000000000
RG7 7 0 1000000000000
RG8 8 0 1000000000000
VS0 6 s0 0
R0 s0 7 82e-2
VS1 8 s1 0
R1 s1 2 82e2
VS2 0 s2 0
V2 e2 s2 DC 27e-1
RI2 e2 2 18e-3
VS3 5 s3 0
R3 s3 0 12e2
VS4 6 s4 0
R4 s4 3 68e3
VS5 4 s5 0
R5 s5 6 10e-2
VS6 8 s6 0
V6 e6 s6 DC 39e0
RI6 e6 1 56e-2
VS7 6 s7 0
R7 s7 8 18e-2
VS8 2 s8 0
V8 e8 s8 DC 18e0
RI8 e8 8 39e-1
.control
set numdgt=17
op
print v(1) v(2) v(3) v(4) v(5) v(6) v(7) v(8)
print i(vs0) i(vs1) i(vs2) i(vs3) i(vs4) i(vs5) i(vs6) i(vs7) i(vs8)
.endc
.end
