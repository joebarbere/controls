controls oracle dc-0182
* Generated (plan F2.7, ADR 0012): do not edit; regenerate with `pnpm sim oracle regen`. dc seed 20261030 index 182 nodes 30 elements 54
.options sparse gmin=1e-12 noopac
RG1 1 0 1000000000000
RG2 2 0 1000000000000
RG3 3 0 1000000000000
RG4 4 0 1000000000000
RG5 5 0 1000000000000
RG6 6 0 1000000000000
RG7 7 0 1000000000000
RG8 8 0 1000000000000
RG9 9 0 1000000000000
RG10 10 0 1000000000000
RG11 11 0 1000000000000
RG12 12 0 1000000000000
RG13 13 0 1000000000000
RG14 14 0 1000000000000
RG15 15 0 1000000000000
RG16 16 0 1000000000000
RG17 17 0 1000000000000
RG18 18 0 1000000000000
RG19 19 0 1000000000000
RG20 20 0 1000000000000
RG21 21 0 1000000000000
RG22 22 0 1000000000000
RG23 23 0 1000000000000
RG24 24 0 1000000000000
RG25 25 0 1000000000000
RG26 26 0 1000000000000
RG27 27 0 1000000000000
RG28 28 0 1000000000000
RG29 29 0 1000000000000
VS0 4 s0 0
R0 s0 28 33e0
VS1 28 s1 0
I1 s1 29 DC 33e-2
VS2 1 s2 0
R2 s2 10 10e-2
VS3 19 s3 0
R3 s3 26 39e2
VS4 19 s4 0
I4 s4 14 DC 22e-4
VS5 1 s5 0
I5 s5 14 DC 33e-4
VS6 24 s6 0
I6 s6 22 DC 68e-3
VS7 29 s7 0
R7 s7 18 18e-1
VS8 0 s8 0
V8 e8 s8 DC 47e0
RI8 e8 9 27e-3
VS9 25 s9 0
R9 s9 10 10e1
VS10 13 s10 0
R10 s10 3 22e1
VS11 26 s11 0
R11 s11 20 68e3
VS12 29 s12 0
V12 e12 s12 DC 10e0
RI12 e12 20 10e-1
VS13 15 s13 0
R13 s13 4 10e0
VS14 3 s14 0
R14 s14 24 27e1
VS15 19 s15 0
R15 s15 9 82e0
VS16 2 s16 0
R16 s16 19 47e-1
VS17 16 s17 0
R17 s17 13 47e0
VS18 4 s18 0
R18 s18 0 18e2
VS19 12 s19 0
R19 s19 19 68e-2
VS20 19 s20 0
I20 s20 22 DC 56e-3
VS21 8 s21 0
I21 s21 23 DC 10e-4
VS22 6 s22 0
I22 s22 10 DC 22e-4
VS23 20 s23 0
R23 s23 29 33e0
VS24 11 s24 0
R24 s24 8 68e1
VS25 12 s25 0
R25 s25 24 15e3
VS26 14 s26 0
R26 s26 4 33e2
VS27 22 s27 0
R27 s27 17 47e2
VS28 4 s28 0
V28 e28 s28 DC 27e1
RI28 e28 11 18e-3
VS29 19 s29 0
R29 s29 10 39e1
VS30 16 s30 0
I30 s30 24 DC 47e-2
VS31 0 s31 0
I31 s31 12 DC 12e-3
VS32 15 s32 0
R32 s32 16 15e3
VS33 21 s33 0
R33 s33 17 33e2
VS34 10 s34 0
R34 s34 17 33e2
VS35 5 s35 0
R35 s35 3 68e1
VS36 2 s36 0
R36 s36 7 15e0
VS37 11 s37 0
R37 s37 23 22e1
VS38 17 s38 0
R38 s38 2 39e-1
VS39 11 s39 0
R39 s39 19 15e-1
VS40 2 s40 0
V40 e40 s40 DC 12e0
RI40 e40 25 10e-2
VS41 9 s41 0
R41 s41 16 15e-1
VS42 16 s42 0
V42 e42 s42 DC 12e-1
RI42 e42 6 47e-2
VS43 23 s43 0
I43 s43 27 DC 27e-1
VS44 24 s44 0
I44 s44 0 DC 27e-2
VS45 13 s45 0
R45 s45 19 15e3
VS46 8 s46 0
V46 e46 s46 DC 18e1
RI46 e46 7 39e-2
VS47 18 s47 0
R47 s47 17 15e1
VS48 25 s48 0
R48 s48 19 10e-2
VS49 14 s49 0
V49 e49 s49 DC 39e1
RI49 e49 13 47e-3
VS50 5 s50 0
V50 e50 s50 DC 56e1
RI50 e50 4 12e-2
VS51 24 s51 0
V51 e51 s51 DC 47e-1
RI51 e51 2 18e-2
VS52 26 s52 0
R52 s52 24 56e0
VS53 27 s53 0
R53 s53 5 33e-2
.control
set numdgt=17
op
print v(1) v(2) v(3) v(4) v(5) v(6) v(7) v(8) v(9) v(10)
print v(11) v(12) v(13) v(14) v(15) v(16) v(17) v(18) v(19) v(20)
print v(21) v(22) v(23) v(24) v(25) v(26) v(27) v(28) v(29)
print i(vs0) i(vs1) i(vs2) i(vs3) i(vs4) i(vs5) i(vs6) i(vs7) i(vs8) i(vs9)
print i(vs10) i(vs11) i(vs12) i(vs13) i(vs14) i(vs15) i(vs16) i(vs17) i(vs18) i(vs19)
print i(vs20) i(vs21) i(vs22) i(vs23) i(vs24) i(vs25) i(vs26) i(vs27) i(vs28) i(vs29)
print i(vs30) i(vs31) i(vs32) i(vs33) i(vs34) i(vs35) i(vs36) i(vs37) i(vs38) i(vs39)
print i(vs40) i(vs41) i(vs42) i(vs43) i(vs44) i(vs45) i(vs46) i(vs47) i(vs48) i(vs49)
print i(vs50) i(vs51) i(vs52) i(vs53)
.endc
.end
