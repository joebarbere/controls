controls oracle dc-0182
* Generated (plan F2.7, ADR 0012): do not edit; regenerate with `pnpm sim oracle regen`. dc seed 20261030 index 182 nodes 30 elements 60
.options sparse gmin=1e-12 noopac
RG1 1 0 1000000000000
RG2 2 0 1000000000000
RG3 3 0 1000000000000
RG4 4 0 1000000000000
RG5 5 0 1000000000000
RG6 6 0 1000000000000
RG7 7 0 1000000000000
RG8 8 0 1000000000000
RG9 9 0 1000000000000
RG10 10 0 1000000000000
RG11 11 0 1000000000000
RG12 12 0 1000000000000
RG13 13 0 1000000000000
RG14 14 0 1000000000000
RG15 15 0 1000000000000
RG16 16 0 1000000000000
RG17 17 0 1000000000000
RG18 18 0 1000000000000
RG19 19 0 1000000000000
RG20 20 0 1000000000000
RG21 21 0 1000000000000
RG22 22 0 1000000000000
RG23 23 0 1000000000000
RG24 24 0 1000000000000
RG25 25 0 1000000000000
RG26 26 0 1000000000000
RG27 27 0 1000000000000
RG28 28 0 1000000000000
RG29 29 0 1000000000000
VS0 8 s0 0
I0 s0 23 DC 10e-4
VS1 6 s1 0
I1 s1 0 DC 22e-4
VS2 19 s2 0
I2 s2 12 DC 12e-3
VS3 22 s3 0
R3 s3 17 47e2
VS4 11 s4 0
R4 s4 8 68e1
VS5 10 s5 0
I5 s5 14 DC 22e-4
VS6 4 s6 0
R6 s6 19 18e2
VS7 15 s7 0
R7 s7 16 15e3
VS8 5 s8 0
R8 s8 3 68e1
VS9 9 s9 0
R9 s9 28 15e-1
VS10 24 s10 0
I10 s10 19 DC 27e-2
VS11 11 s11 0
R11 s11 10 15e-1
VS12 10 s12 0
I12 s12 22 DC 56e-3
VS13 26 s13 0
R13 s13 27 10e3
VS14 0 s14 0
V14 e14 s14 DC 10e0
RI14 e14 22 15e-2
VS15 14 s15 0
R15 s15 4 33e2
VS16 5 s16 0
V16 e16 s16 DC 56e1
RI16 e16 4 12e-2
VS17 23 s17 0
R17 s17 6 22e3
VS18 4 s18 0
R18 s18 28 33e0
VS19 1 s19 0
R19 s19 0 10e-2
VS20 11 s20 0
R20 s20 23 22e1
VS21 10 s21 0
R21 s21 9 82e0
VS22 28 s22 0
I22 s22 29 DC 33e-2
VS23 2 s23 0
V23 e23 s23 DC 12e0
RI23 e23 25 10e-2
VS24 10 s24 0
R24 s24 26 39e2
VS25 24 s25 0
I25 s25 22 DC 68e-3
VS26 13 s26 0
R26 s26 3 22e1
VS27 26 s27 0
R27 s27 24 56e0
VS28 26 s28 0
R28 s28 20 68e3
VS29 21 s29 0
R29 s29 17 33e2
VS30 10 s30 0
R30 s30 0 39e1
VS31 12 s31 0
R31 s31 10 68e-2
VS32 2 s32 0
R32 s32 10 47e-1
VS33 18 s33 0
R33 s33 17 15e1
VS34 16 s34 0
V34 e34 s34 DC 12e-1
RI34 e34 6 47e-2
VS35 4 s35 0
V35 e35 s35 DC 27e1
RI35 e35 11 18e-3
VS36 19 s36 0
V36 e36 s36 DC 47e0
RI36 e36 9 27e-3
VS37 17 s37 0
R37 s37 2 39e-1
VS38 9 s38 0
R38 s38 16 15e-1
VS39 27 s39 0
R39 s39 5 33e-2
VS40 14 s40 0
V40 e40 s40 DC 39e1
RI40 e40 13 47e-3
VS41 29 s41 0
R41 s41 18 18e-1
VS42 16 s42 0
R42 s42 13 47e0
VS43 25 s43 0
R43 s43 10 10e-2
VS44 8 s44 0
V44 e44 s44 DC 18e1
RI44 e44 7 39e-2
VS45 21 s45 0
R45 s45 25 18e1
VS46 0 s46 0
R46 s46 17 33e2
VS47 20 s47 0
R47 s47 29 33e0
VS48 3 s48 0
R48 s48 24 27e1
VS49 23 s49 0
I49 s49 27 DC 27e-1
VS50 15 s50 0
R50 s50 1 18e1
VS51 29 s51 0
V51 e51 s51 DC 10e0
RI51 e51 20 10e-1
VS52 1 s52 0
I52 s52 14 DC 33e-4
VS53 25 s53 0
R53 s53 0 10e1
VS54 15 s54 0
R54 s54 4 10e0
VS55 24 s55 0
V55 e55 s55 DC 47e-1
RI55 e55 2 18e-2
VS56 12 s56 0
R56 s56 24 15e3
VS57 13 s57 0
R57 s57 10 15e3
VS58 16 s58 0
I58 s58 24 DC 47e-2
VS59 2 s59 0
R59 s59 7 15e0
.control
set numdgt=17
op
print v(1) v(2) v(3) v(4) v(5) v(6) v(7) v(8) v(9) v(10)
print v(11) v(12) v(13) v(14) v(15) v(16) v(17) v(18) v(19) v(20)
print v(21) v(22) v(23) v(24) v(25) v(26) v(27) v(28) v(29)
print i(vs0) i(vs1) i(vs2) i(vs3) i(vs4) i(vs5) i(vs6) i(vs7) i(vs8) i(vs9)
print i(vs10) i(vs11) i(vs12) i(vs13) i(vs14) i(vs15) i(vs16) i(vs17) i(vs18) i(vs19)
print i(vs20) i(vs21) i(vs22) i(vs23) i(vs24) i(vs25) i(vs26) i(vs27) i(vs28) i(vs29)
print i(vs30) i(vs31) i(vs32) i(vs33) i(vs34) i(vs35) i(vs36) i(vs37) i(vs38) i(vs39)
print i(vs40) i(vs41) i(vs42) i(vs43) i(vs44) i(vs45) i(vs46) i(vs47) i(vs48) i(vs49)
print i(vs50) i(vs51) i(vs52) i(vs53) i(vs54) i(vs55) i(vs56) i(vs57) i(vs58) i(vs59)
.endc
.end
