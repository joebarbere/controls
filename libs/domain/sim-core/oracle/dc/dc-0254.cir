controls oracle dc-0254
* Generated (plan F2.7, ADR 0012): do not edit; regenerate with `pnpm sim oracle regen`. dc seed 20261030 index 254 nodes 30 elements 41
.options sparse gmin=1e-12 noopac
RG1 1 0 1000000000000
RG2 2 0 1000000000000
RG3 3 0 1000000000000
RG4 4 0 1000000000000
RG5 5 0 1000000000000
RG6 6 0 1000000000000
RG7 7 0 1000000000000
RG8 8 0 1000000000000
RG9 9 0 1000000000000
RG10 10 0 1000000000000
RG11 11 0 1000000000000
RG12 12 0 1000000000000
RG13 13 0 1000000000000
RG14 14 0 1000000000000
RG15 15 0 1000000000000
RG16 16 0 1000000000000
RG17 17 0 1000000000000
RG18 18 0 1000000000000
RG19 19 0 1000000000000
RG20 20 0 1000000000000
RG21 21 0 1000000000000
RG22 22 0 1000000000000
RG23 23 0 1000000000000
RG24 24 0 1000000000000
RG25 25 0 1000000000000
RG26 26 0 1000000000000
RG27 27 0 1000000000000
RG28 28 0 1000000000000
RG29 29 0 1000000000000
VS0 0 s0 0
V0 e0 s0 DC 15e-1
RI0 e0 11 68e-2
VS1 22 s1 0
R1 s1 7 15e0
VS2 22 s2 0
R2 s2 0 33e-2
VS3 16 s3 0
R3 s3 3 56e0
VS4 20 s4 0
R4 s4 11 18e0
VS5 13 s5 0
R5 s5 22 12e0
VS6 14 s6 0
I6 s6 23 DC 33e-4
VS7 27 s7 0
I7 s7 9 DC 27e-3
VS8 20 s8 0
R8 s8 14 15e2
VS9 4 s9 0
R9 s9 10 22e0
VS10 17 s10 0
R10 s10 1 18e2
VS11 20 s11 0
R11 s11 18 22e-2
VS12 26 s12 0
R12 s12 5 18e0
VS13 21 s13 0
V13 e13 s13 DC 82e1
RI13 e13 10 68e-1
VS14 25 s14 0
R14 s14 11 27e1
VS15 23 s15 0
R15 s15 0 22e-1
VS16 1 s16 0
R16 s16 28 27e2
VS17 18 s17 0
R17 s17 17 33e-2
VS18 24 s18 0
R18 s18 29 39e1
VS19 19 s19 0
R19 s19 3 47e-2
VS20 24 s20 0
R20 s20 5 39e-2
VS21 5 s21 0
R21 s21 2 10e0
VS22 21 s22 0
R22 s22 0 56e-2
VS23 1 s23 0
R23 s23 20 82e-1
VS24 13 s24 0
R24 s24 8 18e-1
VS25 20 s25 0
R25 s25 26 22e2
VS26 13 s26 0
R26 s26 27 33e0
VS27 0 s27 0
R27 s27 16 56e2
VS28 13 s28 0
R28 s28 20 22e0
VS29 10 s29 0
V29 e29 s29 DC 10e-1
RI29 e29 22 12e-1
VS30 24 s30 0
I30 s30 0 DC 56e-3
VS31 4 s31 0
I31 s31 9 DC 12e-1
VS32 6 s32 0
V32 e32 s32 DC 47e0
RI32 e32 0 47e-1
VS33 9 s33 0
R33 s33 26 68e3
VS34 3 s34 0
V34 e34 s34 DC 47e1
RI34 e34 12 33e-1
VS35 27 s35 0
R35 s35 19 33e-2
VS36 4 s36 0
R36 s36 23 68e2
VS37 0 s37 0
R37 s37 20 39e0
VS38 16 s38 0
R38 s38 15 27e3
VS39 2 s39 0
R39 s39 18 12e1
VS40 11 s40 0
R40 s40 12 56e-2
.control
set numdgt=17
op
print v(1) v(2) v(3) v(4) v(5) v(6) v(7) v(8) v(9) v(10)
print v(11) v(12) v(13) v(14) v(15) v(16) v(17) v(18) v(19) v(20)
print v(21) v(22) v(23) v(24) v(25) v(26) v(27) v(28) v(29)
print i(vs0) i(vs1) i(vs2) i(vs3) i(vs4) i(vs5) i(vs6) i(vs7) i(vs8) i(vs9)
print i(vs10) i(vs11) i(vs12) i(vs13) i(vs14) i(vs15) i(vs16) i(vs17) i(vs18) i(vs19)
print i(vs20) i(vs21) i(vs22) i(vs23) i(vs24) i(vs25) i(vs26) i(vs27) i(vs28) i(vs29)
print i(vs30) i(vs31) i(vs32) i(vs33) i(vs34) i(vs35) i(vs36) i(vs37) i(vs38) i(vs39)
print i(vs40)
.endc
.end
