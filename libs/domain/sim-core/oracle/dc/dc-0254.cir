controls oracle dc-0254
* Generated (plan F2.7, ADR 0012): do not edit; regenerate with `pnpm sim oracle regen`. dc seed 20261030 index 254 nodes 30 elements 50
.options sparse gmin=1e-12 noopac
RG1 1 0 1000000000000
RG2 2 0 1000000000000
RG3 3 0 1000000000000
RG4 4 0 1000000000000
RG5 5 0 1000000000000
RG6 6 0 1000000000000
RG7 7 0 1000000000000
RG8 8 0 1000000000000
RG9 9 0 1000000000000
RG10 10 0 1000000000000
RG11 11 0 1000000000000
RG12 12 0 1000000000000
RG13 13 0 1000000000000
RG14 14 0 1000000000000
RG15 15 0 1000000000000
RG16 16 0 1000000000000
RG17 17 0 1000000000000
RG18 18 0 1000000000000
RG19 19 0 1000000000000
RG20 20 0 1000000000000
RG21 21 0 1000000000000
RG22 22 0 1000000000000
RG23 23 0 1000000000000
RG24 24 0 1000000000000
RG25 25 0 1000000000000
RG26 26 0 1000000000000
RG27 27 0 1000000000000
RG28 28 0 1000000000000
RG29 29 0 1000000000000
VS0 18 s0 0
R0 s0 17 33e-2
VS1 0 s1 0
V1 e1 s1 DC 10e-1
RI1 e1 22 12e-1
VS2 9 s2 0
R2 s2 10 68e3
VS3 13 s3 0
R3 s3 8 18e-1
VS4 20 s4 0
R4 s4 18 22e-2
VS5 27 s5 0
R5 s5 7 22e1
VS6 4 s6 0
R6 s6 0 22e0
VS7 4 s7 0
I7 s7 9 DC 12e-1
VS8 22 s8 0
R8 s8 26 33e-2
VS9 26 s9 0
R9 s9 16 56e2
VS10 14 s10 0
I10 s10 23 DC 33e-4
VS11 24 s11 0
R11 s11 29 39e1
VS12 21 s12 0
R12 s12 26 56e-2
VS13 23 s13 0
R13 s13 26 22e-1
VS14 26 s14 0
R14 s14 20 39e0
VS15 20 s15 0
R15 s15 11 18e0
VS16 11 s16 0
R16 s16 12 56e-2
VS17 12 s17 0
R17 s17 6 82e-2
VS18 17 s18 0
R18 s18 1 18e2
VS19 14 s19 0
V19 e19 s19 DC 10e1
RI19 e19 4 56e-2
VS20 27 s20 0
R20 s20 19 33e-2
VS21 7 s21 0
R21 s21 9 10e2
VS22 22 s22 0
R22 s22 7 15e0
VS23 1 s23 0
R23 s23 28 27e2
VS24 4 s24 0
R24 s24 23 68e2
VS25 5 s25 0
R25 s25 2 10e0
VS26 13 s26 0
R26 s26 20 22e0
VS27 21 s27 0
V27 e27 s27 DC 82e1
RI27 e27 0 68e-1
VS28 25 s28 0
R28 s28 19 22e-2
VS29 15 s29 0
R29 s29 12 68e-1
VS30 3 s30 0
V30 e30 s30 DC 47e1
RI30 e30 12 33e-1
VS31 27 s31 0
I31 s31 9 DC 27e-3
VS32 24 s32 0
I32 s32 26 DC 56e-3
VS33 25 s33 0
R33 s33 11 27e1
VS34 16 s34 0
R34 s34 3 56e0
VS35 19 s35 0
R35 s35 3 47e-2
VS36 1 s36 0
R36 s36 20 82e-1
VS37 13 s37 0
R37 s37 27 33e0
VS38 16 s38 0
R38 s38 15 27e3
VS39 10 s39 0
R39 s39 5 18e0
VS40 13 s40 0
R40 s40 22 12e0
VS41 29 s41 0
R41 s41 25 82e0
VS42 20 s42 0
R42 s42 14 15e2
VS43 17 s43 0
V43 e43 s43 DC 10e-1
RI43 e43 28 10e-2
VS44 20 s44 0
R44 s44 10 22e2
VS45 2 s45 0
R45 s45 18 12e1
VS46 6 s46 0
V46 e46 s46 DC 47e0
RI46 e46 26 47e-1
VS47 8 s47 0
V47 e47 s47 DC 27e-1
RI47 e47 17 56e-3
VS48 26 s48 0
V48 e48 s48 DC 15e-1
RI48 e48 11 68e-2
VS49 24 s49 0
R49 s49 5 39e-2
.control
set numdgt=17
op
print v(1) v(2) v(3) v(4) v(5) v(6) v(7) v(8) v(9) v(10)
print v(11) v(12) v(13) v(14) v(15) v(16) v(17) v(18) v(19) v(20)
print v(21) v(22) v(23) v(24) v(25) v(26) v(27) v(28) v(29)
print i(vs0) i(vs1) i(vs2) i(vs3) i(vs4) i(vs5) i(vs6) i(vs7) i(vs8) i(vs9)
print i(vs10) i(vs11) i(vs12) i(vs13) i(vs14) i(vs15) i(vs16) i(vs17) i(vs18) i(vs19)
print i(vs20) i(vs21) i(vs22) i(vs23) i(vs24) i(vs25) i(vs26) i(vs27) i(vs28) i(vs29)
print i(vs30) i(vs31) i(vs32) i(vs33) i(vs34) i(vs35) i(vs36) i(vs37) i(vs38) i(vs39)
print i(vs40) i(vs41) i(vs42) i(vs43) i(vs44) i(vs45) i(vs46) i(vs47) i(vs48) i(vs49)
.endc
.end
