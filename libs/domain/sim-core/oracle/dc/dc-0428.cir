controls oracle dc-0428
* Generated (plan F2.7, ADR 0012): do not edit; regenerate with `pnpm sim oracle regen`. dc seed 20261030 index 428 nodes 9 elements 15
.options sparse gmin=1e-12 noopac
RG1 1 0 1000000000000
RG2 2 0 1000000000000
RG3 3 0 1000000000000
RG4 4 0 1000000000000
RG5 5 0 1000000000000
RG6 6 0 1000000000000
RG7 7 0 1000000000000
RG8 8 0 1000000000000
VS0 0 s0 0
V0 e0 s0 DC 56e0
RI0 e0 1 56e-3
VS1 7 s1 0
R1 s1 2 47e-1
VS2 6 s2 0
R2 s2 1 12e2
VS3 6 s3 0
V3 e3 s3 DC 56e-1
RI3 e3 5 47e-2
VS4 4 s4 0
R4 s4 8 27e-2
VS5 5 s5 0
I5 s5 1 DC 39e-3
VS6 2 s6 0
I6 s6 1 DC 39e-4
VS7 5 s7 0
R7 s7 1 12e-2
VS8 5 s8 0
I8 s8 0 DC 12e-3
VS9 8 s9 0
R9 s9 2 12e0
VS10 3 s10 0
V10 e10 s10 DC 18e-1
RI10 e10 2 33e-3
VS11 3 s11 0
R11 s11 5 39e-1
VS12 4 s12 0
R12 s12 6 15e3
VS13 7 s13 0
R13 s13 0 39e0
VS14 2 s14 0
R14 s14 1 15e2
.control
set numdgt=17
op
print v(1) v(2) v(3) v(4) v(5) v(6) v(7) v(8)
print i(vs0) i(vs1) i(vs2) i(vs3) i(vs4) i(vs5) i(vs6) i(vs7) i(vs8) i(vs9)
print i(vs10) i(vs11) i(vs12) i(vs13) i(vs14)
.endc
.end
