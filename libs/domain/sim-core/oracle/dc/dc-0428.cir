controls oracle dc-0428
* Generated (plan F2.7, ADR 0012): do not edit; regenerate with `pnpm sim oracle regen`. dc seed 20261030 index 428 nodes 9 elements 14
.options sparse gmin=1e-12 noopac
RG1 1 0 1000000000000
RG2 2 0 1000000000000
RG3 3 0 1000000000000
RG4 4 0 1000000000000
RG5 5 0 1000000000000
RG6 6 0 1000000000000
RG7 7 0 1000000000000
RG8 8 0 1000000000000
VS0 5 s0 0
R0 s0 1 12e-2
VS1 0 s1 0
V1 e1 s1 DC 18e-1
RI1 e1 2 33e-3
VS2 7 s2 0
R2 s2 2 47e-1
VS3 6 s3 0
R3 s3 1 12e2
VS4 5 s4 0
I4 s4 8 DC 12e-3
VS5 3 s5 0
R5 s5 2 12e0
VS6 7 s6 0
R6 s6 8 39e0
VS7 2 s7 0
R7 s7 1 15e2
VS8 4 s8 0
R8 s8 3 27e-2
VS9 5 s9 0
I9 s9 1 DC 39e-3
VS10 8 s10 0
V10 e10 s10 DC 56e0
RI10 e10 1 56e-3
VS11 2 s11 0
I11 s11 1 DC 39e-4
VS12 4 s12 0
R12 s12 6 15e3
VS13 6 s13 0
V13 e13 s13 DC 56e-1
RI13 e13 5 47e-2
.control
set numdgt=17
op
print v(1) v(2) v(3) v(4) v(5) v(6) v(7) v(8)
print i(vs0) i(vs1) i(vs2) i(vs3) i(vs4) i(vs5) i(vs6) i(vs7) i(vs8) i(vs9)
print i(vs10) i(vs11) i(vs12) i(vs13)
.endc
.end
