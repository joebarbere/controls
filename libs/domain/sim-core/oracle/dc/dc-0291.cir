controls oracle dc-0291
* Generated (plan F2.7, ADR 0012): do not edit; regenerate with `pnpm sim oracle regen`. dc seed 20261030 index 291 nodes 6 elements 11
.options sparse gmin=1e-12 noopac
RG1 1 0 1000000000000
RG2 2 0 1000000000000
RG3 3 0 1000000000000
RG4 4 0 1000000000000
RG5 5 0 1000000000000
VS0 5 s0 0
R0 s0 2 47e2
VS1 3 s1 0
R1 s1 1 39e-2
VS2 2 s2 0
R2 s2 1 22e-2
VS3 0 s3 0
V3 e3 s3 DC 68e0
RI3 e3 4 27e-1
VS4 1 s4 0
R4 s4 4 33e1
VS5 0 s5 0
I5 s5 5 DC 27e-2
VS6 2 s6 0
V6 e6 s6 DC 39e1
RI6 e6 4 12e-1
VS7 4 s7 0
I7 s7 0 DC 56e-1
VS8 5 s8 0
V8 e8 s8 DC 18e0
RI8 e8 3 68e-1
VS9 1 s9 0
R9 s9 4 68e-2
VS10 1 s10 0
I10 s10 4 DC 12e-2
.control
set numdgt=17
op
print v(1) v(2) v(3) v(4) v(5)
print i(vs0) i(vs1) i(vs2) i(vs3) i(vs4) i(vs5) i(vs6) i(vs7) i(vs8) i(vs9)
print i(vs10)
.endc
.end
