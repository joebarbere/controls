controls oracle dc-0291
* Generated (plan F2.7, ADR 0012): do not edit; regenerate with `pnpm sim oracle regen`. dc seed 20261030 index 291 nodes 6 elements 12
.options sparse gmin=1e-12 noopac
RG1 1 0 1000000000000
RG2 2 0 1000000000000
RG3 3 0 1000000000000
RG4 4 0 1000000000000
RG5 5 0 1000000000000
VS0 1 s0 0
R0 s0 0 33e3
VS1 0 s1 0
V1 e1 s1 DC 68e0
RI1 e1 4 27e-1
VS2 4 s2 0
I2 s2 0 DC 56e-1
VS3 1 s3 0
I3 s3 4 DC 12e-2
VS4 5 s4 0
V4 e4 s4 DC 18e0
RI4 e4 3 68e-1
VS5 1 s5 0
R5 s5 4 33e1
VS6 5 s6 0
R6 s6 2 47e2
VS7 2 s7 0
V7 e7 s7 DC 39e1
RI7 e7 4 12e-1
VS8 2 s8 0
R8 s8 1 22e-2
VS9 1 s9 0
R9 s9 4 68e-2
VS10 0 s10 0
I10 s10 5 DC 27e-2
VS11 3 s11 0
R11 s11 1 39e-2
.control
set numdgt=17
op
print v(1) v(2) v(3) v(4) v(5)
print i(vs0) i(vs1) i(vs2) i(vs3) i(vs4) i(vs5) i(vs6) i(vs7) i(vs8) i(vs9)
print i(vs10) i(vs11)
.endc
.end
