controls oracle dc-0370
* Generated (plan F2.7, ADR 0012): do not edit; regenerate with `pnpm sim oracle regen`. dc seed 20261030 index 370 nodes 25 elements 32
.options sparse gmin=1e-12 noopac
RG1 1 0 1000000000000
RG2 2 0 1000000000000
RG3 3 0 1000000000000
RG4 4 0 1000000000000
RG5 5 0 1000000000000
RG6 6 0 1000000000000
RG7 7 0 1000000000000
RG8 8 0 1000000000000
RG9 9 0 1000000000000
RG10 10 0 1000000000000
RG11 11 0 1000000000000
RG12 12 0 1000000000000
RG13 13 0 1000000000000
RG14 14 0 1000000000000
RG15 15 0 1000000000000
RG16 16 0 1000000000000
RG17 17 0 1000000000000
RG18 18 0 1000000000000
RG19 19 0 1000000000000
RG20 20 0 1000000000000
RG21 21 0 1000000000000
RG22 22 0 1000000000000
RG23 23 0 1000000000000
RG24 24 0 1000000000000
VS0 10 s0 0
R0 s0 19 27e-1
VS1 0 s1 0
V1 e1 s1 DC 22e0
RI1 e1 15 22e-2
VS2 4 s2 0
R2 s2 16 12e3
VS3 0 s3 0
R3 s3 8 27e2
VS4 13 s4 0
R4 s4 19 15e0
VS5 11 s5 0
R5 s5 0 82e2
VS6 21 s6 0
V6 e6 s6 DC 27e0
RI6 e6 13 10e-3
VS7 13 s7 0
R7 s7 12 12e-2
VS8 20 s8 0
R8 s8 18 68e0
VS9 7 s9 0
R9 s9 13 56e-1
VS10 17 s10 0
R10 s10 8 33e2
VS11 20 s11 0
R11 s11 16 47e-2
VS12 5 s12 0
I12 s12 17 DC 33e-4
VS13 0 s13 0
R13 s13 2 82e1
VS14 8 s14 0
R14 s14 21 27e2
VS15 14 s15 0
V15 e15 s15 DC 27e0
RI15 e15 13 15e-2
VS16 10 s16 0
R16 s16 5 82e3
VS17 19 s17 0
R17 s17 24 15e0
VS18 9 s18 0
R18 s18 8 33e-2
VS19 0 s19 0
R19 s19 6 22e0
VS20 21 s20 0
V20 e20 s20 DC 18e0
RI20 e20 13 68e-2
VS21 4 s21 0
R21 s21 18 22e-1
VS22 1 s22 0
R22 s22 16 12e-2
VS23 4 s23 0
I23 s23 9 DC 82e-1
VS24 7 s24 0
R24 s24 3 22e-1
VS25 11 s25 0
I25 s25 21 DC 68e-2
VS26 13 s26 0
R26 s26 16 15e-1
VS27 9 s27 0
I27 s27 20 DC 82e-1
VS28 21 s28 0
R28 s28 14 68e-1
VS29 17 s29 0
R29 s29 23 56e3
VS30 9 s30 0
R30 s30 22 56e1
VS31 22 s31 0
R31 s31 24 10e1
.control
set numdgt=17
op
print v(1) v(2) v(3) v(4) v(5) v(6) v(7) v(8) v(9) v(10)
print v(11) v(12) v(13) v(14) v(15) v(16) v(17) v(18) v(19) v(20)
print v(21) v(22) v(23) v(24)
print i(vs0) i(vs1) i(vs2) i(vs3) i(vs4) i(vs5) i(vs6) i(vs7) i(vs8) i(vs9)
print i(vs10) i(vs11) i(vs12) i(vs13) i(vs14) i(vs15) i(vs16) i(vs17) i(vs18) i(vs19)
print i(vs20) i(vs21) i(vs22) i(vs23) i(vs24) i(vs25) i(vs26) i(vs27) i(vs28) i(vs29)
print i(vs30) i(vs31)
.endc
.end
