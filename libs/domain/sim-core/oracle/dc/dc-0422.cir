controls oracle dc-0422
* Generated (plan F2.7, ADR 0012): do not edit; regenerate with `pnpm sim oracle regen`. dc seed 20261030 index 422 nodes 20 elements 36
.options sparse gmin=1e-12 noopac
RG1 1 0 1000000000000
RG2 2 0 1000000000000
RG3 3 0 1000000000000
RG4 4 0 1000000000000
RG5 5 0 1000000000000
RG6 6 0 1000000000000
RG7 7 0 1000000000000
RG8 8 0 1000000000000
RG9 9 0 1000000000000
RG10 10 0 1000000000000
RG11 11 0 1000000000000
RG12 12 0 1000000000000
RG13 13 0 1000000000000
RG14 14 0 1000000000000
RG15 15 0 1000000000000
RG16 16 0 1000000000000
RG17 17 0 1000000000000
RG18 18 0 1000000000000
RG19 19 0 1000000000000
VS0 3 s0 0
R0 s0 18 15e0
VS1 5 s1 0
I1 s1 15 DC 39e-1
VS2 4 s2 0
R2 s2 2 33e3
VS3 0 s3 0
R3 s3 2 10e-1
VS4 0 s4 0
V4 e4 s4 DC 10e1
RI4 e4 5 39e-1
VS5 1 s5 0
R5 s5 11 56e0
VS6 15 s6 0
R6 s6 6 18e2
VS7 1 s7 0
R7 s7 11 47e2
VS8 7 s8 0
R8 s8 10 56e1
VS9 11 s9 0
V9 e9 s9 DC 27e1
RI9 e9 8 27e-3
VS10 9 s10 0
R10 s10 1 15e3
VS11 1 s11 0
R11 s11 15 12e0
VS12 15 s12 0
R12 s12 14 10e1
VS13 9 s13 0
R13 s13 18 68e3
VS14 1 s14 0
V14 e14 s14 DC 12e1
RI14 e14 8 82e-3
VS15 4 s15 0
R15 s15 13 39e-1
VS16 12 s16 0
V16 e16 s16 DC 39e1
RI16 e16 10 47e-1
VS17 19 s17 0
V17 e17 s17 DC 27e1
RI17 e17 11 39e-1
VS18 12 s18 0
R18 s18 15 56e2
VS19 16 s19 0
R19 s19 13 56e2
VS20 11 s20 0
R20 s20 4 82e-1
VS21 10 s21 0
V21 e21 s21 DC 15e-1
RI21 e21 2 82e-3
VS22 12 s22 0
R22 s22 8 27e2
VS23 11 s23 0
R23 s23 7 56e-2
VS24 9 s24 0
R24 s24 19 27e1
VS25 10 s25 0
R25 s25 17 68e2
VS26 5 s26 0
R26 s26 16 10e1
VS27 0 s27 0
R27 s27 17 68e2
VS28 6 s28 0
R28 s28 9 47e-1
VS29 15 s29 0
R29 s29 14 68e-2
VS30 3 s30 0
R30 s30 10 12e-2
VS31 11 s31 0
V31 e31 s31 DC 47e-1
RI31 e31 12 10e-2
VS32 15 s32 0
R32 s32 1 68e1
VS33 11 s33 0
V33 e33 s33 DC 47e-1
RI33 e33 16 15e-2
VS34 7 s34 0
R34 s34 14 22e1
VS35 0 s35 0
R35 s35 9 22e1
.control
set numdgt=17
op
print v(1) v(2) v(3) v(4) v(5) v(6) v(7) v(8) v(9) v(10)
print v(11) v(12) v(13) v(14) v(15) v(16) v(17) v(18) v(19)
print i(vs0) i(vs1) i(vs2) i(vs3) i(vs4) i(vs5) i(vs6) i(vs7) i(vs8) i(vs9)
print i(vs10) i(vs11) i(vs12) i(vs13) i(vs14) i(vs15) i(vs16) i(vs17) i(vs18) i(vs19)
print i(vs20) i(vs21) i(vs22) i(vs23) i(vs24) i(vs25) i(vs26) i(vs27) i(vs28) i(vs29)
print i(vs30) i(vs31) i(vs32) i(vs33) i(vs34) i(vs35)
.endc
.end
