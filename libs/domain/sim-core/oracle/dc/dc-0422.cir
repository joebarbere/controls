controls oracle dc-0422
* Generated (plan F2.7, ADR 0012): do not edit; regenerate with `pnpm sim oracle regen`. dc seed 20261030 index 422 nodes 20 elements 33
.options sparse gmin=1e-12 noopac
RG1 1 0 1000000000000
RG2 2 0 1000000000000
RG3 3 0 1000000000000
RG4 4 0 1000000000000
RG5 5 0 1000000000000
RG6 6 0 1000000000000
RG7 7 0 1000000000000
RG8 8 0 1000000000000
RG9 9 0 1000000000000
RG10 10 0 1000000000000
RG11 11 0 1000000000000
RG12 12 0 1000000000000
RG13 13 0 1000000000000
RG14 14 0 1000000000000
RG15 15 0 1000000000000
RG16 16 0 1000000000000
RG17 17 0 1000000000000
RG18 18 0 1000000000000
RG19 19 0 1000000000000
VS0 4 s0 0
R0 s0 11 33e3
VS1 0 s1 0
V1 e1 s1 DC 47e-1
RI1 e1 12 10e-2
VS2 15 s2 0
R2 s2 1 68e1
VS3 2 s3 0
R3 s3 9 22e1
VS4 15 s4 0
R4 s4 14 10e1
VS5 9 s5 0
R5 s5 18 68e3
VS6 3 s6 0
R6 s6 18 15e0
VS7 0 s7 0
V7 e7 s7 DC 27e1
RI7 e7 8 27e-3
VS8 4 s8 0
R8 s8 13 39e-1
VS9 1 s9 0
R9 s9 15 12e0
VS10 15 s10 0
R10 s10 6 18e2
VS11 0 s11 0
R11 s11 4 82e-1
VS12 0 s12 0
R12 s12 7 56e-2
VS13 1 s13 0
R13 s13 0 56e0
VS14 9 s14 0
R14 s14 1 15e3
VS15 9 s15 0
R15 s15 19 27e1
VS16 2 s16 0
R16 s16 11 10e-1
VS17 12 s17 0
R17 s17 15 56e2
VS18 7 s18 0
R18 s18 14 22e1
VS19 5 s19 0
I19 s19 15 DC 39e-1
VS20 12 s20 0
R20 s20 8 27e2
VS21 7 s21 0
R21 s21 10 56e1
VS22 15 s22 0
R22 s22 14 68e-2
VS23 19 s23 0
V23 e23 s23 DC 27e1
RI23 e23 0 39e-1
VS24 1 s24 0
R24 s24 0 47e2
VS25 2 s25 0
R25 s25 17 68e2
VS26 1 s26 0
V26 e26 s26 DC 12e1
RI26 e26 8 82e-3
VS27 5 s27 0
R27 s27 16 10e1
VS28 10 s28 0
V28 e28 s28 DC 15e-1
RI28 e28 11 82e-3
VS29 12 s29 0
V29 e29 s29 DC 39e1
RI29 e29 10 47e-1
VS30 16 s30 0
R30 s30 13 56e2
VS31 0 s31 0
V31 e31 s31 DC 47e-1
RI31 e31 16 15e-2
VS32 6 s32 0
R32 s32 9 47e-1
.control
set numdgt=17
op
print v(1) v(2) v(3) v(4) v(5) v(6) v(7) v(8) v(9) v(10)
print v(11) v(12) v(13) v(14) v(15) v(16) v(17) v(18) v(19)
print i(vs0) i(vs1) i(vs2) i(vs3) i(vs4) i(vs5) i(vs6) i(vs7) i(vs8) i(vs9)
print i(vs10) i(vs11) i(vs12) i(vs13) i(vs14) i(vs15) i(vs16) i(vs17) i(vs18) i(vs19)
print i(vs20) i(vs21) i(vs22) i(vs23) i(vs24) i(vs25) i(vs26) i(vs27) i(vs28) i(vs29)
print i(vs30) i(vs31) i(vs32)
.endc
.end
