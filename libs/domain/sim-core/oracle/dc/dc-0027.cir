controls oracle dc-0027
* Generated (plan F2.7, ADR 0012): do not edit; regenerate with `pnpm sim oracle regen`. dc seed 20261030 index 27 nodes 10 elements 16
.options sparse gmin=1e-12 noopac
RG1 1 0 1000000000000
RG2 2 0 1000000000000
RG3 3 0 1000000000000
RG4 4 0 1000000000000
RG5 5 0 1000000000000
RG6 6 0 1000000000000
RG7 7 0 1000000000000
RG8 8 0 1000000000000
RG9 9 0 1000000000000
VS0 5 s0 0
R0 s0 0 68e-2
VS1 3 s1 0
R1 s1 7 27e1
VS2 2 s2 0
R2 s2 3 68e2
VS3 0 s3 0
R3 s3 4 10e2
VS4 7 s4 0
R4 s4 2 27e2
VS5 1 s5 0
R5 s5 9 15e0
VS6 7 s6 0
R6 s6 6 22e3
VS7 0 s7 0
V7 e7 s7 DC 22e0
RI7 e7 1 18e-2
VS8 2 s8 0
R8 s8 9 27e3
VS9 4 s9 0
R9 s9 8 12e3
VS10 0 s10 0
R10 s10 6 39e3
VS11 5 s11 0
V11 e11 s11 DC 82e-1
RI11 e11 7 22e-3
VS12 5 s12 0
I12 s12 3 DC 27e-3
VS13 9 s13 0
R13 s13 5 10e-2
VS14 1 s14 0
R14 s14 3 12e2
VS15 8 s15 0
R15 s15 5 22e2
.control
set numdgt=17
op
print v(1) v(2) v(3) v(4) v(5) v(6) v(7) v(8) v(9)
print i(vs0) i(vs1) i(vs2) i(vs3) i(vs4) i(vs5) i(vs6) i(vs7) i(vs8) i(vs9)
print i(vs10) i(vs11) i(vs12) i(vs13) i(vs14) i(vs15)
.endc
.end
