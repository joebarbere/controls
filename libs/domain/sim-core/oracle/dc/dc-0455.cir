controls oracle dc-0455
* Generated (plan F2.7, ADR 0012): do not edit; regenerate with `pnpm sim oracle regen`. dc seed 20261030 index 455 nodes 29 elements 49
.options sparse gmin=1e-12 noopac
RG1 1 0 1000000000000
RG2 2 0 1000000000000
RG3 3 0 1000000000000
RG4 4 0 1000000000000
RG5 5 0 1000000000000
RG6 6 0 1000000000000
RG7 7 0 1000000000000
RG8 8 0 1000000000000
RG9 9 0 1000000000000
RG10 10 0 1000000000000
RG11 11 0 1000000000000
RG12 12 0 1000000000000
RG13 13 0 1000000000000
RG14 14 0 1000000000000
RG15 15 0 1000000000000
RG16 16 0 1000000000000
RG17 17 0 1000000000000
RG18 18 0 1000000000000
RG19 19 0 1000000000000
RG20 20 0 1000000000000
RG21 21 0 1000000000000
RG22 22 0 1000000000000
RG23 23 0 1000000000000
RG24 24 0 1000000000000
RG25 25 0 1000000000000
RG26 26 0 1000000000000
RG27 27 0 1000000000000
RG28 28 0 1000000000000
VS0 20 s0 0
R0 s0 18 18e3
VS1 3 s1 0
R1 s1 4 82e2
VS2 0 s2 0
V2 e2 s2 DC 68e1
RI2 e2 26 22e-3
VS3 10 s3 0
R3 s3 20 18e2
VS4 22 s4 0
V4 e4 s4 DC 33e0
RI4 e4 3 56e-2
VS5 28 s5 0
R5 s5 27 82e2
VS6 6 s6 0
V6 e6 s6 DC 15e1
RI6 e6 0 56e-3
VS7 14 s7 0
I7 s7 1 DC 47e-3
VS8 24 s8 0
I8 s8 16 DC 10e-4
VS9 8 s9 0
R9 s9 15 15e-1
VS10 27 s10 0
R10 s10 2 82e2
VS11 21 s11 0
R11 s11 28 33e2
VS12 0 s12 0
R12 s12 7 82e2
VS13 0 s13 0
R13 s13 26 27e-2
VS14 12 s14 0
R14 s14 1 27e0
VS15 9 s15 0
I15 s15 25 DC 18e-1
VS16 19 s16 0
I16 s16 25 DC 18e-1
VS17 19 s17 0
R17 s17 27 12e2
VS18 22 s18 0
R18 s18 16 56e3
VS19 1 s19 0
R19 s19 10 39e2
VS20 27 s20 0
R20 s20 22 10e0
VS21 6 s21 0
R21 s21 8 18e-2
VS22 11 s22 0
R22 s22 0 33e1
VS23 13 s23 0
V23 e23 s23 DC 22e1
RI23 e23 9 82e-2
VS24 5 s24 0
R24 s24 2 22e2
VS25 13 s25 0
R25 s25 11 27e1
VS26 18 s26 0
V26 e26 s26 DC 15e1
RI26 e26 7 33e-2
VS27 24 s27 0
V27 e27 s27 DC 18e0
RI27 e27 0 12e-1
VS28 10 s28 0
R28 s28 13 68e0
VS29 5 s29 0
V29 e29 s29 DC 18e-1
RI29 e29 12 56e-2
VS30 14 s30 0
R30 s30 17 15e-2
VS31 6 s31 0
R31 s31 16 15e1
VS32 17 s32 0
R32 s32 1 18e-1
VS33 8 s33 0
I33 s33 19 DC 56e-1
VS34 9 s34 0
R34 s34 13 82e0
VS35 0 s35 0
R35 s35 25 39e0
VS36 3 s36 0
R36 s36 24 18e1
VS37 16 s37 0
R37 s37 13 18e-1
VS38 10 s38 0
R38 s38 28 27e2
VS39 16 s39 0
R39 s39 19 22e2
VS40 26 s40 0
R40 s40 14 12e2
VS41 9 s41 0
R41 s41 0 18e-2
VS42 16 s42 0
R42 s42 23 22e1
VS43 18 s43 0
R43 s43 25 82e2
VS44 12 s44 0
V44 e44 s44 DC 33e1
RI44 e44 15 18e-2
VS45 21 s45 0
R45 s45 7 27e0
VS46 16 s46 0
V46 e46 s46 DC 33e1
RI46 e46 4 22e-1
VS47 10 s47 0
R47 s47 15 33e3
VS48 23 s48 0
R48 s48 22 15e1
.control
set numdgt=17
op
print v(1) v(2) v(3) v(4) v(5) v(6) v(7) v(8) v(9) v(10)
print v(11) v(12) v(13) v(14) v(15) v(16) v(17) v(18) v(19) v(20)
print v(21) v(22) v(23) v(24) v(25) v(26) v(27) v(28)
print i(vs0) i(vs1) i(vs2) i(vs3) i(vs4) i(vs5) i(vs6) i(vs7) i(vs8) i(vs9)
print i(vs10) i(vs11) i(vs12) i(vs13) i(vs14) i(vs15) i(vs16) i(vs17) i(vs18) i(vs19)
print i(vs20) i(vs21) i(vs22) i(vs23) i(vs24) i(vs25) i(vs26) i(vs27) i(vs28) i(vs29)
print i(vs30) i(vs31) i(vs32) i(vs33) i(vs34) i(vs35) i(vs36) i(vs37) i(vs38) i(vs39)
print i(vs40) i(vs41) i(vs42) i(vs43) i(vs44) i(vs45) i(vs46) i(vs47) i(vs48)
.endc
.end
