controls oracle dc-0455
* Generated (plan F2.7, ADR 0012): do not edit; regenerate with `pnpm sim oracle regen`. dc seed 20261030 index 455 nodes 29 elements 40
.options sparse gmin=1e-12 noopac
RG1 1 0 1000000000000
RG2 2 0 1000000000000
RG3 3 0 1000000000000
RG4 4 0 1000000000000
RG5 5 0 1000000000000
RG6 6 0 1000000000000
RG7 7 0 1000000000000
RG8 8 0 1000000000000
RG9 9 0 1000000000000
RG10 10 0 1000000000000
RG11 11 0 1000000000000
RG12 12 0 1000000000000
RG13 13 0 1000000000000
RG14 14 0 1000000000000
RG15 15 0 1000000000000
RG16 16 0 1000000000000
RG17 17 0 1000000000000
RG18 18 0 1000000000000
RG19 19 0 1000000000000
RG20 20 0 1000000000000
RG21 21 0 1000000000000
RG22 22 0 1000000000000
RG23 23 0 1000000000000
RG24 24 0 1000000000000
RG25 25 0 1000000000000
RG26 26 0 1000000000000
RG27 27 0 1000000000000
RG28 28 0 1000000000000
VS0 12 s0 0
R0 s0 1 27e0
VS1 21 s1 0
R1 s1 22 33e2
VS2 13 s2 0
R2 s2 11 27e1
VS3 0 s3 0
V3 e3 s3 DC 33e0
RI3 e3 3 56e-2
VS4 28 s4 0
V4 e4 s4 DC 68e1
RI4 e4 26 22e-3
VS5 14 s5 0
R5 s5 17 15e-2
VS6 6 s6 0
V6 e6 s6 DC 15e1
RI6 e6 28 56e-3
VS7 8 s7 0
I7 s7 19 DC 56e-1
VS8 16 s8 0
V8 e8 s8 DC 33e1
RI8 e8 4 22e-1
VS9 6 s9 0
R9 s9 8 18e-2
VS10 16 s10 0
R10 s10 23 22e1
VS11 26 s11 0
R11 s11 14 12e2
VS12 19 s12 0
I12 s12 25 DC 18e-1
VS13 9 s13 0
R13 s13 28 18e-2
VS14 27 s14 0
R14 s14 0 10e0
VS15 5 s15 0
R15 s15 2 22e2
VS16 1 s16 0
R16 s16 10 39e2
VS17 6 s17 0
R17 s17 16 15e1
VS18 10 s18 0
R18 s18 13 68e0
VS19 10 s19 0
R19 s19 15 33e3
VS20 20 s20 0
R20 s20 18 18e3
VS21 3 s21 0
R21 s21 24 18e1
VS22 9 s22 0
R22 s22 13 82e0
VS23 17 s23 0
R23 s23 1 18e-1
VS24 24 s24 0
I24 s24 16 DC 10e-4
VS25 28 s25 0
R25 s25 26 27e-2
VS26 0 s26 0
R26 s26 16 56e3
VS27 27 s27 0
R27 s27 2 82e2
VS28 16 s28 0
R28 s28 13 18e-1
VS29 22 s29 0
R29 s29 27 82e2
VS30 10 s30 0
R30 s30 20 18e2
VS31 18 s31 0
V31 e31 s31 DC 15e1
RI31 e31 7 33e-2
VS32 12 s32 0
V32 e32 s32 DC 33e1
RI32 e32 15 18e-2
VS33 13 s33 0
V33 e33 s33 DC 22e1
RI33 e33 9 82e-2
VS34 14 s34 0
I34 s34 1 DC 47e-3
VS35 9 s35 0
I35 s35 25 DC 18e-1
VS36 10 s36 0
R36 s36 22 27e2
VS37 28 s37 0
R37 s37 25 39e0
VS38 3 s38 0
R38 s38 4 82e2
VS39 19 s39 0
R39 s39 27 12e2
.control
set numdgt=17
op
print v(1) v(2) v(3) v(4) v(5) v(6) v(7) v(8) v(9) v(10)
print v(11) v(12) v(13) v(14) v(15) v(16) v(17) v(18) v(19) v(20)
print v(21) v(22) v(23) v(24) v(25) v(26) v(27) v(28)
print i(vs0) i(vs1) i(vs2) i(vs3) i(vs4) i(vs5) i(vs6) i(vs7) i(vs8) i(vs9)
print i(vs10) i(vs11) i(vs12) i(vs13) i(vs14) i(vs15) i(vs16) i(vs17) i(vs18) i(vs19)
print i(vs20) i(vs21) i(vs22) i(vs23) i(vs24) i(vs25) i(vs26) i(vs27) i(vs28) i(vs29)
print i(vs30) i(vs31) i(vs32) i(vs33) i(vs34) i(vs35) i(vs36) i(vs37) i(vs38) i(vs39)
.endc
.end
