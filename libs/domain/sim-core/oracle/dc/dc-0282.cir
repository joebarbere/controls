controls oracle dc-0282
* Generated (plan F2.7, ADR 0012): do not edit; regenerate with `pnpm sim oracle regen`. dc seed 20261030 index 282 nodes 7 elements 12
.options sparse gmin=1e-12 noopac
RG1 1 0 1000000000000
RG2 2 0 1000000000000
RG3 3 0 1000000000000
RG4 4 0 1000000000000
RG5 5 0 1000000000000
RG6 6 0 1000000000000
VS0 3 s0 0
R0 s0 5 33e1
VS1 0 s1 0
R1 s1 5 15e2
VS2 0 s2 0
V2 e2 s2 DC 12e0
RI2 e2 5 56e-3
VS3 5 s3 0
R3 s3 1 18e-1
VS4 2 s4 0
V4 e4 s4 DC 27e0
RI4 e4 4 82e-1
VS5 0 s5 0
R5 s5 5 22e3
VS6 2 s6 0
R6 s6 3 22e-2
VS7 4 s7 0
R7 s7 1 56e1
VS8 3 s8 0
V8 e8 s8 DC 27e0
RI8 e8 5 12e-2
VS9 2 s9 0
R9 s9 1 82e2
VS10 0 s10 0
R10 s10 6 22e-1
VS11 6 s11 0
R11 s11 1 39e-1
.control
set numdgt=17
op
print v(1) v(2) v(3) v(4) v(5) v(6)
print i(vs0) i(vs1) i(vs2) i(vs3) i(vs4) i(vs5) i(vs6) i(vs7) i(vs8) i(vs9)
print i(vs10) i(vs11)
.endc
.end
