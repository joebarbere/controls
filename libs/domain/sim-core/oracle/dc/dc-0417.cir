controls oracle dc-0417
* Generated (plan F2.7, ADR 0012): do not edit; regenerate with `pnpm sim oracle regen`. dc seed 20261030 index 417 nodes 15 elements 22
.options sparse gmin=1e-12 noopac
RG1 1 0 1000000000000
RG2 2 0 1000000000000
RG3 3 0 1000000000000
RG4 4 0 1000000000000
RG5 5 0 1000000000000
RG6 6 0 1000000000000
RG7 7 0 1000000000000
RG8 8 0 1000000000000
RG9 9 0 1000000000000
RG10 10 0 1000000000000
RG11 11 0 1000000000000
RG12 12 0 1000000000000
RG13 13 0 1000000000000
RG14 14 0 1000000000000
VS0 5 s0 0
R0 s0 6 18e0
VS1 0 s1 0
V1 e1 s1 DC 22e-1
RI1 e1 10 68e-2
VS2 1 s2 0
R2 s2 13 68e2
VS3 2 s3 0
R3 s3 6 27e3
VS4 7 s4 0
R4 s4 5 56e3
VS5 1 s5 0
R5 s5 3 12e1
VS6 12 s6 0
R6 s6 2 39e1
VS7 4 s7 0
R7 s7 5 33e-1
VS8 13 s8 0
R8 s8 11 18e-1
VS9 4 s9 0
R9 s9 3 22e1
VS10 8 s10 0
R10 s10 12 27e-1
VS11 3 s11 0
R11 s11 11 27e3
VS12 12 s12 0
R12 s12 1 12e-1
VS13 13 s13 0
R13 s13 3 56e3
VS14 9 s14 0
R14 s14 11 56e3
VS15 1 s15 0
R15 s15 0 18e1
VS16 1 s16 0
V16 e16 s16 DC 47e1
RI16 e16 6 27e-1
VS17 1 s17 0
V17 e17 s17 DC 33e-1
RI17 e17 5 39e-1
VS18 13 s18 0
V18 e18 s18 DC 47e0
RI18 e18 14 39e-1
VS19 10 s19 0
I19 s19 11 DC 56e-4
VS20 0 s20 0
V20 e20 s20 DC 10e1
RI20 e20 9 18e-1
VS21 3 s21 0
R21 s21 1 39e2
.control
set numdgt=17
op
print v(1) v(2) v(3) v(4) v(5) v(6) v(7) v(8) v(9) v(10)
print v(11) v(12) v(13) v(14)
print i(vs0) i(vs1) i(vs2) i(vs3) i(vs4) i(vs5) i(vs6) i(vs7) i(vs8) i(vs9)
print i(vs10) i(vs11) i(vs12) i(vs13) i(vs14) i(vs15) i(vs16) i(vs17) i(vs18) i(vs19)
print i(vs20) i(vs21)
.endc
.end
