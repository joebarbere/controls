controls oracle dc-0417
* Generated (plan F2.7, ADR 0012): do not edit; regenerate with `pnpm sim oracle regen`. dc seed 20261030 index 417 nodes 15 elements 26
.options sparse gmin=1e-12 noopac
RG1 1 0 1000000000000
RG2 2 0 1000000000000
RG3 3 0 1000000000000
RG4 4 0 1000000000000
RG5 5 0 1000000000000
RG6 6 0 1000000000000
RG7 7 0 1000000000000
RG8 8 0 1000000000000
RG9 9 0 1000000000000
RG10 10 0 1000000000000
RG11 11 0 1000000000000
RG12 12 0 1000000000000
RG13 13 0 1000000000000
RG14 14 0 1000000000000
VS0 0 s0 0
V0 e0 s0 DC 47e0
RI0 e0 14 39e-1
VS1 9 s1 0
R1 s1 11 56e3
VS2 2 s2 0
R2 s2 6 27e3
VS3 13 s3 0
R3 s3 7 33e2
VS4 13 s4 0
V4 e4 s4 DC 47e1
RI4 e4 6 27e-1
VS5 0 s5 0
R5 s5 11 18e-1
VS6 13 s6 0
V6 e6 s6 DC 33e-1
RI6 e6 5 39e-1
VS7 8 s7 0
R7 s7 12 27e-1
VS8 13 s8 0
R8 s8 3 12e1
VS9 8 s9 0
R9 s9 2 56e-2
VS10 0 s10 0
R10 s10 3 56e3
VS11 10 s11 0
I11 s11 11 DC 56e-4
VS12 5 s12 0
R12 s12 6 18e0
VS13 12 s13 0
R13 s13 13 12e-1
VS14 1 s14 0
V14 e14 s14 DC 22e-1
RI14 e14 10 68e-2
VS15 13 s15 0
R15 s15 1 18e1
VS16 1 s16 0
V16 e16 s16 DC 10e1
RI16 e16 9 18e-1
VS17 3 s17 0
R17 s17 11 27e3
VS18 2 s18 0
R18 s18 10 47e2
VS19 3 s19 0
R19 s19 13 39e2
VS20 12 s20 0
R20 s20 2 39e1
VS21 4 s21 0
R21 s21 3 22e1
VS22 7 s22 0
R22 s22 5 56e3
VS23 13 s23 0
R23 s23 0 68e2
VS24 13 s24 0
R24 s24 14 47e-1
VS25 4 s25 0
R25 s25 5 33e-1
.control
set numdgt=17
op
print v(1) v(2) v(3) v(4) v(5) v(6) v(7) v(8) v(9) v(10)
print v(11) v(12) v(13) v(14)
print i(vs0) i(vs1) i(vs2) i(vs3) i(vs4) i(vs5) i(vs6) i(vs7) i(vs8) i(vs9)
print i(vs10) i(vs11) i(vs12) i(vs13) i(vs14) i(vs15) i(vs16) i(vs17) i(vs18) i(vs19)
print i(vs20) i(vs21) i(vs22) i(vs23) i(vs24) i(vs25)
.endc
.end
