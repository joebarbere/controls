controls oracle dc-0134
* Generated (plan F2.7, ADR 0012): do not edit; regenerate with `pnpm sim oracle regen`. dc seed 20261030 index 134 nodes 12 elements 24
.options sparse gmin=1e-12 noopac
RG1 1 0 1000000000000
RG2 2 0 1000000000000
RG3 3 0 1000000000000
RG4 4 0 1000000000000
RG5 5 0 1000000000000
RG6 6 0 1000000000000
RG7 7 0 1000000000000
RG8 8 0 1000000000000
RG9 9 0 1000000000000
RG10 10 0 1000000000000
RG11 11 0 1000000000000
VS0 7 s0 0
I0 s0 8 DC 33e-4
VS1 9 s1 0
R1 s1 10 27e0
VS2 4 s2 0
R2 s2 10 15e0
VS3 9 s3 0
R3 s3 4 10e-2
VS4 0 s4 0
V4 e4 s4 DC 10e1
RI4 e4 8 68e-1
VS5 1 s5 0
I5 s5 5 DC 33e-3
VS6 9 s6 0
R6 s6 4 15e-1
VS7 3 s7 0
R7 s7 2 27e1
VS8 6 s8 0
R8 s8 5 27e0
VS9 4 s9 0
R9 s9 10 33e-2
VS10 4 s10 0
R10 s10 3 82e1
VS11 9 s11 0
V11 e11 s11 DC 27e1
RI11 e11 11 27e-3
VS12 1 s12 0
R12 s12 0 56e-2
VS13 6 s13 0
R13 s13 3 22e1
VS14 1 s14 0
R14 s14 7 33e2
VS15 1 s15 0
V15 e15 s15 DC 18e1
RI15 e15 6 56e-3
VS16 9 s16 0
R16 s16 6 12e2
VS17 6 s17 0
V17 e17 s17 DC 18e0
RI17 e17 3 15e-3
VS18 4 s18 0
V18 e18 s18 DC 47e0
RI18 e18 7 33e-1
VS19 0 s19 0
V19 e19 s19 DC 68e1
RI19 e19 2 22e-1
VS20 2 s20 0
R20 s20 10 22e0
VS21 11 s21 0
R21 s21 10 10e0
VS22 5 s22 0
R22 s22 8 12e0
VS23 10 s23 0
R23 s23 0 39e3
.control
set numdgt=17
op
print v(1) v(2) v(3) v(4) v(5) v(6) v(7) v(8) v(9) v(10)
print v(11)
print i(vs0) i(vs1) i(vs2) i(vs3) i(vs4) i(vs5) i(vs6) i(vs7) i(vs8) i(vs9)
print i(vs10) i(vs11) i(vs12) i(vs13) i(vs14) i(vs15) i(vs16) i(vs17) i(vs18) i(vs19)
print i(vs20) i(vs21) i(vs22) i(vs23)
.endc
.end
