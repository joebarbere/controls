controls oracle dc-0134
* Generated (plan F2.7, ADR 0012): do not edit; regenerate with `pnpm sim oracle regen`. dc seed 20261030 index 134 nodes 12 elements 22
.options sparse gmin=1e-12 noopac
RG1 1 0 1000000000000
RG2 2 0 1000000000000
RG3 3 0 1000000000000
RG4 4 0 1000000000000
RG5 5 0 1000000000000
RG6 6 0 1000000000000
RG7 7 0 1000000000000
RG8 8 0 1000000000000
RG9 9 0 1000000000000
RG10 10 0 1000000000000
RG11 11 0 1000000000000
VS0 0 s0 0
R0 s0 5 27e0
VS1 0 s1 0
V1 e1 s1 DC 18e0
RI1 e1 3 15e-3
VS2 6 s2 0
V2 e2 s2 DC 10e1
RI2 e2 8 68e-1
VS3 9 s3 0
R3 s3 4 10e-2
VS4 9 s4 0
R4 s4 4 15e-1
VS5 1 s5 0
V5 e5 s5 DC 18e1
RI5 e5 0 56e-3
VS6 4 s6 0
R6 s6 10 33e-2
VS7 10 s7 0
R7 s7 6 39e3
VS8 5 s8 0
R8 s8 8 12e0
VS9 9 s9 0
V9 e9 s9 DC 27e1
RI9 e9 11 27e-3
VS10 3 s10 0
R10 s10 2 27e1
VS11 1 s11 0
R11 s11 6 56e-2
VS12 1 s12 0
I12 s12 5 DC 33e-3
VS13 4 s13 0
R13 s13 10 15e0
VS14 9 s14 0
R14 s14 10 27e0
VS15 6 s15 0
V15 e15 s15 DC 68e1
RI15 e15 2 22e-1
VS16 2 s16 0
R16 s16 10 22e0
VS17 7 s17 0
I17 s17 8 DC 33e-4
VS18 4 s18 0
R18 s18 3 82e1
VS19 1 s19 0
R19 s19 7 33e2
VS20 9 s20 0
R20 s20 0 12e2
VS21 0 s21 0
R21 s21 3 22e1
.control
set numdgt=17
op
print v(1) v(2) v(3) v(4) v(5) v(6) v(7) v(8) v(9) v(10)
print v(11)
print i(vs0) i(vs1) i(vs2) i(vs3) i(vs4) i(vs5) i(vs6) i(vs7) i(vs8) i(vs9)
print i(vs10) i(vs11) i(vs12) i(vs13) i(vs14) i(vs15) i(vs16) i(vs17) i(vs18) i(vs19)
print i(vs20) i(vs21)
.endc
.end
