controls oracle dc-0299
* Generated (plan F2.7, ADR 0012): do not edit; regenerate with `pnpm sim oracle regen`. dc seed 20261030 index 299 nodes 23 elements 35
.options sparse gmin=1e-12 noopac
RG1 1 0 1000000000000
RG2 2 0 1000000000000
RG3 3 0 1000000000000
RG4 4 0 1000000000000
RG5 5 0 1000000000000
RG6 6 0 1000000000000
RG7 7 0 1000000000000
RG8 8 0 1000000000000
RG9 9 0 1000000000000
RG10 10 0 1000000000000
RG11 11 0 1000000000000
RG12 12 0 1000000000000
RG13 13 0 1000000000000
RG14 14 0 1000000000000
RG15 15 0 1000000000000
RG16 16 0 1000000000000
RG17 17 0 1000000000000
RG18 18 0 1000000000000
RG19 19 0 1000000000000
RG20 20 0 1000000000000
RG21 21 0 1000000000000
RG22 22 0 1000000000000
VS0 9 s0 0
I0 s0 12 DC 10e-3
VS1 7 s1 0
I1 s1 17 DC 33e-3
VS2 7 s2 0
R2 s2 2 33e-2
VS3 0 s3 0
V3 e3 s3 DC 22e-1
RI3 e3 12 47e-2
VS4 10 s4 0
R4 s4 4 33e2
VS5 13 s5 0
R5 s5 22 22e0
VS6 11 s6 0
R6 s6 22 27e3
VS7 10 s7 0
R7 s7 19 10e-2
VS8 1 s8 0
V8 e8 s8 DC 33e1
RI8 e8 9 68e-1
VS9 7 s9 0
R9 s9 15 12e2
VS10 16 s10 0
R10 s10 3 22e2
VS11 1 s11 0
V11 e11 s11 DC 22e-1
RI11 e11 6 56e-3
VS12 14 s12 0
R12 s12 10 10e0
VS13 16 s13 0
R13 s13 5 68e0
VS14 16 s14 0
R14 s14 11 22e0
VS15 21 s15 0
R15 s15 12 47e0
VS16 4 s16 0
R16 s16 2 18e1
VS17 15 s17 0
R17 s17 13 10e2
VS18 22 s18 0
R18 s18 19 33e0
VS19 3 s19 0
R19 s19 21 15e0
VS20 20 s20 0
R20 s20 4 33e-2
VS21 8 s21 0
V21 e21 s21 DC 27e-1
RI21 e21 15 18e-3
VS22 7 s22 0
R22 s22 4 82e-1
VS23 3 s23 0
V23 e23 s23 DC 12e-1
RI23 e23 7 10e-1
VS24 11 s24 0
R24 s24 7 10e0
VS25 13 s25 0
V25 e25 s25 DC 12e1
RI25 e25 9 18e-3
VS26 6 s26 0
V26 e26 s26 DC 39e1
RI26 e26 20 15e-2
VS27 10 s27 0
R27 s27 0 82e-1
VS28 1 s28 0
R28 s28 10 56e-2
VS29 3 s29 0
R29 s29 17 22e0
VS30 14 s30 0
R30 s30 4 82e1
VS31 9 s31 0
I31 s31 6 DC 10e-3
VS32 4 s32 0
R32 s32 3 27e-1
VS33 17 s33 0
V33 e33 s33 DC 39e-1
RI33 e33 18 12e-1
VS34 20 s34 0
R34 s34 22 18e1
.control
set numdgt=17
op
print v(1) v(2) v(3) v(4) v(5) v(6) v(7) v(8) v(9) v(10)
print v(11) v(12) v(13) v(14) v(15) v(16) v(17) v(18) v(19) v(20)
print v(21) v(22)
print i(vs0) i(vs1) i(vs2) i(vs3) i(vs4) i(vs5) i(vs6) i(vs7) i(vs8) i(vs9)
print i(vs10) i(vs11) i(vs12) i(vs13) i(vs14) i(vs15) i(vs16) i(vs17) i(vs18) i(vs19)
print i(vs20) i(vs21) i(vs22) i(vs23) i(vs24) i(vs25) i(vs26) i(vs27) i(vs28) i(vs29)
print i(vs30) i(vs31) i(vs32) i(vs33) i(vs34)
.endc
.end
