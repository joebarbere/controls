controls oracle dc-0299
* Generated (plan F2.7, ADR 0012): do not edit; regenerate with `pnpm sim oracle regen`. dc seed 20261030 index 299 nodes 23 elements 38
.options sparse gmin=1e-12 noopac
RG1 1 0 1000000000000
RG2 2 0 1000000000000
RG3 3 0 1000000000000
RG4 4 0 1000000000000
RG5 5 0 1000000000000
RG6 6 0 1000000000000
RG7 7 0 1000000000000
RG8 8 0 1000000000000
RG9 9 0 1000000000000
RG10 10 0 1000000000000
RG11 11 0 1000000000000
RG12 12 0 1000000000000
RG13 13 0 1000000000000
RG14 14 0 1000000000000
RG15 15 0 1000000000000
RG16 16 0 1000000000000
RG17 17 0 1000000000000
RG18 18 0 1000000000000
RG19 19 0 1000000000000
RG20 20 0 1000000000000
RG21 21 0 1000000000000
RG22 22 0 1000000000000
VS0 16 s0 0
R0 s0 0 22e2
VS1 0 s1 0
V1 e1 s1 DC 12e-1
RI1 e1 7 10e-1
VS2 9 s2 0
I2 s2 6 DC 10e-3
VS3 4 s3 0
R3 s3 8 12e0
VS4 16 s4 0
R4 s4 11 22e0
VS5 10 s5 0
R5 s5 4 33e2
VS6 6 s6 0
V6 e6 s6 DC 39e1
RI6 e6 20 15e-2
VS7 13 s7 0
R7 s7 22 22e0
VS8 10 s8 0
R8 s8 3 82e-1
VS9 7 s9 0
R9 s9 2 33e-2
VS10 17 s10 0
V10 e10 s10 DC 39e-1
RI10 e10 18 12e-1
VS11 1 s11 0
V11 e11 s11 DC 22e-1
RI11 e11 6 56e-3
VS12 15 s12 0
R12 s12 13 10e2
VS13 16 s13 0
R13 s13 5 68e0
VS14 1 s14 0
V14 e14 s14 DC 33e1
RI14 e14 9 68e-1
VS15 5 s15 0
R15 s15 18 12e0
VS16 13 s16 0
V16 e16 s16 DC 12e1
RI16 e16 9 18e-3
VS17 3 s17 0
V17 e17 s17 DC 22e-1
RI17 e17 12 47e-2
VS18 8 s18 0
V18 e18 s18 DC 27e-1
RI18 e18 15 18e-3
VS19 20 s19 0
R19 s19 4 33e-2
VS20 7 s20 0
I20 s20 17 DC 33e-3
VS21 7 s21 0
R21 s21 4 82e-1
VS22 4 s22 0
R22 s22 2 18e1
VS23 0 s23 0
R23 s23 21 15e0
VS24 9 s24 0
I24 s24 12 DC 10e-3
VS25 14 s25 0
R25 s25 10 10e0
VS26 5 s26 0
R26 s26 22 10e1
VS27 22 s27 0
R27 s27 19 33e0
VS28 7 s28 0
R28 s28 15 12e2
VS29 21 s29 0
R29 s29 12 47e0
VS30 0 s30 0
R30 s30 17 22e0
VS31 10 s31 0
R31 s31 19 10e-2
VS32 1 s32 0
R32 s32 10 56e-2
VS33 4 s33 0
R33 s33 0 27e-1
VS34 11 s34 0
R34 s34 22 27e3
VS35 11 s35 0
R35 s35 7 10e0
VS36 14 s36 0
R36 s36 4 82e1
VS37 20 s37 0
R37 s37 22 18e1
.control
set numdgt=17
op
print v(1) v(2) v(3) v(4) v(5) v(6) v(7) v(8) v(9) v(10)
print v(11) v(12) v(13) v(14) v(15) v(16) v(17) v(18) v(19) v(20)
print v(21) v(22)
print i(vs0) i(vs1) i(vs2) i(vs3) i(vs4) i(vs5) i(vs6) i(vs7) i(vs8) i(vs9)
print i(vs10) i(vs11) i(vs12) i(vs13) i(vs14) i(vs15) i(vs16) i(vs17) i(vs18) i(vs19)
print i(vs20) i(vs21) i(vs22) i(vs23) i(vs24) i(vs25) i(vs26) i(vs27) i(vs28) i(vs29)
print i(vs30) i(vs31) i(vs32) i(vs33) i(vs34) i(vs35) i(vs36) i(vs37)
.endc
.end
