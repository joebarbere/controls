controls oracle dc-0462
* Generated (plan F2.7, ADR 0012): do not edit; regenerate with `pnpm sim oracle regen`. dc seed 20261030 index 462 nodes 12 elements 12
.options sparse gmin=1e-12 noopac
RG1 1 0 1000000000000
RG2 2 0 1000000000000
RG3 3 0 1000000000000
RG4 4 0 1000000000000
RG5 5 0 1000000000000
RG6 6 0 1000000000000
RG7 7 0 1000000000000
RG8 8 0 1000000000000
RG9 9 0 1000000000000
RG10 10 0 1000000000000
RG11 11 0 1000000000000
VS0 7 s0 0
R0 s0 11 12e-2
VS1 3 s1 0
R1 s1 7 15e-2
VS2 4 s2 0
R2 s2 7 18e1
VS3 10 s3 0
R3 s3 11 12e-2
VS4 0 s4 0
V4 e4 s4 DC 12e0
RI4 e4 11 68e-3
VS5 6 s5 0
R5 s5 9 22e0
VS6 3 s6 0
V6 e6 s6 DC 27e0
RI6 e6 9 10e-2
VS7 8 s7 0
R7 s7 7 56e3
VS8 5 s8 0
R8 s8 8 10e-1
VS9 2 s9 0
R9 s9 9 39e1
VS10 11 s10 0
R10 s10 9 82e-1
VS11 6 s11 0
V11 e11 s11 DC 15e1
RI11 e11 1 39e-2
.control
set numdgt=17
op
print v(1) v(2) v(3) v(4) v(5) v(6) v(7) v(8) v(9) v(10)
print v(11)
print i(vs0) i(vs1) i(vs2) i(vs3) i(vs4) i(vs5) i(vs6) i(vs7) i(vs8) i(vs9)
print i(vs10) i(vs11)
.endc
.end
