controls oracle dc-0462
* Generated (plan F2.7, ADR 0012): do not edit; regenerate with `pnpm sim oracle regen`. dc seed 20261030 index 462 nodes 12 elements 18
.options sparse gmin=1e-12 noopac
RG1 1 0 1000000000000
RG2 2 0 1000000000000
RG3 3 0 1000000000000
RG4 4 0 1000000000000
RG5 5 0 1000000000000
RG6 6 0 1000000000000
RG7 7 0 1000000000000
RG8 8 0 1000000000000
RG9 9 0 1000000000000
RG10 10 0 1000000000000
RG11 11 0 1000000000000
VS0 3 s0 0
R0 s0 7 15e-2
VS1 0 s1 0
V1 e1 s1 DC 12e0
RI1 e1 11 68e-3
VS2 8 s2 0
V2 e2 s2 DC 15e1
RI2 e2 1 15e-1
VS3 10 s3 0
R3 s3 11 12e-2
VS4 4 s4 0
R4 s4 7 18e1
VS5 8 s5 0
R5 s5 7 56e3
VS6 3 s6 0
V6 e6 s6 DC 27e0
RI6 e6 9 10e-2
VS7 6 s7 0
V7 e7 s7 DC 15e1
RI7 e7 1 39e-2
VS8 6 s8 0
R8 s8 10 39e-1
VS9 0 s9 0
R9 s9 6 33e-2
VS10 7 s10 0
R10 s10 11 12e-2
VS11 5 s11 0
R11 s11 8 10e-1
VS12 11 s12 0
R12 s12 9 82e-1
VS13 2 s13 0
R13 s13 9 39e1
VS14 6 s14 0
R14 s14 9 22e0
VS15 3 s15 0
R15 s15 2 47e-1
VS16 7 s16 0
R16 s16 5 12e-1
VS17 2 s17 0
R17 s17 4 68e2
.control
set numdgt=17
op
print v(1) v(2) v(3) v(4) v(5) v(6) v(7) v(8) v(9) v(10)
print v(11)
print i(vs0) i(vs1) i(vs2) i(vs3) i(vs4) i(vs5) i(vs6) i(vs7) i(vs8) i(vs9)
print i(vs10) i(vs11) i(vs12) i(vs13) i(vs14) i(vs15) i(vs16) i(vs17)
.endc
.end
