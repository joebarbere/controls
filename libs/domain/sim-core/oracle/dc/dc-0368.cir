controls oracle dc-0368
* Generated (plan F2.7, ADR 0012): do not edit; regenerate with `pnpm sim oracle regen`. dc seed 20261030 index 368 nodes 14 elements 15
.options sparse gmin=1e-12 noopac
RG1 1 0 1000000000000
RG2 2 0 1000000000000
RG3 3 0 1000000000000
RG4 4 0 1000000000000
RG5 5 0 1000000000000
RG6 6 0 1000000000000
RG7 7 0 1000000000000
RG8 8 0 1000000000000
RG9 9 0 1000000000000
RG10 10 0 1000000000000
RG11 11 0 1000000000000
RG12 12 0 1000000000000
RG13 13 0 1000000000000
VS0 5 s0 0
R0 s0 11 68e0
VS1 1 s1 0
R1 s1 9 68e-2
VS2 10 s2 0
R2 s2 7 27e-1
VS3 0 s3 0
V3 e3 s3 DC 33e-1
RI3 e3 9 68e-3
VS4 1 s4 0
R4 s4 4 39e2
VS5 8 s5 0
R5 s5 4 56e0
VS6 1 s6 0
V6 e6 s6 DC 47e1
RI6 e6 4 68e-1
VS7 3 s7 0
R7 s7 8 15e2
VS8 7 s8 0
R8 s8 8 18e2
VS9 8 s9 0
R9 s9 6 15e-2
VS10 5 s10 0
R10 s10 12 82e-1
VS11 2 s11 0
V11 e11 s11 DC 12e1
RI11 e11 13 56e-1
VS12 5 s12 0
R12 s12 3 47e2
VS13 13 s13 0
V13 e13 s13 DC 27e0
RI13 e13 4 47e-2
VS14 11 s14 0
R14 s14 8 33e-2
.control
set numdgt=17
op
print v(1) v(2) v(3) v(4) v(5) v(6) v(7) v(8) v(9) v(10)
print v(11) v(12) v(13)
print i(vs0) i(vs1) i(vs2) i(vs3) i(vs4) i(vs5) i(vs6) i(vs7) i(vs8) i(vs9)
print i(vs10) i(vs11) i(vs12) i(vs13) i(vs14)
.endc
.end
