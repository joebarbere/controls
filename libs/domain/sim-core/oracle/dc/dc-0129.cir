controls oracle dc-0129
* Generated (plan F2.7, ADR 0012): do not edit; regenerate with `pnpm sim oracle regen`. dc seed 20261030 index 129 nodes 22 elements 36
.options sparse gmin=1e-12 noopac
RG1 1 0 1000000000000
RG2 2 0 1000000000000
RG3 3 0 1000000000000
RG4 4 0 1000000000000
RG5 5 0 1000000000000
RG6 6 0 1000000000000
RG7 7 0 1000000000000
RG8 8 0 1000000000000
RG9 9 0 1000000000000
RG10 10 0 1000000000000
RG11 11 0 1000000000000
RG12 12 0 1000000000000
RG13 13 0 1000000000000
RG14 14 0 1000000000000
RG15 15 0 1000000000000
RG16 16 0 1000000000000
RG17 17 0 1000000000000
RG18 18 0 1000000000000
RG19 19 0 1000000000000
RG20 20 0 1000000000000
RG21 21 0 1000000000000
VS0 0 s0 0
V0 e0 s0 DC 33e1
RI0 e0 9 33e-1
VS1 18 s1 0
R1 s1 8 56e1
VS2 7 s2 0
R2 s2 12 27e-1
VS3 9 s3 0
R3 s3 20 47e-1
VS4 12 s4 0
R4 s4 4 33e-2
VS5 6 s5 0
R5 s5 19 18e3
VS6 12 s6 0
R6 s6 16 56e-2
VS7 14 s7 0
I7 s7 13 DC 27e-3
VS8 15 s8 0
R8 s8 20 47e-2
VS9 2 s9 0
R9 s9 9 15e0
VS10 10 s10 0
R10 s10 1 33e-2
VS11 18 s11 0
R11 s11 2 68e0
VS12 18 s12 0
R12 s12 9 10e-2
VS13 6 s13 0
R13 s13 10 12e1
VS14 16 s14 0
R14 s14 11 18e0
VS15 16 s15 0
R15 s15 21 18e-1
VS16 12 s16 0
V16 e16 s16 DC 22e-1
RI16 e16 18 15e-3
VS17 19 s17 0
R17 s17 3 56e3
VS18 5 s18 0
V18 e18 s18 DC 82e-1
RI18 e18 1 56e-3
VS19 13 s19 0
R19 s19 8 39e1
VS20 17 s20 0
R20 s20 6 56e0
VS21 18 s21 0
R21 s21 6 22e3
VS22 0 s22 0
R22 s22 18 33e0
VS23 10 s23 0
V23 e23 s23 DC 15e1
RI23 e23 18 82e-3
VS24 12 s24 0
R24 s24 13 18e1
VS25 5 s25 0
R25 s25 19 56e1
VS26 2 s26 0
V26 e26 s26 DC 56e-1
RI26 e26 15 39e-2
VS27 14 s27 0
V27 e27 s27 DC 33e1
RI27 e27 4 18e-2
VS28 3 s28 0
V28 e28 s28 DC 12e1
RI28 e28 14 27e-2
VS29 9 s29 0
R29 s29 21 33e3
VS30 9 s30 0
R30 s30 11 10e2
VS31 8 s31 0
R31 s31 4 33e3
VS32 5 s32 0
V32 e32 s32 DC 47e0
RI32 e32 7 18e-1
VS33 13 s33 0
V33 e33 s33 DC 18e0
RI33 e33 18 12e-3
VS34 10 s34 0
R34 s34 17 82e3
VS35 5 s35 0
R35 s35 20 18e2
.control
set numdgt=17
op
print v(1) v(2) v(3) v(4) v(5) v(6) v(7) v(8) v(9) v(10)
print v(11) v(12) v(13) v(14) v(15) v(16) v(17) v(18) v(19) v(20)
print v(21)
print i(vs0) i(vs1) i(vs2) i(vs3) i(vs4) i(vs5) i(vs6) i(vs7) i(vs8) i(vs9)
print i(vs10) i(vs11) i(vs12) i(vs13) i(vs14) i(vs15) i(vs16) i(vs17) i(vs18) i(vs19)
print i(vs20) i(vs21) i(vs22) i(vs23) i(vs24) i(vs25) i(vs26) i(vs27) i(vs28) i(vs29)
print i(vs30) i(vs31) i(vs32) i(vs33) i(vs34) i(vs35)
.endc
.end
