controls oracle dc-0129
* Generated (plan F2.7, ADR 0012): do not edit; regenerate with `pnpm sim oracle regen`. dc seed 20261030 index 129 nodes 22 elements 28
.options sparse gmin=1e-12 noopac
RG1 1 0 1000000000000
RG2 2 0 1000000000000
RG3 3 0 1000000000000
RG4 4 0 1000000000000
RG5 5 0 1000000000000
RG6 6 0 1000000000000
RG7 7 0 1000000000000
RG8 8 0 1000000000000
RG9 9 0 1000000000000
RG10 10 0 1000000000000
RG11 11 0 1000000000000
RG12 12 0 1000000000000
RG13 13 0 1000000000000
RG14 14 0 1000000000000
RG15 15 0 1000000000000
RG16 16 0 1000000000000
RG17 17 0 1000000000000
RG18 18 0 1000000000000
RG19 19 0 1000000000000
RG20 20 0 1000000000000
RG21 21 0 1000000000000
VS0 6 s0 0
R0 s0 19 18e3
VS1 18 s1 0
R1 s1 8 56e1
VS2 0 s2 0
V2 e2 s2 DC 18e0
RI2 e2 18 12e-3
VS3 14 s3 0
V3 e3 s3 DC 33e1
RI3 e3 4 18e-2
VS4 8 s4 0
R4 s4 4 33e3
VS5 13 s5 0
R5 s5 0 18e1
VS6 13 s6 0
R6 s6 4 33e-2
VS7 14 s7 0
I7 s7 0 DC 27e-3
VS8 16 s8 0
R8 s8 21 18e-1
VS9 0 s9 0
R9 s9 8 39e1
VS10 10 s10 0
R10 s10 17 82e3
VS11 18 s11 0
R11 s11 6 22e3
VS12 3 s12 0
V12 e12 s12 DC 12e1
RI12 e12 14 27e-2
VS13 2 s13 0
R13 s13 9 15e0
VS14 7 s14 0
R14 s14 13 27e-1
VS15 9 s15 0
R15 s15 21 33e3
VS16 15 s16 0
R16 s16 20 47e-2
VS17 16 s17 0
R17 s17 11 18e0
VS18 10 s18 0
R18 s18 1 33e-2
VS19 18 s19 0
R19 s19 9 10e-2
VS20 9 s20 0
R20 s20 20 47e-1
VS21 12 s21 0
R21 s21 18 33e0
VS22 9 s22 0
R22 s22 11 10e2
VS23 6 s23 0
R23 s23 10 12e1
VS24 10 s24 0
V24 e24 s24 DC 15e1
RI24 e24 18 82e-3
VS25 13 s25 0
V25 e25 s25 DC 22e-1
RI25 e25 18 15e-3
VS26 12 s26 0
V26 e26 s26 DC 33e1
RI26 e26 9 33e-1
VS27 5 s27 0
R27 s27 19 56e1
.control
set numdgt=17
op
print v(1) v(2) v(3) v(4) v(5) v(6) v(7) v(8) v(9) v(10)
print v(11) v(12) v(13) v(14) v(15) v(16) v(17) v(18) v(19) v(20)
print v(21)
print i(vs0) i(vs1) i(vs2) i(vs3) i(vs4) i(vs5) i(vs6) i(vs7) i(vs8) i(vs9)
print i(vs10) i(vs11) i(vs12) i(vs13) i(vs14) i(vs15) i(vs16) i(vs17) i(vs18) i(vs19)
print i(vs20) i(vs21) i(vs22) i(vs23) i(vs24) i(vs25) i(vs26) i(vs27)
.endc
.end
