controls oracle dc-0117
* Generated (plan F2.7, ADR 0012): do not edit; regenerate with `pnpm sim oracle regen`. dc seed 20261030 index 117 nodes 29 elements 36
.options sparse gmin=1e-12 noopac
RG1 1 0 1000000000000
RG2 2 0 1000000000000
RG3 3 0 1000000000000
RG4 4 0 1000000000000
RG5 5 0 1000000000000
RG6 6 0 1000000000000
RG7 7 0 1000000000000
RG8 8 0 1000000000000
RG9 9 0 1000000000000
RG10 10 0 1000000000000
RG11 11 0 1000000000000
RG12 12 0 1000000000000
RG13 13 0 1000000000000
RG14 14 0 1000000000000
RG15 15 0 1000000000000
RG16 16 0 1000000000000
RG17 17 0 1000000000000
RG18 18 0 1000000000000
RG19 19 0 1000000000000
RG20 20 0 1000000000000
RG21 21 0 1000000000000
RG22 22 0 1000000000000
RG23 23 0 1000000000000
RG24 24 0 1000000000000
RG25 25 0 1000000000000
RG26 26 0 1000000000000
RG27 27 0 1000000000000
RG28 28 0 1000000000000
VS0 21 s0 0
R0 s0 12 10e2
VS1 0 s1 0
V1 e1 s1 DC 10e0
RI1 e1 18 82e-2
VS2 4 s2 0
R2 s2 0 39e-1
VS3 21 s3 0
I3 s3 10 DC 33e-1
VS4 16 s4 0
R4 s4 8 12e3
VS5 8 s5 0
R5 s5 7 10e3
VS6 11 s6 0
R6 s6 13 18e-2
VS7 28 s7 0
R7 s7 5 18e-2
VS8 4 s8 0
R8 s8 22 27e-2
VS9 2 s9 0
R9 s9 28 33e0
VS10 24 s10 0
V10 e10 s10 DC 12e-1
RI10 e10 14 22e-2
VS11 8 s11 0
V11 e11 s11 DC 33e1
RI11 e11 18 12e-3
VS12 5 s12 0
V12 e12 s12 DC 15e0
RI12 e12 3 33e-3
VS13 10 s13 0
R13 s13 6 33e2
VS14 9 s14 0
V14 e14 s14 DC 56e1
RI14 e14 12 82e-1
VS15 13 s15 0
V15 e15 s15 DC 82e-1
RI15 e15 25 82e-3
VS16 0 s16 0
R16 s16 23 15e-2
VS17 4 s17 0
R17 s17 11 39e-2
VS18 19 s18 0
V18 e18 s18 DC 68e-1
RI18 e18 20 82e-1
VS19 7 s19 0
V19 e19 s19 DC 27e-1
RI19 e19 27 15e-2
VS20 4 s20 0
R20 s20 5 82e3
VS21 16 s21 0
R21 s21 1 22e1
VS22 21 s22 0
R22 s22 14 33e3
VS23 27 s23 0
R23 s23 10 68e1
VS24 26 s24 0
V24 e24 s24 DC 47e0
RI24 e24 9 22e-2
VS25 16 s25 0
R25 s25 3 15e-1
VS26 1 s26 0
R26 s26 19 39e3
VS27 17 s27 0
V27 e27 s27 DC 68e1
RI27 e27 11 10e-3
VS28 27 s28 0
V28 e28 s28 DC 47e0
RI28 e28 3 56e-1
VS29 23 s29 0
V29 e29 s29 DC 68e0
RI29 e29 11 10e-3
VS30 16 s30 0
R30 s30 26 56e-1
VS31 5 s31 0
R31 s31 14 47e3
VS32 28 s32 0
R32 s32 15 82e-1
VS33 24 s33 0
R33 s33 8 12e1
VS34 8 s34 0
R34 s34 1 39e0
VS35 10 s35 0
R35 s35 4 10e-1
.control
set numdgt=17
op
print v(1) v(2) v(3) v(4) v(5) v(6) v(7) v(8) v(9) v(10)
print v(11) v(12) v(13) v(14) v(15) v(16) v(17) v(18) v(19) v(20)
print v(21) v(22) v(23) v(24) v(25) v(26) v(27) v(28)
print i(vs0) i(vs1) i(vs2) i(vs3) i(vs4) i(vs5) i(vs6) i(vs7) i(vs8) i(vs9)
print i(vs10) i(vs11) i(vs12) i(vs13) i(vs14) i(vs15) i(vs16) i(vs17) i(vs18) i(vs19)
print i(vs20) i(vs21) i(vs22) i(vs23) i(vs24) i(vs25) i(vs26) i(vs27) i(vs28) i(vs29)
print i(vs30) i(vs31) i(vs32) i(vs33) i(vs34) i(vs35)
.endc
.end
