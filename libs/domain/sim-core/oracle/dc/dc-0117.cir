controls oracle dc-0117
* Generated (plan F2.7, ADR 0012): do not edit; regenerate with `pnpm sim oracle regen`. dc seed 20261030 index 117 nodes 29 elements 44
.options sparse gmin=1e-12 noopac
RG1 1 0 1000000000000
RG2 2 0 1000000000000
RG3 3 0 1000000000000
RG4 4 0 1000000000000
RG5 5 0 1000000000000
RG6 6 0 1000000000000
RG7 7 0 1000000000000
RG8 8 0 1000000000000
RG9 9 0 1000000000000
RG10 10 0 1000000000000
RG11 11 0 1000000000000
RG12 12 0 1000000000000
RG13 13 0 1000000000000
RG14 14 0 1000000000000
RG15 15 0 1000000000000
RG16 16 0 1000000000000
RG17 17 0 1000000000000
RG18 18 0 1000000000000
RG19 19 0 1000000000000
RG20 20 0 1000000000000
RG21 21 0 1000000000000
RG22 22 0 1000000000000
RG23 23 0 1000000000000
RG24 24 0 1000000000000
RG25 25 0 1000000000000
RG26 26 0 1000000000000
RG27 27 0 1000000000000
RG28 28 0 1000000000000
VS0 22 s0 0
R0 s0 21 10e-2
VS1 16 s1 0
R1 s1 3 15e-1
VS2 24 s2 0
R2 s2 8 12e1
VS3 21 s3 0
R3 s3 12 10e2
VS4 28 s4 0
R4 s4 15 82e-1
VS5 16 s5 0
R5 s5 1 22e1
VS6 16 s6 0
R6 s6 26 56e-1
VS7 28 s7 0
R7 s7 5 18e-2
VS8 24 s8 0
R8 s8 0 10e3
VS9 0 s9 0
V9 e9 s9 DC 68e-1
RI9 e9 20 82e-1
VS10 5 s10 0
R10 s10 17 27e2
VS11 16 s11 0
R11 s11 8 12e3
VS12 20 s12 0
R12 s12 1 15e2
VS13 24 s13 0
V13 e13 s13 DC 12e-1
RI13 e13 19 22e-2
VS14 27 s14 0
R14 s14 10 68e1
VS15 21 s15 0
R15 s15 19 33e3
VS16 8 s16 0
V16 e16 s16 DC 33e1
RI16 e16 18 12e-3
VS17 9 s17 0
V17 e17 s17 DC 56e1
RI17 e17 12 82e-1
VS18 5 s18 0
V18 e18 s18 DC 15e0
RI18 e18 3 33e-3
VS19 2 s19 0
R19 s19 6 12e0
VS20 8 s20 0
R20 s20 1 39e0
VS21 5 s21 0
R21 s21 19 47e3
VS22 13 s22 0
V22 e22 s22 DC 82e-1
RI22 e22 25 82e-3
VS23 17 s23 0
V23 e23 s23 DC 68e1
RI23 e23 11 10e-3
VS24 21 s24 0
I24 s24 10 DC 33e-1
VS25 14 s25 0
R25 s25 23 15e-2
VS26 11 s26 0
R26 s26 13 18e-2
VS27 10 s27 0
R27 s27 4 10e-1
VS28 15 s28 0
R28 s28 11 15e2
VS29 2 s29 0
R29 s29 28 33e0
VS30 14 s30 0
V30 e30 s30 DC 10e0
RI30 e30 18 82e-2
VS31 1 s31 0
R31 s31 0 39e3
VS32 2 s32 0
R32 s32 16 15e0
VS33 4 s33 0
R33 s33 22 27e-2
VS34 4 s34 0
R34 s34 5 82e3
VS35 8 s35 0
R35 s35 7 10e3
VS36 7 s36 0
V36 e36 s36 DC 27e-1
RI36 e36 27 15e-2
VS37 23 s37 0
V37 e37 s37 DC 68e0
RI37 e37 11 10e-3
VS38 4 s38 0
R38 s38 11 39e-2
VS39 10 s39 0
R39 s39 6 33e2
VS40 26 s40 0
V40 e40 s40 DC 47e0
RI40 e40 9 22e-2
VS41 27 s41 0
V41 e41 s41 DC 47e0
RI41 e41 3 56e-1
VS42 25 s42 0
V42 e42 s42 DC 10e1
RI42 e42 7 33e-2
VS43 4 s43 0
R43 s43 14 39e-1
.control
set numdgt=17
op
print v(1) v(2) v(3) v(4) v(5) v(6) v(7) v(8) v(9) v(10)
print v(11) v(12) v(13) v(14) v(15) v(16) v(17) v(18) v(19) v(20)
print v(21) v(22) v(23) v(24) v(25) v(26) v(27) v(28)
print i(vs0) i(vs1) i(vs2) i(vs3) i(vs4) i(vs5) i(vs6) i(vs7) i(vs8) i(vs9)
print i(vs10) i(vs11) i(vs12) i(vs13) i(vs14) i(vs15) i(vs16) i(vs17) i(vs18) i(vs19)
print i(vs20) i(vs21) i(vs22) i(vs23) i(vs24) i(vs25) i(vs26) i(vs27) i(vs28) i(vs29)
print i(vs30) i(vs31) i(vs32) i(vs33) i(vs34) i(vs35) i(vs36) i(vs37) i(vs38) i(vs39)
print i(vs40) i(vs41) i(vs42) i(vs43)
.endc
.end
