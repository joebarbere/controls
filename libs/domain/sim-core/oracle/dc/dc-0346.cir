controls oracle dc-0346
* Generated (plan F2.7, ADR 0012): do not edit; regenerate with `pnpm sim oracle regen`. dc seed 20261030 index 346 nodes 10 elements 13
.options sparse gmin=1e-12 noopac
RG1 1 0 1000000000000
RG2 2 0 1000000000000
RG3 3 0 1000000000000
RG4 4 0 1000000000000
RG5 5 0 1000000000000
RG6 6 0 1000000000000
RG7 7 0 1000000000000
RG8 8 0 1000000000000
RG9 9 0 1000000000000
VS0 5 s0 0
R0 s0 2 10e1
VS1 5 s1 0
R1 s1 0 33e3
VS2 0 s2 0
R2 s2 1 15e0
VS3 0 s3 0
V3 e3 s3 DC 56e-1
RI3 e3 3 27e-3
VS4 8 s4 0
R4 s4 9 39e-2
VS5 9 s5 0
V5 e5 s5 DC 10e0
RI5 e5 2 56e-1
VS6 2 s6 0
I6 s6 4 DC 39e-1
VS7 6 s7 0
R7 s7 4 56e-1
VS8 4 s8 0
V8 e8 s8 DC 18e0
RI8 e8 5 12e-2
VS9 1 s9 0
R9 s9 7 15e3
VS10 9 s10 0
V10 e10 s10 DC 56e0
RI10 e10 1 15e-3
VS11 1 s11 0
R11 s11 4 47e0
VS12 3 s12 0
I12 s12 8 DC 27e-4
.control
set numdgt=17
op
print v(1) v(2) v(3) v(4) v(5) v(6) v(7) v(8) v(9)
print i(vs0) i(vs1) i(vs2) i(vs3) i(vs4) i(vs5) i(vs6) i(vs7) i(vs8) i(vs9)
print i(vs10) i(vs11) i(vs12)
.endc
.end
