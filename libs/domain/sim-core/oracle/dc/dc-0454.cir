controls oracle dc-0454
* Generated (plan F2.7, ADR 0012): do not edit; regenerate with `pnpm sim oracle regen`. dc seed 20261030 index 454 nodes 21 elements 34
.options sparse gmin=1e-12 noopac
RG1 1 0 1000000000000
RG2 2 0 1000000000000
RG3 3 0 1000000000000
RG4 4 0 1000000000000
RG5 5 0 1000000000000
RG6 6 0 1000000000000
RG7 7 0 1000000000000
RG8 8 0 1000000000000
RG9 9 0 1000000000000
RG10 10 0 1000000000000
RG11 11 0 1000000000000
RG12 12 0 1000000000000
RG13 13 0 1000000000000
RG14 14 0 1000000000000
RG15 15 0 1000000000000
RG16 16 0 1000000000000
RG17 17 0 1000000000000
RG18 18 0 1000000000000
RG19 19 0 1000000000000
RG20 20 0 1000000000000
VS0 0 s0 0
R0 s0 1 27e2
VS1 9 s1 0
R1 s1 14 10e3
VS2 1 s2 0
R2 s2 5 15e2
VS3 20 s3 0
R3 s3 7 47e-1
VS4 11 s4 0
I4 s4 1 DC 27e-1
VS5 10 s5 0
R5 s5 4 47e2
VS6 13 s6 0
R6 s6 20 39e-1
VS7 11 s7 0
R7 s7 7 82e3
VS8 0 s8 0
V8 e8 s8 DC 27e0
RI8 e8 16 22e-1
VS9 6 s9 0
V9 e9 s9 DC 15e-1
RI9 e9 15 27e-2
VS10 19 s10 0
R10 s10 9 15e-2
VS11 11 s11 0
V11 e11 s11 DC 56e-1
RI11 e11 7 18e-3
VS12 2 s12 0
V12 e12 s12 DC 10e-1
RI12 e12 16 68e-1
VS13 8 s13 0
R13 s13 16 27e1
VS14 12 s14 0
R14 s14 2 68e-1
VS15 3 s15 0
V15 e15 s15 DC 27e0
RI15 e15 16 12e-2
VS16 11 s16 0
R16 s16 19 68e-1
VS17 12 s17 0
R17 s17 17 10e-2
VS18 11 s18 0
R18 s18 10 56e2
VS19 5 s19 0
I19 s19 6 DC 82e-4
VS20 3 s20 0
R20 s20 2 68e1
VS21 8 s21 0
R21 s21 11 18e1
VS22 19 s22 0
R22 s22 18 12e1
VS23 4 s23 0
R23 s23 5 27e3
VS24 2 s24 0
I24 s24 10 DC 18e-2
VS25 14 s25 0
R25 s25 2 15e-2
VS26 0 s26 0
I26 s26 19 DC 47e-3
VS27 3 s27 0
R27 s27 14 33e3
VS28 20 s28 0
R28 s28 4 47e3
VS29 6 s29 0
I29 s29 15 DC 82e-2
VS30 16 s30 0
R30 s30 17 39e2
VS31 18 s31 0
V31 e31 s31 DC 27e0
RI31 e31 2 39e-1
VS32 2 s32 0
R32 s32 20 56e2
VS33 15 s33 0
R33 s33 9 27e-1
.control
set numdgt=17
op
print v(1) v(2) v(3) v(4) v(5) v(6) v(7) v(8) v(9) v(10)
print v(11) v(12) v(13) v(14) v(15) v(16) v(17) v(18) v(19) v(20)
print i(vs0) i(vs1) i(vs2) i(vs3) i(vs4) i(vs5) i(vs6) i(vs7) i(vs8) i(vs9)
print i(vs10) i(vs11) i(vs12) i(vs13) i(vs14) i(vs15) i(vs16) i(vs17) i(vs18) i(vs19)
print i(vs20) i(vs21) i(vs22) i(vs23) i(vs24) i(vs25) i(vs26) i(vs27) i(vs28) i(vs29)
print i(vs30) i(vs31) i(vs32) i(vs33)
.endc
.end
