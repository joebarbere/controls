controls oracle dc-0345
* Generated (plan F2.7, ADR 0012): do not edit; regenerate with `pnpm sim oracle regen`. dc seed 20261030 index 345 nodes 10 elements 11
.options sparse gmin=1e-12 noopac
RG1 1 0 1000000000000
RG2 2 0 1000000000000
RG3 3 0 1000000000000
RG4 4 0 1000000000000
RG5 5 0 1000000000000
RG6 6 0 1000000000000
RG7 7 0 1000000000000
RG8 8 0 1000000000000
RG9 9 0 1000000000000
VS0 7 s0 0
I0 s0 5 DC 12e-3
VS1 0 s1 0
V1 e1 s1 DC 10e1
RI1 e1 2 47e-3
VS2 2 s2 0
R2 s2 5 22e-2
VS3 8 s3 0
V3 e3 s3 DC 39e-1
RI3 e3 2 15e-2
VS4 6 s4 0
V4 e4 s4 DC 68e0
RI4 e4 7 47e-3
VS5 8 s5 0
R5 s5 7 82e2
VS6 8 s6 0
R6 s6 0 39e2
VS7 3 s7 0
V7 e7 s7 DC 82e1
RI7 e7 7 68e-2
VS8 1 s8 0
R8 s8 2 82e0
VS9 9 s9 0
R9 s9 0 22e2
VS10 4 s10 0
R10 s10 0 22e1
.control
set numdgt=17
op
print v(1) v(2) v(3) v(4) v(5) v(6) v(7) v(8) v(9)
print i(vs0) i(vs1) i(vs2) i(vs3) i(vs4) i(vs5) i(vs6) i(vs7) i(vs8) i(vs9)
print i(vs10)
.endc
.end
