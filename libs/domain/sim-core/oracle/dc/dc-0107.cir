controls oracle dc-0107
* Generated (plan F2.7, ADR 0012): do not edit; regenerate with `pnpm sim oracle regen`. dc seed 20261030 index 107 nodes 5 elements 6
.options sparse gmin=1e-12 noopac
RG1 1 0 1000000000000
RG2 2 0 1000000000000
RG3 3 0 1000000000000
RG4 4 0 1000000000000
VS0 4 s0 0
R0 s0 1 39e-2
VS1 0 s1 0
R1 s1 4 15e1
VS2 2 s2 0
R2 s2 1 15e2
VS3 3 s3 0
R3 s3 2 33e-1
VS4 0 s4 0
V4 e4 s4 DC 22e1
RI4 e4 1 22e-2
VS5 0 s5 0
R5 s5 3 82e-2
.control
set numdgt=17
op
print v(1) v(2) v(3) v(4)
print i(vs0) i(vs1) i(vs2) i(vs3) i(vs4) i(vs5)
.endc
.end
