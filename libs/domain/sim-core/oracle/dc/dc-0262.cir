controls oracle dc-0262
* Generated (plan F2.7, ADR 0012): do not edit; regenerate with `pnpm sim oracle regen`. dc seed 20261030 index 262 nodes 27 elements 28
.options sparse gmin=1e-12 noopac
RG1 1 0 1000000000000
RG2 2 0 1000000000000
RG3 3 0 1000000000000
RG4 4 0 1000000000000
RG5 5 0 1000000000000
RG6 6 0 1000000000000
RG7 7 0 1000000000000
RG8 8 0 1000000000000
RG9 9 0 1000000000000
RG10 10 0 1000000000000
RG11 11 0 1000000000000
RG12 12 0 1000000000000
RG13 13 0 1000000000000
RG14 14 0 1000000000000
RG15 15 0 1000000000000
RG16 16 0 1000000000000
RG17 17 0 1000000000000
RG18 18 0 1000000000000
RG19 19 0 1000000000000
RG20 20 0 1000000000000
RG21 21 0 1000000000000
RG22 22 0 1000000000000
RG23 23 0 1000000000000
RG24 24 0 1000000000000
RG25 25 0 1000000000000
RG26 26 0 1000000000000
VS0 26 s0 0
R0 s0 24 18e0
VS1 0 s1 0
R1 s1 25 15e2
VS2 0 s2 0
V2 e2 s2 DC 68e-1
RI2 e2 9 15e-1
VS3 24 s3 0
R3 s3 20 33e-2
VS4 15 s4 0
R4 s4 7 39e0
VS5 26 s5 0
R5 s5 3 15e3
VS6 1 s6 0
R6 s6 13 22e2
VS7 21 s7 0
R7 s7 6 15e1
VS8 7 s8 0
R8 s8 14 10e-2
VS9 1 s9 0
R9 s9 11 10e2
VS10 19 s10 0
R10 s10 25 18e3
VS11 21 s11 0
R11 s11 18 47e0
VS12 19 s12 0
R12 s12 4 27e3
VS13 1 s13 0
R13 s13 2 68e3
VS14 16 s14 0
V14 e14 s14 DC 33e1
RI14 e14 15 47e-3
VS15 12 s15 0
V15 e15 s15 DC 39e0
RI15 e15 5 56e-1
VS16 17 s16 0
R16 s16 20 15e0
VS17 17 s17 0
R17 s17 25 82e-1
VS18 15 s18 0
V18 e18 s18 DC 18e0
RI18 e18 11 27e-1
VS19 10 s19 0
R19 s19 3 56e3
VS20 9 s20 0
R20 s20 25 22e-1
VS21 10 s21 0
R21 s21 18 47e0
VS22 19 s22 0
R22 s22 18 15e1
VS23 23 s23 0
R23 s23 9 68e0
VS24 8 s24 0
V24 e24 s24 DC 15e-1
RI24 e24 25 18e-1
VS25 21 s25 0
R25 s25 22 18e1
VS26 11 s26 0
V26 e26 s26 DC 22e-1
RI26 e26 21 68e-3
VS27 12 s27 0
R27 s27 1 56e-1
.control
set numdgt=17
op
print v(1) v(2) v(3) v(4) v(5) v(6) v(7) v(8) v(9) v(10)
print v(11) v(12) v(13) v(14) v(15) v(16) v(17) v(18) v(19) v(20)
print v(21) v(22) v(23) v(24) v(25) v(26)
print i(vs0) i(vs1) i(vs2) i(vs3) i(vs4) i(vs5) i(vs6) i(vs7) i(vs8) i(vs9)
print i(vs10) i(vs11) i(vs12) i(vs13) i(vs14) i(vs15) i(vs16) i(vs17) i(vs18) i(vs19)
print i(vs20) i(vs21) i(vs22) i(vs23) i(vs24) i(vs25) i(vs26) i(vs27)
.endc
.end
