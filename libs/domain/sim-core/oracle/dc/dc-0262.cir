controls oracle dc-0262
* Generated (plan F2.7, ADR 0012): do not edit; regenerate with `pnpm sim oracle regen`. dc seed 20261030 index 262 nodes 27 elements 39
.options sparse gmin=1e-12 noopac
RG1 1 0 1000000000000
RG2 2 0 1000000000000
RG3 3 0 1000000000000
RG4 4 0 1000000000000
RG5 5 0 1000000000000
RG6 6 0 1000000000000
RG7 7 0 1000000000000
RG8 8 0 1000000000000
RG9 9 0 1000000000000
RG10 10 0 1000000000000
RG11 11 0 1000000000000
RG12 12 0 1000000000000
RG13 13 0 1000000000000
RG14 14 0 1000000000000
RG15 15 0 1000000000000
RG16 16 0 1000000000000
RG17 17 0 1000000000000
RG18 18 0 1000000000000
RG19 19 0 1000000000000
RG20 20 0 1000000000000
RG21 21 0 1000000000000
RG22 22 0 1000000000000
RG23 23 0 1000000000000
RG24 24 0 1000000000000
RG25 25 0 1000000000000
RG26 26 0 1000000000000
VS0 0 s0 0
V0 e0 s0 DC 18e0
RI0 e0 11 27e-1
VS1 11 s1 0
V1 e1 s1 DC 22e-1
RI1 e1 15 68e-3
VS2 19 s2 0
R2 s2 18 15e1
VS3 0 s3 0
R3 s3 7 39e0
VS4 1 s4 0
R4 s4 11 10e2
VS5 5 s5 0
R5 s5 2 56e-1
VS6 8 s6 0
V6 e6 s6 DC 10e0
RI6 e6 10 12e-1
VS7 7 s7 0
R7 s7 14 10e-2
VS8 26 s8 0
R8 s8 3 15e3
VS9 24 s9 0
R9 s9 20 33e-2
VS10 1 s10 0
R10 s10 13 22e2
VS11 17 s11 0
R11 s11 25 82e-1
VS12 19 s12 0
R12 s12 25 18e3
VS13 21 s13 0
R13 s13 25 15e2
VS14 16 s14 0
V14 e14 s14 DC 33e1
RI14 e14 0 47e-3
VS15 15 s15 0
R15 s15 22 18e1
VS16 24 s16 0
R16 s16 23 56e1
VS17 20 s17 0
R17 s17 2 15e2
VS18 10 s18 0
R18 s18 18 47e0
VS19 12 s19 0
V19 e19 s19 DC 39e0
RI19 e19 5 56e-1
VS20 21 s20 0
V20 e20 s20 DC 68e-1
RI20 e20 9 15e-1
VS21 19 s21 0
R21 s21 22 12e0
VS22 2 s22 0
V22 e22 s22 DC 22e-1
RI22 e22 6 10e-2
VS23 1 s23 0
R23 s23 2 68e3
VS24 12 s24 0
R24 s24 1 56e-1
VS25 17 s25 0
R25 s25 20 15e0
VS26 26 s26 0
R26 s26 24 18e0
VS27 8 s27 0
V27 e27 s27 DC 15e-1
RI27 e27 25 18e-1
VS28 10 s28 0
R28 s28 3 56e3
VS29 19 s29 0
R29 s29 4 27e3
VS30 11 s30 0
R30 s30 2 12e3
VS31 16 s31 0
R31 s31 14 68e2
VS32 15 s32 0
R32 s32 18 47e0
VS33 16 s33 0
V33 e33 s33 DC 33e-1
RI33 e33 25 18e-1
VS34 15 s34 0
R34 s34 6 15e1
VS35 5 s35 0
V35 e35 s35 DC 27e-1
RI35 e35 13 82e-3
VS36 23 s36 0
R36 s36 9 68e0
VS37 4 s37 0
R37 s37 9 68e0
VS38 9 s38 0
R38 s38 25 22e-1
.control
set numdgt=17
op
print v(1) v(2) v(3) v(4) v(5) v(6) v(7) v(8) v(9) v(10)
print v(11) v(12) v(13) v(14) v(15) v(16) v(17) v(18) v(19) v(20)
print v(21) v(22) v(23) v(24) v(25) v(26)
print i(vs0) i(vs1) i(vs2) i(vs3) i(vs4) i(vs5) i(vs6) i(vs7) i(vs8) i(vs9)
print i(vs10) i(vs11) i(vs12) i(vs13) i(vs14) i(vs15) i(vs16) i(vs17) i(vs18) i(vs19)
print i(vs20) i(vs21) i(vs22) i(vs23) i(vs24) i(vs25) i(vs26) i(vs27) i(vs28) i(vs29)
print i(vs30) i(vs31) i(vs32) i(vs33) i(vs34) i(vs35) i(vs36) i(vs37) i(vs38)
.endc
.end
