controls oracle dc-0267
* Generated (plan F2.7, ADR 0012): do not edit; regenerate with `pnpm sim oracle regen`. dc seed 20261030 index 267 nodes 24 elements 49
.options sparse gmin=1e-12 noopac
RG1 1 0 1000000000000
RG2 2 0 1000000000000
RG3 3 0 1000000000000
RG4 4 0 1000000000000
RG5 5 0 1000000000000
RG6 6 0 1000000000000
RG7 7 0 1000000000000
RG8 8 0 1000000000000
RG9 9 0 1000000000000
RG10 10 0 1000000000000
RG11 11 0 1000000000000
RG12 12 0 1000000000000
RG13 13 0 1000000000000
RG14 14 0 1000000000000
RG15 15 0 1000000000000
RG16 16 0 1000000000000
RG17 17 0 1000000000000
RG18 18 0 1000000000000
RG19 19 0 1000000000000
RG20 20 0 1000000000000
RG21 21 0 1000000000000
RG22 22 0 1000000000000
RG23 23 0 1000000000000
VS0 11 s0 0
R0 s0 17 15e-2
VS1 8 s1 0
R1 s1 11 39e0
VS2 0 s2 0
R2 s2 22 56e1
VS3 6 s3 0
R3 s3 0 68e1
VS4 21 s4 0
I4 s4 1 DC 22e-3
VS5 15 s5 0
I5 s5 9 DC 56e-3
VS6 0 s6 0
R6 s6 16 12e2
VS7 4 s7 0
R7 s7 2 56e-1
VS8 17 s8 0
I8 s8 20 DC 27e-1
VS9 13 s9 0
I9 s9 16 DC 12e-4
VS10 0 s10 0
V10 e10 s10 DC 68e1
RI10 e10 15 68e-1
VS11 9 s11 0
I11 s11 19 DC 39e-2
VS12 23 s12 0
V12 e12 s12 DC 18e-1
RI12 e12 13 68e-3
VS13 10 s13 0
V13 e13 s13 DC 68e-1
RI13 e13 9 12e-2
VS14 2 s14 0
R14 s14 22 56e1
VS15 14 s15 0
V15 e15 s15 DC 12e-1
RI15 e15 6 12e-1
VS16 16 s16 0
R16 s16 11 10e-1
VS17 22 s17 0
R17 s17 1 10e-1
VS18 7 s18 0
I18 s18 6 DC 15e-4
VS19 7 s19 0
V19 e19 s19 DC 56e0
RI19 e19 13 18e-3
VS20 7 s20 0
R20 s20 2 18e2
VS21 20 s21 0
R21 s21 21 22e1
VS22 5 s22 0
V22 e22 s22 DC 22e0
RI22 e22 23 68e-2
VS23 4 s23 0
R23 s23 2 47e3
VS24 13 s24 0
R24 s24 2 56e-1
VS25 6 s25 0
R25 s25 23 10e-1
VS26 0 s26 0
I26 s26 8 DC 22e-3
VS27 14 s27 0
R27 s27 3 56e3
VS28 5 s28 0
R28 s28 3 10e0
VS29 1 s29 0
R29 s29 23 47e3
VS30 12 s30 0
V30 e30 s30 DC 18e0
RI30 e30 23 39e-1
VS31 6 s31 0
R31 s31 11 15e0
VS32 12 s32 0
R32 s32 10 68e0
VS33 19 s33 0
R33 s33 18 27e0
VS34 3 s34 0
R34 s34 12 68e-1
VS35 8 s35 0
R35 s35 18 56e-1
VS36 21 s36 0
R36 s36 6 15e0
VS37 0 s37 0
R37 s37 7 18e2
VS38 19 s38 0
R38 s38 2 18e0
VS39 23 s39 0
R39 s39 9 68e3
VS40 4 s40 0
R40 s40 17 18e-2
VS41 3 s41 0
R41 s41 15 18e1
VS42 7 s42 0
R42 s42 8 68e0
VS43 2 s43 0
I43 s43 19 DC 68e-1
VS44 13 s44 0
V44 e44 s44 DC 12e-1
RI44 e44 20 56e-1
VS45 2 s45 0
V45 e45 s45 DC 56e1
RI45 e45 12 10e-2
VS46 11 s46 0
I46 s46 23 DC 18e-3
VS47 18 s47 0
I47 s47 16 DC 22e-3
VS48 4 s48 0
I48 s48 1 DC 47e-2
.control
set numdgt=17
op
print v(1) v(2) v(3) v(4) v(5) v(6) v(7) v(8) v(9) v(10)
print v(11) v(12) v(13) v(14) v(15) v(16) v(17) v(18) v(19) v(20)
print v(21) v(22) v(23)
print i(vs0) i(vs1) i(vs2) i(vs3) i(vs4) i(vs5) i(vs6) i(vs7) i(vs8) i(vs9)
print i(vs10) i(vs11) i(vs12) i(vs13) i(vs14) i(vs15) i(vs16) i(vs17) i(vs18) i(vs19)
print i(vs20) i(vs21) i(vs22) i(vs23) i(vs24) i(vs25) i(vs26) i(vs27) i(vs28) i(vs29)
print i(vs30) i(vs31) i(vs32) i(vs33) i(vs34) i(vs35) i(vs36) i(vs37) i(vs38) i(vs39)
print i(vs40) i(vs41) i(vs42) i(vs43) i(vs44) i(vs45) i(vs46) i(vs47) i(vs48)
.endc
.end
