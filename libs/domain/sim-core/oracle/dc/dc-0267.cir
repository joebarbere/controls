controls oracle dc-0267
* Generated (plan F2.7, ADR 0012): do not edit; regenerate with `pnpm sim oracle regen`. dc seed 20261030 index 267 nodes 24 elements 45
.options sparse gmin=1e-12 noopac
RG1 1 0 1000000000000
RG2 2 0 1000000000000
RG3 3 0 1000000000000
RG4 4 0 1000000000000
RG5 5 0 1000000000000
RG6 6 0 1000000000000
RG7 7 0 1000000000000
RG8 8 0 1000000000000
RG9 9 0 1000000000000
RG10 10 0 1000000000000
RG11 11 0 1000000000000
RG12 12 0 1000000000000
RG13 13 0 1000000000000
RG14 14 0 1000000000000
RG15 15 0 1000000000000
RG16 16 0 1000000000000
RG17 17 0 1000000000000
RG18 18 0 1000000000000
RG19 19 0 1000000000000
RG20 20 0 1000000000000
RG21 21 0 1000000000000
RG22 22 0 1000000000000
RG23 23 0 1000000000000
VS0 14 s0 0
R0 s0 17 15e-2
VS1 12 s1 0
R1 s1 10 68e0
VS2 13 s2 0
I2 s2 16 DC 12e-4
VS3 14 s3 0
I3 s3 23 DC 18e-3
VS4 19 s4 0
R4 s4 18 27e0
VS5 0 s5 0
R5 s5 3 56e3
VS6 4 s6 0
R6 s6 2 47e3
VS7 7 s7 0
R7 s7 2 18e2
VS8 23 s8 0
R8 s8 9 68e3
VS9 3 s9 0
R9 s9 12 68e-1
VS10 17 s10 0
I10 s10 20 DC 27e-1
VS11 0 s11 0
V11 e11 s11 DC 12e-1
RI11 e11 6 12e-1
VS12 6 s12 0
R12 s12 23 10e-1
VS13 5 s13 0
R13 s13 3 10e0
VS14 8 s14 0
R14 s14 14 39e0
VS15 11 s15 0
R15 s15 7 18e2
VS16 6 s16 0
R16 s16 11 68e1
VS17 6 s17 0
R17 s17 14 15e0
VS18 20 s18 0
R18 s18 21 22e1
VS19 21 s19 0
I19 s19 1 DC 22e-3
VS20 11 s20 0
R20 s20 22 56e1
VS21 7 s21 0
I21 s21 6 DC 15e-4
VS22 2 s22 0
R22 s22 22 56e1
VS23 12 s23 0
V23 e23 s23 DC 18e0
RI23 e23 23 39e-1
VS24 8 s24 0
R24 s24 18 56e-1
VS25 2 s25 0
V25 e25 s25 DC 56e1
RI25 e25 12 10e-2
VS26 13 s26 0
R26 s26 2 56e-1
VS27 13 s27 0
V27 e27 s27 DC 12e-1
RI27 e27 20 56e-1
VS28 5 s28 0
V28 e28 s28 DC 22e0
RI28 e28 23 68e-2
VS29 23 s29 0
V29 e29 s29 DC 18e-1
RI29 e29 13 68e-3
VS30 7 s30 0
V30 e30 s30 DC 56e0
RI30 e30 13 18e-3
VS31 2 s31 0
I31 s31 19 DC 68e-1
VS32 21 s32 0
R32 s32 6 15e0
VS33 9 s33 0
I33 s33 19 DC 39e-2
VS34 3 s34 0
R34 s34 15 18e1
VS35 11 s35 0
R35 s35 16 12e2
VS36 18 s36 0
I36 s36 16 DC 22e-3
VS37 4 s37 0
R37 s37 2 56e-1
VS38 16 s38 0
R38 s38 14 10e-1
VS39 11 s39 0
I39 s39 8 DC 22e-3
VS40 15 s40 0
I40 s40 9 DC 56e-3
VS41 10 s41 0
V41 e41 s41 DC 68e-1
RI41 e41 9 12e-2
VS42 4 s42 0
I42 s42 1 DC 47e-2
VS43 1 s43 0
R43 s43 23 47e3
VS44 7 s44 0
R44 s44 8 68e0
.control
set numdgt=17
op
print v(1) v(2) v(3) v(4) v(5) v(6) v(7) v(8) v(9) v(10)
print v(11) v(12) v(13) v(14) v(15) v(16) v(17) v(18) v(19) v(20)
print v(21) v(22) v(23)
print i(vs0) i(vs1) i(vs2) i(vs3) i(vs4) i(vs5) i(vs6) i(vs7) i(vs8) i(vs9)
print i(vs10) i(vs11) i(vs12) i(vs13) i(vs14) i(vs15) i(vs16) i(vs17) i(vs18) i(vs19)
print i(vs20) i(vs21) i(vs22) i(vs23) i(vs24) i(vs25) i(vs26) i(vs27) i(vs28) i(vs29)
print i(vs30) i(vs31) i(vs32) i(vs33) i(vs34) i(vs35) i(vs36) i(vs37) i(vs38) i(vs39)
print i(vs40) i(vs41) i(vs42) i(vs43) i(vs44)
.endc
.end
