controls oracle dc-0004
* Generated (plan F2.7, ADR 0012): do not edit; regenerate with `pnpm sim oracle regen`. dc seed 20261030 index 4 nodes 3 elements 4
.options sparse gmin=1e-12 noopac
RG1 1 0 1000000000000
RG2 2 0 1000000000000
VS0 0 s0 0
R0 s0 2 12e-1
VS1 2 s1 0
I1 s1 0 DC 27e-1
VS2 2 s2 0
R2 s2 0 22e-1
VS3 0 s3 0
R3 s3 1 82e-2
.control
set numdgt=17
op
print v(1) v(2)
print i(vs0) i(vs1) i(vs2) i(vs3)
.endc
.end
