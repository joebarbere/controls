controls oracle dc-0004
* Generated (plan F2.7, ADR 0012): do not edit; regenerate with `pnpm sim oracle regen`. dc seed 20261030 index 4 nodes 3 elements 5
.options sparse gmin=1e-12 noopac
RG1 1 0 1000000000000
RG2 2 0 1000000000000
VS0 2 s0 0
I0 s0 0 DC 27e-1
VS1 1 s1 0
R1 s1 2 39e-1
VS2 0 s2 0
R2 s2 2 12e-1
VS3 2 s3 0
R3 s3 0 22e-1
VS4 0 s4 0
R4 s4 1 82e-2
.control
set numdgt=17
op
print v(1) v(2)
print i(vs0) i(vs1) i(vs2) i(vs3) i(vs4)
.endc
.end
