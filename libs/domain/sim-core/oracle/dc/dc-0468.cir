controls oracle dc-0468
* Generated (plan F2.7, ADR 0012): do not edit; regenerate with `pnpm sim oracle regen`. dc seed 20261030 index 468 nodes 26 elements 40
.options sparse gmin=1e-12 noopac
RG1 1 0 1000000000000
RG2 2 0 1000000000000
RG3 3 0 1000000000000
RG4 4 0 1000000000000
RG5 5 0 1000000000000
RG6 6 0 1000000000000
RG7 7 0 1000000000000
RG8 8 0 1000000000000
RG9 9 0 1000000000000
RG10 10 0 1000000000000
RG11 11 0 1000000000000
RG12 12 0 1000000000000
RG13 13 0 1000000000000
RG14 14 0 1000000000000
RG15 15 0 1000000000000
RG16 16 0 1000000000000
RG17 17 0 1000000000000
RG18 18 0 1000000000000
RG19 19 0 1000000000000
RG20 20 0 1000000000000
RG21 21 0 1000000000000
RG22 22 0 1000000000000
RG23 23 0 1000000000000
RG24 24 0 1000000000000
RG25 25 0 1000000000000
VS0 0 s0 0
R0 s0 5 82e0
VS1 18 s1 0
R1 s1 16 22e3
VS2 3 s2 0
R2 s2 4 33e0
VS3 22 s3 0
R3 s3 6 56e0
VS4 21 s4 0
R4 s4 18 39e-1
VS5 0 s5 0
V5 e5 s5 DC 82e1
RI5 e5 14 82e-2
VS6 6 s6 0
I6 s6 24 DC 33e-1
VS7 16 s7 0
I7 s7 17 DC 82e-1
VS8 17 s8 0
I8 s8 14 DC 39e-4
VS9 7 s9 0
R9 s9 11 68e2
VS10 19 s10 0
V10 e10 s10 DC 82e0
RI10 e10 4 15e-3
VS11 21 s11 0
R11 s11 19 18e-2
VS12 16 s12 0
I12 s12 25 DC 15e-3
VS13 18 s13 0
R13 s13 9 27e-1
VS14 10 s14 0
V14 e14 s14 DC 18e0
RI14 e14 0 68e-3
VS15 19 s15 0
R15 s15 12 12e0
VS16 22 s16 0
V16 e16 s16 DC 39e0
RI16 e16 15 10e-3
VS17 11 s17 0
R17 s17 4 12e0
VS18 5 s18 0
I18 s18 0 DC 18e-2
VS19 2 s19 0
R19 s19 0 22e-1
VS20 9 s20 0
R20 s20 0 82e2
VS21 15 s21 0
R21 s21 3 27e3
VS22 18 s22 0
R22 s22 16 82e-2
VS23 17 s23 0
V23 e23 s23 DC 22e0
RI23 e23 25 82e-2
VS24 13 s24 0
R24 s24 16 47e2
VS25 2 s25 0
R25 s25 14 22e2
VS26 6 s26 0
R26 s26 16 15e2
VS27 4 s27 0
V27 e27 s27 DC 82e-1
RI27 e27 8 27e-3
VS28 22 s28 0
R28 s28 2 22e0
VS29 12 s29 0
I29 s29 14 DC 39e-4
VS30 6 s30 0
R30 s30 4 82e1
VS31 14 s31 0
R31 s31 17 18e1
VS32 18 s32 0
V32 e32 s32 DC 56e1
RI32 e32 1 82e-2
VS33 24 s33 0
R33 s33 13 10e1
VS34 20 s34 0
R34 s34 0 12e3
VS35 24 s35 0
R35 s35 2 18e2
VS36 4 s36 0
R36 s36 0 10e0
VS37 23 s37 0
R37 s37 1 68e0
VS38 18 s38 0
R38 s38 15 82e2
VS39 25 s39 0
R39 s39 21 56e-2
.control
set numdgt=17
op
print v(1) v(2) v(3) v(4) v(5) v(6) v(7) v(8) v(9) v(10)
print v(11) v(12) v(13) v(14) v(15) v(16) v(17) v(18) v(19) v(20)
print v(21) v(22) v(23) v(24) v(25)
print i(vs0) i(vs1) i(vs2) i(vs3) i(vs4) i(vs5) i(vs6) i(vs7) i(vs8) i(vs9)
print i(vs10) i(vs11) i(vs12) i(vs13) i(vs14) i(vs15) i(vs16) i(vs17) i(vs18) i(vs19)
print i(vs20) i(vs21) i(vs22) i(vs23) i(vs24) i(vs25) i(vs26) i(vs27) i(vs28) i(vs29)
print i(vs30) i(vs31) i(vs32) i(vs33) i(vs34) i(vs35) i(vs36) i(vs37) i(vs38) i(vs39)
.endc
.end
