controls oracle dc-0468
* Generated (plan F2.7, ADR 0012): do not edit; regenerate with `pnpm sim oracle regen`. dc seed 20261030 index 468 nodes 26 elements 47
.options sparse gmin=1e-12 noopac
RG1 1 0 1000000000000
RG2 2 0 1000000000000
RG3 3 0 1000000000000
RG4 4 0 1000000000000
RG5 5 0 1000000000000
RG6 6 0 1000000000000
RG7 7 0 1000000000000
RG8 8 0 1000000000000
RG9 9 0 1000000000000
RG10 10 0 1000000000000
RG11 11 0 1000000000000
RG12 12 0 1000000000000
RG13 13 0 1000000000000
RG14 14 0 1000000000000
RG15 15 0 1000000000000
RG16 16 0 1000000000000
RG17 17 0 1000000000000
RG18 18 0 1000000000000
RG19 19 0 1000000000000
RG20 20 0 1000000000000
RG21 21 0 1000000000000
RG22 22 0 1000000000000
RG23 23 0 1000000000000
RG24 24 0 1000000000000
RG25 25 0 1000000000000
VS0 25 s0 0
R0 s0 21 56e-2
VS1 0 s1 0
V1 e1 s1 DC 39e0
RI1 e1 15 10e-3
VS2 17 s2 0
V2 e2 s2 DC 22e0
RI2 e2 25 82e-2
VS3 24 s3 0
R3 s3 13 10e1
VS4 22 s4 0
R4 s4 4 10e0
VS5 18 s5 0
R5 s5 16 82e-2
VS6 14 s6 0
V6 e6 s6 DC 82e0
RI6 e6 20 22e-1
VS7 18 s7 0
R7 s7 9 27e-1
VS8 11 s8 0
R8 s8 22 12e0
VS9 12 s9 0
I9 s9 14 DC 39e-4
VS10 12 s10 0
R10 s10 2 22e-2
VS11 18 s11 0
R11 s11 15 82e2
VS12 2 s12 0
R12 s12 5 22e-1
VS13 9 s13 0
R13 s13 4 82e2
VS14 22 s14 0
V14 e14 s14 DC 82e-1
RI14 e14 8 27e-3
VS15 0 s15 0
R15 s15 6 56e0
VS16 21 s16 0
R16 s16 19 18e-2
VS17 19 s17 0
V17 e17 s17 DC 82e0
RI17 e17 22 15e-3
VS18 10 s18 0
V18 e18 s18 DC 18e0
RI18 e18 4 68e-3
VS19 2 s19 0
R19 s19 4 22e-1
VS20 6 s20 0
R20 s20 16 15e2
VS21 4 s21 0
V21 e21 s21 DC 82e1
RI21 e21 14 82e-2
VS22 16 s22 0
I22 s22 17 DC 82e-1
VS23 5 s23 0
R23 s23 7 68e1
VS24 20 s24 0
R24 s24 4 12e3
VS25 24 s25 0
R25 s25 2 18e2
VS26 6 s26 0
I26 s26 24 DC 33e-1
VS27 8 s27 0
R27 s27 5 39e0
VS28 15 s28 0
V28 e28 s28 DC 56e0
RI28 e28 10 27e-3
VS29 7 s29 0
R29 s29 11 68e2
VS30 17 s30 0
I30 s30 14 DC 39e-4
VS31 3 s31 0
R31 s31 22 33e0
VS32 23 s32 0
R32 s32 1 68e0
VS33 16 s33 0
I33 s33 25 DC 15e-3
VS34 18 s34 0
R34 s34 16 22e3
VS35 21 s35 0
R35 s35 18 39e-1
VS36 14 s36 0
R36 s36 17 18e1
VS37 15 s37 0
R37 s37 3 27e3
VS38 2 s38 0
R38 s38 14 22e2
VS39 4 s39 0
R39 s39 5 82e0
VS40 18 s40 0
V40 e40 s40 DC 56e1
RI40 e40 1 82e-2
VS41 19 s41 0
R41 s41 12 12e0
VS42 0 s42 0
R42 s42 2 22e0
VS43 5 s43 0
I43 s43 4 DC 18e-2
VS44 6 s44 0
R44 s44 22 82e1
VS45 23 s45 0
R45 s45 6 27e0
VS46 13 s46 0
R46 s46 16 47e2
.control
set numdgt=17
op
print v(1) v(2) v(3) v(4) v(5) v(6) v(7) v(8) v(9) v(10)
print v(11) v(12) v(13) v(14) v(15) v(16) v(17) v(18) v(19) v(20)
print v(21) v(22) v(23) v(24) v(25)
print i(vs0) i(vs1) i(vs2) i(vs3) i(vs4) i(vs5) i(vs6) i(vs7) i(vs8) i(vs9)
print i(vs10) i(vs11) i(vs12) i(vs13) i(vs14) i(vs15) i(vs16) i(vs17) i(vs18) i(vs19)
print i(vs20) i(vs21) i(vs22) i(vs23) i(vs24) i(vs25) i(vs26) i(vs27) i(vs28) i(vs29)
print i(vs30) i(vs31) i(vs32) i(vs33) i(vs34) i(vs35) i(vs36) i(vs37) i(vs38) i(vs39)
print i(vs40) i(vs41) i(vs42) i(vs43) i(vs44) i(vs45) i(vs46)
.endc
.end
