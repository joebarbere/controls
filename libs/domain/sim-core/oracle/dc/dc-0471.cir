controls oracle dc-0471
* Generated (plan F2.7, ADR 0012): do not edit; regenerate with `pnpm sim oracle regen`. dc seed 20261030 index 471 nodes 11 elements 13
.options sparse gmin=1e-12 noopac
RG1 1 0 1000000000000
RG2 2 0 1000000000000
RG3 3 0 1000000000000
RG4 4 0 1000000000000
RG5 5 0 1000000000000
RG6 6 0 1000000000000
RG7 7 0 1000000000000
RG8 8 0 1000000000000
RG9 9 0 1000000000000
RG10 10 0 1000000000000
VS0 8 s0 0
R0 s0 1 68e2
VS1 5 s1 0
R1 s1 1 12e2
VS2 6 s2 0
R2 s2 8 33e3
VS3 2 s3 0
R3 s3 7 12e1
VS4 9 s4 0
R4 s4 1 56e3
VS5 7 s5 0
R5 s5 8 15e0
VS6 2 s6 0
R6 s6 3 22e-2
VS7 2 s7 0
R7 s7 8 39e3
VS8 10 s8 0
R8 s8 0 18e0
VS9 0 s9 0
V9 e9 s9 DC 56e0
RI9 e9 1 22e-1
VS10 1 s10 0
R10 s10 2 27e1
VS11 10 s11 0
I11 s11 8 DC 33e-2
VS12 4 s12 0
V12 e12 s12 DC 33e1
RI12 e12 2 47e-1
.control
set numdgt=17
op
print v(1) v(2) v(3) v(4) v(5) v(6) v(7) v(8) v(9) v(10)
print i(vs0) i(vs1) i(vs2) i(vs3) i(vs4) i(vs5) i(vs6) i(vs7) i(vs8) i(vs9)
print i(vs10) i(vs11) i(vs12)
.endc
.end
