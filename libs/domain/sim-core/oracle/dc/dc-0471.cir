controls oracle dc-0471
* Generated (plan F2.7, ADR 0012): do not edit; regenerate with `pnpm sim oracle regen`. dc seed 20261030 index 471 nodes 11 elements 18
.options sparse gmin=1e-12 noopac
RG1 1 0 1000000000000
RG2 2 0 1000000000000
RG3 3 0 1000000000000
RG4 4 0 1000000000000
RG5 5 0 1000000000000
RG6 6 0 1000000000000
RG7 7 0 1000000000000
RG8 8 0 1000000000000
RG9 9 0 1000000000000
RG10 10 0 1000000000000
VS0 10 s0 0
R0 s0 8 18e0
VS1 3 s1 0
R1 s1 5 68e3
VS2 10 s2 0
I2 s2 4 DC 33e-2
VS3 0 s3 0
V3 e3 s3 DC 33e1
RI3 e3 2 47e-1
VS4 8 s4 0
V4 e4 s4 DC 56e0
RI4 e4 1 22e-1
VS5 1 s5 0
R5 s5 2 27e1
VS6 2 s6 0
R6 s6 3 22e-2
VS7 2 s7 0
R7 s7 7 12e1
VS8 4 s8 0
R8 s8 1 68e2
VS9 6 s9 0
R9 s9 4 33e3
VS10 10 s10 0
V10 e10 s10 DC 56e1
RI10 e10 4 10e-1
VS11 7 s11 0
R11 s11 4 15e0
VS12 2 s12 0
R12 s12 4 39e3
VS13 5 s13 0
R13 s13 6 47e-1
VS14 9 s14 0
R14 s14 1 56e3
VS15 8 s15 0
R15 s15 0 27e1
VS16 10 s16 0
R16 s16 9 10e-2
VS17 5 s17 0
R17 s17 1 12e2
.control
set numdgt=17
op
print v(1) v(2) v(3) v(4) v(5) v(6) v(7) v(8) v(9) v(10)
print i(vs0) i(vs1) i(vs2) i(vs3) i(vs4) i(vs5) i(vs6) i(vs7) i(vs8) i(vs9)
print i(vs10) i(vs11) i(vs12) i(vs13) i(vs14) i(vs15) i(vs16) i(vs17)
.endc
.end
