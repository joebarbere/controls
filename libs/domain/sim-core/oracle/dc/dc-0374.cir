controls oracle dc-0374
* Generated (plan F2.7, ADR 0012): do not edit; regenerate with `pnpm sim oracle regen`. dc seed 20261030 index 374 nodes 29 elements 51
.options sparse gmin=1e-12 noopac
RG1 1 0 1000000000000
RG2 2 0 1000000000000
RG3 3 0 1000000000000
RG4 4 0 1000000000000
RG5 5 0 1000000000000
RG6 6 0 1000000000000
RG7 7 0 1000000000000
RG8 8 0 1000000000000
RG9 9 0 1000000000000
RG10 10 0 1000000000000
RG11 11 0 1000000000000
RG12 12 0 1000000000000
RG13 13 0 1000000000000
RG14 14 0 1000000000000
RG15 15 0 1000000000000
RG16 16 0 1000000000000
RG17 17 0 1000000000000
RG18 18 0 1000000000000
RG19 19 0 1000000000000
RG20 20 0 1000000000000
RG21 21 0 1000000000000
RG22 22 0 1000000000000
RG23 23 0 1000000000000
RG24 24 0 1000000000000
RG25 25 0 1000000000000
RG26 26 0 1000000000000
RG27 27 0 1000000000000
RG28 28 0 1000000000000
VS0 0 s0 0
V0 e0 s0 DC 10e0
RI0 e0 27 22e-2
VS1 7 s1 0
I1 s1 24 DC 47e-4
VS2 17 s2 0
R2 s2 4 56e2
VS3 16 s3 0
R3 s3 18 12e-1
VS4 5 s4 0
R4 s4 22 56e-2
VS5 12 s5 0
I5 s5 17 DC 10e-1
VS6 11 s6 0
R6 s6 18 12e1
VS7 20 s7 0
R7 s7 7 18e3
VS8 13 s8 0
R8 s8 14 47e2
VS9 15 s9 0
R9 s9 4 10e0
VS10 19 s10 0
V10 e10 s10 DC 18e0
RI10 e10 2 10e-2
VS11 21 s11 0
R11 s11 16 47e3
VS12 28 s12 0
R12 s12 19 15e-2
VS13 11 s13 0
I13 s13 13 DC 82e-4
VS14 11 s14 0
R14 s14 9 10e3
VS15 10 s15 0
R15 s15 26 12e0
VS16 12 s16 0
V16 e16 s16 DC 33e0
RI16 e16 16 18e-1
VS17 27 s17 0
I17 s17 21 DC 15e-1
VS18 21 s18 0
R18 s18 10 39e3
VS19 21 s19 0
V19 e19 s19 DC 18e1
RI19 e19 28 56e-3
VS20 22 s20 0
V20 e20 s20 DC 12e1
RI20 e20 14 27e-2
VS21 25 s21 0
R21 s21 16 82e0
VS22 10 s22 0
R22 s22 7 56e0
VS23 12 s23 0
R23 s23 26 12e1
VS24 12 s24 0
V24 e24 s24 DC 68e1
RI24 e24 9 68e-1
VS25 0 s25 0
R25 s25 14 47e1
VS26 11 s26 0
I26 s26 9 DC 15e-3
VS27 13 s27 0
R27 s27 10 27e-2
VS28 20 s28 0
R28 s28 21 68e2
VS29 15 s29 0
R29 s29 7 56e2
VS30 5 s30 0
R30 s30 23 33e-2
VS31 10 s31 0
R31 s31 28 33e-1
VS32 3 s32 0
V32 e32 s32 DC 56e-1
RI32 e32 14 56e-2
VS33 24 s33 0
R33 s33 21 27e2
VS34 6 s34 0
R34 s34 9 82e-1
VS35 5 s35 0
V35 e35 s35 DC 12e1
RI35 e35 19 68e-1
VS36 18 s36 0
R36 s36 23 33e0
VS37 8 s37 0
R37 s37 17 68e0
VS38 28 s38 0
V38 e38 s38 DC 56e0
RI38 e38 27 12e-2
VS39 20 s39 0
R39 s39 18 56e-1
VS40 3 s40 0
R40 s40 5 22e0
VS41 22 s41 0
R41 s41 17 27e0
VS42 16 s42 0
R42 s42 18 68e2
VS43 23 s43 0
R43 s43 12 47e0
VS44 10 s44 0
V44 e44 s44 DC 18e1
RI44 e44 8 22e-1
VS45 25 s45 0
R45 s45 9 22e2
VS46 24 s46 0
R46 s46 1 68e2
VS47 6 s47 0
R47 s47 27 10e-2
VS48 22 s48 0
R48 s48 10 27e1
VS49 10 s49 0
R49 s49 2 18e-2
VS50 3 s50 0
R50 s50 1 15e2
.control
set numdgt=17
op
print v(1) v(2) v(3) v(4) v(5) v(6) v(7) v(8) v(9) v(10)
print v(11) v(12) v(13) v(14) v(15) v(16) v(17) v(18) v(19) v(20)
print v(21) v(22) v(23) v(24) v(25) v(26) v(27) v(28)
print i(vs0) i(vs1) i(vs2) i(vs3) i(vs4) i(vs5) i(vs6) i(vs7) i(vs8) i(vs9)
print i(vs10) i(vs11) i(vs12) i(vs13) i(vs14) i(vs15) i(vs16) i(vs17) i(vs18) i(vs19)
print i(vs20) i(vs21) i(vs22) i(vs23) i(vs24) i(vs25) i(vs26) i(vs27) i(vs28) i(vs29)
print i(vs30) i(vs31) i(vs32) i(vs33) i(vs34) i(vs35) i(vs36) i(vs37) i(vs38) i(vs39)
print i(vs40) i(vs41) i(vs42) i(vs43) i(vs44) i(vs45) i(vs46) i(vs47) i(vs48) i(vs49)
print i(vs50)
.endc
.end
