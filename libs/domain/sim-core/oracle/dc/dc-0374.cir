controls oracle dc-0374
* Generated (plan F2.7, ADR 0012): do not edit; regenerate with `pnpm sim oracle regen`. dc seed 20261030 index 374 nodes 29 elements 45
.options sparse gmin=1e-12 noopac
RG1 1 0 1000000000000
RG2 2 0 1000000000000
RG3 3 0 1000000000000
RG4 4 0 1000000000000
RG5 5 0 1000000000000
RG6 6 0 1000000000000
RG7 7 0 1000000000000
RG8 8 0 1000000000000
RG9 9 0 1000000000000
RG10 10 0 1000000000000
RG11 11 0 1000000000000
RG12 12 0 1000000000000
RG13 13 0 1000000000000
RG14 14 0 1000000000000
RG15 15 0 1000000000000
RG16 16 0 1000000000000
RG17 17 0 1000000000000
RG18 18 0 1000000000000
RG19 19 0 1000000000000
RG20 20 0 1000000000000
RG21 21 0 1000000000000
RG22 22 0 1000000000000
RG23 23 0 1000000000000
RG24 24 0 1000000000000
RG25 25 0 1000000000000
RG26 26 0 1000000000000
RG27 27 0 1000000000000
RG28 28 0 1000000000000
VS0 23 s0 0
R0 s0 12 47e0
VS1 5 s1 0
R1 s1 3 56e-2
VS2 22 s2 0
R2 s2 14 47e1
VS3 5 s3 0
R3 s3 23 33e-2
VS4 0 s4 0
V4 e4 s4 DC 56e-1
RI4 e4 14 56e-2
VS5 6 s5 0
R5 s5 9 82e-1
VS6 25 s6 0
R6 s6 9 22e2
VS7 20 s7 0
R7 s7 18 56e-1
VS8 10 s8 0
R8 s8 28 33e-1
VS9 20 s9 0
R9 s9 7 18e3
VS10 21 s10 0
V10 e10 s10 DC 18e1
RI10 e10 28 56e-3
VS11 3 s11 0
R11 s11 17 27e0
VS12 12 s12 0
V12 e12 s12 DC 33e0
RI12 e12 16 18e-1
VS13 6 s13 0
R13 s13 27 10e-2
VS14 3 s14 0
V14 e14 s14 DC 12e1
RI14 e14 14 27e-2
VS15 27 s15 0
I15 s15 21 DC 15e-1
VS16 10 s16 0
R16 s16 2 18e-2
VS17 28 s17 0
R17 s17 19 15e-2
VS18 24 s18 0
R18 s18 21 27e2
VS19 13 s19 0
R19 s19 10 27e-2
VS20 16 s20 0
R20 s20 18 68e2
VS21 28 s21 0
V21 e21 s21 DC 56e0
RI21 e21 27 12e-2
VS22 10 s22 0
V22 e22 s22 DC 18e1
RI22 e22 8 22e-1
VS23 5 s23 0
V23 e23 s23 DC 12e1
RI23 e23 19 68e-1
VS24 7 s24 0
I24 s24 24 DC 47e-4
VS25 25 s25 0
R25 s25 16 82e0
VS26 18 s26 0
R26 s26 23 33e0
VS27 20 s27 0
R27 s27 21 68e2
VS28 16 s28 0
R28 s28 18 12e-1
VS29 11 s29 0
R29 s29 18 12e1
VS30 12 s30 0
V30 e30 s30 DC 68e1
RI30 e30 9 68e-1
VS31 10 s31 0
R31 s31 7 56e0
VS32 3 s32 0
R32 s32 10 27e1
VS33 12 s33 0
I33 s33 17 DC 10e-1
VS34 21 s34 0
R34 s34 16 47e3
VS35 11 s35 0
I35 s35 9 DC 15e-3
VS36 0 s36 0
R36 s36 5 22e0
VS37 17 s37 0
R37 s37 4 56e2
VS38 0 s38 0
R38 s38 1 15e2
VS39 15 s39 0
R39 s39 4 10e0
VS40 15 s40 0
R40 s40 7 56e2
VS41 10 s41 0
R41 s41 26 12e0
VS42 24 s42 0
R42 s42 1 68e2
VS43 21 s43 0
R43 s43 10 39e3
VS44 11 s44 0
I44 s44 13 DC 82e-4
.control
set numdgt=17
op
print v(1) v(2) v(3) v(4) v(5) v(6) v(7) v(8) v(9) v(10)
print v(11) v(12) v(13) v(14) v(15) v(16) v(17) v(18) v(19) v(20)
print v(21) v(22) v(23) v(24) v(25) v(26) v(27) v(28)
print i(vs0) i(vs1) i(vs2) i(vs3) i(vs4) i(vs5) i(vs6) i(vs7) i(vs8) i(vs9)
print i(vs10) i(vs11) i(vs12) i(vs13) i(vs14) i(vs15) i(vs16) i(vs17) i(vs18) i(vs19)
print i(vs20) i(vs21) i(vs22) i(vs23) i(vs24) i(vs25) i(vs26) i(vs27) i(vs28) i(vs29)
print i(vs30) i(vs31) i(vs32) i(vs33) i(vs34) i(vs35) i(vs36) i(vs37) i(vs38) i(vs39)
print i(vs40) i(vs41) i(vs42) i(vs43) i(vs44)
.endc
.end
