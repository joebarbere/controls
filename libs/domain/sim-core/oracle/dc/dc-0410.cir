controls oracle dc-0410
* Generated (plan F2.7, ADR 0012): do not edit; regenerate with `pnpm sim oracle regen`. dc seed 20261030 index 410 nodes 5 elements 8
.options sparse gmin=1e-12 noopac
RG1 1 0 1000000000000
RG2 2 0 1000000000000
RG3 3 0 1000000000000
RG4 4 0 1000000000000
VS0 4 s0 0
I0 s0 0 DC 47e-4
VS1 1 s1 0
R1 s1 4 22e0
VS2 0 s2 0
R2 s2 3 18e1
VS3 1 s3 0
R3 s3 0 47e3
VS4 2 s4 0
R4 s4 3 10e0
VS5 0 s5 0
I5 s5 4 DC 33e-2
VS6 0 s6 0
V6 e6 s6 DC 18e0
RI6 e6 2 33e-1
VS7 4 s7 0
R7 s7 3 56e-2
.control
set numdgt=17
op
print v(1) v(2) v(3) v(4)
print i(vs0) i(vs1) i(vs2) i(vs3) i(vs4) i(vs5) i(vs6) i(vs7)
.endc
.end
