controls oracle dc-0108
* Generated (plan F2.7, ADR 0012): do not edit; regenerate with `pnpm sim oracle regen`. dc seed 20261030 index 108 nodes 15 elements 25
.options sparse gmin=1e-12 noopac
RG1 1 0 1000000000000
RG2 2 0 1000000000000
RG3 3 0 1000000000000
RG4 4 0 1000000000000
RG5 5 0 1000000000000
RG6 6 0 1000000000000
RG7 7 0 1000000000000
RG8 8 0 1000000000000
RG9 9 0 1000000000000
RG10 10 0 1000000000000
RG11 11 0 1000000000000
RG12 12 0 1000000000000
RG13 13 0 1000000000000
RG14 14 0 1000000000000
VS0 5 s0 0
R0 s0 8 39e3
VS1 0 s1 0
R1 s1 3 39e2
VS2 3 s2 0
R2 s2 10 39e-1
VS3 4 s3 0
R3 s3 0 27e1
VS4 2 s4 0
R4 s4 1 56e-1
VS5 0 s5 0
I5 s5 8 DC 47e-3
VS6 0 s6 0
V6 e6 s6 DC 82e1
RI6 e6 7 47e-3
VS7 14 s7 0
R7 s7 8 56e-2
VS8 2 s8 0
R8 s8 14 33e2
VS9 12 s9 0
R9 s9 4 39e1
VS10 13 s10 0
I10 s10 4 DC 22e-2
VS11 9 s11 0
R11 s11 11 10e0
VS12 7 s12 0
R12 s12 11 10e-2
VS13 11 s13 0
V13 e13 s13 DC 82e-1
RI13 e13 13 27e-2
VS14 12 s14 0
R14 s14 14 15e-1
VS15 1 s15 0
R15 s15 13 12e0
VS16 7 s16 0
R16 s16 12 82e3
VS17 2 s17 0
R17 s17 3 22e-2
VS18 8 s18 0
R18 s18 11 47e1
VS19 8 s19 0
R19 s19 7 18e-1
VS20 7 s20 0
V20 e20 s20 DC 68e1
RI20 e20 6 15e-2
VS21 2 s21 0
R21 s21 13 56e-2
VS22 5 s22 0
R22 s22 3 39e-2
VS23 2 s23 0
R23 s23 10 10e1
VS24 14 s24 0
R24 s24 2 56e0
.control
set numdgt=17
op
print v(1) v(2) v(3) v(4) v(5) v(6) v(7) v(8) v(9) v(10)
print v(11) v(12) v(13) v(14)
print i(vs0) i(vs1) i(vs2) i(vs3) i(vs4) i(vs5) i(vs6) i(vs7) i(vs8) i(vs9)
print i(vs10) i(vs11) i(vs12) i(vs13) i(vs14) i(vs15) i(vs16) i(vs17) i(vs18) i(vs19)
print i(vs20) i(vs21) i(vs22) i(vs23) i(vs24)
.endc
.end
