controls oracle dc-0470
* Generated (plan F2.7, ADR 0012): do not edit; regenerate with `pnpm sim oracle regen`. dc seed 20261030 index 470 nodes 29 elements 39
.options sparse gmin=1e-12 noopac
RG1 1 0 1000000000000
RG2 2 0 1000000000000
RG3 3 0 1000000000000
RG4 4 0 1000000000000
RG5 5 0 1000000000000
RG6 6 0 1000000000000
RG7 7 0 1000000000000
RG8 8 0 1000000000000
RG9 9 0 1000000000000
RG10 10 0 1000000000000
RG11 11 0 1000000000000
RG12 12 0 1000000000000
RG13 13 0 1000000000000
RG14 14 0 1000000000000
RG15 15 0 1000000000000
RG16 16 0 1000000000000
RG17 17 0 1000000000000
RG18 18 0 1000000000000
RG19 19 0 1000000000000
RG20 20 0 1000000000000
RG21 21 0 1000000000000
RG22 22 0 1000000000000
RG23 23 0 1000000000000
RG24 24 0 1000000000000
RG25 25 0 1000000000000
RG26 26 0 1000000000000
RG27 27 0 1000000000000
RG28 28 0 1000000000000
VS0 24 s0 0
R0 s0 26 12e-2
VS1 27 s1 0
R1 s1 10 82e-2
VS2 0 s2 0
V2 e2 s2 DC 56e-1
RI2 e2 6 12e-3
VS3 9 s3 0
V3 e3 s3 DC 15e0
RI3 e3 16 47e-1
VS4 25 s4 0
V4 e4 s4 DC 18e0
RI4 e4 13 39e-2
VS5 23 s5 0
R5 s5 13 68e2
VS6 6 s6 0
R6 s6 21 12e1
VS7 23 s7 0
R7 s7 10 68e3
VS8 7 s8 0
R8 s8 23 82e0
VS9 11 s9 0
V9 e9 s9 DC 39e-1
RI9 e9 28 82e-3
VS10 28 s10 0
R10 s10 2 33e2
VS11 12 s11 0
R11 s11 8 22e1
VS12 22 s12 0
R12 s12 20 68e-1
VS13 4 s13 0
R13 s13 12 15e3
VS14 18 s14 0
R14 s14 25 56e-2
VS15 5 s15 0
R15 s15 13 12e-2
VS16 22 s16 0
R16 s16 5 12e0
VS17 1 s17 0
V17 e17 s17 DC 27e1
RI17 e17 18 56e-2
VS18 17 s18 0
R18 s18 3 18e3
VS19 14 s19 0
V19 e19 s19 DC 27e1
RI19 e19 4 39e-2
VS20 8 s20 0
V20 e20 s20 DC 18e-1
RI20 e20 19 56e-1
VS21 21 s21 0
R21 s21 27 39e-2
VS22 7 s22 0
V22 e22 s22 DC 39e1
RI22 e22 12 56e-2
VS23 18 s23 0
R23 s23 11 12e1
VS24 28 s24 0
R24 s24 1 68e3
VS25 24 s25 0
R25 s25 5 18e0
VS26 3 s26 0
R26 s26 20 47e3
VS27 10 s27 0
R27 s27 19 12e1
VS28 12 s28 0
V28 e28 s28 DC 33e-1
RI28 e28 15 12e-1
VS29 14 s29 0
R29 s29 23 47e-2
VS30 18 s30 0
R30 s30 17 47e0
VS31 9 s31 0
R31 s31 0 22e2
VS32 27 s32 0
R32 s32 22 39e1
VS33 16 s33 0
R33 s33 26 33e-2
VS34 6 s34 0
V34 e34 s34 DC 47e-1
RI34 e34 8 68e-1
VS35 15 s35 0
V35 e35 s35 DC 56e0
RI35 e35 28 68e-2
VS36 0 s36 0
V36 e36 s36 DC 27e1
RI36 e36 2 10e-1
VS37 13 s37 0
R37 s37 1 39e1
VS38 26 s38 0
R38 s38 20 82e2
.control
set numdgt=17
op
print v(1) v(2) v(3) v(4) v(5) v(6) v(7) v(8) v(9) v(10)
print v(11) v(12) v(13) v(14) v(15) v(16) v(17) v(18) v(19) v(20)
print v(21) v(22) v(23) v(24) v(25) v(26) v(27) v(28)
print i(vs0) i(vs1) i(vs2) i(vs3) i(vs4) i(vs5) i(vs6) i(vs7) i(vs8) i(vs9)
print i(vs10) i(vs11) i(vs12) i(vs13) i(vs14) i(vs15) i(vs16) i(vs17) i(vs18) i(vs19)
print i(vs20) i(vs21) i(vs22) i(vs23) i(vs24) i(vs25) i(vs26) i(vs27) i(vs28) i(vs29)
print i(vs30) i(vs31) i(vs32) i(vs33) i(vs34) i(vs35) i(vs36) i(vs37) i(vs38)
.endc
.end
