controls oracle dc-0470
* Generated (plan F2.7, ADR 0012): do not edit; regenerate with `pnpm sim oracle regen`. dc seed 20261030 index 470 nodes 29 elements 29
.options sparse gmin=1e-12 noopac
RG1 1 0 1000000000000
RG2 2 0 1000000000000
RG3 3 0 1000000000000
RG4 4 0 1000000000000
RG5 5 0 1000000000000
RG6 6 0 1000000000000
RG7 7 0 1000000000000
RG8 8 0 1000000000000
RG9 9 0 1000000000000
RG10 10 0 1000000000000
RG11 11 0 1000000000000
RG12 12 0 1000000000000
RG13 13 0 1000000000000
RG14 14 0 1000000000000
RG15 15 0 1000000000000
RG16 16 0 1000000000000
RG17 17 0 1000000000000
RG18 18 0 1000000000000
RG19 19 0 1000000000000
RG20 20 0 1000000000000
RG21 21 0 1000000000000
RG22 22 0 1000000000000
RG23 23 0 1000000000000
RG24 24 0 1000000000000
RG25 25 0 1000000000000
RG26 26 0 1000000000000
RG27 27 0 1000000000000
RG28 28 0 1000000000000
VS0 28 s0 0
R0 s0 1 68e3
VS1 4 s1 0
R1 s1 12 15e3
VS2 18 s2 0
R2 s2 0 12e1
VS3 28 s3 0
R3 s3 2 33e2
VS4 26 s4 0
R4 s4 20 82e2
VS5 18 s5 0
R5 s5 17 47e0
VS6 23 s6 0
R6 s6 11 68e2
VS7 11 s7 0
R7 s7 1 39e1
VS8 0 s8 0
V8 e8 s8 DC 39e-1
RI8 e8 28 82e-3
VS9 10 s9 0
R9 s9 19 12e1
VS10 24 s10 0
R10 s10 26 12e-2
VS11 12 s11 0
R11 s11 8 22e1
VS12 21 s12 0
R12 s12 27 39e-2
VS13 13 s13 0
V13 e13 s13 DC 27e1
RI13 e13 2 10e-1
VS14 14 s14 0
R14 s14 23 47e-2
VS15 13 s15 0
V15 e15 s15 DC 56e-1
RI15 e15 6 12e-3
VS16 23 s16 0
R16 s16 10 68e3
VS17 16 s17 0
R17 s17 26 33e-2
VS18 7 s18 0
R18 s18 23 82e0
VS19 22 s19 0
R19 s19 5 12e0
VS20 1 s20 0
V20 e20 s20 DC 27e1
RI20 e20 18 56e-2
VS21 9 s21 0
R21 s21 13 22e2
VS22 25 s22 0
V22 e22 s22 DC 18e0
RI22 e22 11 39e-2
VS23 14 s23 0
V23 e23 s23 DC 27e1
RI23 e23 4 39e-2
VS24 27 s24 0
R24 s24 10 82e-2
VS25 15 s25 0
V25 e25 s25 DC 56e0
RI25 e25 28 68e-2
VS26 17 s26 0
R26 s26 3 18e3
VS27 24 s27 0
R27 s27 5 18e0
VS28 5 s28 0
R28 s28 11 12e-2
.control
set numdgt=17
op
print v(1) v(2) v(3) v(4) v(5) v(6) v(7) v(8) v(9) v(10)
print v(11) v(12) v(13) v(14) v(15) v(16) v(17) v(18) v(19) v(20)
print v(21) v(22) v(23) v(24) v(25) v(26) v(27) v(28)
print i(vs0) i(vs1) i(vs2) i(vs3) i(vs4) i(vs5) i(vs6) i(vs7) i(vs8) i(vs9)
print i(vs10) i(vs11) i(vs12) i(vs13) i(vs14) i(vs15) i(vs16) i(vs17) i(vs18) i(vs19)
print i(vs20) i(vs21) i(vs22) i(vs23) i(vs24) i(vs25) i(vs26) i(vs27) i(vs28)
.endc
.end
