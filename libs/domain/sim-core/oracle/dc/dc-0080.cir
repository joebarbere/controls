controls oracle dc-0080
* Generated (plan F2.7, ADR 0012): do not edit; regenerate with `pnpm sim oracle regen`. dc seed 20261030 index 80 nodes 7 elements 13
.options sparse gmin=1e-12 noopac
RG1 1 0 1000000000000
RG2 2 0 1000000000000
RG3 3 0 1000000000000
RG4 4 0 1000000000000
RG5 5 0 1000000000000
RG6 6 0 1000000000000
VS0 5 s0 0
R0 s0 4 15e-2
VS1 1 s1 0
I1 s1 2 DC 56e-4
VS2 0 s2 0
V2 e2 s2 DC 82e-1
RI2 e2 3 22e-3
VS3 2 s3 0
R3 s3 1 15e-2
VS4 1 s4 0
R4 s4 3 82e0
VS5 5 s5 0
R5 s5 6 47e1
VS6 1 s6 0
R6 s6 3 15e2
VS7 1 s7 0
R7 s7 5 15e-1
VS8 6 s8 0
R8 s8 2 15e-1
VS9 1 s9 0
I9 s9 0 DC 12e-4
VS10 4 s10 0
R10 s10 0 47e-2
VS11 6 s11 0
I11 s11 0 DC 82e-2
VS12 0 s12 0
R12 s12 1 39e1
.control
set numdgt=17
op
print v(1) v(2) v(3) v(4) v(5) v(6)
print i(vs0) i(vs1) i(vs2) i(vs3) i(vs4) i(vs5) i(vs6) i(vs7) i(vs8) i(vs9)
print i(vs10) i(vs11) i(vs12)
.endc
.end
