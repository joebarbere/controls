controls oracle dc-0080
* Generated (plan F2.7, ADR 0012): do not edit; regenerate with `pnpm sim oracle regen`. dc seed 20261030 index 80 nodes 7 elements 11
.options sparse gmin=1e-12 noopac
RG1 1 0 1000000000000
RG2 2 0 1000000000000
RG3 3 0 1000000000000
RG4 4 0 1000000000000
RG5 5 0 1000000000000
RG6 6 0 1000000000000
VS0 6 s0 0
I0 s0 0 DC 82e-2
VS1 5 s1 0
R1 s1 4 15e-2
VS2 0 s2 0
V2 e2 s2 DC 82e-1
RI2 e2 3 22e-3
VS3 1 s3 0
R3 s3 3 82e0
VS4 6 s4 0
R4 s4 2 15e-1
VS5 1 s5 0
R5 s5 5 15e-1
VS6 1 s6 0
R6 s6 3 15e2
VS7 5 s7 0
R7 s7 6 47e1
VS8 1 s8 0
I8 s8 0 DC 12e-4
VS9 0 s9 0
R9 s9 1 39e1
VS10 1 s10 0
I10 s10 2 DC 56e-4
.control
set numdgt=17
op
print v(1) v(2) v(3) v(4) v(5) v(6)
print i(vs0) i(vs1) i(vs2) i(vs3) i(vs4) i(vs5) i(vs6) i(vs7) i(vs8) i(vs9)
print i(vs10)
.endc
.end
