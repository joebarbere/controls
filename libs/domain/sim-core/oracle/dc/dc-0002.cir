controls oracle dc-0002
* Generated (plan F2.7, ADR 0012): do not edit; regenerate with `pnpm sim oracle regen`. dc seed 20261030 index 2 nodes 30 elements 61
.options sparse gmin=1e-12 noopac
RG1 1 0 1000000000000
RG2 2 0 1000000000000
RG3 3 0 1000000000000
RG4 4 0 1000000000000
RG5 5 0 1000000000000
RG6 6 0 1000000000000
RG7 7 0 1000000000000
RG8 8 0 1000000000000
RG9 9 0 1000000000000
RG10 10 0 1000000000000
RG11 11 0 1000000000000
RG12 12 0 1000000000000
RG13 13 0 1000000000000
RG14 14 0 1000000000000
RG15 15 0 1000000000000
RG16 16 0 1000000000000
RG17 17 0 1000000000000
RG18 18 0 1000000000000
RG19 19 0 1000000000000
RG20 20 0 1000000000000
RG21 21 0 1000000000000
RG22 22 0 1000000000000
RG23 23 0 1000000000000
RG24 24 0 1000000000000
RG25 25 0 1000000000000
RG26 26 0 1000000000000
RG27 27 0 1000000000000
RG28 28 0 1000000000000
RG29 29 0 1000000000000
VS0 0 s0 0
V0 e0 s0 DC 68e1
RI0 e0 20 12e-3
VS1 21 s1 0
R1 s1 25 56e0
VS2 17 s2 0
R2 s2 4 18e-2
VS3 1 s3 0
R3 s3 17 18e-1
VS4 9 s4 0
I4 s4 0 DC 47e-1
VS5 6 s5 0
R5 s5 2 68e-2
VS6 21 s6 0
R6 s6 6 47e1
VS7 13 s7 0
R7 s7 19 18e2
VS8 20 s8 0
R8 s8 14 47e2
VS9 27 s9 0
R9 s9 8 18e3
VS10 1 s10 0
I10 s10 17 DC 47e-4
VS11 9 s11 0
R11 s11 16 47e1
VS12 27 s12 0
R12 s12 25 33e-2
VS13 20 s13 0
I13 s13 17 DC 10e-3
VS14 14 s14 0
R14 s14 9 33e1
VS15 4 s15 0
R15 s15 16 27e3
VS16 26 s16 0
I16 s16 17 DC 15e-1
VS17 21 s17 0
R17 s17 27 18e1
VS18 29 s18 0
I18 s18 1 DC 10e-2
VS19 24 s19 0
V19 e19 s19 DC 10e1
RI19 e19 15 33e-1
VS20 10 s20 0
R20 s20 16 47e0
VS21 17 s21 0
V21 e21 s21 DC 22e0
RI21 e21 7 22e-2
VS22 1 s22 0
R22 s22 10 18e2
VS23 21 s23 0
R23 s23 27 82e-1
VS24 4 s24 0
R24 s24 26 33e-2
VS25 22 s25 0
R25 s25 27 56e-1
VS26 6 s26 0
R26 s26 0 27e-2
VS27 22 s27 0
R27 s27 0 18e-2
VS28 29 s28 0
R28 s28 25 56e3
VS29 9 s29 0
R29 s29 0 33e-2
VS30 18 s30 0
I30 s30 16 DC 56e-3
VS31 2 s31 0
V31 e31 s31 DC 39e1
RI31 e31 29 27e-2
VS32 16 s32 0
R32 s32 28 68e3
VS33 7 s33 0
R33 s33 23 39e0
VS34 13 s34 0
R34 s34 14 27e3
VS35 5 s35 0
R35 s35 8 27e-1
VS36 17 s36 0
V36 e36 s36 DC 33e-1
RI36 e36 11 39e-1
VS37 13 s37 0
R37 s37 21 33e-2
VS38 15 s38 0
I38 s38 17 DC 15e-4
VS39 21 s39 0
R39 s39 18 68e3
VS40 23 s40 0
R40 s40 16 47e2
VS41 12 s41 0
R41 s41 21 12e-2
VS42 8 s42 0
R42 s42 12 10e0
VS43 24 s43 0
R43 s43 3 56e0
VS44 8 s44 0
I44 s44 13 DC 47e-2
VS45 2 s45 0
R45 s45 27 33e1
VS46 15 s46 0
R46 s46 22 68e3
VS47 7 s47 0
R47 s47 3 56e2
VS48 17 s48 0
R48 s48 15 56e2
VS49 23 s49 0
R49 s49 27 33e-1
VS50 16 s50 0
V50 e50 s50 DC 10e1
RI50 e50 17 10e-2
VS51 6 s51 0
I51 s51 16 DC 47e-4
VS52 19 s52 0
V52 e52 s52 DC 27e0
RI52 e52 1 39e-3
VS53 12 s53 0
V53 e53 s53 DC 47e1
RI53 e53 5 68e-2
VS54 27 s54 0
R54 s54 4 10e-2
VS55 18 s55 0
I55 s55 12 DC 68e-2
VS56 18 s56 0
R56 s56 3 12e2
VS57 14 s57 0
R57 s57 12 18e-1
VS58 28 s58 0
R58 s58 22 56e2
VS59 26 s59 0
R59 s59 8 82e3
VS60 21 s60 0
R60 s60 11 12e3
.control
set numdgt=17
op
print v(1) v(2) v(3) v(4) v(5) v(6) v(7) v(8) v(9) v(10)
print v(11) v(12) v(13) v(14) v(15) v(16) v(17) v(18) v(19) v(20)
print v(21) v(22) v(23) v(24) v(25) v(26) v(27) v(28) v(29)
print i(vs0) i(vs1) i(vs2) i(vs3) i(vs4) i(vs5) i(vs6) i(vs7) i(vs8) i(vs9)
print i(vs10) i(vs11) i(vs12) i(vs13) i(vs14) i(vs15) i(vs16) i(vs17) i(vs18) i(vs19)
print i(vs20) i(vs21) i(vs22) i(vs23) i(vs24) i(vs25) i(vs26) i(vs27) i(vs28) i(vs29)
print i(vs30) i(vs31) i(vs32) i(vs33) i(vs34) i(vs35) i(vs36) i(vs37) i(vs38) i(vs39)
print i(vs40) i(vs41) i(vs42) i(vs43) i(vs44) i(vs45) i(vs46) i(vs47) i(vs48) i(vs49)
print i(vs50) i(vs51) i(vs52) i(vs53) i(vs54) i(vs55) i(vs56) i(vs57) i(vs58) i(vs59)
print i(vs60)
.endc
.end
