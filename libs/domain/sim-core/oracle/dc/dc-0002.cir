controls oracle dc-0002
* Generated (plan F2.7, ADR 0012): do not edit; regenerate with `pnpm sim oracle regen`. dc seed 20261030 index 2 nodes 30 elements 59
.options sparse gmin=1e-12 noopac
RG1 1 0 1000000000000
RG2 2 0 1000000000000
RG3 3 0 1000000000000
RG4 4 0 1000000000000
RG5 5 0 1000000000000
RG6 6 0 1000000000000
RG7 7 0 1000000000000
RG8 8 0 1000000000000
RG9 9 0 1000000000000
RG10 10 0 1000000000000
RG11 11 0 1000000000000
RG12 12 0 1000000000000
RG13 13 0 1000000000000
RG14 14 0 1000000000000
RG15 15 0 1000000000000
RG16 16 0 1000000000000
RG17 17 0 1000000000000
RG18 18 0 1000000000000
RG19 19 0 1000000000000
RG20 20 0 1000000000000
RG21 21 0 1000000000000
RG22 22 0 1000000000000
RG23 23 0 1000000000000
RG24 24 0 1000000000000
RG25 25 0 1000000000000
RG26 26 0 1000000000000
RG27 27 0 1000000000000
RG28 28 0 1000000000000
RG29 29 0 1000000000000
VS0 23 s0 0
R0 s0 16 33e-1
VS1 18 s1 0
R1 s1 3 12e2
VS2 7 s2 0
R2 s2 23 39e0
VS3 0 s3 0
V3 e3 s3 DC 10e1
RI3 e3 17 10e-2
VS4 9 s4 0
R4 s4 27 33e-2
VS5 16 s5 0
R5 s5 4 10e-2
VS6 8 s6 0
I6 s6 13 DC 47e-2
VS7 18 s7 0
I7 s7 0 DC 56e-3
VS8 21 s8 0
R8 s8 6 47e1
VS9 2 s9 0
V9 e9 s9 DC 39e1
RI9 e9 29 27e-2
VS10 6 s10 0
R10 s10 2 68e-2
VS11 20 s11 0
I11 s11 17 DC 10e-3
VS12 15 s12 0
R12 s12 22 68e3
VS13 22 s13 0
R13 s13 27 18e-2
VS14 1 s14 0
R14 s14 17 18e-1
VS15 21 s15 0
R15 s15 18 68e3
VS16 18 s16 0
I16 s16 12 DC 68e-2
VS17 14 s17 0
R17 s17 12 18e-1
VS18 17 s18 0
V18 e18 s18 DC 33e-1
RI18 e18 11 39e-1
VS19 6 s19 0
R19 s19 27 27e-2
VS20 22 s20 0
R20 s20 16 56e-1
VS21 16 s21 0
R21 s21 25 33e-2
VS22 10 s22 0
R22 s22 0 47e0
VS23 4 s23 0
R23 s23 26 33e-2
VS24 17 s24 0
R24 s24 4 18e-2
VS25 26 s25 0
I25 s25 17 DC 15e-1
VS26 8 s26 0
R26 s26 12 10e0
VS27 6 s27 0
I27 s27 0 DC 47e-4
VS28 21 s28 0
R28 s28 16 82e-1
VS29 12 s29 0
V29 e29 s29 DC 47e1
RI29 e29 5 68e-2
VS30 26 s30 0
R30 s30 8 82e3
VS31 12 s31 0
R31 s31 21 12e-2
VS32 1 s32 0
R32 s32 10 18e2
VS33 17 s33 0
V33 e33 s33 DC 22e0
RI33 e33 7 22e-2
VS34 17 s34 0
R34 s34 15 56e2
VS35 21 s35 0
R35 s35 25 56e0
VS36 13 s36 0
R36 s36 19 18e2
VS37 29 s37 0
R37 s37 25 56e3
VS38 9 s38 0
R38 s38 0 47e1
VS39 24 s39 0
V39 e39 s39 DC 10e1
RI39 e39 15 33e-1
VS40 28 s40 0
R40 s40 22 56e2
VS41 7 s41 0
R41 s41 3 56e2
VS42 27 s42 0
V42 e42 s42 DC 68e1
RI42 e42 20 12e-3
VS43 29 s43 0
I43 s43 1 DC 10e-2
VS44 23 s44 0
R44 s44 0 47e2
VS45 21 s45 0
R45 s45 16 18e1
VS46 16 s46 0
R46 s46 8 18e3
VS47 24 s47 0
R47 s47 3 56e0
VS48 13 s48 0
R48 s48 14 27e3
VS49 21 s49 0
R49 s49 11 12e3
VS50 13 s50 0
R50 s50 21 33e-2
VS51 4 s51 0
R51 s51 0 27e3
VS52 15 s52 0
I52 s52 17 DC 15e-4
VS53 2 s53 0
R53 s53 16 33e1
VS54 9 s54 0
I54 s54 27 DC 47e-1
VS55 14 s55 0
R55 s55 9 33e1
VS56 1 s56 0
I56 s56 17 DC 47e-4
VS57 19 s57 0
V57 e57 s57 DC 27e0
RI57 e57 1 39e-3
VS58 5 s58 0
R58 s58 8 27e-1
.control
set numdgt=17
op
print v(1) v(2) v(3) v(4) v(5) v(6) v(7) v(8) v(9) v(10)
print v(11) v(12) v(13) v(14) v(15) v(16) v(17) v(18) v(19) v(20)
print v(21) v(22) v(23) v(24) v(25) v(26) v(27) v(28) v(29)
print i(vs0) i(vs1) i(vs2) i(vs3) i(vs4) i(vs5) i(vs6) i(vs7) i(vs8) i(vs9)
print i(vs10) i(vs11) i(vs12) i(vs13) i(vs14) i(vs15) i(vs16) i(vs17) i(vs18) i(vs19)
print i(vs20) i(vs21) i(vs22) i(vs23) i(vs24) i(vs25) i(vs26) i(vs27) i(vs28) i(vs29)
print i(vs30) i(vs31) i(vs32) i(vs33) i(vs34) i(vs35) i(vs36) i(vs37) i(vs38) i(vs39)
print i(vs40) i(vs41) i(vs42) i(vs43) i(vs44) i(vs45) i(vs46) i(vs47) i(vs48) i(vs49)
print i(vs50) i(vs51) i(vs52) i(vs53) i(vs54) i(vs55) i(vs56) i(vs57) i(vs58)
.endc
.end
