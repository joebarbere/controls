controls oracle dc-0204
* Generated (plan F2.7, ADR 0012): do not edit; regenerate with `pnpm sim oracle regen`. dc seed 20261030 index 204 nodes 13 elements 21
.options sparse gmin=1e-12 noopac
RG1 1 0 1000000000000
RG2 2 0 1000000000000
RG3 3 0 1000000000000
RG4 4 0 1000000000000
RG5 5 0 1000000000000
RG6 6 0 1000000000000
RG7 7 0 1000000000000
RG8 8 0 1000000000000
RG9 9 0 1000000000000
RG10 10 0 1000000000000
RG11 11 0 1000000000000
RG12 12 0 1000000000000
VS0 10 s0 0
R0 s0 9 56e-1
VS1 9 s1 0
I1 s1 10 DC 18e-2
VS2 10 s2 0
R2 s2 8 39e3
VS3 0 s3 0
V3 e3 s3 DC 47e1
RI3 e3 10 18e-1
VS4 0 s4 0
R4 s4 3 68e-2
VS5 12 s5 0
R5 s5 10 10e-2
VS6 9 s6 0
R6 s6 11 39e1
VS7 4 s7 0
R7 s7 10 18e2
VS8 1 s8 0
R8 s8 2 12e2
VS9 7 s9 0
R9 s9 4 82e0
VS10 6 s10 0
R10 s10 3 22e-2
VS11 9 s11 0
R11 s11 7 10e0
VS12 4 s12 0
R12 s12 0 82e-2
VS13 7 s13 0
R13 s13 11 15e-2
VS14 10 s14 0
R14 s14 7 22e3
VS15 1 s15 0
R15 s15 8 82e0
VS16 6 s16 0
R16 s16 12 15e-2
VS17 1 s17 0
R17 s17 5 47e1
VS18 10 s18 0
R18 s18 2 39e3
VS19 1 s19 0
R19 s19 4 27e-2
VS20 12 s20 0
R20 s20 5 18e3
.control
set numdgt=17
op
print v(1) v(2) v(3) v(4) v(5) v(6) v(7) v(8) v(9) v(10)
print v(11) v(12)
print i(vs0) i(vs1) i(vs2) i(vs3) i(vs4) i(vs5) i(vs6) i(vs7) i(vs8) i(vs9)
print i(vs10) i(vs11) i(vs12) i(vs13) i(vs14) i(vs15) i(vs16) i(vs17) i(vs18) i(vs19)
print i(vs20)
.endc
.end
