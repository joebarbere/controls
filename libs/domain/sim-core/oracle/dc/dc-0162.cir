controls oracle dc-0162
* Generated (plan F2.7, ADR 0012): do not edit; regenerate with `pnpm sim oracle regen`. dc seed 20261030 index 162 nodes 7 elements 15
.options sparse gmin=1e-12 noopac
RG1 1 0 1000000000000
RG2 2 0 1000000000000
RG3 3 0 1000000000000
RG4 4 0 1000000000000
RG5 5 0 1000000000000
RG6 6 0 1000000000000
VS0 0 s0 0
I0 s0 6 DC 15e-2
VS1 4 s1 0
R1 s1 2 47e-2
VS2 2 s2 0
R2 s2 4 56e2
VS3 3 s3 0
R3 s3 2 15e0
VS4 1 s4 0
R4 s4 4 68e0
VS5 0 s5 0
R5 s5 6 27e0
VS6 0 s6 0
V6 e6 s6 DC 15e1
RI6 e6 6 27e-2
VS7 6 s7 0
V7 e7 s7 DC 39e1
RI7 e7 1 12e-1
VS8 1 s8 0
V8 e8 s8 DC 82e1
RI8 e8 5 12e-1
VS9 5 s9 0
R9 s9 0 22e0
VS10 0 s10 0
R10 s10 2 12e3
VS11 4 s11 0
R11 s11 3 56e-2
VS12 4 s12 0
R12 s12 1 82e1
VS13 5 s13 0
R13 s13 0 47e-1
VS14 2 s14 0
V14 e14 s14 DC 22e1
RI14 e14 1 10e-3
.control
set numdgt=17
op
print v(1) v(2) v(3) v(4) v(5) v(6)
print i(vs0) i(vs1) i(vs2) i(vs3) i(vs4) i(vs5) i(vs6) i(vs7) i(vs8) i(vs9)
print i(vs10) i(vs11) i(vs12) i(vs13) i(vs14)
.endc
.end
