controls oracle dc-0162
* Generated (plan F2.7, ADR 0012): do not edit; regenerate with `pnpm sim oracle regen`. dc seed 20261030 index 162 nodes 7 elements 13
.options sparse gmin=1e-12 noopac
RG1 1 0 1000000000000
RG2 2 0 1000000000000
RG3 3 0 1000000000000
RG4 4 0 1000000000000
RG5 5 0 1000000000000
RG6 6 0 1000000000000
VS0 4 s0 0
R0 s0 2 47e-2
VS1 0 s1 0
R1 s1 6 27e0
VS2 3 s2 0
R2 s2 2 15e0
VS3 5 s3 0
R3 s3 0 47e-1
VS4 0 s4 0
V4 e4 s4 DC 15e1
RI4 e4 6 27e-2
VS5 1 s5 0
V5 e5 s5 DC 82e1
RI5 e5 5 12e-1
VS6 2 s6 0
R6 s6 4 56e2
VS7 2 s7 0
V7 e7 s7 DC 22e1
RI7 e7 1 10e-3
VS8 0 s8 0
R8 s8 2 12e3
VS9 1 s9 0
R9 s9 4 68e0
VS10 5 s10 0
R10 s10 0 22e0
VS11 4 s11 0
R11 s11 1 82e1
VS12 0 s12 0
I12 s12 6 DC 15e-2
.control
set numdgt=17
op
print v(1) v(2) v(3) v(4) v(5) v(6)
print i(vs0) i(vs1) i(vs2) i(vs3) i(vs4) i(vs5) i(vs6) i(vs7) i(vs8) i(vs9)
print i(vs10) i(vs11) i(vs12)
.endc
.end
