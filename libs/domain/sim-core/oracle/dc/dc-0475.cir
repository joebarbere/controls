controls oracle dc-0475
* Generated (plan F2.7, ADR 0012): do not edit; regenerate with `pnpm sim oracle regen`. dc seed 20261030 index 475 nodes 10 elements 16
.options sparse gmin=1e-12 noopac
RG1 1 0 1000000000000
RG2 2 0 1000000000000
RG3 3 0 1000000000000
RG4 4 0 1000000000000
RG5 5 0 1000000000000
RG6 6 0 1000000000000
RG7 7 0 1000000000000
RG8 8 0 1000000000000
RG9 9 0 1000000000000
VS0 3 s0 0
R0 s0 1 56e2
VS1 9 s1 0
R1 s1 0 47e2
VS2 4 s2 0
R2 s2 2 33e2
VS3 8 s3 0
R3 s3 9 68e3
VS4 8 s4 0
R4 s4 7 27e-1
VS5 8 s5 0
R5 s5 4 27e2
VS6 3 s6 0
R6 s6 9 47e-1
VS7 7 s7 0
R7 s7 1 12e0
VS8 7 s8 0
R8 s8 0 56e2
VS9 0 s9 0
R9 s9 1 82e-1
VS10 6 s10 0
R10 s10 5 39e-2
VS11 5 s11 0
R11 s11 1 22e3
VS12 9 s12 0
R12 s12 6 18e-1
VS13 0 s13 0
V13 e13 s13 DC 68e1
RI13 e13 8 12e-2
VS14 9 s14 0
R14 s14 7 68e2
VS15 1 s15 0
R15 s15 2 18e1
.control
set numdgt=17
op
print v(1) v(2) v(3) v(4) v(5) v(6) v(7) v(8) v(9)
print i(vs0) i(vs1) i(vs2) i(vs3) i(vs4) i(vs5) i(vs6) i(vs7) i(vs8) i(vs9)
print i(vs10) i(vs11) i(vs12) i(vs13) i(vs14) i(vs15)
.endc
.end
