controls oracle dc-0012
* Generated (plan F2.7, ADR 0012): do not edit; regenerate with `pnpm sim oracle regen`. dc seed 20261030 index 12 nodes 7 elements 13
.options sparse gmin=1e-12 noopac
RG1 1 0 1000000000000
RG2 2 0 1000000000000
RG3 3 0 1000000000000
RG4 4 0 1000000000000
RG5 5 0 1000000000000
RG6 6 0 1000000000000
VS0 4 s0 0
R0 s0 3 12e2
VS1 0 s1 0
I1 s1 3 DC 15e-1
VS2 5 s2 0
R2 s2 1 33e-2
VS3 4 s3 0
R3 s3 5 47e2
VS4 0 s4 0
I4 s4 3 DC 18e-4
VS5 4 s5 0
R5 s5 6 56e1
VS6 5 s6 0
I6 s6 2 DC 39e-4
VS7 1 s7 0
R7 s7 5 27e1
VS8 2 s8 0
R8 s8 0 82e3
VS9 5 s9 0
R9 s9 3 82e2
VS10 1 s10 0
R10 s10 3 15e-2
VS11 2 s11 0
R11 s11 0 22e2
VS12 0 s12 0
V12 e12 s12 DC 33e1
RI12 e12 3 10e-3
.control
set numdgt=17
op
print v(1) v(2) v(3) v(4) v(5) v(6)
print i(vs0) i(vs1) i(vs2) i(vs3) i(vs4) i(vs5) i(vs6) i(vs7) i(vs8) i(vs9)
print i(vs10) i(vs11) i(vs12)
.endc
.end
