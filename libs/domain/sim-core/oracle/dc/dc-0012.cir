controls oracle dc-0012
* Generated (plan F2.7, ADR 0012): do not edit; regenerate with `pnpm sim oracle regen`. dc seed 20261030 index 12 nodes 7 elements 15
.options sparse gmin=1e-12 noopac
RG1 1 0 1000000000000
RG2 2 0 1000000000000
RG3 3 0 1000000000000
RG4 4 0 1000000000000
RG5 5 0 1000000000000
RG6 6 0 1000000000000
VS0 5 s0 0
R0 s0 1 33e-2
VS1 4 s1 0
R1 s1 2 47e2
VS2 0 s2 0
I2 s2 3 DC 15e-1
VS3 5 s3 0
R3 s3 3 82e2
VS4 2 s4 0
R4 s4 0 82e3
VS5 2 s5 0
R5 s5 0 22e2
VS6 4 s6 0
R6 s6 3 12e2
VS7 1 s7 0
R7 s7 6 18e3
VS8 0 s8 0
V8 e8 s8 DC 33e1
RI8 e8 3 10e-3
VS9 4 s9 0
R9 s9 5 47e2
VS10 1 s10 0
R10 s10 3 15e-2
VS11 5 s11 0
I11 s11 2 DC 39e-4
VS12 1 s12 0
R12 s12 5 27e1
VS13 4 s13 0
R13 s13 6 56e1
VS14 0 s14 0
I14 s14 3 DC 18e-4
.control
set numdgt=17
op
print v(1) v(2) v(3) v(4) v(5) v(6)
print i(vs0) i(vs1) i(vs2) i(vs3) i(vs4) i(vs5) i(vs6) i(vs7) i(vs8) i(vs9)
print i(vs10) i(vs11) i(vs12) i(vs13) i(vs14)
.endc
.end
