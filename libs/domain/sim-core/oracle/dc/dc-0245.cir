controls oracle dc-0245
* Generated (plan F2.7, ADR 0012): do not edit; regenerate with `pnpm sim oracle regen`. dc seed 20261030 index 245 nodes 6 elements 6
.options sparse gmin=1e-12 noopac
RG1 1 0 1000000000000
RG2 2 0 1000000000000
RG3 3 0 1000000000000
RG4 4 0 1000000000000
RG5 5 0 1000000000000
VS0 2 s0 0
R0 s0 0 47e1
VS1 0 s1 0
V1 e1 s1 DC 47e1
RI1 e1 5 27e-3
VS2 5 s2 0
R2 s2 3 56e-2
VS3 3 s3 0
V3 e3 s3 DC 18e0
RI3 e3 4 15e-3
VS4 1 s4 0
R4 s4 5 68e0
VS5 5 s5 0
R5 s5 0 33e0
.control
set numdgt=17
op
print v(1) v(2) v(3) v(4) v(5)
print i(vs0) i(vs1) i(vs2) i(vs3) i(vs4) i(vs5)
.endc
.end
