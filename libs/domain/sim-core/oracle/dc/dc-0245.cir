controls oracle dc-0245
* Generated (plan F2.7, ADR 0012): do not edit; regenerate with `pnpm sim oracle regen`. dc seed 20261030 index 245 nodes 6 elements 7
.options sparse gmin=1e-12 noopac
RG1 1 0 1000000000000
RG2 2 0 1000000000000
RG3 3 0 1000000000000
RG4 4 0 1000000000000
RG5 5 0 1000000000000
VS0 0 s0 0
V0 e0 s0 DC 47e1
RI0 e0 5 27e-3
VS1 3 s1 0
V1 e1 s1 DC 18e0
RI1 e1 4 15e-3
VS2 2 s2 0
R2 s2 0 47e1
VS3 1 s3 0
R3 s3 5 68e0
VS4 2 s4 0
V4 e4 s4 DC 82e0
RI4 e4 1 12e-1
VS5 5 s5 0
R5 s5 3 56e-2
VS6 1 s6 0
V6 e6 s6 DC 56e1
RI6 e6 4 10e-3
.control
set numdgt=17
op
print v(1) v(2) v(3) v(4) v(5)
print i(vs0) i(vs1) i(vs2) i(vs3) i(vs4) i(vs5) i(vs6)
.endc
.end
