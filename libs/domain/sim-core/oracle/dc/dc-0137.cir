controls oracle dc-0137
* Generated (plan F2.7, ADR 0012): do not edit; regenerate with `pnpm sim oracle regen`. dc seed 20261030 index 137 nodes 20 elements 24
.options sparse gmin=1e-12 noopac
RG1 1 0 1000000000000
RG2 2 0 1000000000000
RG3 3 0 1000000000000
RG4 4 0 1000000000000
RG5 5 0 1000000000000
RG6 6 0 1000000000000
RG7 7 0 1000000000000
RG8 8 0 1000000000000
RG9 9 0 1000000000000
RG10 10 0 1000000000000
RG11 11 0 1000000000000
RG12 12 0 1000000000000
RG13 13 0 1000000000000
RG14 14 0 1000000000000
RG15 15 0 1000000000000
RG16 16 0 1000000000000
RG17 17 0 1000000000000
RG18 18 0 1000000000000
RG19 19 0 1000000000000
VS0 8 s0 0
R0 s0 15 10e1
VS1 0 s1 0
V1 e1 s1 DC 15e1
RI1 e1 7 33e-2
VS2 9 s2 0
R2 s2 2 39e2
VS3 4 s3 0
R3 s3 2 39e0
VS4 14 s4 0
R4 s4 10 82e3
VS5 16 s5 0
R5 s5 19 15e-2
VS6 9 s6 0
R6 s6 5 47e0
VS7 12 s7 0
R7 s7 10 56e2
VS8 7 s8 0
V8 e8 s8 DC 56e-1
RI8 e8 8 56e-1
VS9 8 s9 0
R9 s9 7 82e-2
VS10 13 s10 0
V10 e10 s10 DC 10e1
RI10 e10 3 39e-1
VS11 18 s11 0
V11 e11 s11 DC 33e-1
RI11 e11 11 10e-2
VS12 16 s12 0
V12 e12 s12 DC 22e1
RI12 e12 7 27e-1
VS13 9 s13 0
V13 e13 s13 DC 22e0
RI13 e13 13 12e-2
VS14 12 s14 0
I14 s14 3 DC 33e-1
VS15 2 s15 0
I15 s15 18 DC 47e-3
VS16 3 s16 0
R16 s16 2 10e-1
VS17 7 s17 0
R17 s17 18 82e0
VS18 17 s18 0
R18 s18 13 68e0
VS19 6 s19 0
V19 e19 s19 DC 56e-1
RI19 e19 4 15e-1
VS20 3 s20 0
R20 s20 10 68e1
VS21 1 s21 0
R21 s21 6 39e3
VS22 18 s22 0
R22 s22 3 56e2
VS23 7 s23 0
R23 s23 15 22e-2
.control
set numdgt=17
op
print v(1) v(2) v(3) v(4) v(5) v(6) v(7) v(8) v(9) v(10)
print v(11) v(12) v(13) v(14) v(15) v(16) v(17) v(18) v(19)
print i(vs0) i(vs1) i(vs2) i(vs3) i(vs4) i(vs5) i(vs6) i(vs7) i(vs8) i(vs9)
print i(vs10) i(vs11) i(vs12) i(vs13) i(vs14) i(vs15) i(vs16) i(vs17) i(vs18) i(vs19)
print i(vs20) i(vs21) i(vs22) i(vs23)
.endc
.end
