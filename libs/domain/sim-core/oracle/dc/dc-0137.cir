controls oracle dc-0137
* Generated (plan F2.7, ADR 0012): do not edit; regenerate with `pnpm sim oracle regen`. dc seed 20261030 index 137 nodes 20 elements 32
.options sparse gmin=1e-12 noopac
RG1 1 0 1000000000000
RG2 2 0 1000000000000
RG3 3 0 1000000000000
RG4 4 0 1000000000000
RG5 5 0 1000000000000
RG6 6 0 1000000000000
RG7 7 0 1000000000000
RG8 8 0 1000000000000
RG9 9 0 1000000000000
RG10 10 0 1000000000000
RG11 11 0 1000000000000
RG12 12 0 1000000000000
RG13 13 0 1000000000000
RG14 14 0 1000000000000
RG15 15 0 1000000000000
RG16 16 0 1000000000000
RG17 17 0 1000000000000
RG18 18 0 1000000000000
RG19 19 0 1000000000000
VS0 0 s0 0
V0 e0 s0 DC 15e0
RI0 e0 12 82e-2
VS1 9 s1 0
V1 e1 s1 DC 22e0
RI1 e1 11 12e-2
VS2 6 s2 0
V2 e2 s2 DC 56e-1
RI2 e2 4 15e-1
VS3 11 s3 0
V3 e3 s3 DC 10e1
RI3 e3 3 39e-1
VS4 4 s4 0
R4 s4 2 39e0
VS5 3 s5 0
V5 e5 s5 DC 47e-1
RI5 e5 19 22e-1
VS6 1 s6 0
V6 e6 s6 DC 39e1
RI6 e6 12 27e-2
VS7 3 s7 0
R7 s7 2 10e-1
VS8 17 s8 0
R8 s8 11 68e0
VS9 16 s9 0
R9 s9 19 15e-2
VS10 1 s10 0
R10 s10 10 82e1
VS11 9 s11 0
R11 s11 5 47e0
VS12 1 s12 0
R12 s12 6 39e3
VS13 7 s13 0
R13 s13 15 22e-2
VS14 7 s14 0
V14 e14 s14 DC 56e-1
RI14 e14 8 56e-1
VS15 7 s15 0
R15 s15 18 82e0
VS16 3 s16 0
R16 s16 10 68e1
VS17 16 s17 0
V17 e17 s17 DC 22e1
RI17 e17 7 27e-1
VS18 14 s18 0
R18 s18 10 82e3
VS19 13 s19 0
R19 s19 1 33e3
VS20 12 s20 0
R20 s20 10 56e2
VS21 12 s21 0
I21 s21 3 DC 33e-1
VS22 18 s22 0
R22 s22 3 56e2
VS23 15 s23 0
V23 e23 s23 DC 12e0
RI23 e23 14 39e-3
VS24 18 s24 0
V24 e24 s24 DC 33e-1
RI24 e24 0 10e-2
VS25 8 s25 0
R25 s25 15 10e1
VS26 8 s26 0
R26 s26 7 82e-2
VS27 9 s27 0
R27 s27 2 39e2
VS28 13 s28 0
V28 e28 s28 DC 15e1
RI28 e28 7 33e-2
VS29 2 s29 0
I29 s29 18 DC 47e-3
VS30 13 s30 0
R30 s30 5 10e2
VS31 10 s31 0
R31 s31 17 68e3
.control
set numdgt=17
op
print v(1) v(2) v(3) v(4) v(5) v(6) v(7) v(8) v(9) v(10)
print v(11) v(12) v(13) v(14) v(15) v(16) v(17) v(18) v(19)
print i(vs0) i(vs1) i(vs2) i(vs3) i(vs4) i(vs5) i(vs6) i(vs7) i(vs8) i(vs9)
print i(vs10) i(vs11) i(vs12) i(vs13) i(vs14) i(vs15) i(vs16) i(vs17) i(vs18) i(vs19)
print i(vs20) i(vs21) i(vs22) i(vs23) i(vs24) i(vs25) i(vs26) i(vs27) i(vs28) i(vs29)
print i(vs30) i(vs31)
.endc
.end
