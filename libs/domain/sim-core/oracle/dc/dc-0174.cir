controls oracle dc-0174
* Generated (plan F2.7, ADR 0012): do not edit; regenerate with `pnpm sim oracle regen`. dc seed 20261030 index 174 nodes 13 elements 19
.options sparse gmin=1e-12 noopac
RG1 1 0 1000000000000
RG2 2 0 1000000000000
RG3 3 0 1000000000000
RG4 4 0 1000000000000
RG5 5 0 1000000000000
RG6 6 0 1000000000000
RG7 7 0 1000000000000
RG8 8 0 1000000000000
RG9 9 0 1000000000000
RG10 10 0 1000000000000
RG11 11 0 1000000000000
RG12 12 0 1000000000000
VS0 7 s0 0
R0 s0 11 82e-2
VS1 5 s1 0
R1 s1 2 12e0
VS2 0 s2 0
V2 e2 s2 DC 56e0
RI2 e2 5 18e-1
VS3 2 s3 0
R3 s3 3 68e3
VS4 2 s4 0
R4 s4 1 47e3
VS5 8 s5 0
R5 s5 12 68e1
VS6 2 s6 0
R6 s6 9 82e-1
VS7 4 s7 0
R7 s7 2 68e-2
VS8 10 s8 0
R8 s8 6 18e-1
VS9 8 s9 0
R9 s9 0 47e2
VS10 12 s10 0
R10 s10 4 10e-2
VS11 6 s11 0
R11 s11 12 68e-1
VS12 11 s12 0
R12 s12 9 18e3
VS13 3 s13 0
R13 s13 4 47e-2
VS14 8 s14 0
R14 s14 10 33e2
VS15 7 s15 0
R15 s15 8 33e3
VS16 0 s16 0
V16 e16 s16 DC 10e1
RI16 e16 12 82e-3
VS17 0 s17 0
I17 s17 10 DC 12e-3
VS18 1 s18 0
R18 s18 8 27e1
.control
set numdgt=17
op
print v(1) v(2) v(3) v(4) v(5) v(6) v(7) v(8) v(9) v(10)
print v(11) v(12)
print i(vs0) i(vs1) i(vs2) i(vs3) i(vs4) i(vs5) i(vs6) i(vs7) i(vs8) i(vs9)
print i(vs10) i(vs11) i(vs12) i(vs13) i(vs14) i(vs15) i(vs16) i(vs17) i(vs18)
.endc
.end
