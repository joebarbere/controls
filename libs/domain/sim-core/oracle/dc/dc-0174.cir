controls oracle dc-0174
* Generated (plan F2.7, ADR 0012): do not edit; regenerate with `pnpm sim oracle regen`. dc seed 20261030 index 174 nodes 13 elements 15
.options sparse gmin=1e-12 noopac
RG1 1 0 1000000000000
RG2 2 0 1000000000000
RG3 3 0 1000000000000
RG4 4 0 1000000000000
RG5 5 0 1000000000000
RG6 6 0 1000000000000
RG7 7 0 1000000000000
RG8 8 0 1000000000000
RG9 9 0 1000000000000
RG10 10 0 1000000000000
RG11 11 0 1000000000000
RG12 12 0 1000000000000
VS0 12 s0 0
R0 s0 4 10e-2
VS1 8 s1 0
R1 s1 2 47e2
VS2 8 s2 0
R2 s2 10 33e2
VS3 7 s3 0
R3 s3 8 33e3
VS4 4 s4 0
R4 s4 0 68e-2
VS5 5 s5 0
R5 s5 0 12e0
VS6 2 s6 0
I6 s6 10 DC 12e-3
VS7 0 s7 0
R7 s7 9 82e-1
VS8 1 s8 0
R8 s8 8 27e1
VS9 0 s9 0
R9 s9 1 47e3
VS10 10 s10 0
R10 s10 6 18e-1
VS11 8 s11 0
R11 s11 12 68e1
VS12 11 s12 0
R12 s12 9 18e3
VS13 3 s13 0
R13 s13 4 47e-2
VS14 6 s14 0
R14 s14 12 68e-1
.control
set numdgt=17
op
print v(1) v(2) v(3) v(4) v(5) v(6) v(7) v(8) v(9) v(10)
print v(11) v(12)
print i(vs0) i(vs1) i(vs2) i(vs3) i(vs4) i(vs5) i(vs6) i(vs7) i(vs8) i(vs9)
print i(vs10) i(vs11) i(vs12) i(vs13) i(vs14)
.endc
.end
