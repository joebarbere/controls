controls oracle dc-0328
* Generated (plan F2.7, ADR 0012): do not edit; regenerate with `pnpm sim oracle regen`. dc seed 20261030 index 328 nodes 4 elements 7
.options sparse gmin=1e-12 noopac
RG1 1 0 1000000000000
RG2 2 0 1000000000000
RG3 3 0 1000000000000
VS0 0 s0 0
R0 s0 2 39e0
VS1 0 s1 0
R1 s1 1 12e-1
VS2 2 s2 0
I2 s2 3 DC 15e-4
VS3 0 s3 0
V3 e3 s3 DC 39e1
RI3 e3 2 82e-2
VS4 1 s4 0
R4 s4 0 12e3
VS5 0 s5 0
I5 s5 1 DC 56e-3
VS6 0 s6 0
R6 s6 3 27e-1
.control
set numdgt=17
op
print v(1) v(2) v(3)
print i(vs0) i(vs1) i(vs2) i(vs3) i(vs4) i(vs5) i(vs6)
.endc
.end
