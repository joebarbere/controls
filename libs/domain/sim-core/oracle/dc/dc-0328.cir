controls oracle dc-0328
* Generated (plan F2.7, ADR 0012): do not edit; regenerate with `pnpm sim oracle regen`. dc seed 20261030 index 328 nodes 4 elements 9
.options sparse gmin=1e-12 noopac
RG1 1 0 1000000000000
RG2 2 0 1000000000000
RG3 3 0 1000000000000
VS0 1 s0 0
R0 s0 0 12e3
VS1 2 s1 0
I1 s1 3 DC 15e-4
VS2 0 s2 0
V2 e2 s2 DC 39e1
RI2 e2 2 82e-2
VS3 2 s3 0
V3 e3 s3 DC 68e0
RI3 e3 3 82e-3
VS4 3 s4 0
R4 s4 1 15e-1
VS5 0 s5 0
I5 s5 1 DC 56e-3
VS6 0 s6 0
R6 s6 2 39e0
VS7 0 s7 0
R7 s7 1 12e-1
VS8 0 s8 0
R8 s8 3 27e-1
.control
set numdgt=17
op
print v(1) v(2) v(3)
print i(vs0) i(vs1) i(vs2) i(vs3) i(vs4) i(vs5) i(vs6) i(vs7) i(vs8)
.endc
.end
