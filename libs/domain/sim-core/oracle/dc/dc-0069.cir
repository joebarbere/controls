controls oracle dc-0069
* Generated (plan F2.7, ADR 0012): do not edit; regenerate with `pnpm sim oracle regen`. dc seed 20261030 index 69 nodes 5 elements 8
.options sparse gmin=1e-12 noopac
RG1 1 0 1000000000000
RG2 2 0 1000000000000
RG3 3 0 1000000000000
RG4 4 0 1000000000000
VS0 1 s0 0
R0 s0 3 68e-2
VS1 0 s1 0
V1 e1 s1 DC 33e-1
RI1 e1 4 33e-1
VS2 2 s2 0
R2 s2 0 39e-1
VS3 0 s3 0
V3 e3 s3 DC 56e1
RI3 e3 1 82e-1
VS4 2 s4 0
R4 s4 3 56e-2
VS5 0 s5 0
R5 s5 3 68e0
VS6 0 s6 0
R6 s6 2 47e-2
VS7 3 s7 0
R7 s7 4 27e-2
.control
set numdgt=17
op
print v(1) v(2) v(3) v(4)
print i(vs0) i(vs1) i(vs2) i(vs3) i(vs4) i(vs5) i(vs6) i(vs7)
.endc
.end
