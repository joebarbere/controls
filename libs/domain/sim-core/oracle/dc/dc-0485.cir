controls oracle dc-0485
* Generated (plan F2.7, ADR 0012): do not edit; regenerate with `pnpm sim oracle regen`. dc seed 20261030 index 485 nodes 11 elements 21
.options sparse gmin=1e-12 noopac
RG1 1 0 1000000000000
RG2 2 0 1000000000000
RG3 3 0 1000000000000
RG4 4 0 1000000000000
RG5 5 0 1000000000000
RG6 6 0 1000000000000
RG7 7 0 1000000000000
RG8 8 0 1000000000000
RG9 9 0 1000000000000
RG10 10 0 1000000000000
VS0 0 s0 0
V0 e0 s0 DC 68e-1
RI0 e0 3 33e-1
VS1 8 s1 0
V1 e1 s1 DC 18e1
RI1 e1 0 15e-3
VS2 4 s2 0
V2 e2 s2 DC 56e1
RI2 e2 8 10e-1
VS3 4 s3 0
R3 s3 0 15e1
VS4 0 s4 0
R4 s4 4 56e1
VS5 4 s5 0
R5 s5 3 15e-1
VS6 6 s6 0
R6 s6 1 68e-2
VS7 10 s7 0
V7 e7 s7 DC 33e1
RI7 e7 2 10e-3
VS8 7 s8 0
V8 e8 s8 DC 68e-1
RI8 e8 9 22e-2
VS9 9 s9 0
R9 s9 8 68e1
VS10 6 s10 0
I10 s10 2 DC 39e-3
VS11 6 s11 0
R11 s11 2 33e0
VS12 8 s12 0
R12 s12 10 22e-1
VS13 9 s13 0
R13 s13 6 18e-1
VS14 0 s14 0
R14 s14 1 15e-2
VS15 9 s15 0
R15 s15 10 68e3
VS16 2 s16 0
R16 s16 7 10e-2
VS17 1 s17 0
R17 s17 3 18e2
VS18 1 s18 0
R18 s18 8 47e3
VS19 0 s19 0
R19 s19 6 56e0
VS20 5 s20 0
V20 e20 s20 DC 15e0
RI20 e20 3 27e-2
.control
set numdgt=17
op
print v(1) v(2) v(3) v(4) v(5) v(6) v(7) v(8) v(9) v(10)
print i(vs0) i(vs1) i(vs2) i(vs3) i(vs4) i(vs5) i(vs6) i(vs7) i(vs8) i(vs9)
print i(vs10) i(vs11) i(vs12) i(vs13) i(vs14) i(vs15) i(vs16) i(vs17) i(vs18) i(vs19)
print i(vs20)
.endc
.end
