controls oracle dc-0485
* Generated (plan F2.7, ADR 0012): do not edit; regenerate with `pnpm sim oracle regen`. dc seed 20261030 index 485 nodes 11 elements 22
.options sparse gmin=1e-12 noopac
RG1 1 0 1000000000000
RG2 2 0 1000000000000
RG3 3 0 1000000000000
RG4 4 0 1000000000000
RG5 5 0 1000000000000
RG6 6 0 1000000000000
RG7 7 0 1000000000000
RG8 8 0 1000000000000
RG9 9 0 1000000000000
RG10 10 0 1000000000000
VS0 0 s0 0
V0 e0 s0 DC 68e-1
RI0 e0 9 22e-2
VS1 8 s1 0
V1 e1 s1 DC 18e1
RI1 e1 7 15e-3
VS2 9 s2 0
R2 s2 8 68e1
VS3 6 s3 0
I3 s3 2 DC 39e-3
VS4 4 s4 0
R4 s4 7 15e1
VS5 7 s5 0
R5 s5 4 56e1
VS6 0 s6 0
R6 s6 5 33e1
VS7 1 s7 0
R7 s7 3 18e2
VS8 7 s8 0
R8 s8 6 56e0
VS9 9 s9 0
R9 s9 6 18e-1
VS10 8 s10 0
R10 s10 10 22e-1
VS11 7 s11 0
V11 e11 s11 DC 68e-1
RI11 e11 3 33e-1
VS12 5 s12 0
V12 e12 s12 DC 15e0
RI12 e12 3 27e-2
VS13 1 s13 0
R13 s13 8 47e3
VS14 2 s14 0
R14 s14 0 10e-2
VS15 7 s15 0
R15 s15 1 15e-2
VS16 6 s16 0
R16 s16 2 33e0
VS17 6 s17 0
R17 s17 1 68e-2
VS18 4 s18 0
R18 s18 3 15e-1
VS19 4 s19 0
V19 e19 s19 DC 56e1
RI19 e19 8 10e-1
VS20 9 s20 0
R20 s20 10 68e3
VS21 10 s21 0
V21 e21 s21 DC 33e1
RI21 e21 2 10e-3
.control
set numdgt=17
op
print v(1) v(2) v(3) v(4) v(5) v(6) v(7) v(8) v(9) v(10)
print i(vs0) i(vs1) i(vs2) i(vs3) i(vs4) i(vs5) i(vs6) i(vs7) i(vs8) i(vs9)
print i(vs10) i(vs11) i(vs12) i(vs13) i(vs14) i(vs15) i(vs16) i(vs17) i(vs18) i(vs19)
print i(vs20) i(vs21)
.endc
.end
