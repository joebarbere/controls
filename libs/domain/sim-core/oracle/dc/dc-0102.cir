controls oracle dc-0102
* Generated (plan F2.7, ADR 0012): do not edit; regenerate with `pnpm sim oracle regen`. dc seed 20261030 index 102 nodes 21 elements 28
.options sparse gmin=1e-12 noopac
RG1 1 0 1000000000000
RG2 2 0 1000000000000
RG3 3 0 1000000000000
RG4 4 0 1000000000000
RG5 5 0 1000000000000
RG6 6 0 1000000000000
RG7 7 0 1000000000000
RG8 8 0 1000000000000
RG9 9 0 1000000000000
RG10 10 0 1000000000000
RG11 11 0 1000000000000
RG12 12 0 1000000000000
RG13 13 0 1000000000000
RG14 14 0 1000000000000
RG15 15 0 1000000000000
RG16 16 0 1000000000000
RG17 17 0 1000000000000
RG18 18 0 1000000000000
RG19 19 0 1000000000000
RG20 20 0 1000000000000
VS0 0 s0 0
V0 e0 s0 DC 12e-1
RI0 e0 1 22e-2
VS1 1 s1 0
R1 s1 17 18e-2
VS2 20 s2 0
R2 s2 8 39e1
VS3 4 s3 0
V3 e3 s3 DC 22e0
RI3 e3 6 27e-3
VS4 9 s4 0
R4 s4 10 82e1
VS5 20 s5 0
R5 s5 7 47e0
VS6 6 s6 0
R6 s6 2 18e2
VS7 16 s7 0
R7 s7 17 10e2
VS8 5 s8 0
V8 e8 s8 DC 15e-1
RI8 e8 6 82e-1
VS9 8 s9 0
R9 s9 19 27e-2
VS10 9 s10 0
R10 s10 11 39e0
VS11 17 s11 0
R11 s11 5 10e2
VS12 18 s12 0
R12 s12 15 18e0
VS13 14 s13 0
R13 s13 15 68e3
VS14 1 s14 0
V14 e14 s14 DC 33e-1
RI14 e14 18 10e-3
VS15 3 s15 0
V15 e15 s15 DC 33e0
RI15 e15 8 15e-1
VS16 7 s16 0
R16 s16 5 15e-1
VS17 15 s17 0
R17 s17 13 15e1
VS18 9 s18 0
V18 e18 s18 DC 68e-1
RI18 e18 6 27e-2
VS19 2 s19 0
R19 s19 10 12e-2
VS20 3 s20 0
R20 s20 16 82e3
VS21 11 s21 0
R21 s21 13 27e1
VS22 6 s22 0
R22 s22 15 47e-1
VS23 14 s23 0
R23 s23 12 15e1
VS24 0 s24 0
R24 s24 5 39e1
VS25 19 s25 0
R25 s25 4 18e3
VS26 1 s26 0
R26 s26 20 18e3
VS27 12 s27 0
R27 s27 6 27e2
.control
set numdgt=17
op
print v(1) v(2) v(3) v(4) v(5) v(6) v(7) v(8) v(9) v(10)
print v(11) v(12) v(13) v(14) v(15) v(16) v(17) v(18) v(19) v(20)
print i(vs0) i(vs1) i(vs2) i(vs3) i(vs4) i(vs5) i(vs6) i(vs7) i(vs8) i(vs9)
print i(vs10) i(vs11) i(vs12) i(vs13) i(vs14) i(vs15) i(vs16) i(vs17) i(vs18) i(vs19)
print i(vs20) i(vs21) i(vs22) i(vs23) i(vs24) i(vs25) i(vs26) i(vs27)
.endc
.end
