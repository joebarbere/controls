controls oracle dc-0102
* Generated (plan F2.7, ADR 0012): do not edit; regenerate with `pnpm sim oracle regen`. dc seed 20261030 index 102 nodes 21 elements 21
.options sparse gmin=1e-12 noopac
RG1 1 0 1000000000000
RG2 2 0 1000000000000
RG3 3 0 1000000000000
RG4 4 0 1000000000000
RG5 5 0 1000000000000
RG6 6 0 1000000000000
RG7 7 0 1000000000000
RG8 8 0 1000000000000
RG9 9 0 1000000000000
RG10 10 0 1000000000000
RG11 11 0 1000000000000
RG12 12 0 1000000000000
RG13 13 0 1000000000000
RG14 14 0 1000000000000
RG15 15 0 1000000000000
RG16 16 0 1000000000000
RG17 17 0 1000000000000
RG18 18 0 1000000000000
RG19 19 0 1000000000000
RG20 20 0 1000000000000
VS0 7 s0 0
R0 s0 5 15e-1
VS1 11 s1 0
R1 s1 13 27e1
VS2 1 s2 0
R2 s2 20 18e3
VS3 1 s3 0
R3 s3 17 18e-2
VS4 0 s4 0
V4 e4 s4 DC 22e0
RI4 e4 6 27e-3
VS5 9 s5 0
R5 s5 5 39e1
VS6 14 s6 0
R6 s6 15 68e3
VS7 12 s7 0
R7 s7 6 27e2
VS8 4 s8 0
R8 s8 11 39e0
VS9 19 s9 0
R9 s9 0 18e3
VS10 2 s10 0
R10 s10 10 12e-2
VS11 9 s11 0
V11 e11 s11 DC 12e-1
RI11 e11 1 22e-2
VS12 3 s12 0
R12 s12 16 82e3
VS13 6 s13 0
R13 s13 15 47e-1
VS14 1 s14 0
V14 e14 s14 DC 33e-1
RI14 e14 18 10e-3
VS15 5 s15 0
V15 e15 s15 DC 15e-1
RI15 e15 6 82e-1
VS16 4 s16 0
R16 s16 10 82e1
VS17 6 s17 0
R17 s17 4 15e2
VS18 4 s18 0
V18 e18 s18 DC 68e-1
RI18 e18 6 27e-2
VS19 16 s19 0
R19 s19 17 10e2
VS20 20 s20 0
R20 s20 8 39e1
.control
set numdgt=17
op
print v(1) v(2) v(3) v(4) v(5) v(6) v(7) v(8) v(9) v(10)
print v(11) v(12) v(13) v(14) v(15) v(16) v(17) v(18) v(19) v(20)
print i(vs0) i(vs1) i(vs2) i(vs3) i(vs4) i(vs5) i(vs6) i(vs7) i(vs8) i(vs9)
print i(vs10) i(vs11) i(vs12) i(vs13) i(vs14) i(vs15) i(vs16) i(vs17) i(vs18) i(vs19)
print i(vs20)
.endc
.end
