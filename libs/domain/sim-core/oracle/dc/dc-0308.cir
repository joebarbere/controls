controls oracle dc-0308
* Generated (plan F2.7, ADR 0012): do not edit; regenerate with `pnpm sim oracle regen`. dc seed 20261030 index 308 nodes 6 elements 10
.options sparse gmin=1e-12 noopac
RG1 1 0 1000000000000
RG2 2 0 1000000000000
RG3 3 0 1000000000000
RG4 4 0 1000000000000
RG5 5 0 1000000000000
VS0 4 s0 0
R0 s0 3 22e3
VS1 1 s1 0
R1 s1 2 27e1
VS2 4 s2 0
R2 s2 5 18e-1
VS3 5 s3 0
R3 s3 0 10e0
VS4 0 s4 0
V4 e4 s4 DC 56e-1
RI4 e4 1 15e-2
VS5 5 s5 0
V5 e5 s5 DC 33e-1
RI5 e5 1 56e-1
VS6 2 s6 0
R6 s6 0 82e0
VS7 0 s7 0
R7 s7 5 33e-1
VS8 2 s8 0
R8 s8 0 18e-1
VS9 3 s9 0
R9 s9 0 68e2
.control
set numdgt=17
op
print v(1) v(2) v(3) v(4) v(5)
print i(vs0) i(vs1) i(vs2) i(vs3) i(vs4) i(vs5) i(vs6) i(vs7) i(vs8) i(vs9)
.endc
.end
