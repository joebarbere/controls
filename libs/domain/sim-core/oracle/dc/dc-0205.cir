controls oracle dc-0205
* Generated (plan F2.7, ADR 0012): do not edit; regenerate with `pnpm sim oracle regen`. dc seed 20261030 index 205 nodes 30 elements 40
.options sparse gmin=1e-12 noopac
RG1 1 0 1000000000000
RG2 2 0 1000000000000
RG3 3 0 1000000000000
RG4 4 0 1000000000000
RG5 5 0 1000000000000
RG6 6 0 1000000000000
RG7 7 0 1000000000000
RG8 8 0 1000000000000
RG9 9 0 1000000000000
RG10 10 0 1000000000000
RG11 11 0 1000000000000
RG12 12 0 1000000000000
RG13 13 0 1000000000000
RG14 14 0 1000000000000
RG15 15 0 1000000000000
RG16 16 0 1000000000000
RG17 17 0 1000000000000
RG18 18 0 1000000000000
RG19 19 0 1000000000000
RG20 20 0 1000000000000
RG21 21 0 1000000000000
RG22 22 0 1000000000000
RG23 23 0 1000000000000
RG24 24 0 1000000000000
RG25 25 0 1000000000000
RG26 26 0 1000000000000
RG27 27 0 1000000000000
RG28 28 0 1000000000000
RG29 29 0 1000000000000
VS0 3 s0 0
R0 s0 16 56e3
VS1 24 s1 0
R1 s1 7 82e0
VS2 16 s2 0
R2 s2 10 33e-1
VS3 27 s3 0
R3 s3 25 56e0
VS4 5 s4 0
R4 s4 21 47e-2
VS5 1 s5 0
R5 s5 21 47e1
VS6 11 s6 0
R6 s6 3 22e3
VS7 22 s7 0
R7 s7 4 56e1
VS8 2 s8 0
R8 s8 23 47e3
VS9 17 s9 0
R9 s9 18 10e-2
VS10 12 s10 0
R10 s10 9 12e0
VS11 13 s11 0
I11 s11 18 DC 10e-3
VS12 0 s12 0
V12 e12 s12 DC 56e1
RI12 e12 9 47e-3
VS13 13 s13 0
I13 s13 5 DC 47e-1
VS14 28 s14 0
V14 e14 s14 DC 47e0
RI14 e14 4 82e-1
VS15 27 s15 0
R15 s15 11 15e-2
VS16 17 s16 0
R16 s16 11 39e-1
VS17 19 s17 0
R17 s17 17 47e-1
VS18 1 s18 0
V18 e18 s18 DC 82e1
RI18 e18 22 33e-2
VS19 24 s19 0
R19 s19 0 18e-1
VS20 5 s20 0
R20 s20 2 22e2
VS21 5 s21 0
I21 s21 25 DC 12e-1
VS22 9 s22 0
R22 s22 13 15e-1
VS23 6 s23 0
R23 s23 26 82e1
VS24 27 s24 0
R24 s24 7 33e3
VS25 20 s25 0
R25 s25 9 82e2
VS26 16 s26 0
I26 s26 24 DC 12e-3
VS27 26 s27 0
R27 s27 1 47e3
VS28 22 s28 0
R28 s28 14 18e-1
VS29 3 s29 0
R29 s29 22 27e2
VS30 12 s30 0
V30 e30 s30 DC 82e-1
RI30 e30 16 39e-2
VS31 9 s31 0
R31 s31 3 33e0
VS32 6 s32 0
R32 s32 2 15e3
VS33 4 s33 0
R33 s33 22 18e0
VS34 13 s34 0
I34 s34 20 DC 18e-1
VS35 1 s35 0
R35 s35 2 10e-2
VS36 15 s36 0
V36 e36 s36 DC 68e0
RI36 e36 29 68e-3
VS37 19 s37 0
I37 s37 6 DC 18e-1
VS38 26 s38 0
R38 s38 29 15e1
VS39 8 s39 0
V39 e39 s39 DC 12e1
RI39 e39 14 56e-3
.control
set numdgt=17
op
print v(1) v(2) v(3) v(4) v(5) v(6) v(7) v(8) v(9) v(10)
print v(11) v(12) v(13) v(14) v(15) v(16) v(17) v(18) v(19) v(20)
print v(21) v(22) v(23) v(24) v(25) v(26) v(27) v(28) v(29)
print i(vs0) i(vs1) i(vs2) i(vs3) i(vs4) i(vs5) i(vs6) i(vs7) i(vs8) i(vs9)
print i(vs10) i(vs11) i(vs12) i(vs13) i(vs14) i(vs15) i(vs16) i(vs17) i(vs18) i(vs19)
print i(vs20) i(vs21) i(vs22) i(vs23) i(vs24) i(vs25) i(vs26) i(vs27) i(vs28) i(vs29)
print i(vs30) i(vs31) i(vs32) i(vs33) i(vs34) i(vs35) i(vs36) i(vs37) i(vs38) i(vs39)
.endc
.end
