controls oracle dc-0205
* Generated (plan F2.7, ADR 0012): do not edit; regenerate with `pnpm sim oracle regen`. dc seed 20261030 index 205 nodes 30 elements 49
.options sparse gmin=1e-12 noopac
RG1 1 0 1000000000000
RG2 2 0 1000000000000
RG3 3 0 1000000000000
RG4 4 0 1000000000000
RG5 5 0 1000000000000
RG6 6 0 1000000000000
RG7 7 0 1000000000000
RG8 8 0 1000000000000
RG9 9 0 1000000000000
RG10 10 0 1000000000000
RG11 11 0 1000000000000
RG12 12 0 1000000000000
RG13 13 0 1000000000000
RG14 14 0 1000000000000
RG15 15 0 1000000000000
RG16 16 0 1000000000000
RG17 17 0 1000000000000
RG18 18 0 1000000000000
RG19 19 0 1000000000000
RG20 20 0 1000000000000
RG21 21 0 1000000000000
RG22 22 0 1000000000000
RG23 23 0 1000000000000
RG24 24 0 1000000000000
RG25 25 0 1000000000000
RG26 26 0 1000000000000
RG27 27 0 1000000000000
RG28 28 0 1000000000000
RG29 29 0 1000000000000
VS0 27 s0 0
R0 s0 7 33e3
VS1 15 s1 0
R1 s1 6 22e0
VS2 1 s2 0
R2 s2 22 27e2
VS3 22 s3 0
R3 s3 14 18e-1
VS4 13 s4 0
R4 s4 14 56e2
VS5 18 s5 0
R5 s5 20 10e-2
VS6 22 s6 0
R6 s6 4 56e1
VS7 20 s7 0
R7 s7 9 82e2
VS8 13 s8 0
I8 s8 5 DC 47e-1
VS9 0 s9 0
V9 e9 s9 DC 82e1
RI9 e9 22 33e-2
VS10 9 s10 0
R10 s10 1 33e0
VS11 12 s11 0
R11 s11 9 12e0
VS12 27 s12 0
R12 s12 25 56e0
VS13 5 s13 0
R13 s13 21 47e-2
VS14 24 s14 0
R14 s14 3 18e-1
VS15 5 s15 0
I15 s15 25 DC 12e-1
VS16 4 s16 0
R16 s16 22 18e0
VS17 20 s17 0
V17 e17 s17 DC 22e-1
RI17 e17 21 27e-2
VS18 8 s18 0
V18 e18 s18 DC 12e1
RI18 e18 14 56e-3
VS19 3 s19 0
V19 e19 s19 DC 56e1
RI19 e19 9 47e-3
VS20 24 s20 0
R20 s20 7 82e0
VS21 28 s21 0
V21 e21 s21 DC 47e0
RI21 e21 4 82e-1
VS22 16 s22 0
R22 s22 10 33e-1
VS23 17 s23 0
R23 s23 18 10e-2
VS24 11 s24 0
R24 s24 1 22e3
VS25 5 s25 0
R25 s25 2 22e2
VS26 27 s26 0
R26 s26 11 15e-2
VS27 6 s27 0
R27 s27 2 15e3
VS28 0 s28 0
R28 s28 21 47e1
VS29 1 s29 0
R29 s29 16 56e3
VS30 6 s30 0
R30 s30 26 82e1
VS31 26 s31 0
R31 s31 0 47e3
VS32 15 s32 0
V32 e32 s32 DC 68e0
RI32 e32 29 68e-3
VS33 4 s33 0
R33 s33 25 47e-2
VS34 26 s34 0
R34 s34 23 39e-2
VS35 7 s35 0
R35 s35 10 10e-1
VS36 19 s36 0
I36 s36 6 DC 18e-1
VS37 13 s37 0
I37 s37 20 DC 18e-1
VS38 8 s38 0
R38 s38 26 39e1
VS39 19 s39 0
R39 s39 17 47e-1
VS40 2 s40 0
R40 s40 23 47e3
VS41 16 s41 0
I41 s41 24 DC 12e-3
VS42 13 s42 0
I42 s42 18 DC 10e-3
VS43 9 s43 0
R43 s43 13 15e-1
VS44 26 s44 0
R44 s44 29 15e1
VS45 12 s45 0
V45 e45 s45 DC 82e-1
RI45 e45 16 39e-2
VS46 19 s46 0
R46 s46 28 10e1
VS47 0 s47 0
R47 s47 2 10e-2
VS48 17 s48 0
R48 s48 11 39e-1
.control
set numdgt=17
op
print v(1) v(2) v(3) v(4) v(5) v(6) v(7) v(8) v(9) v(10)
print v(11) v(12) v(13) v(14) v(15) v(16) v(17) v(18) v(19) v(20)
print v(21) v(22) v(23) v(24) v(25) v(26) v(27) v(28) v(29)
print i(vs0) i(vs1) i(vs2) i(vs3) i(vs4) i(vs5) i(vs6) i(vs7) i(vs8) i(vs9)
print i(vs10) i(vs11) i(vs12) i(vs13) i(vs14) i(vs15) i(vs16) i(vs17) i(vs18) i(vs19)
print i(vs20) i(vs21) i(vs22) i(vs23) i(vs24) i(vs25) i(vs26) i(vs27) i(vs28) i(vs29)
print i(vs30) i(vs31) i(vs32) i(vs33) i(vs34) i(vs35) i(vs36) i(vs37) i(vs38) i(vs39)
print i(vs40) i(vs41) i(vs42) i(vs43) i(vs44) i(vs45) i(vs46) i(vs47) i(vs48)
.endc
.end
