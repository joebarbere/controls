controls oracle dc-0034
* Generated (plan F2.7, ADR 0012): do not edit; regenerate with `pnpm sim oracle regen`. dc seed 20261030 index 34 nodes 22 elements 35
.options sparse gmin=1e-12 noopac
RG1 1 0 1000000000000
RG2 2 0 1000000000000
RG3 3 0 1000000000000
RG4 4 0 1000000000000
RG5 5 0 1000000000000
RG6 6 0 1000000000000
RG7 7 0 1000000000000
RG8 8 0 1000000000000
RG9 9 0 1000000000000
RG10 10 0 1000000000000
RG11 11 0 1000000000000
RG12 12 0 1000000000000
RG13 13 0 1000000000000
RG14 14 0 1000000000000
RG15 15 0 1000000000000
RG16 16 0 1000000000000
RG17 17 0 1000000000000
RG18 18 0 1000000000000
RG19 19 0 1000000000000
RG20 20 0 1000000000000
RG21 21 0 1000000000000
VS0 15 s0 0
R0 s0 9 33e0
VS1 7 s1 0
R1 s1 11 18e1
VS2 0 s2 0
V2 e2 s2 DC 33e-1
RI2 e2 11 10e-3
VS3 12 s3 0
V3 e3 s3 DC 15e-1
RI3 e3 7 68e-2
VS4 12 s4 0
R4 s4 16 15e-1
VS5 20 s5 0
R5 s5 3 47e1
VS6 14 s6 0
R6 s6 3 39e2
VS7 5 s7 0
V7 e7 s7 DC 15e0
RI7 e7 2 12e-2
VS8 10 s8 0
R8 s8 3 15e-2
VS9 16 s9 0
V9 e9 s9 DC 18e0
RI9 e9 17 27e-1
VS10 5 s10 0
R10 s10 9 39e-2
VS11 8 s11 0
R11 s11 12 82e1
VS12 13 s12 0
V12 e12 s12 DC 22e1
RI12 e12 14 68e-3
VS13 18 s13 0
R13 s13 19 33e1
VS14 13 s14 0
R14 s14 16 56e-2
VS15 14 s15 0
R15 s15 20 33e2
VS16 4 s16 0
R16 s16 18 15e0
VS17 6 s17 0
R17 s17 20 39e3
VS18 5 s18 0
R18 s18 8 68e-2
VS19 10 s19 0
R19 s19 2 56e-2
VS20 6 s20 0
I20 s20 8 DC 15e-2
VS21 2 s21 0
R21 s21 4 12e3
VS22 2 s22 0
R22 s22 18 18e0
VS23 14 s23 0
V23 e23 s23 DC 15e1
RI23 e23 1 33e-3
VS24 2 s24 0
R24 s24 13 33e-1
VS25 21 s25 0
R25 s25 20 56e0
VS26 0 s26 0
R26 s26 16 10e-2
VS27 14 s27 0
V27 e27 s27 DC 33e-1
RI27 e27 12 18e-3
VS28 1 s28 0
R28 s28 21 22e3
VS29 3 s29 0
R29 s29 7 18e-2
VS30 14 s30 0
V30 e30 s30 DC 27e0
RI30 e30 18 68e-3
VS31 19 s31 0
R31 s31 17 56e2
VS32 6 s32 0
I32 s32 10 DC 10e-3
VS33 15 s33 0
R33 s33 18 68e-1
VS34 6 s34 0
R34 s34 13 27e0
.control
set numdgt=17
op
print v(1) v(2) v(3) v(4) v(5) v(6) v(7) v(8) v(9) v(10)
print v(11) v(12) v(13) v(14) v(15) v(16) v(17) v(18) v(19) v(20)
print v(21)
print i(vs0) i(vs1) i(vs2) i(vs3) i(vs4) i(vs5) i(vs6) i(vs7) i(vs8) i(vs9)
print i(vs10) i(vs11) i(vs12) i(vs13) i(vs14) i(vs15) i(vs16) i(vs17) i(vs18) i(vs19)
print i(vs20) i(vs21) i(vs22) i(vs23) i(vs24) i(vs25) i(vs26) i(vs27) i(vs28) i(vs29)
print i(vs30) i(vs31) i(vs32) i(vs33) i(vs34)
.endc
.end
