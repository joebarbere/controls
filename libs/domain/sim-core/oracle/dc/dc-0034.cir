controls oracle dc-0034
* Generated (plan F2.7, ADR 0012): do not edit; regenerate with `pnpm sim oracle regen`. dc seed 20261030 index 34 nodes 22 elements 30
.options sparse gmin=1e-12 noopac
RG1 1 0 1000000000000
RG2 2 0 1000000000000
RG3 3 0 1000000000000
RG4 4 0 1000000000000
RG5 5 0 1000000000000
RG6 6 0 1000000000000
RG7 7 0 1000000000000
RG8 8 0 1000000000000
RG9 9 0 1000000000000
RG10 10 0 1000000000000
RG11 11 0 1000000000000
RG12 12 0 1000000000000
RG13 13 0 1000000000000
RG14 14 0 1000000000000
RG15 15 0 1000000000000
RG16 16 0 1000000000000
RG17 17 0 1000000000000
RG18 18 0 1000000000000
RG19 19 0 1000000000000
RG20 20 0 1000000000000
RG21 21 0 1000000000000
VS0 0 s0 0
V0 e0 s0 DC 18e0
RI0 e0 17 27e-1
VS1 12 s1 0
R1 s1 0 15e-1
VS2 21 s2 0
R2 s2 20 56e0
VS3 6 s3 0
R3 s3 20 39e3
VS4 15 s4 0
R4 s4 16 68e-1
VS5 2 s5 0
R5 s5 16 18e0
VS6 7 s6 0
R6 s6 11 18e1
VS7 6 s7 0
R7 s7 13 27e0
VS8 2 s8 0
R8 s8 13 33e-1
VS9 14 s9 0
R9 s9 20 33e2
VS10 4 s10 0
R10 s10 16 15e0
VS11 16 s11 0
R11 s11 19 33e1
VS12 6 s12 0
I12 s12 10 DC 10e-3
VS13 3 s13 0
R13 s13 7 18e-2
VS14 13 s14 0
V14 e14 s14 DC 22e1
RI14 e14 14 68e-3
VS15 14 s15 0
R15 s15 3 39e2
VS16 13 s16 0
R16 s16 0 56e-2
VS17 5 s17 0
R17 s17 9 39e-2
VS18 14 s18 0
V18 e18 s18 DC 33e-1
RI18 e18 12 18e-3
VS19 6 s19 0
I19 s19 8 DC 15e-2
VS20 12 s20 0
V20 e20 s20 DC 15e-1
RI20 e20 7 68e-2
VS21 5 s21 0
V21 e21 s21 DC 15e0
RI21 e21 2 12e-2
VS22 20 s22 0
R22 s22 3 47e1
VS23 14 s23 0
V23 e23 s23 DC 15e1
RI23 e23 1 33e-3
VS24 18 s24 0
R24 s24 0 10e-2
VS25 15 s25 0
R25 s25 9 33e0
VS26 5 s26 0
R26 s26 8 68e-2
VS27 14 s27 0
V27 e27 s27 DC 27e0
RI27 e27 16 68e-3
VS28 2 s28 0
R28 s28 4 12e3
VS29 10 s29 0
R29 s29 2 56e-2
.control
set numdgt=17
op
print v(1) v(2) v(3) v(4) v(5) v(6) v(7) v(8) v(9) v(10)
print v(11) v(12) v(13) v(14) v(15) v(16) v(17) v(18) v(19) v(20)
print v(21)
print i(vs0) i(vs1) i(vs2) i(vs3) i(vs4) i(vs5) i(vs6) i(vs7) i(vs8) i(vs9)
print i(vs10) i(vs11) i(vs12) i(vs13) i(vs14) i(vs15) i(vs16) i(vs17) i(vs18) i(vs19)
print i(vs20) i(vs21) i(vs22) i(vs23) i(vs24) i(vs25) i(vs26) i(vs27) i(vs28) i(vs29)
.endc
.end
