controls oracle dc-0487
* Generated (plan F2.7, ADR 0012): do not edit; regenerate with `pnpm sim oracle regen`. dc seed 20261030 index 487 nodes 25 elements 40
.options sparse gmin=1e-12 noopac
RG1 1 0 1000000000000
RG2 2 0 1000000000000
RG3 3 0 1000000000000
RG4 4 0 1000000000000
RG5 5 0 1000000000000
RG6 6 0 1000000000000
RG7 7 0 1000000000000
RG8 8 0 1000000000000
RG9 9 0 1000000000000
RG10 10 0 1000000000000
RG11 11 0 1000000000000
RG12 12 0 1000000000000
RG13 13 0 1000000000000
RG14 14 0 1000000000000
RG15 15 0 1000000000000
RG16 16 0 1000000000000
RG17 17 0 1000000000000
RG18 18 0 1000000000000
RG19 19 0 1000000000000
RG20 20 0 1000000000000
RG21 21 0 1000000000000
RG22 22 0 1000000000000
RG23 23 0 1000000000000
RG24 24 0 1000000000000
VS0 14 s0 0
R0 s0 3 56e-1
VS1 0 s1 0
V1 e1 s1 DC 39e-1
RI1 e1 12 27e-3
VS2 4 s2 0
R2 s2 19 18e1
VS3 13 s3 0
R3 s3 20 82e-2
VS4 3 s4 0
R4 s4 6 10e2
VS5 15 s5 0
R5 s5 16 27e0
VS6 19 s6 0
R6 s6 5 33e-1
VS7 21 s7 0
R7 s7 7 82e-1
VS8 10 s8 0
R8 s8 0 15e2
VS9 3 s9 0
I9 s9 17 DC 47e-3
VS10 18 s10 0
R10 s10 6 18e3
VS11 20 s11 0
V11 e11 s11 DC 18e-1
RI11 e11 18 15e-3
VS12 20 s12 0
I12 s12 18 DC 82e-2
VS13 0 s13 0
R13 s13 8 15e0
VS14 6 s14 0
R14 s14 23 15e2
VS15 14 s15 0
I15 s15 24 DC 82e-4
VS16 24 s16 0
V16 e16 s16 DC 18e0
RI16 e16 16 56e-2
VS17 2 s17 0
R17 s17 14 22e-2
VS18 2 s18 0
R18 s18 21 22e-1
VS19 14 s19 0
R19 s19 22 10e2
VS20 0 s20 0
V20 e20 s20 DC 10e0
RI20 e20 23 47e-2
VS21 9 s21 0
R21 s21 2 15e1
VS22 19 s22 0
R22 s22 9 47e-1
VS23 15 s23 0
R23 s23 14 33e1
VS24 0 s24 0
R24 s24 18 39e1
VS25 0 s25 0
R25 s25 11 33e3
VS26 6 s26 0
V26 e26 s26 DC 10e0
RI26 e26 24 33e-1
VS27 9 s27 0
V27 e27 s27 DC 27e1
RI27 e27 24 33e-2
VS28 13 s28 0
R28 s28 22 22e0
VS29 2 s29 0
R29 s29 0 68e1
VS30 6 s30 0
R30 s30 1 56e-1
VS31 4 s31 0
R31 s31 8 47e3
VS32 17 s32 0
R32 s32 9 68e0
VS33 18 s33 0
R33 s33 12 27e-1
VS34 22 s34 0
R34 s34 7 68e-1
VS35 8 s35 0
R35 s35 5 68e-1
VS36 19 s36 0
R36 s36 1 27e0
VS37 10 s37 0
R37 s37 12 82e-2
VS38 11 s38 0
V38 e38 s38 DC 33e0
RI38 e38 17 12e-1
VS39 17 s39 0
R39 s39 13 22e-2
.control
set numdgt=17
op
print v(1) v(2) v(3) v(4) v(5) v(6) v(7) v(8) v(9) v(10)
print v(11) v(12) v(13) v(14) v(15) v(16) v(17) v(18) v(19) v(20)
print v(21) v(22) v(23) v(24)
print i(vs0) i(vs1) i(vs2) i(vs3) i(vs4) i(vs5) i(vs6) i(vs7) i(vs8) i(vs9)
print i(vs10) i(vs11) i(vs12) i(vs13) i(vs14) i(vs15) i(vs16) i(vs17) i(vs18) i(vs19)
print i(vs20) i(vs21) i(vs22) i(vs23) i(vs24) i(vs25) i(vs26) i(vs27) i(vs28) i(vs29)
print i(vs30) i(vs31) i(vs32) i(vs33) i(vs34) i(vs35) i(vs36) i(vs37) i(vs38) i(vs39)
.endc
.end
