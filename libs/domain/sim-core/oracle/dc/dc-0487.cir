controls oracle dc-0487
* Generated (plan F2.7, ADR 0012): do not edit; regenerate with `pnpm sim oracle regen`. dc seed 20261030 index 487 nodes 25 elements 32
.options sparse gmin=1e-12 noopac
RG1 1 0 1000000000000
RG2 2 0 1000000000000
RG3 3 0 1000000000000
RG4 4 0 1000000000000
RG5 5 0 1000000000000
RG6 6 0 1000000000000
RG7 7 0 1000000000000
RG8 8 0 1000000000000
RG9 9 0 1000000000000
RG10 10 0 1000000000000
RG11 11 0 1000000000000
RG12 12 0 1000000000000
RG13 13 0 1000000000000
RG14 14 0 1000000000000
RG15 15 0 1000000000000
RG16 16 0 1000000000000
RG17 17 0 1000000000000
RG18 18 0 1000000000000
RG19 19 0 1000000000000
RG20 20 0 1000000000000
RG21 21 0 1000000000000
RG22 22 0 1000000000000
RG23 23 0 1000000000000
RG24 24 0 1000000000000
VS0 8 s0 0
R0 s0 5 68e-1
VS1 2 s1 0
R1 s1 14 22e-2
VS2 21 s2 0
R2 s2 7 82e-1
VS3 3 s3 0
R3 s3 6 10e2
VS4 4 s4 0
R4 s4 19 18e1
VS5 0 s5 0
R5 s5 18 39e1
VS6 13 s6 0
R6 s6 22 22e0
VS7 0 s7 0
V7 e7 s7 DC 39e-1
RI7 e7 12 27e-3
VS8 10 s8 0
R8 s8 0 15e2
VS9 3 s9 0
I9 s9 17 DC 47e-3
VS10 20 s10 0
I10 s10 18 DC 82e-2
VS11 14 s11 0
I11 s11 24 DC 82e-4
VS12 18 s12 0
R12 s12 6 18e3
VS13 15 s13 0
R13 s13 14 33e1
VS14 6 s14 0
V14 e14 s14 DC 10e0
RI14 e14 24 33e-1
VS15 2 s15 0
R15 s15 21 22e-1
VS16 0 s16 0
R16 s16 11 33e3
VS17 14 s17 0
R17 s17 3 56e-1
VS18 17 s18 0
R18 s18 9 68e0
VS19 15 s19 0
R19 s19 16 27e0
VS20 2 s20 0
R20 s20 0 68e1
VS21 0 s21 0
R21 s21 8 15e0
VS22 18 s22 0
R22 s22 12 27e-1
VS23 6 s23 0
R23 s23 1 56e-1
VS24 9 s24 0
R24 s24 2 15e1
VS25 19 s25 0
R25 s25 1 27e0
VS26 14 s26 0
R26 s26 22 10e2
VS27 20 s27 0
V27 e27 s27 DC 18e-1
RI27 e27 18 15e-3
VS28 19 s28 0
R28 s28 9 47e-1
VS29 0 s29 0
V29 e29 s29 DC 10e0
RI29 e29 23 47e-2
VS30 17 s30 0
R30 s30 13 22e-2
VS31 9 s31 0
V31 e31 s31 DC 27e1
RI31 e31 24 33e-2
.control
set numdgt=17
op
print v(1) v(2) v(3) v(4) v(5) v(6) v(7) v(8) v(9) v(10)
print v(11) v(12) v(13) v(14) v(15) v(16) v(17) v(18) v(19) v(20)
print v(21) v(22) v(23) v(24)
print i(vs0) i(vs1) i(vs2) i(vs3) i(vs4) i(vs5) i(vs6) i(vs7) i(vs8) i(vs9)
print i(vs10) i(vs11) i(vs12) i(vs13) i(vs14) i(vs15) i(vs16) i(vs17) i(vs18) i(vs19)
print i(vs20) i(vs21) i(vs22) i(vs23) i(vs24) i(vs25) i(vs26) i(vs27) i(vs28) i(vs29)
print i(vs30) i(vs31)
.endc
.end
