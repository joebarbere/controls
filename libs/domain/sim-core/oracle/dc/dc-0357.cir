controls oracle dc-0357
* Generated (plan F2.7, ADR 0012): do not edit; regenerate with `pnpm sim oracle regen`. dc seed 20261030 index 357 nodes 17 elements 31
.options sparse gmin=1e-12 noopac
RG1 1 0 1000000000000
RG2 2 0 1000000000000
RG3 3 0 1000000000000
RG4 4 0 1000000000000
RG5 5 0 1000000000000
RG6 6 0 1000000000000
RG7 7 0 1000000000000
RG8 8 0 1000000000000
RG9 9 0 1000000000000
RG10 10 0 1000000000000
RG11 11 0 1000000000000
RG12 12 0 1000000000000
RG13 13 0 1000000000000
RG14 14 0 1000000000000
RG15 15 0 1000000000000
RG16 16 0 1000000000000
VS0 2 s0 0
R0 s0 3 82e3
VS1 4 s1 0
R1 s1 0 47e-2
VS2 3 s2 0
R2 s2 13 39e0
VS3 8 s3 0
R3 s3 16 82e1
VS4 13 s4 0
R4 s4 10 15e3
VS5 10 s5 0
R5 s5 1 68e1
VS6 6 s6 0
R6 s6 15 18e-2
VS7 14 s7 0
R7 s7 16 27e0
VS8 8 s8 0
I8 s8 13 DC 18e-4
VS9 6 s9 0
R9 s9 7 68e0
VS10 1 s10 0
R10 s10 5 15e0
VS11 0 s11 0
V11 e11 s11 DC 22e0
RI11 e11 16 47e-1
VS12 0 s12 0
R12 s12 7 18e2
VS13 12 s13 0
I13 s13 10 DC 22e-2
VS14 10 s14 0
R14 s14 9 18e-2
VS15 5 s15 0
V15 e15 s15 DC 12e1
RI15 e15 2 22e-3
VS16 11 s16 0
R16 s16 6 10e1
VS17 8 s17 0
V17 e17 s17 DC 82e-1
RI17 e17 9 18e-2
VS18 12 s18 0
R18 s18 3 56e2
VS19 15 s19 0
R19 s19 14 56e2
VS20 7 s20 0
R20 s20 2 39e1
VS21 2 s21 0
R21 s21 11 68e3
VS22 1 s22 0
R22 s22 14 82e3
VS23 12 s23 0
R23 s23 11 82e-1
VS24 9 s24 0
V24 e24 s24 DC 56e0
RI24 e24 6 18e-2
VS25 3 s25 0
R25 s25 1 12e3
VS26 9 s26 0
V26 e26 s26 DC 68e-1
RI26 e26 2 15e-3
VS27 15 s27 0
V27 e27 s27 DC 15e1
RI27 e27 9 10e-1
VS28 4 s28 0
R28 s28 7 15e-1
VS29 6 s29 0
R29 s29 2 82e3
VS30 13 s30 0
R30 s30 14 56e0
.control
set numdgt=17
op
print v(1) v(2) v(3) v(4) v(5) v(6) v(7) v(8) v(9) v(10)
print v(11) v(12) v(13) v(14) v(15) v(16)
print i(vs0) i(vs1) i(vs2) i(vs3) i(vs4) i(vs5) i(vs6) i(vs7) i(vs8) i(vs9)
print i(vs10) i(vs11) i(vs12) i(vs13) i(vs14) i(vs15) i(vs16) i(vs17) i(vs18) i(vs19)
print i(vs20) i(vs21) i(vs22) i(vs23) i(vs24) i(vs25) i(vs26) i(vs27) i(vs28) i(vs29)
print i(vs30)
.endc
.end
