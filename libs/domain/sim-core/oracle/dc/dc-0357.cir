controls oracle dc-0357
* Generated (plan F2.7, ADR 0012): do not edit; regenerate with `pnpm sim oracle regen`. dc seed 20261030 index 357 nodes 17 elements 30
.options sparse gmin=1e-12 noopac
RG1 1 0 1000000000000
RG2 2 0 1000000000000
RG3 3 0 1000000000000
RG4 4 0 1000000000000
RG5 5 0 1000000000000
RG6 6 0 1000000000000
RG7 7 0 1000000000000
RG8 8 0 1000000000000
RG9 9 0 1000000000000
RG10 10 0 1000000000000
RG11 11 0 1000000000000
RG12 12 0 1000000000000
RG13 13 0 1000000000000
RG14 14 0 1000000000000
RG15 15 0 1000000000000
RG16 16 0 1000000000000
VS0 12 s0 0
I0 s0 10 DC 22e-2
VS1 12 s1 0
R1 s1 3 56e2
VS2 0 s2 0
V2 e2 s2 DC 68e-1
RI2 e2 2 15e-3
VS3 4 s3 0
R3 s3 6 47e-2
VS4 15 s4 0
R4 s4 14 56e2
VS5 3 s5 0
R5 s5 13 39e0
VS6 8 s6 0
R6 s6 16 82e1
VS7 3 s7 0
R7 s7 1 12e3
VS8 0 s8 0
V8 e8 s8 DC 56e0
RI8 e8 9 18e-2
VS9 10 s9 0
R9 s9 1 68e1
VS10 11 s10 0
R10 s10 9 10e1
VS11 10 s11 0
R11 s11 0 18e-2
VS12 4 s12 0
R12 s12 7 15e-1
VS13 7 s13 0
R13 s13 2 39e1
VS14 14 s14 0
R14 s14 16 27e0
VS15 2 s15 0
R15 s15 11 68e3
VS16 8 s16 0
I16 s16 13 DC 18e-4
VS17 9 s17 0
R17 s17 2 82e3
VS18 2 s18 0
R18 s18 3 82e3
VS19 5 s19 0
V19 e19 s19 DC 12e1
RI19 e19 2 22e-3
VS20 15 s20 0
V20 e20 s20 DC 15e1
RI20 e20 0 10e-1
VS21 13 s21 0
R21 s21 14 56e0
VS22 6 s22 0
R22 s22 7 18e2
VS23 1 s23 0
R23 s23 14 82e3
VS24 6 s24 0
V24 e24 s24 DC 22e0
RI24 e24 16 47e-1
VS25 9 s25 0
R25 s25 15 18e-2
VS26 9 s26 0
R26 s26 7 68e0
VS27 8 s27 0
V27 e27 s27 DC 82e-1
RI27 e27 0 18e-2
VS28 12 s28 0
R28 s28 11 82e-1
VS29 13 s29 0
R29 s29 10 15e3
.control
set numdgt=17
op
print v(1) v(2) v(3) v(4) v(5) v(6) v(7) v(8) v(9) v(10)
print v(11) v(12) v(13) v(14) v(15) v(16)
print i(vs0) i(vs1) i(vs2) i(vs3) i(vs4) i(vs5) i(vs6) i(vs7) i(vs8) i(vs9)
print i(vs10) i(vs11) i(vs12) i(vs13) i(vs14) i(vs15) i(vs16) i(vs17) i(vs18) i(vs19)
print i(vs20) i(vs21) i(vs22) i(vs23) i(vs24) i(vs25) i(vs26) i(vs27) i(vs28) i(vs29)
.endc
.end
