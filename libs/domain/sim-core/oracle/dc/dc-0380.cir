controls oracle dc-0380
* Generated (plan F2.7, ADR 0012): do not edit; regenerate with `pnpm sim oracle regen`. dc seed 20261030 index 380 nodes 30 elements 35
.options sparse gmin=1e-12 noopac
RG1 1 0 1000000000000
RG2 2 0 1000000000000
RG3 3 0 1000000000000
RG4 4 0 1000000000000
RG5 5 0 1000000000000
RG6 6 0 1000000000000
RG7 7 0 1000000000000
RG8 8 0 1000000000000
RG9 9 0 1000000000000
RG10 10 0 1000000000000
RG11 11 0 1000000000000
RG12 12 0 1000000000000
RG13 13 0 1000000000000
RG14 14 0 1000000000000
RG15 15 0 1000000000000
RG16 16 0 1000000000000
RG17 17 0 1000000000000
RG18 18 0 1000000000000
RG19 19 0 1000000000000
RG20 20 0 1000000000000
RG21 21 0 1000000000000
RG22 22 0 1000000000000
RG23 23 0 1000000000000
RG24 24 0 1000000000000
RG25 25 0 1000000000000
RG26 26 0 1000000000000
RG27 27 0 1000000000000
RG28 28 0 1000000000000
RG29 29 0 1000000000000
VS0 0 s0 0
V0 e0 s0 DC 47e1
RI0 e0 9 82e-2
VS1 16 s1 0
R1 s1 24 56e-1
VS2 16 s2 0
R2 s2 27 47e1
VS3 0 s3 0
V3 e3 s3 DC 39e-1
RI3 e3 14 22e-1
VS4 11 s4 0
R4 s4 19 22e2
VS5 1 s5 0
R5 s5 19 33e0
VS6 16 s6 0
R6 s6 18 15e-2
VS7 1 s7 0
R7 s7 22 27e1
VS8 23 s8 0
R8 s8 4 27e-2
VS9 8 s9 0
R9 s9 9 33e-1
VS10 10 s10 0
R10 s10 4 68e-2
VS11 17 s11 0
V11 e11 s11 DC 68e1
RI11 e11 24 82e-3
VS12 20 s12 0
V12 e12 s12 DC 22e0
RI12 e12 11 33e-1
VS13 26 s13 0
R13 s13 13 22e0
VS14 1 s14 0
V14 e14 s14 DC 39e1
RI14 e14 29 56e-2
VS15 5 s15 0
R15 s15 21 22e0
VS16 15 s16 0
R16 s16 27 39e-1
VS17 0 s17 0
R17 s17 26 15e3
VS18 18 s18 0
R18 s18 24 15e3
VS19 26 s19 0
V19 e19 s19 DC 47e1
RI19 e19 3 12e-1
VS20 6 s20 0
R20 s20 0 56e3
VS21 16 s21 0
R21 s21 0 10e2
VS22 1 s22 0
R22 s22 22 56e3
VS23 21 s23 0
R23 s23 26 68e2
VS24 6 s24 0
V24 e24 s24 DC 33e-1
RI24 e24 9 68e-1
VS25 12 s25 0
R25 s25 25 33e3
VS26 4 s26 0
R26 s26 16 10e-1
VS27 21 s27 0
R27 s27 2 10e1
VS28 20 s28 0
R28 s28 7 39e2
VS29 8 s29 0
V29 e29 s29 DC 18e-1
RI29 e29 3 47e-2
VS30 18 s30 0
R30 s30 15 10e0
VS31 13 s31 0
R31 s31 28 18e0
VS32 11 s32 0
R32 s32 16 18e0
VS33 12 s33 0
R33 s33 21 27e1
VS34 11 s34 0
V34 e34 s34 DC 18e-1
RI34 e34 18 47e-2
.control
set numdgt=17
op
print v(1) v(2) v(3) v(4) v(5) v(6) v(7) v(8) v(9) v(10)
print v(11) v(12) v(13) v(14) v(15) v(16) v(17) v(18) v(19) v(20)
print v(21) v(22) v(23) v(24) v(25) v(26) v(27) v(28) v(29)
print i(vs0) i(vs1) i(vs2) i(vs3) i(vs4) i(vs5) i(vs6) i(vs7) i(vs8) i(vs9)
print i(vs10) i(vs11) i(vs12) i(vs13) i(vs14) i(vs15) i(vs16) i(vs17) i(vs18) i(vs19)
print i(vs20) i(vs21) i(vs22) i(vs23) i(vs24) i(vs25) i(vs26) i(vs27) i(vs28) i(vs29)
print i(vs30) i(vs31) i(vs32) i(vs33) i(vs34)
.endc
.end
