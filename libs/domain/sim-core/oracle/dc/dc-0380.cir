controls oracle dc-0380
* Generated (plan F2.7, ADR 0012): do not edit; regenerate with `pnpm sim oracle regen`. dc seed 20261030 index 380 nodes 30 elements 46
.options sparse gmin=1e-12 noopac
RG1 1 0 1000000000000
RG2 2 0 1000000000000
RG3 3 0 1000000000000
RG4 4 0 1000000000000
RG5 5 0 1000000000000
RG6 6 0 1000000000000
RG7 7 0 1000000000000
RG8 8 0 1000000000000
RG9 9 0 1000000000000
RG10 10 0 1000000000000
RG11 11 0 1000000000000
RG12 12 0 1000000000000
RG13 13 0 1000000000000
RG14 14 0 1000000000000
RG15 15 0 1000000000000
RG16 16 0 1000000000000
RG17 17 0 1000000000000
RG18 18 0 1000000000000
RG19 19 0 1000000000000
RG20 20 0 1000000000000
RG21 21 0 1000000000000
RG22 22 0 1000000000000
RG23 23 0 1000000000000
RG24 24 0 1000000000000
RG25 25 0 1000000000000
RG26 26 0 1000000000000
RG27 27 0 1000000000000
RG28 28 0 1000000000000
RG29 29 0 1000000000000
VS0 29 s0 0
R0 s0 23 39e-1
VS1 0 s1 0
V1 e1 s1 DC 18e-1
RI1 e1 3 47e-2
VS2 0 s2 0
R2 s2 12 56e3
VS3 10 s3 0
R3 s3 11 18e0
VS4 12 s4 0
R4 s4 25 33e3
VS5 1 s5 0
V5 e5 s5 DC 39e1
RI5 e5 29 56e-2
VS6 20 s6 0
R6 s6 7 39e2
VS7 28 s7 0
R7 s7 1 12e2
VS8 6 s8 0
V8 e8 s8 DC 33e-1
RI8 e8 9 68e-1
VS9 10 s9 0
R9 s9 4 68e-2
VS10 28 s10 0
R10 s10 26 15e2
VS11 8 s11 0
R11 s11 16 18e0
VS12 21 s12 0
R12 s12 2 10e1
VS13 25 s13 0
V13 e13 s13 DC 68e0
RI13 e13 21 56e-2
VS14 23 s14 0
R14 s14 4 27e-2
VS15 25 s15 0
R15 s15 5 15e1
VS16 26 s16 0
V16 e16 s16 DC 47e1
RI16 e16 3 12e-1
VS17 11 s17 0
V17 e17 s17 DC 47e1
RI17 e17 9 82e-2
VS18 17 s18 0
V18 e18 s18 DC 68e1
RI18 e18 24 82e-3
VS19 15 s19 0
R19 s19 27 39e-1
VS20 16 s20 0
R20 s20 24 56e-1
VS21 22 s21 0
V21 e21 s21 DC 68e0
RI21 e21 17 12e-1
VS22 11 s22 0
R22 s22 26 15e3
VS23 1 s23 0
R23 s23 19 33e0
VS24 18 s24 0
R24 s24 15 10e0
VS25 11 s25 0
V25 e25 s25 DC 39e-1
RI25 e25 14 22e-1
VS26 16 s26 0
R26 s26 18 15e-2
VS27 20 s27 0
V27 e27 s27 DC 22e0
RI27 e27 8 33e-1
VS28 13 s28 0
R28 s28 28 18e0
VS29 8 s29 0
V29 e29 s29 DC 18e-1
RI29 e29 18 47e-2
VS30 4 s30 0
R30 s30 14 68e1
VS31 12 s31 0
R31 s31 21 27e1
VS32 0 s32 0
R32 s32 9 33e-1
VS33 26 s33 0
R33 s33 13 22e0
VS34 16 s34 0
R34 s34 27 47e1
VS35 8 s35 0
R35 s35 19 22e2
VS36 4 s36 0
R36 s36 16 10e-1
VS37 1 s37 0
R37 s37 22 27e1
VS38 6 s38 0
R38 s38 11 56e3
VS39 16 s39 0
R39 s39 11 10e2
VS40 21 s40 0
R40 s40 26 68e2
VS41 18 s41 0
R41 s41 24 15e3
VS42 1 s42 0
R42 s42 22 56e3
VS43 1 s43 0
R43 s43 7 10e1
VS44 5 s44 0
R44 s44 21 22e0
VS45 11 s45 0
R45 s45 2 56e-2
.control
set numdgt=17
op
print v(1) v(2) v(3) v(4) v(5) v(6) v(7) v(8) v(9) v(10)
print v(11) v(12) v(13) v(14) v(15) v(16) v(17) v(18) v(19) v(20)
print v(21) v(22) v(23) v(24) v(25) v(26) v(27) v(28) v(29)
print i(vs0) i(vs1) i(vs2) i(vs3) i(vs4) i(vs5) i(vs6) i(vs7) i(vs8) i(vs9)
print i(vs10) i(vs11) i(vs12) i(vs13) i(vs14) i(vs15) i(vs16) i(vs17) i(vs18) i(vs19)
print i(vs20) i(vs21) i(vs22) i(vs23) i(vs24) i(vs25) i(vs26) i(vs27) i(vs28) i(vs29)
print i(vs30) i(vs31) i(vs32) i(vs33) i(vs34) i(vs35) i(vs36) i(vs37) i(vs38) i(vs39)
print i(vs40) i(vs41) i(vs42) i(vs43) i(vs44) i(vs45)
.endc
.end
