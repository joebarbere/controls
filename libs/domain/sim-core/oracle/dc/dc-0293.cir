controls oracle dc-0293
* Generated (plan F2.7, ADR 0012): do not edit; regenerate with `pnpm sim oracle regen`. dc seed 20261030 index 293 nodes 29 elements 49
.options sparse gmin=1e-12 noopac
RG1 1 0 1000000000000
RG2 2 0 1000000000000
RG3 3 0 1000000000000
RG4 4 0 1000000000000
RG5 5 0 1000000000000
RG6 6 0 1000000000000
RG7 7 0 1000000000000
RG8 8 0 1000000000000
RG9 9 0 1000000000000
RG10 10 0 1000000000000
RG11 11 0 1000000000000
RG12 12 0 1000000000000
RG13 13 0 1000000000000
RG14 14 0 1000000000000
RG15 15 0 1000000000000
RG16 16 0 1000000000000
RG17 17 0 1000000000000
RG18 18 0 1000000000000
RG19 19 0 1000000000000
RG20 20 0 1000000000000
RG21 21 0 1000000000000
RG22 22 0 1000000000000
RG23 23 0 1000000000000
RG24 24 0 1000000000000
RG25 25 0 1000000000000
RG26 26 0 1000000000000
RG27 27 0 1000000000000
RG28 28 0 1000000000000
VS0 0 s0 0
V0 e0 s0 DC 33e-1
RI0 e0 9 15e-3
VS1 6 s1 0
R1 s1 14 33e1
VS2 9 s2 0
I2 s2 18 DC 47e-3
VS3 25 s3 0
R3 s3 21 33e-1
VS4 9 s4 0
I4 s4 14 DC 27e-4
VS5 0 s5 0
I5 s5 27 DC 82e-2
VS6 9 s6 0
I6 s6 19 DC 27e-2
VS7 2 s7 0
R7 s7 1 39e-2
VS8 1 s8 0
R8 s8 7 56e1
VS9 21 s9 0
I9 s9 8 DC 18e-2
VS10 8 s10 0
R10 s10 26 27e1
VS11 0 s11 0
I11 s11 13 DC 22e-1
VS12 2 s12 0
R12 s12 17 82e1
VS13 16 s13 0
R13 s13 25 68e0
VS14 0 s14 0
R14 s14 10 12e2
VS15 25 s15 0
R15 s15 0 39e-2
VS16 20 s16 0
R16 s16 5 15e3
VS17 15 s17 0
V17 e17 s17 DC 15e-1
RI17 e17 19 33e-2
VS18 12 s18 0
R18 s18 10 10e2
VS19 26 s19 0
R19 s19 11 22e-2
VS20 18 s20 0
V20 e20 s20 DC 68e-1
RI20 e20 12 18e-2
VS21 3 s21 0
V21 e21 s21 DC 22e1
RI21 e21 16 82e-1
VS22 24 s22 0
R22 s22 3 68e-2
VS23 6 s23 0
R23 s23 20 10e0
VS24 14 s24 0
R24 s24 22 15e-2
VS25 5 s25 0
R25 s25 24 39e-1
VS26 15 s26 0
R26 s26 25 68e2
VS27 5 s27 0
R27 s27 28 12e0
VS28 19 s28 0
R28 s28 11 39e0
VS29 23 s29 0
I29 s29 25 DC 68e-3
VS30 3 s30 0
R30 s30 14 22e0
VS31 0 s31 0
R31 s31 1 82e0
VS32 1 s32 0
R32 s32 3 39e-1
VS33 21 s33 0
V33 e33 s33 DC 15e1
RI33 e33 2 68e-3
VS34 10 s34 0
R34 s34 20 33e-2
VS35 4 s35 0
R35 s35 20 39e3
VS36 4 s36 0
R36 s36 15 33e-2
VS37 22 s37 0
R37 s37 28 68e3
VS38 13 s38 0
I38 s38 28 DC 15e-2
VS39 23 s39 0
R39 s39 18 10e2
VS40 23 s40 0
R40 s40 17 15e2
VS41 7 s41 0
R41 s41 27 47e1
VS42 16 s42 0
V42 e42 s42 DC 10e0
RI42 e42 19 12e-3
VS43 13 s43 0
R43 s43 4 27e1
VS44 5 s44 0
R44 s44 4 15e2
VS45 19 s45 0
R45 s45 13 33e3
VS46 11 s46 0
V46 e46 s46 DC 47e0
RI46 e46 0 10e-2
VS47 9 s47 0
R47 s47 27 15e-2
VS48 8 s48 0
R48 s48 15 15e3
.control
set numdgt=17
op
print v(1) v(2) v(3) v(4) v(5) v(6) v(7) v(8) v(9) v(10)
print v(11) v(12) v(13) v(14) v(15) v(16) v(17) v(18) v(19) v(20)
print v(21) v(22) v(23) v(24) v(25) v(26) v(27) v(28)
print i(vs0) i(vs1) i(vs2) i(vs3) i(vs4) i(vs5) i(vs6) i(vs7) i(vs8) i(vs9)
print i(vs10) i(vs11) i(vs12) i(vs13) i(vs14) i(vs15) i(vs16) i(vs17) i(vs18) i(vs19)
print i(vs20) i(vs21) i(vs22) i(vs23) i(vs24) i(vs25) i(vs26) i(vs27) i(vs28) i(vs29)
print i(vs30) i(vs31) i(vs32) i(vs33) i(vs34) i(vs35) i(vs36) i(vs37) i(vs38) i(vs39)
print i(vs40) i(vs41) i(vs42) i(vs43) i(vs44) i(vs45) i(vs46) i(vs47) i(vs48)
.endc
.end
