controls oracle dc-0224
* Generated (plan F2.7, ADR 0012): do not edit; regenerate with `pnpm sim oracle regen`. dc seed 20261030 index 224 nodes 21 elements 39
.options sparse gmin=1e-12 noopac
RG1 1 0 1000000000000
RG2 2 0 1000000000000
RG3 3 0 1000000000000
RG4 4 0 1000000000000
RG5 5 0 1000000000000
RG6 6 0 1000000000000
RG7 7 0 1000000000000
RG8 8 0 1000000000000
RG9 9 0 1000000000000
RG10 10 0 1000000000000
RG11 11 0 1000000000000
RG12 12 0 1000000000000
RG13 13 0 1000000000000
RG14 14 0 1000000000000
RG15 15 0 1000000000000
RG16 16 0 1000000000000
RG17 17 0 1000000000000
RG18 18 0 1000000000000
RG19 19 0 1000000000000
RG20 20 0 1000000000000
VS0 0 s0 0
V0 e0 s0 DC 22e0
RI0 e0 10 18e-1
VS1 0 s1 0
R1 s1 3 68e-2
VS2 10 s2 0
I2 s2 11 DC 39e-1
VS3 18 s3 0
R3 s3 11 82e0
VS4 6 s4 0
R4 s4 7 18e3
VS5 9 s5 0
R5 s5 15 10e1
VS6 0 s6 0
R6 s6 9 82e-2
VS7 3 s7 0
V7 e7 s7 DC 47e-1
RI7 e7 13 15e-2
VS8 1 s8 0
R8 s8 20 47e1
VS9 1 s9 0
V9 e9 s9 DC 68e0
RI9 e9 3 33e-1
VS10 15 s10 0
R10 s10 9 33e-1
VS11 16 s11 0
R11 s11 19 68e0
VS12 15 s12 0
R12 s12 18 12e3
VS13 17 s13 0
R13 s13 14 56e3
VS14 7 s14 0
V14 e14 s14 DC 39e0
RI14 e14 16 18e-1
VS15 20 s15 0
R15 s15 5 82e-2
VS16 8 s16 0
R16 s16 6 18e0
VS17 8 s17 0
R17 s17 12 33e1
VS18 4 s18 0
R18 s18 7 15e2
VS19 2 s19 0
R19 s19 6 47e3
VS20 15 s20 0
R20 s20 1 18e3
VS21 8 s21 0
R21 s21 15 22e3
VS22 14 s22 0
I22 s22 17 DC 10e-2
VS23 2 s23 0
R23 s23 4 27e1
VS24 10 s24 0
V24 e24 s24 DC 33e0
RI24 e24 5 39e-1
VS25 17 s25 0
V25 e25 s25 DC 56e0
RI25 e25 7 10e-3
VS26 11 s26 0
R26 s26 18 12e2
VS27 9 s27 0
R27 s27 12 15e-1
VS28 4 s28 0
R28 s28 0 68e3
VS29 20 s29 0
R29 s29 4 15e-1
VS30 5 s30 0
R30 s30 12 22e0
VS31 7 s31 0
V31 e31 s31 DC 82e0
RI31 e31 15 68e-3
VS32 11 s32 0
R32 s32 8 18e2
VS33 13 s33 0
I33 s33 11 DC 15e-1
VS34 19 s34 0
R34 s34 13 27e3
VS35 12 s35 0
R35 s35 8 47e0
VS36 5 s36 0
I36 s36 9 DC 18e-3
VS37 0 s37 0
R37 s37 14 56e2
VS38 3 s38 0
R38 s38 17 27e-1
.control
set numdgt=17
op
print v(1) v(2) v(3) v(4) v(5) v(6) v(7) v(8) v(9) v(10)
print v(11) v(12) v(13) v(14) v(15) v(16) v(17) v(18) v(19) v(20)
print i(vs0) i(vs1) i(vs2) i(vs3) i(vs4) i(vs5) i(vs6) i(vs7) i(vs8) i(vs9)
print i(vs10) i(vs11) i(vs12) i(vs13) i(vs14) i(vs15) i(vs16) i(vs17) i(vs18) i(vs19)
print i(vs20) i(vs21) i(vs22) i(vs23) i(vs24) i(vs25) i(vs26) i(vs27) i(vs28) i(vs29)
print i(vs30) i(vs31) i(vs32) i(vs33) i(vs34) i(vs35) i(vs36) i(vs37) i(vs38)
.endc
.end
