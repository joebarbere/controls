controls oracle dc-0224
* Generated (plan F2.7, ADR 0012): do not edit; regenerate with `pnpm sim oracle regen`. dc seed 20261030 index 224 nodes 21 elements 35
.options sparse gmin=1e-12 noopac
RG1 1 0 1000000000000
RG2 2 0 1000000000000
RG3 3 0 1000000000000
RG4 4 0 1000000000000
RG5 5 0 1000000000000
RG6 6 0 1000000000000
RG7 7 0 1000000000000
RG8 8 0 1000000000000
RG9 9 0 1000000000000
RG10 10 0 1000000000000
RG11 11 0 1000000000000
RG12 12 0 1000000000000
RG13 13 0 1000000000000
RG14 14 0 1000000000000
RG15 15 0 1000000000000
RG16 16 0 1000000000000
RG17 17 0 1000000000000
RG18 18 0 1000000000000
RG19 19 0 1000000000000
RG20 20 0 1000000000000
VS0 15 s0 0
R0 s0 9 33e-1
VS1 5 s1 0
I1 s1 9 DC 18e-3
VS2 7 s2 0
R2 s2 3 68e-2
VS3 8 s3 0
R3 s3 6 18e0
VS4 0 s4 0
V4 e4 s4 DC 39e0
RI4 e4 16 18e-1
VS5 4 s5 0
R5 s5 0 15e2
VS6 20 s6 0
R6 s6 4 15e-1
VS7 19 s7 0
R7 s7 13 27e3
VS8 7 s8 0
R8 s8 9 82e-2
VS9 7 s9 0
V9 e9 s9 DC 22e0
RI9 e9 10 18e-1
VS10 7 s10 0
R10 s10 14 56e2
VS11 1 s11 0
V11 e11 s11 DC 68e0
RI11 e11 3 33e-1
VS12 16 s12 0
R12 s12 19 68e0
VS13 17 s13 0
R13 s13 14 56e3
VS14 18 s14 0
R14 s14 11 82e0
VS15 3 s15 0
V15 e15 s15 DC 47e-1
RI15 e15 13 15e-2
VS16 0 s16 0
V16 e16 s16 DC 82e0
RI16 e16 15 68e-3
VS17 2 s17 0
R17 s17 4 27e1
VS18 15 s18 0
R18 s18 1 18e3
VS19 4 s19 0
R19 s19 7 68e3
VS20 15 s20 0
R20 s20 18 12e3
VS21 9 s21 0
R21 s21 15 10e1
VS22 10 s22 0
I22 s22 11 DC 39e-1
VS23 5 s23 0
R23 s23 12 22e0
VS24 8 s24 0
R24 s24 15 22e3
VS25 14 s25 0
I25 s25 17 DC 10e-2
VS26 8 s26 0
R26 s26 12 33e1
VS27 11 s27 0
R27 s27 8 18e2
VS28 9 s28 0
R28 s28 12 15e-1
VS29 6 s29 0
R29 s29 0 18e3
VS30 12 s30 0
R30 s30 8 47e0
VS31 11 s31 0
R31 s31 18 12e2
VS32 3 s32 0
R32 s32 17 27e-1
VS33 17 s33 0
V33 e33 s33 DC 56e0
RI33 e33 0 10e-3
VS34 13 s34 0
I34 s34 11 DC 15e-1
.control
set numdgt=17
op
print v(1) v(2) v(3) v(4) v(5) v(6) v(7) v(8) v(9) v(10)
print v(11) v(12) v(13) v(14) v(15) v(16) v(17) v(18) v(19) v(20)
print i(vs0) i(vs1) i(vs2) i(vs3) i(vs4) i(vs5) i(vs6) i(vs7) i(vs8) i(vs9)
print i(vs10) i(vs11) i(vs12) i(vs13) i(vs14) i(vs15) i(vs16) i(vs17) i(vs18) i(vs19)
print i(vs20) i(vs21) i(vs22) i(vs23) i(vs24) i(vs25) i(vs26) i(vs27) i(vs28) i(vs29)
print i(vs30) i(vs31) i(vs32) i(vs33) i(vs34)
.endc
.end
