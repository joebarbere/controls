controls oracle dc-0243
* Generated (plan F2.7, ADR 0012): do not edit; regenerate with `pnpm sim oracle regen`. dc seed 20261030 index 243 nodes 25 elements 40
.options sparse gmin=1e-12 noopac
RG1 1 0 1000000000000
RG2 2 0 1000000000000
RG3 3 0 1000000000000
RG4 4 0 1000000000000
RG5 5 0 1000000000000
RG6 6 0 1000000000000
RG7 7 0 1000000000000
RG8 8 0 1000000000000
RG9 9 0 1000000000000
RG10 10 0 1000000000000
RG11 11 0 1000000000000
RG12 12 0 1000000000000
RG13 13 0 1000000000000
RG14 14 0 1000000000000
RG15 15 0 1000000000000
RG16 16 0 1000000000000
RG17 17 0 1000000000000
RG18 18 0 1000000000000
RG19 19 0 1000000000000
RG20 20 0 1000000000000
RG21 21 0 1000000000000
RG22 22 0 1000000000000
RG23 23 0 1000000000000
RG24 24 0 1000000000000
VS0 0 s0 0
V0 e0 s0 DC 56e0
RI0 e0 22 56e-2
VS1 16 s1 0
R1 s1 21 56e0
VS2 5 s2 0
V2 e2 s2 DC 56e1
RI2 e2 9 15e-1
VS3 2 s3 0
R3 s3 7 22e3
VS4 23 s4 0
R4 s4 20 10e0
VS5 9 s5 0
V5 e5 s5 DC 22e-1
RI5 e5 12 15e-3
VS6 16 s6 0
R6 s6 11 12e-1
VS7 10 s7 0
V7 e7 s7 DC 22e1
RI7 e7 2 33e-3
VS8 3 s8 0
R8 s8 18 18e2
VS9 16 s9 0
R9 s9 13 47e2
VS10 18 s10 0
R10 s10 19 56e3
VS11 8 s11 0
V11 e11 s11 DC 33e0
RI11 e11 16 56e-3
VS12 20 s12 0
R12 s12 22 56e2
VS13 11 s13 0
I13 s13 16 DC 27e-4
VS14 19 s14 0
R14 s14 5 47e1
VS15 9 s15 0
R15 s15 19 27e3
VS16 8 s16 0
R16 s16 3 18e-1
VS17 23 s17 0
R17 s17 11 12e-1
VS18 4 s18 0
R18 s18 16 82e1
VS19 16 s19 0
R19 s19 0 22e1
VS20 9 s20 0
R20 s20 20 68e2
VS21 6 s21 0
R21 s21 8 15e-1
VS22 16 s22 0
R22 s22 14 10e1
VS23 18 s23 0
R23 s23 8 12e3
VS24 12 s24 0
R24 s24 7 22e-2
VS25 4 s25 0
R25 s25 6 47e-1
VS26 13 s26 0
R26 s26 20 27e1
VS27 1 s27 0
R27 s27 19 18e0
VS28 8 s28 0
R28 s28 21 33e3
VS29 23 s29 0
V29 e29 s29 DC 33e-1
RI29 e29 4 68e-2
VS30 9 s30 0
R30 s30 17 68e-1
VS31 8 s31 0
R31 s31 17 18e2
VS32 15 s32 0
R32 s32 21 39e2
VS33 9 s33 0
R33 s33 16 12e1
VS34 21 s34 0
V34 e34 s34 DC 18e-1
RI34 e34 24 15e-2
VS35 1 s35 0
R35 s35 18 12e0
VS36 7 s36 0
V36 e36 s36 DC 18e0
RI36 e36 21 10e-2
VS37 24 s37 0
R37 s37 14 27e3
VS38 14 s38 0
R38 s38 15 33e2
VS39 9 s39 0
R39 s39 10 68e1
.control
set numdgt=17
op
print v(1) v(2) v(3) v(4) v(5) v(6) v(7) v(8) v(9) v(10)
print v(11) v(12) v(13) v(14) v(15) v(16) v(17) v(18) v(19) v(20)
print v(21) v(22) v(23) v(24)
print i(vs0) i(vs1) i(vs2) i(vs3) i(vs4) i(vs5) i(vs6) i(vs7) i(vs8) i(vs9)
print i(vs10) i(vs11) i(vs12) i(vs13) i(vs14) i(vs15) i(vs16) i(vs17) i(vs18) i(vs19)
print i(vs20) i(vs21) i(vs22) i(vs23) i(vs24) i(vs25) i(vs26) i(vs27) i(vs28) i(vs29)
print i(vs30) i(vs31) i(vs32) i(vs33) i(vs34) i(vs35) i(vs36) i(vs37) i(vs38) i(vs39)
.endc
.end
