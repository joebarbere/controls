controls oracle dc-0243
* Generated (plan F2.7, ADR 0012): do not edit; regenerate with `pnpm sim oracle regen`. dc seed 20261030 index 243 nodes 25 elements 29
.options sparse gmin=1e-12 noopac
RG1 1 0 1000000000000
RG2 2 0 1000000000000
RG3 3 0 1000000000000
RG4 4 0 1000000000000
RG5 5 0 1000000000000
RG6 6 0 1000000000000
RG7 7 0 1000000000000
RG8 8 0 1000000000000
RG9 9 0 1000000000000
RG10 10 0 1000000000000
RG11 11 0 1000000000000
RG12 12 0 1000000000000
RG13 13 0 1000000000000
RG14 14 0 1000000000000
RG15 15 0 1000000000000
RG16 16 0 1000000000000
RG17 17 0 1000000000000
RG18 18 0 1000000000000
RG19 19 0 1000000000000
RG20 20 0 1000000000000
RG21 21 0 1000000000000
RG22 22 0 1000000000000
RG23 23 0 1000000000000
RG24 24 0 1000000000000
VS0 16 s0 0
R0 s0 8 56e0
VS1 19 s1 0
R1 s1 5 47e1
VS2 2 s2 0
R2 s2 7 22e3
VS3 18 s3 0
R3 s3 0 12e3
VS4 16 s4 0
R4 s4 14 10e1
VS5 0 s5 0
V5 e5 s5 DC 33e0
RI5 e5 16 56e-3
VS6 9 s6 0
R6 s6 17 68e-1
VS7 10 s7 0
V7 e7 s7 DC 22e1
RI7 e7 2 33e-3
VS8 0 s8 0
R8 s8 8 33e3
VS9 1 s9 0
R9 s9 18 12e0
VS10 7 s10 0
V10 e10 s10 DC 18e0
RI10 e10 8 10e-2
VS11 20 s11 0
R11 s11 22 56e2
VS12 8 s12 0
V12 e12 s12 DC 18e-1
RI12 e12 24 15e-2
VS13 6 s13 0
R13 s13 0 15e-1
VS14 4 s14 0
R14 s14 16 82e1
VS15 13 s15 0
R15 s15 20 27e1
VS16 9 s16 0
V16 e16 s16 DC 22e-1
RI16 e16 12 15e-3
VS17 9 s17 0
R17 s17 19 27e3
VS18 14 s18 0
R18 s18 15 33e2
VS19 9 s19 0
R19 s19 16 12e1
VS20 9 s20 0
R20 s20 20 68e2
VS21 0 s21 0
R21 s21 17 18e2
VS22 12 s22 0
R22 s22 7 22e-2
VS23 16 s23 0
R23 s23 11 12e-1
VS24 0 s24 0
R24 s24 3 18e-1
VS25 9 s25 0
R25 s25 10 68e1
VS26 11 s26 0
I26 s26 16 DC 27e-4
VS27 23 s27 0
R27 s27 20 10e0
VS28 21 s28 0
V28 e28 s28 DC 56e0
RI28 e28 22 56e-2
.control
set numdgt=17
op
print v(1) v(2) v(3) v(4) v(5) v(6) v(7) v(8) v(9) v(10)
print v(11) v(12) v(13) v(14) v(15) v(16) v(17) v(18) v(19) v(20)
print v(21) v(22) v(23) v(24)
print i(vs0) i(vs1) i(vs2) i(vs3) i(vs4) i(vs5) i(vs6) i(vs7) i(vs8) i(vs9)
print i(vs10) i(vs11) i(vs12) i(vs13) i(vs14) i(vs15) i(vs16) i(vs17) i(vs18) i(vs19)
print i(vs20) i(vs21) i(vs22) i(vs23) i(vs24) i(vs25) i(vs26) i(vs27) i(vs28)
.endc
.end
