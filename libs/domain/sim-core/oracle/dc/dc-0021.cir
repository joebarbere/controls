controls oracle dc-0021
* Generated (plan F2.7, ADR 0012): do not edit; regenerate with `pnpm sim oracle regen`. dc seed 20261030 index 21 nodes 15 elements 27
.options sparse gmin=1e-12 noopac
RG1 1 0 1000000000000
RG2 2 0 1000000000000
RG3 3 0 1000000000000
RG4 4 0 1000000000000
RG5 5 0 1000000000000
RG6 6 0 1000000000000
RG7 7 0 1000000000000
RG8 8 0 1000000000000
RG9 9 0 1000000000000
RG10 10 0 1000000000000
RG11 11 0 1000000000000
RG12 12 0 1000000000000
RG13 13 0 1000000000000
RG14 14 0 1000000000000
VS0 6 s0 0
R0 s0 3 39e-1
VS1 7 s1 0
R1 s1 5 47e-1
VS2 4 s2 0
R2 s2 2 47e0
VS3 10 s3 0
R3 s3 12 68e1
VS4 0 s4 0
R4 s4 11 47e0
VS5 12 s5 0
R5 s5 8 22e0
VS6 2 s6 0
R6 s6 5 15e1
VS7 2 s7 0
R7 s7 6 18e2
VS8 1 s8 0
I8 s8 4 DC 22e-3
VS9 8 s9 0
I9 s9 12 DC 39e-3
VS10 5 s10 0
R10 s10 4 15e1
VS11 2 s11 0
R11 s11 9 56e-2
VS12 7 s12 0
R12 s12 11 47e1
VS13 5 s13 0
R13 s13 1 82e-1
VS14 2 s14 0
R14 s14 14 33e3
VS15 10 s15 0
I15 s15 14 DC 15e-4
VS16 11 s16 0
R16 s16 14 82e-2
VS17 0 s17 0
V17 e17 s17 DC 15e0
RI17 e17 9 27e-2
VS18 12 s18 0
R18 s18 13 22e1
VS19 0 s19 0
V19 e19 s19 DC 15e-1
RI19 e19 13 27e-1
VS20 1 s20 0
R20 s20 8 82e2
VS21 10 s21 0
R21 s21 3 12e-1
VS22 5 s22 0
V22 e22 s22 DC 33e1
RI22 e22 11 12e-2
VS23 14 s23 0
R23 s23 12 82e0
VS24 7 s24 0
R24 s24 3 22e-2
VS25 2 s25 0
I25 s25 3 DC 68e-3
VS26 3 s26 0
R26 s26 2 82e-2
.control
set numdgt=17
op
print v(1) v(2) v(3) v(4) v(5) v(6) v(7) v(8) v(9) v(10)
print v(11) v(12) v(13) v(14)
print i(vs0) i(vs1) i(vs2) i(vs3) i(vs4) i(vs5) i(vs6) i(vs7) i(vs8) i(vs9)
print i(vs10) i(vs11) i(vs12) i(vs13) i(vs14) i(vs15) i(vs16) i(vs17) i(vs18) i(vs19)
print i(vs20) i(vs21) i(vs22) i(vs23) i(vs24) i(vs25) i(vs26)
.endc
.end
