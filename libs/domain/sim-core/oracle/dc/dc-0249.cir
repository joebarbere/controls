controls oracle dc-0249
* Generated (plan F2.7, ADR 0012): do not edit; regenerate with `pnpm sim oracle regen`. dc seed 20261030 index 249 nodes 20 elements 20
.options sparse gmin=1e-12 noopac
RG1 1 0 1000000000000
RG2 2 0 1000000000000
RG3 3 0 1000000000000
RG4 4 0 1000000000000
RG5 5 0 1000000000000
RG6 6 0 1000000000000
RG7 7 0 1000000000000
RG8 8 0 1000000000000
RG9 9 0 1000000000000
RG10 10 0 1000000000000
RG11 11 0 1000000000000
RG12 12 0 1000000000000
RG13 13 0 1000000000000
RG14 14 0 1000000000000
RG15 15 0 1000000000000
RG16 16 0 1000000000000
RG17 17 0 1000000000000
RG18 18 0 1000000000000
RG19 19 0 1000000000000
VS0 0 s0 0
R0 s0 18 27e-1
VS1 1 s1 0
R1 s1 18 82e0
VS2 11 s2 0
R2 s2 9 39e0
VS3 0 s3 0
V3 e3 s3 DC 82e0
RI3 e3 9 68e-1
VS4 15 s4 0
R4 s4 17 82e1
VS5 2 s5 0
R5 s5 9 18e-1
VS6 7 s6 0
R6 s6 12 82e1
VS7 17 s7 0
R7 s7 6 47e2
VS8 8 s8 0
R8 s8 10 68e-2
VS9 5 s9 0
R9 s9 9 12e1
VS10 4 s10 0
R10 s10 6 39e1
VS11 6 s11 0
R11 s11 18 82e0
VS12 10 s12 0
R12 s12 6 18e-1
VS13 16 s13 0
R13 s13 18 82e-1
VS14 7 s14 0
R14 s14 6 22e2
VS15 10 s15 0
R15 s15 14 56e0
VS16 7 s16 0
V16 e16 s16 DC 15e-1
RI16 e16 6 15e-1
VS17 19 s17 0
R17 s17 18 18e0
VS18 13 s18 0
R18 s18 1 10e0
VS19 6 s19 0
V19 e19 s19 DC 18e-1
RI19 e19 3 33e-3
.control
set numdgt=17
op
print v(1) v(2) v(3) v(4) v(5) v(6) v(7) v(8) v(9) v(10)
print v(11) v(12) v(13) v(14) v(15) v(16) v(17) v(18) v(19)
print i(vs0) i(vs1) i(vs2) i(vs3) i(vs4) i(vs5) i(vs6) i(vs7) i(vs8) i(vs9)
print i(vs10) i(vs11) i(vs12) i(vs13) i(vs14) i(vs15) i(vs16) i(vs17) i(vs18) i(vs19)
.endc
.end
