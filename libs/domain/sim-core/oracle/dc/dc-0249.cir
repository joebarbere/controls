controls oracle dc-0249
* Generated (plan F2.7, ADR 0012): do not edit; regenerate with `pnpm sim oracle regen`. dc seed 20261030 index 249 nodes 20 elements 29
.options sparse gmin=1e-12 noopac
RG1 1 0 1000000000000
RG2 2 0 1000000000000
RG3 3 0 1000000000000
RG4 4 0 1000000000000
RG5 5 0 1000000000000
RG6 6 0 1000000000000
RG7 7 0 1000000000000
RG8 8 0 1000000000000
RG9 9 0 1000000000000
RG10 10 0 1000000000000
RG11 11 0 1000000000000
RG12 12 0 1000000000000
RG13 13 0 1000000000000
RG14 14 0 1000000000000
RG15 15 0 1000000000000
RG16 16 0 1000000000000
RG17 17 0 1000000000000
RG18 18 0 1000000000000
RG19 19 0 1000000000000
VS0 1 s0 0
R0 s0 14 68e-1
VS1 5 s1 0
R1 s1 17 22e0
VS2 10 s2 0
R2 s2 14 56e0
VS3 0 s3 0
V3 e3 s3 DC 22e1
RI3 e3 19 39e-3
VS4 6 s4 0
V4 e4 s4 DC 82e0
RI4 e4 9 68e-1
VS5 5 s5 0
R5 s5 9 12e1
VS6 19 s6 0
R6 s6 18 18e0
VS7 8 s7 0
R7 s7 15 10e2
VS8 2 s8 0
V8 e8 s8 DC 18e-1
RI8 e8 3 33e-3
VS9 0 s9 0
R9 s9 9 18e-1
VS10 11 s10 0
R10 s10 9 39e0
VS11 3 s11 0
R11 s11 8 10e2
VS12 17 s12 0
R12 s12 2 47e2
VS13 13 s13 0
R13 s13 15 18e0
VS14 6 s14 0
R14 s14 18 27e-1
VS15 4 s15 0
R15 s15 2 39e1
VS16 8 s16 0
R16 s16 10 68e-2
VS17 16 s17 0
V17 e17 s17 DC 47e0
RI17 e17 17 82e-1
VS18 15 s18 0
R18 s18 17 82e1
VS19 4 s19 0
R19 s19 8 15e3
VS20 2 s20 0
R20 s20 18 82e0
VS21 7 s21 0
V21 e21 s21 DC 15e-1
RI21 e21 2 15e-1
VS22 13 s22 0
R22 s22 1 10e0
VS23 10 s23 0
R23 s23 2 18e-1
VS24 11 s24 0
R24 s24 15 15e0
VS25 1 s25 0
R25 s25 18 82e0
VS26 16 s26 0
R26 s26 18 82e-1
VS27 12 s27 0
R27 s27 11 47e-2
VS28 7 s28 0
R28 s28 12 82e1
.control
set numdgt=17
op
print v(1) v(2) v(3) v(4) v(5) v(6) v(7) v(8) v(9) v(10)
print v(11) v(12) v(13) v(14) v(15) v(16) v(17) v(18) v(19)
print i(vs0) i(vs1) i(vs2) i(vs3) i(vs4) i(vs5) i(vs6) i(vs7) i(vs8) i(vs9)
print i(vs10) i(vs11) i(vs12) i(vs13) i(vs14) i(vs15) i(vs16) i(vs17) i(vs18) i(vs19)
print i(vs20) i(vs21) i(vs22) i(vs23) i(vs24) i(vs25) i(vs26) i(vs27) i(vs28)
.endc
.end
