controls oracle dc-0450
* Generated (plan F2.7, ADR 0012): do not edit; regenerate with `pnpm sim oracle regen`. dc seed 20261030 index 450 nodes 14 elements 25
.options sparse gmin=1e-12 noopac
RG1 1 0 1000000000000
RG2 2 0 1000000000000
RG3 3 0 1000000000000
RG4 4 0 1000000000000
RG5 5 0 1000000000000
RG6 6 0 1000000000000
RG7 7 0 1000000000000
RG8 8 0 1000000000000
RG9 9 0 1000000000000
RG10 10 0 1000000000000
RG11 11 0 1000000000000
RG12 12 0 1000000000000
RG13 13 0 1000000000000
VS0 0 s0 0
V0 e0 s0 DC 22e0
RI0 e0 1 82e-1
VS1 9 s1 0
R1 s1 4 10e1
VS2 8 s2 0
R2 s2 4 39e1
VS3 10 s3 0
I3 s3 5 DC 68e-4
VS4 11 s4 0
R4 s4 5 12e3
VS5 5 s5 0
R5 s5 1 47e-1
VS6 11 s6 0
R6 s6 8 33e2
VS7 12 s7 0
R7 s7 9 15e-1
VS8 9 s8 0
R8 s8 7 12e-2
VS9 1 s9 0
R9 s9 7 56e0
VS10 0 s10 0
R10 s10 2 82e1
VS11 9 s11 0
R11 s11 1 15e3
VS12 2 s12 0
R12 s12 12 27e3
VS13 2 s13 0
R13 s13 0 12e2
VS14 3 s14 0
R14 s14 7 10e-2
VS15 4 s15 0
V15 e15 s15 DC 10e0
RI15 e15 0 15e-3
VS16 8 s16 0
R16 s16 12 68e-1
VS17 12 s17 0
R17 s17 6 18e2
VS18 1 s18 0
R18 s18 5 47e-2
VS19 2 s19 0
I19 s19 1 DC 12e-3
VS20 0 s20 0
R20 s20 13 10e-1
VS21 3 s21 0
R21 s21 10 56e-2
VS22 1 s22 0
V22 e22 s22 DC 39e-1
RI22 e22 0 68e-2
VS23 13 s23 0
R23 s23 7 27e-2
VS24 6 s24 0
V24 e24 s24 DC 22e0
RI24 e24 10 22e-3
.control
set numdgt=17
op
print v(1) v(2) v(3) v(4) v(5) v(6) v(7) v(8) v(9) v(10)
print v(11) v(12) v(13)
print i(vs0) i(vs1) i(vs2) i(vs3) i(vs4) i(vs5) i(vs6) i(vs7) i(vs8) i(vs9)
print i(vs10) i(vs11) i(vs12) i(vs13) i(vs14) i(vs15) i(vs16) i(vs17) i(vs18) i(vs19)
print i(vs20) i(vs21) i(vs22) i(vs23) i(vs24)
.endc
.end
