controls oracle dc-0450
* Generated (plan F2.7, ADR 0012): do not edit; regenerate with `pnpm sim oracle regen`. dc seed 20261030 index 450 nodes 14 elements 22
.options sparse gmin=1e-12 noopac
RG1 1 0 1000000000000
RG2 2 0 1000000000000
RG3 3 0 1000000000000
RG4 4 0 1000000000000
RG5 5 0 1000000000000
RG6 6 0 1000000000000
RG7 7 0 1000000000000
RG8 8 0 1000000000000
RG9 9 0 1000000000000
RG10 10 0 1000000000000
RG11 11 0 1000000000000
RG12 12 0 1000000000000
RG13 13 0 1000000000000
VS0 0 s0 0
V0 e0 s0 DC 39e-1
RI0 e0 9 68e-2
VS1 2 s1 0
I1 s1 0 DC 12e-3
VS2 0 s2 0
R2 s2 5 47e-2
VS3 2 s3 0
R3 s3 9 12e2
VS4 0 s4 0
R4 s4 7 56e0
VS5 1 s5 0
R5 s5 0 15e3
VS6 9 s6 0
R6 s6 2 82e1
VS7 9 s7 0
R7 s7 13 10e-1
VS8 11 s8 0
R8 s8 8 33e2
VS9 8 s9 0
R9 s9 4 39e1
VS10 12 s10 0
R10 s10 6 18e2
VS11 11 s11 0
R11 s11 5 12e3
VS12 10 s12 0
I12 s12 5 DC 68e-4
VS13 3 s13 0
R13 s13 10 56e-2
VS14 4 s14 0
V14 e14 s14 DC 10e0
RI14 e14 9 15e-3
VS15 9 s15 0
V15 e15 s15 DC 22e0
RI15 e15 0 82e-1
VS16 3 s16 0
R16 s16 7 10e-2
VS17 1 s17 0
R17 s17 7 12e-2
VS18 8 s18 0
R18 s18 12 68e-1
VS19 5 s19 0
R19 s19 0 47e-1
VS20 12 s20 0
R20 s20 1 15e-1
VS21 1 s21 0
R21 s21 4 10e1
.control
set numdgt=17
op
print v(1) v(2) v(3) v(4) v(5) v(6) v(7) v(8) v(9) v(10)
print v(11) v(12) v(13)
print i(vs0) i(vs1) i(vs2) i(vs3) i(vs4) i(vs5) i(vs6) i(vs7) i(vs8) i(vs9)
print i(vs10) i(vs11) i(vs12) i(vs13) i(vs14) i(vs15) i(vs16) i(vs17) i(vs18) i(vs19)
print i(vs20) i(vs21)
.endc
.end
