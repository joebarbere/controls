controls oracle dc-0053
* Generated (plan F2.7, ADR 0012): do not edit; regenerate with `pnpm sim oracle regen`. dc seed 20261030 index 53 nodes 3 elements 4
.options sparse gmin=1e-12 noopac
RG1 1 0 1000000000000
RG2 2 0 1000000000000
VS0 0 s0 0
V0 e0 s0 DC 27e-1
RI0 e0 1 68e-2
VS1 0 s1 0
I1 s1 1 DC 68e-2
VS2 2 s2 0
I2 s2 0 DC 68e-4
VS3 2 s3 0
V3 e3 s3 DC 68e0
RI3 e3 0 15e-1
.control
set numdgt=17
op
print v(1) v(2)
print i(vs0) i(vs1) i(vs2) i(vs3)
.endc
.end
