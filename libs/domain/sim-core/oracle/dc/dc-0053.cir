controls oracle dc-0053
* Generated (plan F2.7, ADR 0012): do not edit; regenerate with `pnpm sim oracle regen`. dc seed 20261030 index 53 nodes 3 elements 5
.options sparse gmin=1e-12 noopac
RG1 1 0 1000000000000
RG2 2 0 1000000000000
VS0 0 s0 0
I0 s0 2 DC 68e-4
VS1 0 s1 0
V1 e1 s1 DC 68e0
RI1 e1 2 15e-1
VS2 2 s2 0
V2 e2 s2 DC 27e-1
RI2 e2 1 68e-2
VS3 2 s3 0
I3 s3 1 DC 68e-2
VS4 0 s4 0
R4 s4 1 82e-1
.control
set numdgt=17
op
print v(1) v(2)
print i(vs0) i(vs1) i(vs2) i(vs3) i(vs4)
.endc
.end
