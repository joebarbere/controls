controls oracle dc-0393
* Generated (plan F2.7, ADR 0012): do not edit; regenerate with `pnpm sim oracle regen`. dc seed 20261030 index 393 nodes 11 elements 23
.options sparse gmin=1e-12 noopac
RG1 1 0 1000000000000
RG2 2 0 1000000000000
RG3 3 0 1000000000000
RG4 4 0 1000000000000
RG5 5 0 1000000000000
RG6 6 0 1000000000000
RG7 7 0 1000000000000
RG8 8 0 1000000000000
RG9 9 0 1000000000000
RG10 10 0 1000000000000
VS0 3 s0 0
R0 s0 0 33e3
VS1 1 s1 0
R1 s1 2 68e2
VS2 6 s2 0
R2 s2 0 82e-2
VS3 4 s3 0
R3 s3 1 33e2
VS4 9 s4 0
R4 s4 8 47e-1
VS5 1 s5 0
R5 s5 9 27e3
VS6 10 s6 0
R6 s6 4 47e-1
VS7 6 s7 0
R7 s7 10 39e-1
VS8 0 s8 0
V8 e8 s8 DC 27e-1
RI8 e8 4 33e-1
VS9 0 s9 0
I9 s9 1 DC 33e-1
VS10 9 s10 0
R10 s10 0 39e1
VS11 4 s11 0
V11 e11 s11 DC 22e1
RI11 e11 1 10e-2
VS12 0 s12 0
R12 s12 2 68e3
VS13 7 s13 0
R13 s13 10 68e1
VS14 8 s14 0
R14 s14 4 82e2
VS15 10 s15 0
R15 s15 1 10e2
VS16 6 s16 0
V16 e16 s16 DC 33e1
RI16 e16 5 22e-3
VS17 6 s17 0
R17 s17 3 82e-1
VS18 3 s18 0
I18 s18 10 DC 18e-3
VS19 10 s19 0
R19 s19 5 47e0
VS20 4 s20 0
I20 s20 6 DC 27e-3
VS21 6 s21 0
R21 s21 5 27e0
VS22 9 s22 0
V22 e22 s22 DC 47e0
RI22 e22 7 12e-3
.control
set numdgt=17
op
print v(1) v(2) v(3) v(4) v(5) v(6) v(7) v(8) v(9) v(10)
print i(vs0) i(vs1) i(vs2) i(vs3) i(vs4) i(vs5) i(vs6) i(vs7) i(vs8) i(vs9)
print i(vs10) i(vs11) i(vs12) i(vs13) i(vs14) i(vs15) i(vs16) i(vs17) i(vs18) i(vs19)
print i(vs20) i(vs21) i(vs22)
.endc
.end
