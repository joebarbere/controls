controls oracle dc-0393
* Generated (plan F2.7, ADR 0012): do not edit; regenerate with `pnpm sim oracle regen`. dc seed 20261030 index 393 nodes 11 elements 21
.options sparse gmin=1e-12 noopac
RG1 1 0 1000000000000
RG2 2 0 1000000000000
RG3 3 0 1000000000000
RG4 4 0 1000000000000
RG5 5 0 1000000000000
RG6 6 0 1000000000000
RG7 7 0 1000000000000
RG8 8 0 1000000000000
RG9 9 0 1000000000000
RG10 10 0 1000000000000
VS0 10 s0 0
R0 s0 0 47e-1
VS1 8 s1 0
R1 s1 0 82e2
VS2 3 s2 0
I2 s2 10 DC 18e-3
VS3 4 s3 0
R3 s3 3 82e-1
VS4 4 s4 0
R4 s4 10 39e-1
VS5 9 s5 0
R5 s5 6 39e1
VS6 10 s6 0
R6 s6 1 10e2
VS7 1 s7 0
R7 s7 9 27e3
VS8 0 s8 0
R8 s8 1 33e2
VS9 0 s9 0
V9 e9 s9 DC 22e1
RI9 e9 1 10e-2
VS10 9 s10 0
V10 e10 s10 DC 47e0
RI10 e10 7 12e-3
VS11 6 s11 0
R11 s11 2 68e3
VS12 0 s12 0
I12 s12 4 DC 27e-3
VS13 6 s13 0
I13 s13 1 DC 33e-1
VS14 4 s14 0
V14 e14 s14 DC 33e1
RI14 e14 5 22e-3
VS15 9 s15 0
R15 s15 8 47e-1
VS16 6 s16 0
V16 e16 s16 DC 27e-1
RI16 e16 0 33e-1
VS17 1 s17 0
R17 s17 2 68e2
VS18 4 s18 0
R18 s18 5 27e0
VS19 7 s19 0
R19 s19 10 68e1
VS20 10 s20 0
R20 s20 5 47e0
.control
set numdgt=17
op
print v(1) v(2) v(3) v(4) v(5) v(6) v(7) v(8) v(9) v(10)
print i(vs0) i(vs1) i(vs2) i(vs3) i(vs4) i(vs5) i(vs6) i(vs7) i(vs8) i(vs9)
print i(vs10) i(vs11) i(vs12) i(vs13) i(vs14) i(vs15) i(vs16) i(vs17) i(vs18) i(vs19)
print i(vs20)
.endc
.end
