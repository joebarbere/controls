controls oracle dc-0424
* Generated (plan F2.7, ADR 0012): do not edit; regenerate with `pnpm sim oracle regen`. dc seed 20261030 index 424 nodes 15 elements 25
.options sparse gmin=1e-12 noopac
RG1 1 0 1000000000000
RG2 2 0 1000000000000
RG3 3 0 1000000000000
RG4 4 0 1000000000000
RG5 5 0 1000000000000
RG6 6 0 1000000000000
RG7 7 0 1000000000000
RG8 8 0 1000000000000
RG9 9 0 1000000000000
RG10 10 0 1000000000000
RG11 11 0 1000000000000
RG12 12 0 1000000000000
RG13 13 0 1000000000000
RG14 14 0 1000000000000
VS0 9 s0 0
R0 s0 6 18e-2
VS1 1 s1 0
R1 s1 9 39e-1
VS2 2 s2 0
R2 s2 7 47e0
VS3 3 s3 0
I3 s3 11 DC 10e-3
VS4 13 s4 0
I4 s4 6 DC 68e-1
VS5 3 s5 0
R5 s5 11 18e3
VS6 1 s6 0
R6 s6 8 82e0
VS7 2 s7 0
R7 s7 7 18e1
VS8 2 s8 0
R8 s8 0 68e2
VS9 10 s9 0
R9 s9 6 56e2
VS10 0 s10 0
V10 e10 s10 DC 15e1
RI10 e10 13 39e-1
VS11 3 s11 0
R11 s11 4 12e-2
VS12 13 s12 0
V12 e12 s12 DC 82e0
RI12 e12 11 22e-2
VS13 13 s13 0
R13 s13 6 68e-1
VS14 14 s14 0
R14 s14 4 12e1
VS15 5 s15 0
I15 s15 2 DC 33e-1
VS16 13 s16 0
R16 s16 6 68e-1
VS17 10 s17 0
R17 s17 6 82e2
VS18 2 s18 0
R18 s18 8 47e2
VS19 11 s19 0
V19 e19 s19 DC 10e0
RI19 e19 3 15e-1
VS20 5 s20 0
R20 s20 6 10e3
VS21 0 s21 0
R21 s21 11 56e1
VS22 7 s22 0
R22 s22 1 27e3
VS23 11 s23 0
R23 s23 3 15e3
VS24 12 s24 0
R24 s24 10 22e0
.control
set numdgt=17
op
print v(1) v(2) v(3) v(4) v(5) v(6) v(7) v(8) v(9) v(10)
print v(11) v(12) v(13) v(14)
print i(vs0) i(vs1) i(vs2) i(vs3) i(vs4) i(vs5) i(vs6) i(vs7) i(vs8) i(vs9)
print i(vs10) i(vs11) i(vs12) i(vs13) i(vs14) i(vs15) i(vs16) i(vs17) i(vs18) i(vs19)
print i(vs20) i(vs21) i(vs22) i(vs23) i(vs24)
.endc
.end
