controls oracle dc-0424
* Generated (plan F2.7, ADR 0012): do not edit; regenerate with `pnpm sim oracle regen`. dc seed 20261030 index 424 nodes 15 elements 27
.options sparse gmin=1e-12 noopac
RG1 1 0 1000000000000
RG2 2 0 1000000000000
RG3 3 0 1000000000000
RG4 4 0 1000000000000
RG5 5 0 1000000000000
RG6 6 0 1000000000000
RG7 7 0 1000000000000
RG8 8 0 1000000000000
RG9 9 0 1000000000000
RG10 10 0 1000000000000
RG11 11 0 1000000000000
RG12 12 0 1000000000000
RG13 13 0 1000000000000
RG14 14 0 1000000000000
VS0 3 s0 0
R0 s0 4 12e-2
VS1 3 s1 0
R1 s1 0 18e3
VS2 2 s2 0
R2 s2 7 47e0
VS3 5 s3 0
R3 s3 6 10e3
VS4 2 s4 0
R4 s4 8 47e2
VS5 2 s5 0
R5 s5 7 18e1
VS6 1 s6 0
R6 s6 8 82e0
VS7 13 s7 0
I7 s7 6 DC 68e-1
VS8 0 s8 0
V8 e8 s8 DC 10e0
RI8 e8 3 15e-1
VS9 1 s9 0
R9 s9 9 39e-1
VS10 9 s10 0
R10 s10 6 18e-2
VS11 7 s11 0
R11 s11 1 27e3
VS12 10 s12 0
R12 s12 6 56e2
VS13 14 s13 0
R13 s13 5 22e3
VS14 14 s14 0
R14 s14 4 12e1
VS15 12 s15 0
R15 s15 13 33e3
VS16 12 s16 0
R16 s16 10 22e0
VS17 13 s17 0
V17 e17 s17 DC 82e0
RI17 e17 0 22e-2
VS18 0 s18 0
R18 s18 3 15e3
VS19 11 s19 0
R19 s19 0 56e1
VS20 11 s20 0
V20 e20 s20 DC 15e1
RI20 e20 13 39e-1
VS21 5 s21 0
I21 s21 2 DC 33e-1
VS22 2 s22 0
R22 s22 11 68e2
VS23 13 s23 0
R23 s23 6 68e-1
VS24 3 s24 0
I24 s24 0 DC 10e-3
VS25 10 s25 0
R25 s25 6 82e2
VS26 13 s26 0
R26 s26 6 68e-1
.control
set numdgt=17
op
print v(1) v(2) v(3) v(4) v(5) v(6) v(7) v(8) v(9) v(10)
print v(11) v(12) v(13) v(14)
print i(vs0) i(vs1) i(vs2) i(vs3) i(vs4) i(vs5) i(vs6) i(vs7) i(vs8) i(vs9)
print i(vs10) i(vs11) i(vs12) i(vs13) i(vs14) i(vs15) i(vs16) i(vs17) i(vs18) i(vs19)
print i(vs20) i(vs21) i(vs22) i(vs23) i(vs24) i(vs25) i(vs26)
.endc
.end
