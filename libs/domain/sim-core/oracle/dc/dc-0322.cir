controls oracle dc-0322
* Generated (plan F2.7, ADR 0012): do not edit; regenerate with `pnpm sim oracle regen`. dc seed 20261030 index 322 nodes 5 elements 6
.options sparse gmin=1e-12 noopac
RG1 1 0 1000000000000
RG2 2 0 1000000000000
RG3 3 0 1000000000000
RG4 4 0 1000000000000
VS0 4 s0 0
R0 s0 1 39e-1
VS1 1 s1 0
R1 s1 3 27e0
VS2 0 s2 0
V2 e2 s2 DC 15e-1
RI2 e2 2 47e-1
VS3 1 s3 0
I3 s3 4 DC 18e-4
VS4 2 s4 0
R4 s4 1 82e3
VS5 1 s5 0
R5 s5 4 56e-1
.control
set numdgt=17
op
print v(1) v(2) v(3) v(4)
print i(vs0) i(vs1) i(vs2) i(vs3) i(vs4) i(vs5)
.endc
.end
