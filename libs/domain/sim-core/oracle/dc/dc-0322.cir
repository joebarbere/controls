controls oracle dc-0322
* Generated (plan F2.7, ADR 0012): do not edit; regenerate with `pnpm sim oracle regen`. dc seed 20261030 index 322 nodes 5 elements 8
.options sparse gmin=1e-12 noopac
RG1 1 0 1000000000000
RG2 2 0 1000000000000
RG3 3 0 1000000000000
RG4 4 0 1000000000000
VS0 1 s0 0
R0 s0 4 56e-1
VS1 4 s1 0
R1 s1 1 39e-1
VS2 2 s2 0
R2 s2 4 68e0
VS3 0 s3 0
R3 s3 3 47e0
VS4 1 s4 0
R4 s4 3 27e0
VS5 0 s5 0
V5 e5 s5 DC 15e-1
RI5 e5 2 47e-1
VS6 2 s6 0
R6 s6 1 82e3
VS7 1 s7 0
I7 s7 4 DC 18e-4
.control
set numdgt=17
op
print v(1) v(2) v(3) v(4)
print i(vs0) i(vs1) i(vs2) i(vs3) i(vs4) i(vs5) i(vs6) i(vs7)
.endc
.end
