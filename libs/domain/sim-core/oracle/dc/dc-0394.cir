controls oracle dc-0394
* Generated (plan F2.7, ADR 0012): do not edit; regenerate with `pnpm sim oracle regen`. dc seed 20261030 index 394 nodes 23 elements 38
.options sparse gmin=1e-12 noopac
RG1 1 0 1000000000000
RG2 2 0 1000000000000
RG3 3 0 1000000000000
RG4 4 0 1000000000000
RG5 5 0 1000000000000
RG6 6 0 1000000000000
RG7 7 0 1000000000000
RG8 8 0 1000000000000
RG9 9 0 1000000000000
RG10 10 0 1000000000000
RG11 11 0 1000000000000
RG12 12 0 1000000000000
RG13 13 0 1000000000000
RG14 14 0 1000000000000
RG15 15 0 1000000000000
RG16 16 0 1000000000000
RG17 17 0 1000000000000
RG18 18 0 1000000000000
RG19 19 0 1000000000000
RG20 20 0 1000000000000
RG21 21 0 1000000000000
RG22 22 0 1000000000000
VS0 21 s0 0
R0 s0 9 47e3
VS1 17 s1 0
R1 s1 22 33e1
VS2 2 s2 0
R2 s2 17 22e0
VS3 0 s3 0
R3 s3 11 82e-2
VS4 14 s4 0
R4 s4 2 10e-2
VS5 22 s5 0
R5 s5 9 68e2
VS6 6 s6 0
R6 s6 19 27e0
VS7 6 s7 0
R7 s7 13 27e2
VS8 3 s8 0
R8 s8 21 82e-1
VS9 13 s9 0
R9 s9 2 39e3
VS10 5 s10 0
I10 s10 9 DC 39e-1
VS11 1 s11 0
R11 s11 7 82e3
VS12 0 s12 0
V12 e12 s12 DC 33e0
RI12 e12 8 22e-2
VS13 16 s13 0
R13 s13 13 27e3
VS14 4 s14 0
R14 s14 3 12e0
VS15 2 s15 0
R15 s15 0 82e-2
VS16 18 s16 0
R16 s16 2 18e-1
VS17 6 s17 0
R17 s17 9 39e0
VS18 22 s18 0
I18 s18 4 DC 56e-1
VS19 15 s19 0
R19 s19 17 56e1
VS20 4 s20 0
I20 s20 13 DC 15e-1
VS21 20 s21 0
R21 s21 13 15e-1
VS22 10 s22 0
R22 s22 18 22e-2
VS23 16 s23 0
R23 s23 13 56e3
VS24 19 s24 0
R24 s24 3 39e-1
VS25 8 s25 0
R25 s25 15 68e3
VS26 8 s26 0
R26 s26 17 39e1
VS27 10 s27 0
R27 s27 7 22e-2
VS28 4 s28 0
R28 s28 20 27e0
VS29 3 s29 0
V29 e29 s29 DC 22e1
RI29 e29 2 15e-1
VS30 3 s30 0
V30 e30 s30 DC 12e1
RI30 e30 12 22e-3
VS31 1 s31 0
V31 e31 s31 DC 18e0
RI31 e31 2 39e-3
VS32 6 s32 0
R32 s32 14 47e0
VS33 4 s33 0
R33 s33 5 10e1
VS34 5 s34 0
V34 e34 s34 DC 33e1
RI34 e34 16 18e-3
VS35 12 s35 0
R35 s35 17 39e-2
VS36 8 s36 0
R36 s36 11 39e-1
VS37 10 s37 0
R37 s37 13 33e2
.control
set numdgt=17
op
print v(1) v(2) v(3) v(4) v(5) v(6) v(7) v(8) v(9) v(10)
print v(11) v(12) v(13) v(14) v(15) v(16) v(17) v(18) v(19) v(20)
print v(21) v(22)
print i(vs0) i(vs1) i(vs2) i(vs3) i(vs4) i(vs5) i(vs6) i(vs7) i(vs8) i(vs9)
print i(vs10) i(vs11) i(vs12) i(vs13) i(vs14) i(vs15) i(vs16) i(vs17) i(vs18) i(vs19)
print i(vs20) i(vs21) i(vs22) i(vs23) i(vs24) i(vs25) i(vs26) i(vs27) i(vs28) i(vs29)
print i(vs30) i(vs31) i(vs32) i(vs33) i(vs34) i(vs35) i(vs36) i(vs37)
.endc
.end
