controls oracle dc-0394
* Generated (plan F2.7, ADR 0012): do not edit; regenerate with `pnpm sim oracle regen`. dc seed 20261030 index 394 nodes 23 elements 32
.options sparse gmin=1e-12 noopac
RG1 1 0 1000000000000
RG2 2 0 1000000000000
RG3 3 0 1000000000000
RG4 4 0 1000000000000
RG5 5 0 1000000000000
RG6 6 0 1000000000000
RG7 7 0 1000000000000
RG8 8 0 1000000000000
RG9 9 0 1000000000000
RG10 10 0 1000000000000
RG11 11 0 1000000000000
RG12 12 0 1000000000000
RG13 13 0 1000000000000
RG14 14 0 1000000000000
RG15 15 0 1000000000000
RG16 16 0 1000000000000
RG17 17 0 1000000000000
RG18 18 0 1000000000000
RG19 19 0 1000000000000
RG20 20 0 1000000000000
RG21 21 0 1000000000000
RG22 22 0 1000000000000
VS0 16 s0 0
R0 s0 13 27e3
VS1 5 s1 0
I1 s1 9 DC 39e-1
VS2 6 s2 0
R2 s2 19 27e0
VS3 22 s3 0
R3 s3 9 68e2
VS4 8 s4 0
R4 s4 17 39e1
VS5 20 s5 0
R5 s5 13 15e-1
VS6 10 s6 0
R6 s6 13 33e2
VS7 10 s7 0
R7 s7 7 22e-2
VS8 4 s8 0
I8 s8 13 DC 15e-1
VS9 0 s9 0
R9 s9 7 82e3
VS10 6 s10 0
R10 s10 13 27e2
VS11 17 s11 0
R11 s11 22 33e1
VS12 3 s12 0
R12 s12 21 82e-1
VS13 16 s13 0
R13 s13 13 56e3
VS14 22 s14 0
I14 s14 4 DC 56e-1
VS15 0 s15 0
V15 e15 s15 DC 18e0
RI15 e15 2 39e-3
VS16 13 s16 0
R16 s16 2 39e3
VS17 2 s17 0
R17 s17 17 22e0
VS18 1 s18 0
V18 e18 s18 DC 33e0
RI18 e18 8 22e-2
VS19 4 s19 0
R19 s19 5 10e1
VS20 2 s20 0
R20 s20 1 82e-2
VS21 8 s21 0
R21 s21 11 39e-1
VS22 8 s22 0
R22 s22 15 68e3
VS23 6 s23 0
R23 s23 14 47e0
VS24 4 s24 0
R24 s24 3 12e0
VS25 15 s25 0
R25 s25 17 56e1
VS26 6 s26 0
R26 s26 9 39e0
VS27 3 s27 0
V27 e27 s27 DC 12e1
RI27 e27 12 22e-3
VS28 1 s28 0
R28 s28 11 82e-2
VS29 14 s29 0
R29 s29 2 10e-2
VS30 3 s30 0
V30 e30 s30 DC 22e1
RI30 e30 2 15e-1
VS31 18 s31 0
R31 s31 2 18e-1
.control
set numdgt=17
op
print v(1) v(2) v(3) v(4) v(5) v(6) v(7) v(8) v(9) v(10)
print v(11) v(12) v(13) v(14) v(15) v(16) v(17) v(18) v(19) v(20)
print v(21) v(22)
print i(vs0) i(vs1) i(vs2) i(vs3) i(vs4) i(vs5) i(vs6) i(vs7) i(vs8) i(vs9)
print i(vs10) i(vs11) i(vs12) i(vs13) i(vs14) i(vs15) i(vs16) i(vs17) i(vs18) i(vs19)
print i(vs20) i(vs21) i(vs22) i(vs23) i(vs24) i(vs25) i(vs26) i(vs27) i(vs28) i(vs29)
print i(vs30) i(vs31)
.endc
.end
