controls oracle dc-0189
* Generated (plan F2.7, ADR 0012): do not edit; regenerate with `pnpm sim oracle regen`. dc seed 20261030 index 189 nodes 27 elements 38
.options sparse gmin=1e-12 noopac
RG1 1 0 1000000000000
RG2 2 0 1000000000000
RG3 3 0 1000000000000
RG4 4 0 1000000000000
RG5 5 0 1000000000000
RG6 6 0 1000000000000
RG7 7 0 1000000000000
RG8 8 0 1000000000000
RG9 9 0 1000000000000
RG10 10 0 1000000000000
RG11 11 0 1000000000000
RG12 12 0 1000000000000
RG13 13 0 1000000000000
RG14 14 0 1000000000000
RG15 15 0 1000000000000
RG16 16 0 1000000000000
RG17 17 0 1000000000000
RG18 18 0 1000000000000
RG19 19 0 1000000000000
RG20 20 0 1000000000000
RG21 21 0 1000000000000
RG22 22 0 1000000000000
RG23 23 0 1000000000000
RG24 24 0 1000000000000
RG25 25 0 1000000000000
RG26 26 0 1000000000000
VS0 0 s0 0
R0 s0 18 33e-1
VS1 24 s1 0
R1 s1 19 27e2
VS2 19 s2 0
R2 s2 17 39e2
VS3 16 s3 0
R3 s3 10 82e1
VS4 9 s4 0
R4 s4 6 82e1
VS5 0 s5 0
V5 e5 s5 DC 18e0
RI5 e5 14 82e-2
VS6 16 s6 0
R6 s6 3 22e1
VS7 4 s7 0
R7 s7 17 10e0
VS8 9 s8 0
V8 e8 s8 DC 12e0
RI8 e8 26 12e-2
VS9 2 s9 0
R9 s9 12 12e1
VS10 8 s10 0
I10 s10 17 DC 22e-3
VS11 12 s11 0
R11 s11 7 10e3
VS12 12 s12 0
R12 s12 22 27e1
VS13 19 s13 0
R13 s13 20 27e-1
VS14 2 s14 0
R14 s14 20 33e1
VS15 0 s15 0
R15 s15 7 12e2
VS16 2 s16 0
V16 e16 s16 DC 33e1
RI16 e16 9 33e-1
VS17 17 s17 0
R17 s17 8 18e0
VS18 21 s18 0
R18 s18 1 27e0
VS19 15 s19 0
R19 s19 11 15e-2
VS20 6 s20 0
R20 s20 13 18e2
VS21 14 s21 0
R21 s21 25 47e-2
VS22 20 s22 0
R22 s22 10 27e2
VS23 24 s23 0
R23 s23 3 33e2
VS24 13 s24 0
R24 s24 20 15e-1
VS25 1 s25 0
R25 s25 19 18e-1
VS26 12 s26 0
R26 s26 8 18e1
VS27 25 s27 0
R27 s27 0 33e0
VS28 0 s28 0
R28 s28 4 22e0
VS29 11 s29 0
R29 s29 19 18e-1
VS30 22 s30 0
R30 s30 26 82e1
VS31 20 s31 0
R31 s31 25 22e2
VS32 2 s32 0
V32 e32 s32 DC 68e-1
RI32 e32 23 22e-3
VS33 5 s33 0
R33 s33 0 15e0
VS34 23 s34 0
R34 s34 18 56e-1
VS35 2 s35 0
R35 s35 21 82e-2
VS36 6 s36 0
R36 s36 15 10e1
VS37 12 s37 0
R37 s37 5 33e1
.control
set numdgt=17
op
print v(1) v(2) v(3) v(4) v(5) v(6) v(7) v(8) v(9) v(10)
print v(11) v(12) v(13) v(14) v(15) v(16) v(17) v(18) v(19) v(20)
print v(21) v(22) v(23) v(24) v(25) v(26)
print i(vs0) i(vs1) i(vs2) i(vs3) i(vs4) i(vs5) i(vs6) i(vs7) i(vs8) i(vs9)
print i(vs10) i(vs11) i(vs12) i(vs13) i(vs14) i(vs15) i(vs16) i(vs17) i(vs18) i(vs19)
print i(vs20) i(vs21) i(vs22) i(vs23) i(vs24) i(vs25) i(vs26) i(vs27) i(vs28) i(vs29)
print i(vs30) i(vs31) i(vs32) i(vs33) i(vs34) i(vs35) i(vs36) i(vs37)
.endc
.end
