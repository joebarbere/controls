controls oracle dc-0189
* Generated (plan F2.7, ADR 0012): do not edit; regenerate with `pnpm sim oracle regen`. dc seed 20261030 index 189 nodes 27 elements 28
.options sparse gmin=1e-12 noopac
RG1 1 0 1000000000000
RG2 2 0 1000000000000
RG3 3 0 1000000000000
RG4 4 0 1000000000000
RG5 5 0 1000000000000
RG6 6 0 1000000000000
RG7 7 0 1000000000000
RG8 8 0 1000000000000
RG9 9 0 1000000000000
RG10 10 0 1000000000000
RG11 11 0 1000000000000
RG12 12 0 1000000000000
RG13 13 0 1000000000000
RG14 14 0 1000000000000
RG15 15 0 1000000000000
RG16 16 0 1000000000000
RG17 17 0 1000000000000
RG18 18 0 1000000000000
RG19 19 0 1000000000000
RG20 20 0 1000000000000
RG21 21 0 1000000000000
RG22 22 0 1000000000000
RG23 23 0 1000000000000
RG24 24 0 1000000000000
RG25 25 0 1000000000000
RG26 26 0 1000000000000
VS0 19 s0 0
R0 s0 17 39e2
VS1 2 s1 0
R1 s1 18 33e-1
VS2 0 s2 0
V2 e2 s2 DC 68e-1
RI2 e2 23 22e-3
VS3 15 s3 0
R3 s3 11 15e-2
VS4 4 s4 0
R4 s4 17 10e0
VS5 6 s5 0
R5 s5 13 18e2
VS6 14 s6 0
R6 s6 25 47e-2
VS7 11 s7 0
R7 s7 19 18e-1
VS8 25 s8 0
R8 s8 2 33e0
VS9 9 s9 0
R9 s9 6 82e1
VS10 24 s10 0
R10 s10 19 27e2
VS11 0 s11 0
R11 s11 20 33e1
VS12 1 s12 0
R12 s12 19 18e-1
VS13 12 s13 0
R13 s13 22 27e1
VS14 16 s14 0
R14 s14 3 22e1
VS15 0 s15 0
V15 e15 s15 DC 33e1
RI15 e15 9 33e-1
VS16 2 s16 0
R16 s16 7 12e2
VS17 16 s17 0
R17 s17 10 82e1
VS18 22 s18 0
R18 s18 26 82e1
VS19 5 s19 0
R19 s19 2 15e0
VS20 19 s20 0
R20 s20 20 27e-1
VS21 20 s21 0
R21 s21 10 27e2
VS22 12 s22 0
R22 s22 8 18e1
VS23 2 s23 0
V23 e23 s23 DC 18e0
RI23 e23 14 82e-2
VS24 20 s24 0
R24 s24 25 22e2
VS25 21 s25 0
R25 s25 1 27e0
VS26 8 s26 0
I26 s26 17 DC 22e-3
VS27 0 s27 0
R27 s27 12 12e1
.control
set numdgt=17
op
print v(1) v(2) v(3) v(4) v(5) v(6) v(7) v(8) v(9) v(10)
print v(11) v(12) v(13) v(14) v(15) v(16) v(17) v(18) v(19) v(20)
print v(21) v(22) v(23) v(24) v(25) v(26)
print i(vs0) i(vs1) i(vs2) i(vs3) i(vs4) i(vs5) i(vs6) i(vs7) i(vs8) i(vs9)
print i(vs10) i(vs11) i(vs12) i(vs13) i(vs14) i(vs15) i(vs16) i(vs17) i(vs18) i(vs19)
print i(vs20) i(vs21) i(vs22) i(vs23) i(vs24) i(vs25) i(vs26) i(vs27)
.endc
.end
