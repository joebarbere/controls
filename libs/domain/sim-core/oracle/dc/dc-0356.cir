controls oracle dc-0356
* Generated (plan F2.7, ADR 0012): do not edit; regenerate with `pnpm sim oracle regen`. dc seed 20261030 index 356 nodes 30 elements 43
.options sparse gmin=1e-12 noopac
RG1 1 0 1000000000000
RG2 2 0 1000000000000
RG3 3 0 1000000000000
RG4 4 0 1000000000000
RG5 5 0 1000000000000
RG6 6 0 1000000000000
RG7 7 0 1000000000000
RG8 8 0 1000000000000
RG9 9 0 1000000000000
RG10 10 0 1000000000000
RG11 11 0 1000000000000
RG12 12 0 1000000000000
RG13 13 0 1000000000000
RG14 14 0 1000000000000
RG15 15 0 1000000000000
RG16 16 0 1000000000000
RG17 17 0 1000000000000
RG18 18 0 1000000000000
RG19 19 0 1000000000000
RG20 20 0 1000000000000
RG21 21 0 1000000000000
RG22 22 0 1000000000000
RG23 23 0 1000000000000
RG24 24 0 1000000000000
RG25 25 0 1000000000000
RG26 26 0 1000000000000
RG27 27 0 1000000000000
RG28 28 0 1000000000000
RG29 29 0 1000000000000
VS0 19 s0 0
R0 s0 25 27e2
VS1 17 s1 0
R1 s1 6 68e-2
VS2 3 s2 0
R2 s2 18 12e3
VS3 27 s3 0
R3 s3 7 27e0
VS4 0 s4 0
V4 e4 s4 DC 33e1
RI4 e4 2 12e-1
VS5 9 s5 0
V5 e5 s5 DC 18e1
RI5 e5 4 68e-2
VS6 6 s6 0
V6 e6 s6 DC 56e0
RI6 e6 20 27e-3
VS7 12 s7 0
R7 s7 0 27e-2
VS8 14 s8 0
R8 s8 4 10e0
VS9 13 s9 0
I9 s9 0 DC 39e-2
VS10 13 s10 0
V10 e10 s10 DC 10e0
RI10 e10 17 68e-3
VS11 13 s11 0
R11 s11 7 15e-2
VS12 6 s12 0
R12 s12 3 33e-1
VS13 0 s13 0
R13 s13 4 82e-2
VS14 1 s14 0
V14 e14 s14 DC 47e-1
RI14 e14 16 82e-1
VS15 1 s15 0
R15 s15 0 12e-1
VS16 6 s16 0
R16 s16 11 15e0
VS17 26 s17 0
I17 s17 22 DC 27e-1
VS18 26 s18 0
R18 s18 7 33e-1
VS19 21 s19 0
R19 s19 22 82e-1
VS20 5 s20 0
R20 s20 11 10e1
VS21 21 s21 0
R21 s21 12 27e1
VS22 27 s22 0
I22 s22 14 DC 18e-1
VS23 16 s23 0
I23 s23 4 DC 12e-2
VS24 16 s24 0
R24 s24 6 39e0
VS25 4 s25 0
V25 e25 s25 DC 68e-1
RI25 e25 23 12e-1
VS26 3 s26 0
R26 s26 24 33e2
VS27 13 s27 0
R27 s27 28 39e1
VS28 28 s28 0
R28 s28 24 47e1
VS29 2 s29 0
R29 s29 24 27e0
VS30 16 s30 0
I30 s30 8 DC 47e-4
VS31 10 s31 0
R31 s31 3 33e-2
VS32 11 s32 0
V32 e32 s32 DC 12e0
RI32 e32 26 47e-3
VS33 5 s33 0
R33 s33 29 27e2
VS34 1 s34 0
R34 s34 19 27e-1
VS35 3 s35 0
R35 s35 12 10e-2
VS36 8 s36 0
R36 s36 1 68e0
VS37 1 s37 0
R37 s37 15 10e-1
VS38 20 s38 0
R38 s38 0 56e2
VS39 12 s39 0
R39 s39 4 22e2
VS40 20 s40 0
R40 s40 16 33e-2
VS41 4 s41 0
R41 s41 11 56e3
VS42 0 s42 0
R42 s42 23 82e-1
.control
set numdgt=17
op
print v(1) v(2) v(3) v(4) v(5) v(6) v(7) v(8) v(9) v(10)
print v(11) v(12) v(13) v(14) v(15) v(16) v(17) v(18) v(19) v(20)
print v(21) v(22) v(23) v(24) v(25) v(26) v(27) v(28) v(29)
print i(vs0) i(vs1) i(vs2) i(vs3) i(vs4) i(vs5) i(vs6) i(vs7) i(vs8) i(vs9)
print i(vs10) i(vs11) i(vs12) i(vs13) i(vs14) i(vs15) i(vs16) i(vs17) i(vs18) i(vs19)
print i(vs20) i(vs21) i(vs22) i(vs23) i(vs24) i(vs25) i(vs26) i(vs27) i(vs28) i(vs29)
print i(vs30) i(vs31) i(vs32) i(vs33) i(vs34) i(vs35) i(vs36) i(vs37) i(vs38) i(vs39)
print i(vs40) i(vs41) i(vs42)
.endc
.end
