controls oracle dc-0244
* Generated (plan F2.7, ADR 0012): do not edit; regenerate with `pnpm sim oracle regen`. dc seed 20261030 index 244 nodes 19 elements 34
.options sparse gmin=1e-12 noopac
RG1 1 0 1000000000000
RG2 2 0 1000000000000
RG3 3 0 1000000000000
RG4 4 0 1000000000000
RG5 5 0 1000000000000
RG6 6 0 1000000000000
RG7 7 0 1000000000000
RG8 8 0 1000000000000
RG9 9 0 1000000000000
RG10 10 0 1000000000000
RG11 11 0 1000000000000
RG12 12 0 1000000000000
RG13 13 0 1000000000000
RG14 14 0 1000000000000
RG15 15 0 1000000000000
RG16 16 0 1000000000000
RG17 17 0 1000000000000
RG18 18 0 1000000000000
VS0 12 s0 0
R0 s0 0 12e1
VS1 11 s1 0
R1 s1 4 22e-2
VS2 16 s2 0
I2 s2 8 DC 33e-1
VS3 9 s3 0
R3 s3 16 56e2
VS4 3 s4 0
R4 s4 8 12e3
VS5 7 s5 0
R5 s5 18 68e1
VS6 10 s6 0
R6 s6 11 15e0
VS7 18 s7 0
R7 s7 11 27e1
VS8 0 s8 0
V8 e8 s8 DC 12e0
RI8 e8 14 18e-2
VS9 15 s9 0
R9 s9 7 18e2
VS10 7 s10 0
R10 s10 4 27e2
VS11 1 s11 0
V11 e11 s11 DC 82e1
RI11 e11 18 18e-3
VS12 17 s12 0
R12 s12 4 27e2
VS13 6 s13 0
R13 s13 5 68e-2
VS14 9 s14 0
R14 s14 6 68e-2
VS15 11 s15 0
I15 s15 1 DC 10e-1
VS16 14 s16 0
R16 s16 13 18e1
VS17 4 s17 0
R17 s17 15 33e-1
VS18 5 s18 0
V18 e18 s18 DC 33e-1
RI18 e18 0 22e-2
VS19 5 s19 0
R19 s19 10 27e3
VS20 17 s20 0
R20 s20 5 56e1
VS21 9 s21 0
R21 s21 2 47e-1
VS22 9 s22 0
R22 s22 4 27e2
VS23 16 s23 0
R23 s23 9 12e-2
VS24 14 s24 0
R24 s24 9 12e1
VS25 3 s25 0
R25 s25 1 10e0
VS26 13 s26 0
R26 s26 7 12e1
VS27 16 s27 0
R27 s27 10 10e0
VS28 2 s28 0
R28 s28 8 68e2
VS29 8 s29 0
R29 s29 12 12e-2
VS30 17 s30 0
R30 s30 0 22e3
VS31 9 s31 0
R31 s31 18 33e-2
VS32 3 s32 0
R32 s32 17 39e-1
VS33 15 s33 0
R33 s33 17 10e0
.control
set numdgt=17
op
print v(1) v(2) v(3) v(4) v(5) v(6) v(7) v(8) v(9) v(10)
print v(11) v(12) v(13) v(14) v(15) v(16) v(17) v(18)
print i(vs0) i(vs1) i(vs2) i(vs3) i(vs4) i(vs5) i(vs6) i(vs7) i(vs8) i(vs9)
print i(vs10) i(vs11) i(vs12) i(vs13) i(vs14) i(vs15) i(vs16) i(vs17) i(vs18) i(vs19)
print i(vs20) i(vs21) i(vs22) i(vs23) i(vs24) i(vs25) i(vs26) i(vs27) i(vs28) i(vs29)
print i(vs30) i(vs31) i(vs32) i(vs33)
.endc
.end
