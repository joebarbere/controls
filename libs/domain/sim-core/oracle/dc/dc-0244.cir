controls oracle dc-0244
* Generated (plan F2.7, ADR 0012): do not edit; regenerate with `pnpm sim oracle regen`. dc seed 20261030 index 244 nodes 19 elements 30
.options sparse gmin=1e-12 noopac
RG1 1 0 1000000000000
RG2 2 0 1000000000000
RG3 3 0 1000000000000
RG4 4 0 1000000000000
RG5 5 0 1000000000000
RG6 6 0 1000000000000
RG7 7 0 1000000000000
RG8 8 0 1000000000000
RG9 9 0 1000000000000
RG10 10 0 1000000000000
RG11 11 0 1000000000000
RG12 12 0 1000000000000
RG13 13 0 1000000000000
RG14 14 0 1000000000000
RG15 15 0 1000000000000
RG16 16 0 1000000000000
RG17 17 0 1000000000000
RG18 18 0 1000000000000
VS0 4 s0 0
R0 s0 15 33e-1
VS1 5 s1 0
R1 s1 10 27e3
VS2 11 s2 0
R2 s2 4 22e-2
VS3 17 s3 0
R3 s3 0 22e3
VS4 18 s4 0
R4 s4 11 27e1
VS5 11 s5 0
I5 s5 1 DC 10e-1
VS6 2 s6 0
R6 s6 8 68e2
VS7 16 s7 0
R7 s7 9 12e-2
VS8 9 s8 0
R8 s8 18 33e-2
VS9 7 s9 0
R9 s9 4 27e2
VS10 10 s10 0
R10 s10 11 15e0
VS11 15 s11 0
R11 s11 7 18e2
VS12 0 s12 0
V12 e12 s12 DC 12e0
RI12 e12 14 18e-2
VS13 9 s13 0
R13 s13 16 56e2
VS14 14 s14 0
R14 s14 9 12e1
VS15 8 s15 0
R15 s15 12 12e-2
VS16 14 s16 0
R16 s16 13 18e1
VS17 5 s17 0
V17 e17 s17 DC 33e-1
RI17 e17 0 22e-2
VS18 9 s18 0
R18 s18 2 47e-1
VS19 3 s19 0
R19 s19 1 10e0
VS20 3 s20 0
R20 s20 8 12e3
VS21 16 s21 0
I21 s21 8 DC 33e-1
VS22 3 s22 0
R22 s22 17 39e-1
VS23 12 s23 0
R23 s23 0 12e1
VS24 9 s24 0
R24 s24 4 27e2
VS25 9 s25 0
R25 s25 6 68e-2
VS26 15 s26 0
R26 s26 17 10e0
VS27 17 s27 0
R27 s27 5 56e1
VS28 17 s28 0
R28 s28 4 27e2
VS29 7 s29 0
R29 s29 18 68e1
.control
set numdgt=17
op
print v(1) v(2) v(3) v(4) v(5) v(6) v(7) v(8) v(9) v(10)
print v(11) v(12) v(13) v(14) v(15) v(16) v(17) v(18)
print i(vs0) i(vs1) i(vs2) i(vs3) i(vs4) i(vs5) i(vs6) i(vs7) i(vs8) i(vs9)
print i(vs10) i(vs11) i(vs12) i(vs13) i(vs14) i(vs15) i(vs16) i(vs17) i(vs18) i(vs19)
print i(vs20) i(vs21) i(vs22) i(vs23) i(vs24) i(vs25) i(vs26) i(vs27) i(vs28) i(vs29)
.endc
.end
