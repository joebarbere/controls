controls oracle dc-0396
* Generated (plan F2.7, ADR 0012): do not edit; regenerate with `pnpm sim oracle regen`. dc seed 20261030 index 396 nodes 8 elements 12
.options sparse gmin=1e-12 noopac
RG1 1 0 1000000000000
RG2 2 0 1000000000000
RG3 3 0 1000000000000
RG4 4 0 1000000000000
RG5 5 0 1000000000000
RG6 6 0 1000000000000
RG7 7 0 1000000000000
VS0 7 s0 0
R0 s0 6 82e-1
VS1 3 s1 0
R1 s1 4 33e-1
VS2 1 s2 0
I2 s2 3 DC 39e-4
VS3 5 s3 0
I3 s3 1 DC 39e-3
VS4 1 s4 0
R4 s4 6 18e2
VS5 3 s5 0
R5 s5 0 47e0
VS6 2 s6 0
R6 s6 5 82e-2
VS7 0 s7 0
R7 s7 7 68e2
VS8 1 s8 0
R8 s8 2 12e-1
VS9 1 s9 0
R9 s9 0 22e0
VS10 3 s10 0
R10 s10 0 82e3
VS11 1 s11 0
R11 s11 7 22e1
.control
set numdgt=17
op
print v(1) v(2) v(3) v(4) v(5) v(6) v(7)
print i(vs0) i(vs1) i(vs2) i(vs3) i(vs4) i(vs5) i(vs6) i(vs7) i(vs8) i(vs9)
print i(vs10) i(vs11)
.endc
.end
