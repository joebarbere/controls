controls oracle dc-0396
* Generated (plan F2.7, ADR 0012): do not edit; regenerate with `pnpm sim oracle regen`. dc seed 20261030 index 396 nodes 8 elements 13
.options sparse gmin=1e-12 noopac
RG1 1 0 1000000000000
RG2 2 0 1000000000000
RG3 3 0 1000000000000
RG4 4 0 1000000000000
RG5 5 0 1000000000000
RG6 6 0 1000000000000
RG7 7 0 1000000000000
VS0 0 s0 0
I0 s0 1 DC 39e-3
VS1 3 s1 0
R1 s1 4 33e-1
VS2 5 s2 0
R2 s2 7 68e2
VS3 1 s3 0
R3 s3 2 12e-1
VS4 1 s4 0
I4 s4 3 DC 39e-4
VS5 0 s5 0
V5 e5 s5 DC 12e0
RI5 e5 4 47e-1
VS6 3 s6 0
R6 s6 5 47e0
VS7 2 s7 0
R7 s7 0 82e-2
VS8 7 s8 0
R8 s8 6 82e-1
VS9 1 s9 0
R9 s9 7 22e1
VS10 1 s10 0
R10 s10 6 18e2
VS11 3 s11 0
R11 s11 5 82e3
VS12 1 s12 0
R12 s12 5 22e0
.control
set numdgt=17
op
print v(1) v(2) v(3) v(4) v(5) v(6) v(7)
print i(vs0) i(vs1) i(vs2) i(vs3) i(vs4) i(vs5) i(vs6) i(vs7) i(vs8) i(vs9)
print i(vs10) i(vs11) i(vs12)
.endc
.end
