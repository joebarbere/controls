controls oracle dc-0157
* Generated (plan F2.7, ADR 0012): do not edit; regenerate with `pnpm sim oracle regen`. dc seed 20261030 index 157 nodes 14 elements 29
.options sparse gmin=1e-12 noopac
RG1 1 0 1000000000000
RG2 2 0 1000000000000
RG3 3 0 1000000000000
RG4 4 0 1000000000000
RG5 5 0 1000000000000
RG6 6 0 1000000000000
RG7 7 0 1000000000000
RG8 8 0 1000000000000
RG9 9 0 1000000000000
RG10 10 0 1000000000000
RG11 11 0 1000000000000
RG12 12 0 1000000000000
RG13 13 0 1000000000000
VS0 12 s0 0
R0 s0 9 39e2
VS1 1 s1 0
R1 s1 11 18e-2
VS2 10 s2 0
R2 s2 13 10e-1
VS3 6 s3 0
I3 s3 13 DC 39e-2
VS4 4 s4 0
R4 s4 5 82e3
VS5 5 s5 0
R5 s5 6 27e0
VS6 1 s6 0
R6 s6 2 10e-1
VS7 0 s7 0
V7 e7 s7 DC 47e-1
RI7 e7 12 39e-3
VS8 7 s8 0
I8 s8 8 DC 47e-3
VS9 2 s9 0
V9 e9 s9 DC 82e1
RI9 e9 3 33e-3
VS10 7 s10 0
R10 s10 11 82e2
VS11 7 s11 0
R11 s11 12 68e1
VS12 6 s12 0
R12 s12 9 12e3
VS13 2 s13 0
R13 s13 6 15e3
VS14 1 s14 0
R14 s14 2 68e-1
VS15 0 s15 0
V15 e15 s15 DC 82e-1
RI15 e15 8 39e-1
VS16 3 s16 0
R16 s16 0 39e3
VS17 4 s17 0
R17 s17 11 12e2
VS18 12 s18 0
R18 s18 2 22e1
VS19 4 s19 0
I19 s19 13 DC 39e-4
VS20 12 s20 0
R20 s20 5 47e-2
VS21 1 s21 0
I21 s21 13 DC 10e-4
VS22 12 s22 0
R22 s22 11 39e-2
VS23 1 s23 0
R23 s23 3 18e2
VS24 4 s24 0
I24 s24 0 DC 68e-4
VS25 11 s25 0
V25 e25 s25 DC 68e0
RI25 e25 13 82e-2
VS26 11 s26 0
V26 e26 s26 DC 56e0
RI26 e26 8 15e-2
VS27 6 s27 0
R27 s27 10 18e1
VS28 8 s28 0
R28 s28 10 47e3
.control
set numdgt=17
op
print v(1) v(2) v(3) v(4) v(5) v(6) v(7) v(8) v(9) v(10)
print v(11) v(12) v(13)
print i(vs0) i(vs1) i(vs2) i(vs3) i(vs4) i(vs5) i(vs6) i(vs7) i(vs8) i(vs9)
print i(vs10) i(vs11) i(vs12) i(vs13) i(vs14) i(vs15) i(vs16) i(vs17) i(vs18) i(vs19)
print i(vs20) i(vs21) i(vs22) i(vs23) i(vs24) i(vs25) i(vs26) i(vs27) i(vs28)
.endc
.end
