controls oracle dc-0157
* Generated (plan F2.7, ADR 0012): do not edit; regenerate with `pnpm sim oracle regen`. dc seed 20261030 index 157 nodes 14 elements 27
.options sparse gmin=1e-12 noopac
RG1 1 0 1000000000000
RG2 2 0 1000000000000
RG3 3 0 1000000000000
RG4 4 0 1000000000000
RG5 5 0 1000000000000
RG6 6 0 1000000000000
RG7 7 0 1000000000000
RG8 8 0 1000000000000
RG9 9 0 1000000000000
RG10 10 0 1000000000000
RG11 11 0 1000000000000
RG12 12 0 1000000000000
RG13 13 0 1000000000000
VS0 0 s0 0
V0 e0 s0 DC 82e1
RI0 e0 3 33e-3
VS1 5 s1 0
R1 s1 6 27e0
VS2 4 s2 0
R2 s2 11 12e2
VS3 6 s3 0
I3 s3 13 DC 39e-2
VS4 1 s4 0
R4 s4 0 68e-1
VS5 11 s5 0
V5 e5 s5 DC 68e0
RI5 e5 13 82e-2
VS6 8 s6 0
R6 s6 10 47e3
VS7 1 s7 0
R7 s7 0 10e-1
VS8 7 s8 0
R8 s8 11 82e2
VS9 4 s9 0
I9 s9 13 DC 39e-4
VS10 7 s10 0
R10 s10 2 68e1
VS11 2 s11 0
R11 s11 5 47e-2
VS12 1 s12 0
I12 s12 13 DC 10e-4
VS13 2 s13 0
R13 s13 0 22e1
VS14 6 s14 0
R14 s14 10 18e1
VS15 1 s15 0
R15 s15 11 18e-2
VS16 0 s16 0
R16 s16 6 15e3
VS17 4 s17 0
I17 s17 12 DC 68e-4
VS18 1 s18 0
R18 s18 3 18e2
VS19 3 s19 0
R19 s19 12 39e3
VS20 11 s20 0
V20 e20 s20 DC 56e0
RI20 e20 8 15e-2
VS21 12 s21 0
V21 e21 s21 DC 47e-1
RI21 e21 2 39e-3
VS22 10 s22 0
R22 s22 13 10e-1
VS23 12 s23 0
V23 e23 s23 DC 82e-1
RI23 e23 8 39e-1
VS24 2 s24 0
R24 s24 9 39e2
VS25 7 s25 0
I25 s25 8 DC 47e-3
VS26 2 s26 0
R26 s26 11 39e-2
.control
set numdgt=17
op
print v(1) v(2) v(3) v(4) v(5) v(6) v(7) v(8) v(9) v(10)
print v(11) v(12) v(13)
print i(vs0) i(vs1) i(vs2) i(vs3) i(vs4) i(vs5) i(vs6) i(vs7) i(vs8) i(vs9)
print i(vs10) i(vs11) i(vs12) i(vs13) i(vs14) i(vs15) i(vs16) i(vs17) i(vs18) i(vs19)
print i(vs20) i(vs21) i(vs22) i(vs23) i(vs24) i(vs25) i(vs26)
.endc
.end
