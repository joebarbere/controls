controls oracle dc-0253
* Generated (plan F2.7, ADR 0012): do not edit; regenerate with `pnpm sim oracle regen`. dc seed 20261030 index 253 nodes 12 elements 16
.options sparse gmin=1e-12 noopac
RG1 1 0 1000000000000
RG2 2 0 1000000000000
RG3 3 0 1000000000000
RG4 4 0 1000000000000
RG5 5 0 1000000000000
RG6 6 0 1000000000000
RG7 7 0 1000000000000
RG8 8 0 1000000000000
RG9 9 0 1000000000000
RG10 10 0 1000000000000
RG11 11 0 1000000000000
VS0 11 s0 0
R0 s0 1 33e1
VS1 5 s1 0
R1 s1 0 18e-1
VS2 9 s2 0
R2 s2 4 10e-2
VS3 2 s3 0
R3 s3 0 27e3
VS4 0 s4 0
R4 s4 9 27e3
VS5 7 s5 0
R5 s5 9 10e-1
VS6 0 s6 0
R6 s6 6 18e-2
VS7 0 s7 0
V7 e7 s7 DC 12e1
RI7 e7 9 56e-2
VS8 8 s8 0
R8 s8 3 56e2
VS9 3 s9 0
V9 e9 s9 DC 56e1
RI9 e9 2 10e-2
VS10 5 s10 0
R10 s10 9 33e-2
VS11 11 s11 0
R11 s11 0 18e0
VS12 3 s12 0
R12 s12 11 82e2
VS13 10 s13 0
R13 s13 9 15e-2
VS14 1 s14 0
V14 e14 s14 DC 10e1
RI14 e14 6 82e-3
VS15 10 s15 0
R15 s15 8 33e-1
.control
set numdgt=17
op
print v(1) v(2) v(3) v(4) v(5) v(6) v(7) v(8) v(9) v(10)
print v(11)
print i(vs0) i(vs1) i(vs2) i(vs3) i(vs4) i(vs5) i(vs6) i(vs7) i(vs8) i(vs9)
print i(vs10) i(vs11) i(vs12) i(vs13) i(vs14) i(vs15)
.endc
.end
