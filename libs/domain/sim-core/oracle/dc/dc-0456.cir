controls oracle dc-0456
* Generated (plan F2.7, ADR 0012): do not edit; regenerate with `pnpm sim oracle regen`. dc seed 20261030 index 456 nodes 9 elements 13
.options sparse gmin=1e-12 noopac
RG1 1 0 1000000000000
RG2 2 0 1000000000000
RG3 3 0 1000000000000
RG4 4 0 1000000000000
RG5 5 0 1000000000000
RG6 6 0 1000000000000
RG7 7 0 1000000000000
RG8 8 0 1000000000000
VS0 0 s0 0
V0 e0 s0 DC 33e0
RI0 e0 8 39e-1
VS1 2 s1 0
R1 s1 4 22e2
VS2 2 s2 0
R2 s2 6 22e2
VS3 4 s3 0
R3 s3 6 33e3
VS4 6 s4 0
V4 e4 s4 DC 10e1
RI4 e4 1 15e-1
VS5 2 s5 0
R5 s5 3 39e2
VS6 6 s6 0
R6 s6 5 68e2
VS7 7 s7 0
V7 e7 s7 DC 47e0
RI7 e7 8 27e-3
VS8 6 s8 0
R8 s8 0 56e3
VS9 0 s9 0
R9 s9 1 15e1
VS10 5 s10 0
R10 s10 7 18e-2
VS11 1 s11 0
V11 e11 s11 DC 39e-1
RI11 e11 3 18e-3
VS12 0 s12 0
R12 s12 7 18e-2
.control
set numdgt=17
op
print v(1) v(2) v(3) v(4) v(5) v(6) v(7) v(8)
print i(vs0) i(vs1) i(vs2) i(vs3) i(vs4) i(vs5) i(vs6) i(vs7) i(vs8) i(vs9)
print i(vs10) i(vs11) i(vs12)
.endc
.end
