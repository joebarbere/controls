controls oracle dc-0426
* Generated (plan F2.7, ADR 0012): do not edit; regenerate with `pnpm sim oracle regen`. dc seed 20261030 index 426 nodes 29 elements 56
.options sparse gmin=1e-12 noopac
RG1 1 0 1000000000000
RG2 2 0 1000000000000
RG3 3 0 1000000000000
RG4 4 0 1000000000000
RG5 5 0 1000000000000
RG6 6 0 1000000000000
RG7 7 0 1000000000000
RG8 8 0 1000000000000
RG9 9 0 1000000000000
RG10 10 0 1000000000000
RG11 11 0 1000000000000
RG12 12 0 1000000000000
RG13 13 0 1000000000000
RG14 14 0 1000000000000
RG15 15 0 1000000000000
RG16 16 0 1000000000000
RG17 17 0 1000000000000
RG18 18 0 1000000000000
RG19 19 0 1000000000000
RG20 20 0 1000000000000
RG21 21 0 1000000000000
RG22 22 0 1000000000000
RG23 23 0 1000000000000
RG24 24 0 1000000000000
RG25 25 0 1000000000000
RG26 26 0 1000000000000
RG27 27 0 1000000000000
RG28 28 0 1000000000000
VS0 3 s0 0
R0 s0 26 82e2
VS1 0 s1 0
V1 e1 s1 DC 47e-1
RI1 e1 6 82e-1
VS2 3 s2 0
R2 s2 21 47e-2
VS3 9 s3 0
I3 s3 8 DC 22e-1
VS4 23 s4 0
R4 s4 20 18e1
VS5 20 s5 0
V5 e5 s5 DC 22e0
RI5 e5 21 18e-3
VS6 9 s6 0
V6 e6 s6 DC 10e0
RI6 e6 0 27e-3
VS7 23 s7 0
R7 s7 4 10e3
VS8 24 s8 0
R8 s8 12 82e1
VS9 1 s9 0
R9 s9 7 18e-1
VS10 25 s10 0
R10 s10 10 12e1
VS11 26 s11 0
R11 s11 4 39e1
VS12 7 s12 0
I12 s12 25 DC 18e-3
VS13 13 s13 0
R13 s13 0 68e-1
VS14 13 s14 0
R14 s14 7 12e3
VS15 12 s15 0
I15 s15 19 DC 27e-4
VS16 5 s16 0
V16 e16 s16 DC 10e1
RI16 e16 19 15e-1
VS17 5 s17 0
I17 s17 24 DC 33e-2
VS18 16 s18 0
R18 s18 7 39e3
VS19 4 s19 0
V19 e19 s19 DC 27e1
RI19 e19 7 82e-3
VS20 20 s20 0
R20 s20 12 39e1
VS21 6 s21 0
V21 e21 s21 DC 47e1
RI21 e21 14 27e-1
VS22 19 s22 0
R22 s22 11 33e0
VS23 24 s23 0
V23 e23 s23 DC 56e0
RI23 e23 22 22e-2
VS24 13 s24 0
R24 s24 27 15e-2
VS25 25 s25 0
R25 s25 7 22e2
VS26 7 s26 0
R26 s26 22 27e-2
VS27 7 s27 0
I27 s27 0 DC 10e-1
VS28 12 s28 0
V28 e28 s28 DC 10e1
RI28 e28 9 33e-2
VS29 8 s29 0
R29 s29 28 39e-2
VS30 0 s30 0
R30 s30 22 18e-1
VS31 10 s31 0
R31 s31 22 22e2
VS32 22 s32 0
R32 s32 17 47e-2
VS33 18 s33 0
R33 s33 16 10e-2
VS34 17 s34 0
R34 s34 24 12e-2
VS35 18 s35 0
R35 s35 6 10e-1
VS36 27 s36 0
V36 e36 s36 DC 82e0
RI36 e36 26 33e-3
VS37 0 s37 0
R37 s37 8 39e-1
VS38 1 s38 0
I38 s38 7 DC 39e-2
VS39 24 s39 0
I39 s39 21 DC 22e-2
VS40 4 s40 0
R40 s40 2 27e2
VS41 1 s41 0
R41 s41 5 47e1
VS42 15 s42 0
V42 e42 s42 DC 27e-1
RI42 e42 14 82e-2
VS43 12 s43 0
R43 s43 27 27e-2
VS44 27 s44 0
R44 s44 22 10e3
VS45 7 s45 0
R45 s45 15 47e2
VS46 11 s46 0
I46 s46 18 DC 39e-3
VS47 1 s47 0
R47 s47 28 15e0
VS48 22 s48 0
V48 e48 s48 DC 12e1
RI48 e48 17 27e-1
VS49 2 s49 0
R49 s49 23 82e2
VS50 24 s50 0
R50 s50 12 18e3
VS51 20 s51 0
R51 s51 3 18e3
VS52 23 s52 0
V52 e52 s52 DC 39e1
RI52 e52 11 18e-2
VS53 24 s53 0
R53 s53 19 10e0
VS54 8 s54 0
I54 s54 13 DC 18e-2
VS55 20 s55 0
R55 s55 2 82e2
.control
set numdgt=17
op
print v(1) v(2) v(3) v(4) v(5) v(6) v(7) v(8) v(9) v(10)
print v(11) v(12) v(13) v(14) v(15) v(16) v(17) v(18) v(19) v(20)
print v(21) v(22) v(23) v(24) v(25) v(26) v(27) v(28)
print i(vs0) i(vs1) i(vs2) i(vs3) i(vs4) i(vs5) i(vs6) i(vs7) i(vs8) i(vs9)
print i(vs10) i(vs11) i(vs12) i(vs13) i(vs14) i(vs15) i(vs16) i(vs17) i(vs18) i(vs19)
print i(vs20) i(vs21) i(vs22) i(vs23) i(vs24) i(vs25) i(vs26) i(vs27) i(vs28) i(vs29)
print i(vs30) i(vs31) i(vs32) i(vs33) i(vs34) i(vs35) i(vs36) i(vs37) i(vs38) i(vs39)
print i(vs40) i(vs41) i(vs42) i(vs43) i(vs44) i(vs45) i(vs46) i(vs47) i(vs48) i(vs49)
print i(vs50) i(vs51) i(vs52) i(vs53) i(vs54) i(vs55)
.endc
.end
