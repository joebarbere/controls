controls oracle dc-0478
* Generated (plan F2.7, ADR 0012): do not edit; regenerate with `pnpm sim oracle regen`. dc seed 20261030 index 478 nodes 21 elements 30
.options sparse gmin=1e-12 noopac
RG1 1 0 1000000000000
RG2 2 0 1000000000000
RG3 3 0 1000000000000
RG4 4 0 1000000000000
RG5 5 0 1000000000000
RG6 6 0 1000000000000
RG7 7 0 1000000000000
RG8 8 0 1000000000000
RG9 9 0 1000000000000
RG10 10 0 1000000000000
RG11 11 0 1000000000000
RG12 12 0 1000000000000
RG13 13 0 1000000000000
RG14 14 0 1000000000000
RG15 15 0 1000000000000
RG16 16 0 1000000000000
RG17 17 0 1000000000000
RG18 18 0 1000000000000
RG19 19 0 1000000000000
RG20 20 0 1000000000000
VS0 15 s0 0
R0 s0 7 56e-1
VS1 0 s1 0
V1 e1 s1 DC 33e0
RI1 e1 5 47e-2
VS2 8 s2 0
R2 s2 13 12e-2
VS3 20 s3 0
V3 e3 s3 DC 56e0
RI3 e3 3 10e-3
VS4 6 s4 0
R4 s4 17 82e2
VS5 16 s5 0
R5 s5 11 82e3
VS6 7 s6 0
R6 s6 18 22e3
VS7 4 s7 0
I7 s7 6 DC 39e-3
VS8 19 s8 0
V8 e8 s8 DC 18e0
RI8 e8 4 68e-1
VS9 0 s9 0
R9 s9 2 56e-2
VS10 4 s10 0
R10 s10 12 18e-2
VS11 7 s11 0
V11 e11 s11 DC 10e-1
RI11 e11 20 47e-3
VS12 7 s12 0
R12 s12 17 15e-1
VS13 1 s13 0
V13 e13 s13 DC 68e-1
RI13 e13 6 18e-2
VS14 13 s14 0
R14 s14 9 68e0
VS15 18 s15 0
R15 s15 2 56e0
VS16 12 s16 0
R16 s16 11 39e-2
VS17 1 s17 0
R17 s17 17 12e-2
VS18 6 s18 0
I18 s18 12 DC 12e-1
VS19 4 s19 0
R19 s19 7 10e0
VS20 0 s20 0
R20 s20 20 56e-2
VS21 7 s21 0
R21 s21 14 33e1
VS22 7 s22 0
V22 e22 s22 DC 82e-1
RI22 e22 5 22e-3
VS23 1 s23 0
R23 s23 8 82e-2
VS24 1 s24 0
R24 s24 15 22e1
VS25 8 s25 0
R25 s25 10 39e-2
VS26 3 s26 0
R26 s26 19 22e-2
VS27 17 s27 0
R27 s27 9 18e-1
VS28 10 s28 0
R28 s28 14 82e2
VS29 16 s29 0
V29 e29 s29 DC 27e0
RI29 e29 14 39e-2
.control
set numdgt=17
op
print v(1) v(2) v(3) v(4) v(5) v(6) v(7) v(8) v(9) v(10)
print v(11) v(12) v(13) v(14) v(15) v(16) v(17) v(18) v(19) v(20)
print i(vs0) i(vs1) i(vs2) i(vs3) i(vs4) i(vs5) i(vs6) i(vs7) i(vs8) i(vs9)
print i(vs10) i(vs11) i(vs12) i(vs13) i(vs14) i(vs15) i(vs16) i(vs17) i(vs18) i(vs19)
print i(vs20) i(vs21) i(vs22) i(vs23) i(vs24) i(vs25) i(vs26) i(vs27) i(vs28) i(vs29)
.endc
.end
