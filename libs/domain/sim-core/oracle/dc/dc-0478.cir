controls oracle dc-0478
* Generated (plan F2.7, ADR 0012): do not edit; regenerate with `pnpm sim oracle regen`. dc seed 20261030 index 478 nodes 21 elements 24
.options sparse gmin=1e-12 noopac
RG1 1 0 1000000000000
RG2 2 0 1000000000000
RG3 3 0 1000000000000
RG4 4 0 1000000000000
RG5 5 0 1000000000000
RG6 6 0 1000000000000
RG7 7 0 1000000000000
RG8 8 0 1000000000000
RG9 9 0 1000000000000
RG10 10 0 1000000000000
RG11 11 0 1000000000000
RG12 12 0 1000000000000
RG13 13 0 1000000000000
RG14 14 0 1000000000000
RG15 15 0 1000000000000
RG16 16 0 1000000000000
RG17 17 0 1000000000000
RG18 18 0 1000000000000
RG19 19 0 1000000000000
RG20 20 0 1000000000000
VS0 6 s0 0
I0 s0 12 DC 12e-1
VS1 0 s1 0
V1 e1 s1 DC 82e-1
RI1 e1 5 22e-3
VS2 1 s2 0
V2 e2 s2 DC 68e-1
RI2 e2 6 18e-2
VS3 16 s3 0
V3 e3 s3 DC 27e0
RI3 e3 14 39e-2
VS4 19 s4 0
V4 e4 s4 DC 18e0
RI4 e4 4 68e-1
VS5 0 s5 0
R5 s5 18 22e3
VS6 7 s6 0
R6 s6 20 56e-2
VS7 4 s7 0
R7 s7 12 18e-2
VS8 10 s8 0
R8 s8 14 82e2
VS9 4 s9 0
R9 s9 0 10e0
VS10 8 s10 0
R10 s10 13 12e-2
VS11 13 s11 0
R11 s11 9 68e0
VS12 0 s12 0
V12 e12 s12 DC 10e-1
RI12 e12 20 47e-3
VS13 17 s13 0
R13 s13 9 18e-1
VS14 7 s14 0
R14 s14 2 56e-2
VS15 4 s15 0
I15 s15 6 DC 39e-3
VS16 1 s16 0
R16 s16 8 82e-2
VS17 16 s17 0
R17 s17 11 82e3
VS18 1 s18 0
R18 s18 17 12e-2
VS19 20 s19 0
V19 e19 s19 DC 56e0
RI19 e19 3 10e-3
VS20 0 s20 0
R20 s20 14 33e1
VS21 1 s21 0
R21 s21 15 22e1
VS22 0 s22 0
R22 s22 17 15e-1
VS23 15 s23 0
R23 s23 0 56e-1
.control
set numdgt=17
op
print v(1) v(2) v(3) v(4) v(5) v(6) v(7) v(8) v(9) v(10)
print v(11) v(12) v(13) v(14) v(15) v(16) v(17) v(18) v(19) v(20)
print i(vs0) i(vs1) i(vs2) i(vs3) i(vs4) i(vs5) i(vs6) i(vs7) i(vs8) i(vs9)
print i(vs10) i(vs11) i(vs12) i(vs13) i(vs14) i(vs15) i(vs16) i(vs17) i(vs18) i(vs19)
print i(vs20) i(vs21) i(vs22) i(vs23)
.endc
.end
