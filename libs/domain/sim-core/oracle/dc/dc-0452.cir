controls oracle dc-0452
* Generated (plan F2.7, ADR 0012): do not edit; regenerate with `pnpm sim oracle regen`. dc seed 20261030 index 452 nodes 8 elements 15
.options sparse gmin=1e-12 noopac
RG1 1 0 1000000000000
RG2 2 0 1000000000000
RG3 3 0 1000000000000
RG4 4 0 1000000000000
RG5 5 0 1000000000000
RG6 6 0 1000000000000
RG7 7 0 1000000000000
VS0 6 s0 0
R0 s0 3 18e-2
VS1 6 s1 0
R1 s1 1 68e0
VS2 0 s2 0
V2 e2 s2 DC 22e0
RI2 e2 4 22e-2
VS3 4 s3 0
V3 e3 s3 DC 15e0
RI3 e3 5 33e-3
VS4 3 s4 0
V4 e4 s4 DC 22e-1
RI4 e4 5 39e-2
VS5 4 s5 0
R5 s5 7 18e0
VS6 5 s6 0
R6 s6 4 12e3
VS7 0 s7 0
V7 e7 s7 DC 39e0
RI7 e7 4 12e-2
VS8 2 s8 0
R8 s8 1 12e2
VS9 1 s9 0
R9 s9 4 68e1
VS10 3 s10 0
R10 s10 4 22e2
VS11 7 s11 0
V11 e11 s11 DC 22e1
RI11 e11 3 56e-1
VS12 2 s12 0
R12 s12 5 18e0
VS13 2 s13 0
I13 s13 3 DC 12e-2
VS14 3 s14 0
R14 s14 7 39e-1
.control
set numdgt=17
op
print v(1) v(2) v(3) v(4) v(5) v(6) v(7)
print i(vs0) i(vs1) i(vs2) i(vs3) i(vs4) i(vs5) i(vs6) i(vs7) i(vs8) i(vs9)
print i(vs10) i(vs11) i(vs12) i(vs13) i(vs14)
.endc
.end
