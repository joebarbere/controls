controls oracle dc-0014
* Generated (plan F2.7, ADR 0012): do not edit; regenerate with `pnpm sim oracle regen`. dc seed 20261030 index 14 nodes 14 elements 14
.options sparse gmin=1e-12 noopac
RG1 1 0 1000000000000
RG2 2 0 1000000000000
RG3 3 0 1000000000000
RG4 4 0 1000000000000
RG5 5 0 1000000000000
RG6 6 0 1000000000000
RG7 7 0 1000000000000
RG8 8 0 1000000000000
RG9 9 0 1000000000000
RG10 10 0 1000000000000
RG11 11 0 1000000000000
RG12 12 0 1000000000000
RG13 13 0 1000000000000
VS0 11 s0 0
R0 s0 9 39e2
VS1 0 s1 0
V1 e1 s1 DC 82e-1
RI1 e1 8 39e-1
VS2 5 s2 0
R2 s2 10 15e-1
VS3 9 s3 0
R3 s3 7 47e2
VS4 5 s4 0
V4 e4 s4 DC 18e0
RI4 e4 11 22e-3
VS5 4 s5 0
R5 s5 13 47e-1
VS6 8 s6 0
V6 e6 s6 DC 10e-1
RI6 e6 11 10e-2
VS7 9 s7 0
R7 s7 13 47e0
VS8 5 s8 0
R8 s8 2 82e-1
VS9 0 s9 0
R9 s9 3 22e1
VS10 5 s10 0
R10 s10 12 82e-1
VS11 6 s11 0
R11 s11 10 39e0
VS12 11 s12 0
R12 s12 1 39e3
VS13 5 s13 0
R13 s13 11 33e2
.control
set numdgt=17
op
print v(1) v(2) v(3) v(4) v(5) v(6) v(7) v(8) v(9) v(10)
print v(11) v(12) v(13)
print i(vs0) i(vs1) i(vs2) i(vs3) i(vs4) i(vs5) i(vs6) i(vs7) i(vs8) i(vs9)
print i(vs10) i(vs11) i(vs12) i(vs13)
.endc
.end
