controls oracle dc-0472
* Generated (plan F2.7, ADR 0012): do not edit; regenerate with `pnpm sim oracle regen`. dc seed 20261030 index 472 nodes 20 elements 37
.options sparse gmin=1e-12 noopac
RG1 1 0 1000000000000
RG2 2 0 1000000000000
RG3 3 0 1000000000000
RG4 4 0 1000000000000
RG5 5 0 1000000000000
RG6 6 0 1000000000000
RG7 7 0 1000000000000
RG8 8 0 1000000000000
RG9 9 0 1000000000000
RG10 10 0 1000000000000
RG11 11 0 1000000000000
RG12 12 0 1000000000000
RG13 13 0 1000000000000
RG14 14 0 1000000000000
RG15 15 0 1000000000000
RG16 16 0 1000000000000
RG17 17 0 1000000000000
RG18 18 0 1000000000000
RG19 19 0 1000000000000
VS0 7 s0 0
R0 s0 9 22e3
VS1 1 s1 0
I1 s1 18 DC 22e-2
VS2 11 s2 0
R2 s2 9 33e1
VS3 8 s3 0
R3 s3 18 68e0
VS4 10 s4 0
R4 s4 0 18e1
VS5 14 s5 0
R5 s5 6 27e2
VS6 13 s6 0
R6 s6 1 39e1
VS7 17 s7 0
R7 s7 9 18e1
VS8 3 s8 0
I8 s8 19 DC 18e-1
VS9 3 s9 0
R9 s9 4 12e3
VS10 0 s10 0
V10 e10 s10 DC 12e0
RI10 e10 16 56e-1
VS11 1 s11 0
R11 s11 11 68e-2
VS12 19 s12 0
V12 e12 s12 DC 15e0
RI12 e12 9 27e-3
VS13 12 s13 0
V13 e13 s13 DC 47e-1
RI13 e13 9 39e-3
VS14 15 s14 0
R14 s14 4 18e-1
VS15 14 s15 0
R15 s15 10 27e0
VS16 14 s16 0
R16 s16 3 33e-2
VS17 2 s17 0
R17 s17 10 15e-1
VS18 17 s18 0
R18 s18 15 12e1
VS19 13 s19 0
R19 s19 1 56e3
VS20 16 s20 0
R20 s20 19 27e3
VS21 3 s21 0
R21 s21 12 56e2
VS22 16 s22 0
V22 e22 s22 DC 15e-1
RI22 e22 17 10e-3
VS23 14 s23 0
R23 s23 19 56e3
VS24 3 s24 0
R24 s24 16 47e-2
VS25 13 s25 0
R25 s25 15 39e-2
VS26 14 s26 0
R26 s26 11 18e0
VS27 9 s27 0
V27 e27 s27 DC 68e0
RI27 e27 5 18e-1
VS28 3 s28 0
I28 s28 14 DC 39e-3
VS29 2 s29 0
V29 e29 s29 DC 27e-1
RI29 e29 16 33e-1
VS30 18 s30 0
V30 e30 s30 DC 12e0
RI30 e30 5 18e-2
VS31 8 s31 0
R31 s31 16 82e-2
VS32 9 s32 0
R32 s32 2 56e2
VS33 1 s33 0
R33 s33 13 68e-2
VS34 5 s34 0
R34 s34 14 47e2
VS35 12 s35 0
R35 s35 5 82e2
VS36 1 s36 0
I36 s36 2 DC 68e-4
.control
set numdgt=17
op
print v(1) v(2) v(3) v(4) v(5) v(6) v(7) v(8) v(9) v(10)
print v(11) v(12) v(13) v(14) v(15) v(16) v(17) v(18) v(19)
print i(vs0) i(vs1) i(vs2) i(vs3) i(vs4) i(vs5) i(vs6) i(vs7) i(vs8) i(vs9)
print i(vs10) i(vs11) i(vs12) i(vs13) i(vs14) i(vs15) i(vs16) i(vs17) i(vs18) i(vs19)
print i(vs20) i(vs21) i(vs22) i(vs23) i(vs24) i(vs25) i(vs26) i(vs27) i(vs28) i(vs29)
print i(vs30) i(vs31) i(vs32) i(vs33) i(vs34) i(vs35) i(vs36)
.endc
.end
