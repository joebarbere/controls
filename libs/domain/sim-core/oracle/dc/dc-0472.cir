controls oracle dc-0472
* Generated (plan F2.7, ADR 0012): do not edit; regenerate with `pnpm sim oracle regen`. dc seed 20261030 index 472 nodes 20 elements 39
.options sparse gmin=1e-12 noopac
RG1 1 0 1000000000000
RG2 2 0 1000000000000
RG3 3 0 1000000000000
RG4 4 0 1000000000000
RG5 5 0 1000000000000
RG6 6 0 1000000000000
RG7 7 0 1000000000000
RG8 8 0 1000000000000
RG9 9 0 1000000000000
RG10 10 0 1000000000000
RG11 11 0 1000000000000
RG12 12 0 1000000000000
RG13 13 0 1000000000000
RG14 14 0 1000000000000
RG15 15 0 1000000000000
RG16 16 0 1000000000000
RG17 17 0 1000000000000
RG18 18 0 1000000000000
RG19 19 0 1000000000000
VS0 16 s0 0
R0 s0 19 27e3
VS1 1 s1 0
I1 s1 2 DC 68e-4
VS2 14 s2 0
R2 s2 11 18e0
VS3 7 s3 0
R3 s3 12 56e1
VS4 13 s4 0
R4 s4 1 39e1
VS5 9 s5 0
R5 s5 2 56e2
VS6 1 s6 0
R6 s6 11 68e-2
VS7 14 s7 0
R7 s7 10 27e0
VS8 0 s8 0
V8 e8 s8 DC 47e-1
RI8 e8 9 39e-3
VS9 1 s9 0
I9 s9 18 DC 22e-2
VS10 10 s10 0
R10 s10 17 18e1
VS11 1 s11 0
R11 s11 13 68e-2
VS12 5 s12 0
R12 s12 14 47e2
VS13 3 s13 0
I13 s13 19 DC 18e-1
VS14 9 s14 0
V14 e14 s14 DC 68e0
RI14 e14 5 18e-1
VS15 16 s15 0
V15 e15 s15 DC 15e-1
RI15 e15 12 10e-3
VS16 17 s16 0
V16 e16 s16 DC 12e0
RI16 e16 16 56e-1
VS17 3 s17 0
R17 s17 0 56e2
VS18 2 s18 0
V18 e18 s18 DC 27e-1
RI18 e18 16 33e-1
VS19 13 s19 0
R19 s19 1 56e3
VS20 7 s20 0
R20 s20 9 22e3
VS21 14 s21 0
R21 s21 19 56e3
VS22 8 s22 0
R22 s22 16 82e-2
VS23 18 s23 0
V23 e23 s23 DC 12e0
RI23 e23 5 18e-2
VS24 8 s24 0
R24 s24 18 68e0
VS25 3 s25 0
R25 s25 4 12e3
VS26 14 s26 0
R26 s26 6 27e2
VS27 19 s27 0
V27 e27 s27 DC 15e0
RI27 e27 9 27e-3
VS28 11 s28 0
R28 s28 9 33e1
VS29 3 s29 0
I29 s29 14 DC 39e-3
VS30 14 s30 0
R30 s30 3 33e-2
VS31 2 s31 0
R31 s31 10 15e-1
VS32 0 s32 0
R32 s32 5 82e2
VS33 13 s33 0
R33 s33 15 39e-2
VS34 15 s34 0
R34 s34 4 18e-1
VS35 10 s35 0
R35 s35 6 47e3
VS36 12 s36 0
R36 s36 15 12e1
VS37 12 s37 0
R37 s37 9 18e1
VS38 3 s38 0
R38 s38 16 47e-2
.control
set numdgt=17
op
print v(1) v(2) v(3) v(4) v(5) v(6) v(7) v(8) v(9) v(10)
print v(11) v(12) v(13) v(14) v(15) v(16) v(17) v(18) v(19)
print i(vs0) i(vs1) i(vs2) i(vs3) i(vs4) i(vs5) i(vs6) i(vs7) i(vs8) i(vs9)
print i(vs10) i(vs11) i(vs12) i(vs13) i(vs14) i(vs15) i(vs16) i(vs17) i(vs18) i(vs19)
print i(vs20) i(vs21) i(vs22) i(vs23) i(vs24) i(vs25) i(vs26) i(vs27) i(vs28) i(vs29)
print i(vs30) i(vs31) i(vs32) i(vs33) i(vs34) i(vs35) i(vs36) i(vs37) i(vs38)
.endc
.end
