controls oracle dc-0421
* Generated (plan F2.7, ADR 0012): do not edit; regenerate with `pnpm sim oracle regen`. dc seed 20261030 index 421 nodes 29 elements 43
.options sparse gmin=1e-12 noopac
RG1 1 0 1000000000000
RG2 2 0 1000000000000
RG3 3 0 1000000000000
RG4 4 0 1000000000000
RG5 5 0 1000000000000
RG6 6 0 1000000000000
RG7 7 0 1000000000000
RG8 8 0 1000000000000
RG9 9 0 1000000000000
RG10 10 0 1000000000000
RG11 11 0 1000000000000
RG12 12 0 1000000000000
RG13 13 0 1000000000000
RG14 14 0 1000000000000
RG15 15 0 1000000000000
RG16 16 0 1000000000000
RG17 17 0 1000000000000
RG18 18 0 1000000000000
RG19 19 0 1000000000000
RG20 20 0 1000000000000
RG21 21 0 1000000000000
RG22 22 0 1000000000000
RG23 23 0 1000000000000
RG24 24 0 1000000000000
RG25 25 0 1000000000000
RG26 26 0 1000000000000
RG27 27 0 1000000000000
RG28 28 0 1000000000000
VS0 0 s0 0
V0 e0 s0 DC 15e1
RI0 e0 17 47e-1
VS1 2 s1 0
R1 s1 1 82e2
VS2 22 s2 0
R2 s2 26 10e0
VS3 11 s3 0
V3 e3 s3 DC 15e1
RI3 e3 3 47e-3
VS4 25 s4 0
R4 s4 10 10e3
VS5 14 s5 0
V5 e5 s5 DC 18e0
RI5 e5 20 12e-3
VS6 19 s6 0
R6 s6 14 39e0
VS7 9 s7 0
R7 s7 4 82e2
VS8 5 s8 0
V8 e8 s8 DC 12e-1
RI8 e8 6 27e-2
VS9 18 s9 0
R9 s9 22 56e2
VS10 26 s10 0
R10 s10 17 47e0
VS11 0 s11 0
V11 e11 s11 DC 68e0
RI11 e11 15 68e-1
VS12 8 s12 0
R12 s12 3 68e-2
VS13 10 s13 0
V13 e13 s13 DC 47e-1
RI13 e13 8 12e-1
VS14 0 s14 0
V14 e14 s14 DC 56e-1
RI14 e14 3 33e-2
VS15 6 s15 0
V15 e15 s15 DC 68e1
RI15 e15 24 56e-3
VS16 12 s16 0
V16 e16 s16 DC 56e1
RI16 e16 5 47e-2
VS17 9 s17 0
R17 s17 23 39e-2
VS18 6 s18 0
R18 s18 17 22e3
VS19 1 s19 0
R19 s19 27 56e3
VS20 22 s20 0
R20 s20 17 27e-1
VS21 23 s21 0
I21 s21 14 DC 47e-1
VS22 1 s22 0
V22 e22 s22 DC 68e1
RI22 e22 3 33e-2
VS23 17 s23 0
R23 s23 20 15e0
VS24 21 s24 0
R24 s24 23 39e3
VS25 3 s25 0
R25 s25 16 47e1
VS26 11 s26 0
R26 s26 2 22e3
VS27 21 s27 0
R27 s27 6 15e-1
VS28 20 s28 0
R28 s28 11 15e3
VS29 0 s29 0
V29 e29 s29 DC 22e-1
RI29 e29 1 39e-3
VS30 24 s30 0
R30 s30 25 33e0
VS31 24 s31 0
R31 s31 20 33e-1
VS32 9 s32 0
R32 s32 3 12e2
VS33 3 s33 0
V33 e33 s33 DC 82e-1
RI33 e33 27 82e-2
VS34 12 s34 0
R34 s34 8 15e2
VS35 10 s35 0
R35 s35 25 18e2
VS36 7 s36 0
R36 s36 10 68e0
VS37 2 s37 0
I37 s37 18 DC 33e-1
VS38 15 s38 0
R38 s38 9 15e1
VS39 9 s39 0
R39 s39 0 68e3
VS40 13 s40 0
V40 e40 s40 DC 56e0
RI40 e40 1 56e-3
VS41 0 s41 0
R41 s41 21 47e-1
VS42 9 s42 0
R42 s42 28 68e1
.control
set numdgt=17
op
print v(1) v(2) v(3) v(4) v(5) v(6) v(7) v(8) v(9) v(10)
print v(11) v(12) v(13) v(14) v(15) v(16) v(17) v(18) v(19) v(20)
print v(21) v(22) v(23) v(24) v(25) v(26) v(27) v(28)
print i(vs0) i(vs1) i(vs2) i(vs3) i(vs4) i(vs5) i(vs6) i(vs7) i(vs8) i(vs9)
print i(vs10) i(vs11) i(vs12) i(vs13) i(vs14) i(vs15) i(vs16) i(vs17) i(vs18) i(vs19)
print i(vs20) i(vs21) i(vs22) i(vs23) i(vs24) i(vs25) i(vs26) i(vs27) i(vs28) i(vs29)
print i(vs30) i(vs31) i(vs32) i(vs33) i(vs34) i(vs35) i(vs36) i(vs37) i(vs38) i(vs39)
print i(vs40) i(vs41) i(vs42)
.endc
.end
