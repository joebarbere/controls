controls oracle dc-0421
* Generated (plan F2.7, ADR 0012): do not edit; regenerate with `pnpm sim oracle regen`. dc seed 20261030 index 421 nodes 29 elements 49
.options sparse gmin=1e-12 noopac
RG1 1 0 1000000000000
RG2 2 0 1000000000000
RG3 3 0 1000000000000
RG4 4 0 1000000000000
RG5 5 0 1000000000000
RG6 6 0 1000000000000
RG7 7 0 1000000000000
RG8 8 0 1000000000000
RG9 9 0 1000000000000
RG10 10 0 1000000000000
RG11 11 0 1000000000000
RG12 12 0 1000000000000
RG13 13 0 1000000000000
RG14 14 0 1000000000000
RG15 15 0 1000000000000
RG16 16 0 1000000000000
RG17 17 0 1000000000000
RG18 18 0 1000000000000
RG19 19 0 1000000000000
RG20 20 0 1000000000000
RG21 21 0 1000000000000
RG22 22 0 1000000000000
RG23 23 0 1000000000000
RG24 24 0 1000000000000
RG25 25 0 1000000000000
RG26 26 0 1000000000000
RG27 27 0 1000000000000
RG28 28 0 1000000000000
VS0 0 s0 0
V0 e0 s0 DC 56e0
RI0 e0 1 56e-3
VS1 23 s1 0
I1 s1 14 DC 47e-1
VS2 17 s2 0
R2 s2 20 15e0
VS3 2 s3 0
I3 s3 18 DC 33e-1
VS4 15 s4 0
R4 s4 9 15e1
VS5 5 s5 0
V5 e5 s5 DC 12e-1
RI5 e5 6 27e-2
VS6 18 s6 0
R6 s6 22 56e2
VS7 10 s7 0
R7 s7 25 18e2
VS8 13 s8 0
R8 s8 21 47e-1
VS9 19 s9 0
R9 s9 14 39e0
VS10 19 s10 0
R10 s10 17 15e-1
VS11 24 s11 0
R11 s11 20 33e-1
VS12 16 s12 0
R12 s12 28 68e3
VS13 22 s13 0
R13 s13 4 39e2
VS14 1 s14 0
V14 e14 s14 DC 68e1
RI14 e14 3 33e-2
VS15 26 s15 0
R15 s15 17 47e0
VS16 1 s16 0
R16 s16 27 56e3
VS17 11 s17 0
R17 s17 2 22e3
VS18 13 s18 0
V18 e18 s18 DC 56e-1
RI18 e18 3 33e-2
VS19 12 s19 0
V19 e19 s19 DC 56e1
RI19 e19 5 47e-2
VS20 7 s20 0
R20 s20 10 68e0
VS21 18 s21 0
R21 s21 1 56e-1
VS22 7 s22 0
R22 s22 4 82e0
VS23 6 s23 0
R23 s23 17 22e3
VS24 13 s24 0
V24 e24 s24 DC 68e0
RI24 e24 15 68e-1
VS25 9 s25 0
R25 s25 3 12e2
VS26 9 s26 0
R26 s26 4 82e2
VS27 21 s27 0
R27 s27 6 15e-1
VS28 24 s28 0
R28 s28 25 33e0
VS29 14 s29 0
V29 e29 s29 DC 18e0
RI29 e29 20 12e-3
VS30 3 s30 0
R30 s30 16 47e1
VS31 12 s31 0
R31 s31 8 15e2
VS32 22 s32 0
R32 s32 26 10e0
VS33 2 s33 0
R33 s33 1 82e2
VS34 13 s34 0
V34 e34 s34 DC 15e1
RI34 e34 17 47e-1
VS35 9 s35 0
R35 s35 13 68e3
VS36 20 s36 0
R36 s36 11 15e3
VS37 3 s37 0
V37 e37 s37 DC 82e-1
RI37 e37 27 82e-2
VS38 22 s38 0
R38 s38 17 27e-1
VS39 13 s39 0
V39 e39 s39 DC 22e-1
RI39 e39 1 39e-3
VS40 9 s40 0
R40 s40 23 39e-2
VS41 21 s41 0
R41 s41 23 39e3
VS42 23 s42 0
R42 s42 0 56e3
VS43 6 s43 0
V43 e43 s43 DC 68e1
RI43 e43 24 56e-3
VS44 9 s44 0
R44 s44 28 68e1
VS45 11 s45 0
V45 e45 s45 DC 15e1
RI45 e45 3 47e-3
VS46 8 s46 0
R46 s46 3 68e-2
VS47 10 s47 0
V47 e47 s47 DC 47e-1
RI47 e47 8 12e-1
VS48 25 s48 0
R48 s48 10 10e3
.control
set numdgt=17
op
print v(1) v(2) v(3) v(4) v(5) v(6) v(7) v(8) v(9) v(10)
print v(11) v(12) v(13) v(14) v(15) v(16) v(17) v(18) v(19) v(20)
print v(21) v(22) v(23) v(24) v(25) v(26) v(27) v(28)
print i(vs0) i(vs1) i(vs2) i(vs3) i(vs4) i(vs5) i(vs6) i(vs7) i(vs8) i(vs9)
print i(vs10) i(vs11) i(vs12) i(vs13) i(vs14) i(vs15) i(vs16) i(vs17) i(vs18) i(vs19)
print i(vs20) i(vs21) i(vs22) i(vs23) i(vs24) i(vs25) i(vs26) i(vs27) i(vs28) i(vs29)
print i(vs30) i(vs31) i(vs32) i(vs33) i(vs34) i(vs35) i(vs36) i(vs37) i(vs38) i(vs39)
print i(vs40) i(vs41) i(vs42) i(vs43) i(vs44) i(vs45) i(vs46) i(vs47) i(vs48)
.endc
.end
