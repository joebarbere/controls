controls oracle dc-0303
* Generated (plan F2.7, ADR 0012): do not edit; regenerate with `pnpm sim oracle regen`. dc seed 20261030 index 303 nodes 22 elements 31
.options sparse gmin=1e-12 noopac
RG1 1 0 1000000000000
RG2 2 0 1000000000000
RG3 3 0 1000000000000
RG4 4 0 1000000000000
RG5 5 0 1000000000000
RG6 6 0 1000000000000
RG7 7 0 1000000000000
RG8 8 0 1000000000000
RG9 9 0 1000000000000
RG10 10 0 1000000000000
RG11 11 0 1000000000000
RG12 12 0 1000000000000
RG13 13 0 1000000000000
RG14 14 0 1000000000000
RG15 15 0 1000000000000
RG16 16 0 1000000000000
RG17 17 0 1000000000000
RG18 18 0 1000000000000
RG19 19 0 1000000000000
RG20 20 0 1000000000000
RG21 21 0 1000000000000
VS0 4 s0 0
I0 s0 18 DC 15e-4
VS1 7 s1 0
I1 s1 17 DC 47e-3
VS2 17 s2 0
R2 s2 9 33e0
VS3 0 s3 0
V3 e3 s3 DC 39e0
RI3 e3 13 82e-3
VS4 11 s4 0
R4 s4 10 39e-2
VS5 4 s5 0
V5 e5 s5 DC 68e0
RI5 e5 2 39e-2
VS6 8 s6 0
R6 s6 4 10e3
VS7 18 s7 0
R7 s7 10 33e3
VS8 15 s8 0
R8 s8 17 39e3
VS9 10 s9 0
R9 s9 19 56e0
VS10 5 s10 0
R10 s10 12 39e1
VS11 20 s11 0
R11 s11 10 22e-1
VS12 3 s12 0
R12 s12 14 22e-1
VS13 4 s13 0
V13 e13 s13 DC 10e0
RI13 e13 10 82e-3
VS14 7 s14 0
I14 s14 15 DC 22e-2
VS15 4 s15 0
R15 s15 15 47e1
VS16 0 s16 0
R16 s16 4 47e2
VS17 11 s17 0
R17 s17 5 15e-2
VS18 5 s18 0
I18 s18 15 DC 18e-2
VS19 14 s19 0
V19 e19 s19 DC 22e0
RI19 e19 9 33e-3
VS20 21 s20 0
R20 s20 13 22e3
VS21 6 s21 0
R21 s21 20 82e2
VS22 9 s22 0
R22 s22 16 33e2
VS23 18 s23 0
R23 s23 6 39e2
VS24 12 s24 0
V24 e24 s24 DC 12e1
RI24 e24 5 22e-1
VS25 17 s25 0
R25 s25 1 47e1
VS26 20 s26 0
V26 e26 s26 DC 18e-1
RI26 e26 16 10e-3
VS27 9 s27 0
R27 s27 5 22e3
VS28 7 s28 0
R28 s28 10 15e-1
VS29 20 s29 0
R29 s29 17 27e-2
VS30 11 s30 0
R30 s30 19 15e1
.control
set numdgt=17
op
print v(1) v(2) v(3) v(4) v(5) v(6) v(7) v(8) v(9) v(10)
print v(11) v(12) v(13) v(14) v(15) v(16) v(17) v(18) v(19) v(20)
print v(21)
print i(vs0) i(vs1) i(vs2) i(vs3) i(vs4) i(vs5) i(vs6) i(vs7) i(vs8) i(vs9)
print i(vs10) i(vs11) i(vs12) i(vs13) i(vs14) i(vs15) i(vs16) i(vs17) i(vs18) i(vs19)
print i(vs20) i(vs21) i(vs22) i(vs23) i(vs24) i(vs25) i(vs26) i(vs27) i(vs28) i(vs29)
print i(vs30)
.endc
.end
