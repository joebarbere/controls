controls oracle dc-0303
* Generated (plan F2.7, ADR 0012): do not edit; regenerate with `pnpm sim oracle regen`. dc seed 20261030 index 303 nodes 22 elements 37
.options sparse gmin=1e-12 noopac
RG1 1 0 1000000000000
RG2 2 0 1000000000000
RG3 3 0 1000000000000
RG4 4 0 1000000000000
RG5 5 0 1000000000000
RG6 6 0 1000000000000
RG7 7 0 1000000000000
RG8 8 0 1000000000000
RG9 9 0 1000000000000
RG10 10 0 1000000000000
RG11 11 0 1000000000000
RG12 12 0 1000000000000
RG13 13 0 1000000000000
RG14 14 0 1000000000000
RG15 15 0 1000000000000
RG16 16 0 1000000000000
RG17 17 0 1000000000000
RG18 18 0 1000000000000
RG19 19 0 1000000000000
RG20 20 0 1000000000000
RG21 21 0 1000000000000
VS0 7 s0 0
I0 s0 17 DC 47e-3
VS1 7 s1 0
R1 s1 17 33e1
VS2 9 s2 0
R2 s2 16 33e2
VS3 6 s3 0
R3 s3 20 82e2
VS4 0 s4 0
V4 e4 s4 DC 33e1
RI4 e4 2 39e-1
VS5 18 s5 0
R5 s5 10 33e3
VS6 11 s6 0
R6 s6 0 15e-2
VS7 1 s7 0
R7 s7 12 27e-1
VS8 0 s8 0
I8 s8 15 DC 18e-2
VS9 8 s9 0
R9 s9 4 10e3
VS10 15 s10 0
R10 s10 17 39e3
VS11 17 s11 0
R11 s11 1 47e1
VS12 8 s12 0
R12 s12 3 82e-1
VS13 7 s13 0
R13 s13 10 15e-1
VS14 10 s14 0
R14 s14 19 56e0
VS15 5 s15 0
R15 s15 17 33e1
VS16 18 s16 0
R16 s16 6 39e2
VS17 20 s17 0
V17 e17 s17 DC 18e-1
RI17 e17 16 10e-3
VS18 20 s18 0
R18 s18 17 27e-2
VS19 3 s19 0
R19 s19 14 22e-1
VS20 4 s20 0
R20 s20 15 47e1
VS21 4 s21 0
V21 e21 s21 DC 10e0
RI21 e21 10 82e-3
VS22 17 s22 0
R22 s22 9 33e0
VS23 12 s23 0
V23 e23 s23 DC 12e1
RI23 e23 0 22e-1
VS24 5 s24 0
V24 e24 s24 DC 39e0
RI24 e24 13 82e-3
VS25 14 s25 0
V25 e25 s25 DC 22e0
RI25 e25 9 33e-3
VS26 4 s26 0
V26 e26 s26 DC 68e0
RI26 e26 2 39e-2
VS27 19 s27 0
R27 s27 21 22e-1
VS28 0 s28 0
R28 s28 12 39e1
VS29 7 s29 0
I29 s29 15 DC 22e-2
VS30 4 s30 0
I30 s30 18 DC 15e-4
VS31 5 s31 0
R31 s31 4 47e2
VS32 21 s32 0
R32 s32 13 22e3
VS33 9 s33 0
R33 s33 0 22e3
VS34 11 s34 0
R34 s34 10 39e-2
VS35 11 s35 0
R35 s35 19 15e1
VS36 20 s36 0
R36 s36 10 22e-1
.control
set numdgt=17
op
print v(1) v(2) v(3) v(4) v(5) v(6) v(7) v(8) v(9) v(10)
print v(11) v(12) v(13) v(14) v(15) v(16) v(17) v(18) v(19) v(20)
print v(21)
print i(vs0) i(vs1) i(vs2) i(vs3) i(vs4) i(vs5) i(vs6) i(vs7) i(vs8) i(vs9)
print i(vs10) i(vs11) i(vs12) i(vs13) i(vs14) i(vs15) i(vs16) i(vs17) i(vs18) i(vs19)
print i(vs20) i(vs21) i(vs22) i(vs23) i(vs24) i(vs25) i(vs26) i(vs27) i(vs28) i(vs29)
print i(vs30) i(vs31) i(vs32) i(vs33) i(vs34) i(vs35) i(vs36)
.endc
.end
