controls oracle dc-0085
* Generated (plan F2.7, ADR 0012): do not edit; regenerate with `pnpm sim oracle regen`. dc seed 20261030 index 85 nodes 15 elements 24
.options sparse gmin=1e-12 noopac
RG1 1 0 1000000000000
RG2 2 0 1000000000000
RG3 3 0 1000000000000
RG4 4 0 1000000000000
RG5 5 0 1000000000000
RG6 6 0 1000000000000
RG7 7 0 1000000000000
RG8 8 0 1000000000000
RG9 9 0 1000000000000
RG10 10 0 1000000000000
RG11 11 0 1000000000000
RG12 12 0 1000000000000
RG13 13 0 1000000000000
RG14 14 0 1000000000000
VS0 10 s0 0
R0 s0 3 56e2
VS1 13 s1 0
R1 s1 4 33e3
VS2 0 s2 0
R2 s2 4 27e-1
VS3 5 s3 0
R3 s3 0 56e2
VS4 10 s4 0
R4 s4 2 27e-1
VS5 0 s5 0
V5 e5 s5 DC 39e-1
RI5 e5 14 56e-2
VS6 7 s6 0
I6 s6 4 DC 39e-3
VS7 12 s7 0
R7 s7 0 47e0
VS8 14 s8 0
V8 e8 s8 DC 12e-1
RI8 e8 4 18e-1
VS9 6 s9 0
R9 s9 8 33e2
VS10 7 s10 0
R10 s10 0 82e-1
VS11 0 s11 0
R11 s11 8 18e0
VS12 3 s12 0
R12 s12 12 10e-1
VS13 12 s13 0
R13 s13 2 27e-2
VS14 2 s14 0
R14 s14 1 18e3
VS15 10 s15 0
I15 s15 1 DC 27e-1
VS16 6 s16 0
R16 s16 11 68e3
VS17 7 s17 0
R17 s17 8 12e-2
VS18 5 s18 0
V18 e18 s18 DC 12e0
RI18 e18 9 27e-2
VS19 9 s19 0
V19 e19 s19 DC 12e1
RI19 e19 4 18e-1
VS20 13 s20 0
V20 e20 s20 DC 56e1
RI20 e20 8 15e-3
VS21 7 s21 0
R21 s21 4 10e2
VS22 1 s22 0
I22 s22 9 DC 15e-2
VS23 1 s23 0
R23 s23 5 56e1
.control
set numdgt=17
op
print v(1) v(2) v(3) v(4) v(5) v(6) v(7) v(8) v(9) v(10)
print v(11) v(12) v(13) v(14)
print i(vs0) i(vs1) i(vs2) i(vs3) i(vs4) i(vs5) i(vs6) i(vs7) i(vs8) i(vs9)
print i(vs10) i(vs11) i(vs12) i(vs13) i(vs14) i(vs15) i(vs16) i(vs17) i(vs18) i(vs19)
print i(vs20) i(vs21) i(vs22) i(vs23)
.endc
.end
