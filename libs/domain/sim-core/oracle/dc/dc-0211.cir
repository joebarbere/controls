controls oracle dc-0211
* Generated (plan F2.7, ADR 0012): do not edit; regenerate with `pnpm sim oracle regen`. dc seed 20261030 index 211 nodes 19 elements 36
.options sparse gmin=1e-12 noopac
RG1 1 0 1000000000000
RG2 2 0 1000000000000
RG3 3 0 1000000000000
RG4 4 0 1000000000000
RG5 5 0 1000000000000
RG6 6 0 1000000000000
RG7 7 0 1000000000000
RG8 8 0 1000000000000
RG9 9 0 1000000000000
RG10 10 0 1000000000000
RG11 11 0 1000000000000
RG12 12 0 1000000000000
RG13 13 0 1000000000000
RG14 14 0 1000000000000
RG15 15 0 1000000000000
RG16 16 0 1000000000000
RG17 17 0 1000000000000
RG18 18 0 1000000000000
VS0 14 s0 0
R0 s0 13 39e0
VS1 7 s1 0
R1 s1 3 22e-2
VS2 14 s2 0
I2 s2 11 DC 22e-3
VS3 9 s3 0
R3 s3 11 47e3
VS4 9 s4 0
R4 s4 17 56e2
VS5 0 s5 0
V5 e5 s5 DC 12e1
RI5 e5 18 18e-2
VS6 1 s6 0
R6 s6 6 82e-1
VS7 7 s7 0
R7 s7 18 33e0
VS8 5 s8 0
V8 e8 s8 DC 15e-1
RI8 e8 17 27e-3
VS9 18 s9 0
R9 s9 1 12e3
VS10 13 s10 0
V10 e10 s10 DC 10e1
RI10 e10 17 47e-1
VS11 3 s11 0
V11 e11 s11 DC 22e0
RI11 e11 15 22e-3
VS12 17 s12 0
R12 s12 13 56e1
VS13 15 s13 0
I13 s13 17 DC 12e-4
VS14 10 s14 0
R14 s14 8 39e2
VS15 16 s15 0
V15 e15 s15 DC 27e-1
RI15 e15 5 22e-1
VS16 11 s16 0
R16 s16 14 12e-1
VS17 11 s17 0
R17 s17 5 15e3
VS18 18 s18 0
I18 s18 4 DC 33e-2
VS19 2 s19 0
R19 s19 4 56e3
VS20 11 s20 0
I20 s20 14 DC 18e-1
VS21 4 s21 0
V21 e21 s21 DC 12e1
RI21 e21 15 15e-2
VS22 9 s22 0
I22 s22 0 DC 82e-4
VS23 17 s23 0
V23 e23 s23 DC 10e0
RI23 e23 15 39e-1
VS24 13 s24 0
V24 e24 s24 DC 39e0
RI24 e24 9 56e-3
VS25 14 s25 0
R25 s25 8 82e2
VS26 18 s26 0
R26 s26 5 27e1
VS27 1 s27 0
R27 s27 10 12e0
VS28 0 s28 0
R28 s28 17 39e1
VS29 7 s29 0
R29 s29 3 47e2
VS30 16 s30 0
I30 s30 7 DC 47e-4
VS31 8 s31 0
V31 e31 s31 DC 39e0
RI31 e31 6 56e-3
VS32 13 s32 0
V32 e32 s32 DC 10e0
RI32 e32 12 33e-2
VS33 16 s33 0
R33 s33 18 39e3
VS34 14 s34 0
R34 s34 5 68e3
VS35 6 s35 0
R35 s35 18 12e1
.control
set numdgt=17
op
print v(1) v(2) v(3) v(4) v(5) v(6) v(7) v(8) v(9) v(10)
print v(11) v(12) v(13) v(14) v(15) v(16) v(17) v(18)
print i(vs0) i(vs1) i(vs2) i(vs3) i(vs4) i(vs5) i(vs6) i(vs7) i(vs8) i(vs9)
print i(vs10) i(vs11) i(vs12) i(vs13) i(vs14) i(vs15) i(vs16) i(vs17) i(vs18) i(vs19)
print i(vs20) i(vs21) i(vs22) i(vs23) i(vs24) i(vs25) i(vs26) i(vs27) i(vs28) i(vs29)
print i(vs30) i(vs31) i(vs32) i(vs33) i(vs34) i(vs35)
.endc
.end
