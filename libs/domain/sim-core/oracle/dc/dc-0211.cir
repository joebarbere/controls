controls oracle dc-0211
* Generated (plan F2.7, ADR 0012): do not edit; regenerate with `pnpm sim oracle regen`. dc seed 20261030 index 211 nodes 19 elements 38
.options sparse gmin=1e-12 noopac
RG1 1 0 1000000000000
RG2 2 0 1000000000000
RG3 3 0 1000000000000
RG4 4 0 1000000000000
RG5 5 0 1000000000000
RG6 6 0 1000000000000
RG7 7 0 1000000000000
RG8 8 0 1000000000000
RG9 9 0 1000000000000
RG10 10 0 1000000000000
RG11 11 0 1000000000000
RG12 12 0 1000000000000
RG13 13 0 1000000000000
RG14 14 0 1000000000000
RG15 15 0 1000000000000
RG16 16 0 1000000000000
RG17 17 0 1000000000000
RG18 18 0 1000000000000
VS0 11 s0 0
I0 s0 14 DC 18e-1
VS1 0 s1 0
V1 e1 s1 DC 39e0
RI1 e1 6 56e-3
VS2 2 s2 0
V2 e2 s2 DC 12e-1
RI2 e2 6 22e-2
VS3 1 s3 0
R3 s3 6 82e-1
VS4 15 s4 0
I4 s4 8 DC 12e-4
VS5 17 s5 0
R5 s5 8 39e1
VS6 16 s6 0
I6 s6 7 DC 47e-4
VS7 7 s7 0
R7 s7 3 47e2
VS8 18 s8 0
I8 s8 4 DC 33e-2
VS9 11 s9 0
R9 s9 5 15e3
VS10 9 s10 0
I10 s10 17 DC 82e-4
VS11 11 s11 0
R11 s11 14 12e-1
VS12 16 s12 0
R12 s12 18 39e3
VS13 14 s13 0
R13 s13 13 39e0
VS14 7 s14 0
R14 s14 3 22e-2
VS15 4 s15 0
V15 e15 s15 DC 12e1
RI15 e15 15 15e-2
VS16 6 s16 0
R16 s16 18 12e1
VS17 14 s17 0
R17 s17 5 68e3
VS18 8 s18 0
V18 e18 s18 DC 10e0
RI18 e18 15 39e-1
VS19 14 s19 0
R19 s19 0 82e2
VS20 13 s20 0
V20 e20 s20 DC 39e0
RI20 e20 9 56e-3
VS21 14 s21 0
I21 s21 11 DC 22e-3
VS22 5 s22 0
V22 e22 s22 DC 15e-1
RI22 e22 8 27e-3
VS23 18 s23 0
R23 s23 1 12e3
VS24 10 s24 0
R24 s24 0 39e2
VS25 8 s25 0
R25 s25 13 56e1
VS26 16 s26 0
V26 e26 s26 DC 27e-1
RI26 e26 5 22e-1
VS27 9 s27 0
R27 s27 11 47e3
VS28 12 s28 0
R28 s28 14 33e2
VS29 17 s29 0
V29 e29 s29 DC 12e1
RI29 e29 18 18e-2
VS30 9 s30 0
R30 s30 8 56e2
VS31 13 s31 0
V31 e31 s31 DC 10e1
RI31 e31 8 47e-1
VS32 18 s32 0
R32 s32 5 27e1
VS33 2 s33 0
R33 s33 4 56e3
VS34 13 s34 0
V34 e34 s34 DC 10e0
RI34 e34 12 33e-2
VS35 1 s35 0
R35 s35 10 12e0
VS36 7 s36 0
R36 s36 18 33e0
VS37 3 s37 0
V37 e37 s37 DC 22e0
RI37 e37 15 22e-3
.control
set numdgt=17
op
print v(1) v(2) v(3) v(4) v(5) v(6) v(7) v(8) v(9) v(10)
print v(11) v(12) v(13) v(14) v(15) v(16) v(17) v(18)
print i(vs0) i(vs1) i(vs2) i(vs3) i(vs4) i(vs5) i(vs6) i(vs7) i(vs8) i(vs9)
print i(vs10) i(vs11) i(vs12) i(vs13) i(vs14) i(vs15) i(vs16) i(vs17) i(vs18) i(vs19)
print i(vs20) i(vs21) i(vs22) i(vs23) i(vs24) i(vs25) i(vs26) i(vs27) i(vs28) i(vs29)
print i(vs30) i(vs31) i(vs32) i(vs33) i(vs34) i(vs35) i(vs36) i(vs37)
.endc
.end
