controls oracle dc-0030
* Generated (plan F2.7, ADR 0012): do not edit; regenerate with `pnpm sim oracle regen`. dc seed 20261030 index 30 nodes 6 elements 10
.options sparse gmin=1e-12 noopac
RG1 1 0 1000000000000
RG2 2 0 1000000000000
RG3 3 0 1000000000000
RG4 4 0 1000000000000
RG5 5 0 1000000000000
VS0 1 s0 0
R0 s0 3 56e3
VS1 0 s1 0
I1 s1 4 DC 15e-4
VS2 0 s2 0
V2 e2 s2 DC 47e1
RI2 e2 3 27e-1
VS3 2 s3 0
R3 s3 4 82e-2
VS4 4 s4 0
R4 s4 0 82e3
VS5 0 s5 0
V5 e5 s5 DC 12e0
RI5 e5 4 10e-2
VS6 0 s6 0
I6 s6 5 DC 68e-2
VS7 2 s7 0
R7 s7 3 27e3
VS8 3 s8 0
R8 s8 5 12e2
VS9 5 s9 0
R9 s9 2 18e-1
.control
set numdgt=17
op
print v(1) v(2) v(3) v(4) v(5)
print i(vs0) i(vs1) i(vs2) i(vs3) i(vs4) i(vs5) i(vs6) i(vs7) i(vs8) i(vs9)
.endc
.end
