controls oracle dc-0195
* Generated (plan F2.7, ADR 0012): do not edit; regenerate with `pnpm sim oracle regen`. dc seed 20261030 index 195 nodes 7 elements 11
.options sparse gmin=1e-12 noopac
RG1 1 0 1000000000000
RG2 2 0 1000000000000
RG3 3 0 1000000000000
RG4 4 0 1000000000000
RG5 5 0 1000000000000
RG6 6 0 1000000000000
VS0 4 s0 0
R0 s0 6 18e3
VS1 0 s1 0
V1 e1 s1 DC 56e-1
RI1 e1 2 15e-1
VS2 1 s2 0
R2 s2 2 18e0
VS3 3 s3 0
R3 s3 6 82e-2
VS4 5 s4 0
R4 s4 3 68e0
VS5 5 s5 0
I5 s5 3 DC 18e-2
VS6 3 s6 0
I6 s6 2 DC 18e-3
VS7 2 s7 0
R7 s7 6 22e-2
VS8 0 s8 0
R8 s8 5 27e-2
VS9 5 s9 0
R9 s9 4 39e1
VS10 0 s10 0
R10 s10 1 22e0
.control
set numdgt=17
op
print v(1) v(2) v(3) v(4) v(5) v(6)
print i(vs0) i(vs1) i(vs2) i(vs3) i(vs4) i(vs5) i(vs6) i(vs7) i(vs8) i(vs9)
print i(vs10)
.endc
.end
