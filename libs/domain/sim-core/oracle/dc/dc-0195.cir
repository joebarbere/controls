controls oracle dc-0195
* Generated (plan F2.7, ADR 0012): do not edit; regenerate with `pnpm sim oracle regen`. dc seed 20261030 index 195 nodes 7 elements 9
.options sparse gmin=1e-12 noopac
RG1 1 0 1000000000000
RG2 2 0 1000000000000
RG3 3 0 1000000000000
RG4 4 0 1000000000000
RG5 5 0 1000000000000
RG6 6 0 1000000000000
VS0 3 s0 0
I0 s0 2 DC 18e-3
VS1 2 s1 0
R1 s1 6 22e-2
VS2 5 s2 0
R2 s2 4 39e1
VS3 3 s3 0
R3 s3 6 82e-2
VS4 0 s4 0
V4 e4 s4 DC 56e-1
RI4 e4 2 15e-1
VS5 1 s5 0
R5 s5 2 18e0
VS6 4 s6 0
R6 s6 6 18e3
VS7 0 s7 0
R7 s7 1 22e0
VS8 5 s8 0
I8 s8 3 DC 18e-2
.control
set numdgt=17
op
print v(1) v(2) v(3) v(4) v(5) v(6)
print i(vs0) i(vs1) i(vs2) i(vs3) i(vs4) i(vs5) i(vs6) i(vs7) i(vs8)
.endc
.end
