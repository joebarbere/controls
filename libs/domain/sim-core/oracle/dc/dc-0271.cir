controls oracle dc-0271
* Generated (plan F2.7, ADR 0012): do not edit; regenerate with `pnpm sim oracle regen`. dc seed 20261030 index 271 nodes 5 elements 7
.options sparse gmin=1e-12 noopac
RG1 1 0 1000000000000
RG2 2 0 1000000000000
RG3 3 0 1000000000000
RG4 4 0 1000000000000
VS0 3 s0 0
R0 s0 4 39e-2
VS1 0 s1 0
V1 e1 s1 DC 27e1
RI1 e1 2 18e-3
VS2 4 s2 0
R2 s2 2 39e-1
VS3 2 s3 0
R3 s3 1 18e1
VS4 0 s4 0
R4 s4 3 33e2
VS5 4 s5 0
R5 s5 0 27e-1
VS6 1 s6 0
V6 e6 s6 DC 10e1
RI6 e6 4 68e-1
.control
set numdgt=17
op
print v(1) v(2) v(3) v(4)
print i(vs0) i(vs1) i(vs2) i(vs3) i(vs4) i(vs5) i(vs6)
.endc
.end
