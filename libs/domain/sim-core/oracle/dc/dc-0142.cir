controls oracle dc-0142
* Generated (plan F2.7, ADR 0012): do not edit; regenerate with `pnpm sim oracle regen`. dc seed 20261030 index 142 nodes 14 elements 24
.options sparse gmin=1e-12 noopac
RG1 1 0 1000000000000
RG2 2 0 1000000000000
RG3 3 0 1000000000000
RG4 4 0 1000000000000
RG5 5 0 1000000000000
RG6 6 0 1000000000000
RG7 7 0 1000000000000
RG8 8 0 1000000000000
RG9 9 0 1000000000000
RG10 10 0 1000000000000
RG11 11 0 1000000000000
RG12 12 0 1000000000000
RG13 13 0 1000000000000
VS0 13 s0 0
R0 s0 1 22e-2
VS1 6 s1 0
R1 s1 1 18e0
VS2 4 s2 0
R2 s2 2 82e-1
VS3 0 s3 0
V3 e3 s3 DC 82e-1
RI3 e3 8 33e-3
VS4 3 s4 0
R4 s4 8 56e1
VS5 3 s5 0
R5 s5 10 33e0
VS6 13 s6 0
V6 e6 s6 DC 12e1
RI6 e6 6 39e-2
VS7 9 s7 0
R7 s7 12 47e-1
VS8 5 s8 0
R8 s8 6 47e2
VS9 3 s9 0
V9 e9 s9 DC 22e0
RI9 e9 5 12e-2
VS10 8 s10 0
R10 s10 3 12e-2
VS11 3 s11 0
R11 s11 9 47e3
VS12 7 s12 0
R12 s12 5 33e0
VS13 11 s13 0
I13 s13 4 DC 82e-1
VS14 10 s14 0
R14 s14 2 68e-1
VS15 11 s15 0
V15 e15 s15 DC 82e0
RI15 e15 7 47e-3
VS16 11 s16 0
R16 s16 2 39e-2
VS17 5 s17 0
V17 e17 s17 DC 15e0
RI17 e17 0 18e-1
VS18 12 s18 0
R18 s18 4 82e3
VS19 2 s19 0
R19 s19 10 22e0
VS20 5 s20 0
V20 e20 s20 DC 18e0
RI20 e20 13 33e-1
VS21 5 s21 0
R21 s21 11 33e3
VS22 3 s22 0
R22 s22 13 82e-1
VS23 5 s23 0
R23 s23 1 33e3
.control
set numdgt=17
op
print v(1) v(2) v(3) v(4) v(5) v(6) v(7) v(8) v(9) v(10)
print v(11) v(12) v(13)
print i(vs0) i(vs1) i(vs2) i(vs3) i(vs4) i(vs5) i(vs6) i(vs7) i(vs8) i(vs9)
print i(vs10) i(vs11) i(vs12) i(vs13) i(vs14) i(vs15) i(vs16) i(vs17) i(vs18) i(vs19)
print i(vs20) i(vs21) i(vs22) i(vs23)
.endc
.end
