controls oracle dc-0273
* Generated (plan F2.7, ADR 0012): do not edit; regenerate with `pnpm sim oracle regen`. dc seed 20261030 index 273 nodes 6 elements 7
.options sparse gmin=1e-12 noopac
RG1 1 0 1000000000000
RG2 2 0 1000000000000
RG3 3 0 1000000000000
RG4 4 0 1000000000000
RG5 5 0 1000000000000
VS0 0 s0 0
V0 e0 s0 DC 15e0
RI0 e0 5 47e-1
VS1 1 s1 0
R1 s1 0 18e-1
VS2 1 s2 0
V2 e2 s2 DC 10e1
RI2 e2 2 18e-3
VS3 4 s3 0
R3 s3 3 47e3
VS4 2 s4 0
R4 s4 3 39e0
VS5 4 s5 0
V5 e5 s5 DC 47e1
RI5 e5 1 10e-2
VS6 2 s6 0
R6 s6 5 39e0
.control
set numdgt=17
op
print v(1) v(2) v(3) v(4) v(5)
print i(vs0) i(vs1) i(vs2) i(vs3) i(vs4) i(vs5) i(vs6)
.endc
.end
