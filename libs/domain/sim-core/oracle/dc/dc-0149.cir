controls oracle dc-0149
* Generated (plan F2.7, ADR 0012): do not edit; regenerate with `pnpm sim oracle regen`. dc seed 20261030 index 149 nodes 15 elements 26
.options sparse gmin=1e-12 noopac
RG1 1 0 1000000000000
RG2 2 0 1000000000000
RG3 3 0 1000000000000
RG4 4 0 1000000000000
RG5 5 0 1000000000000
RG6 6 0 1000000000000
RG7 7 0 1000000000000
RG8 8 0 1000000000000
RG9 9 0 1000000000000
RG10 10 0 1000000000000
RG11 11 0 1000000000000
RG12 12 0 1000000000000
RG13 13 0 1000000000000
RG14 14 0 1000000000000
VS0 13 s0 0
R0 s0 6 56e1
VS1 1 s1 0
R1 s1 10 12e3
VS2 6 s2 0
R2 s2 2 15e1
VS3 0 s3 0
V3 e3 s3 DC 27e-1
RI3 e3 4 33e-1
VS4 7 s4 0
R4 s4 11 39e1
VS5 1 s5 0
R5 s5 12 12e3
VS6 8 s6 0
I6 s6 12 DC 47e-3
VS7 10 s7 0
V7 e7 s7 DC 22e1
RI7 e7 14 27e-1
VS8 0 s8 0
R8 s8 4 22e1
VS9 12 s9 0
R9 s9 6 15e-1
VS10 3 s10 0
V10 e10 s10 DC 27e1
RI10 e10 2 18e-3
VS11 3 s11 0
R11 s11 11 68e-2
VS12 1 s12 0
R12 s12 2 56e-2
VS13 3 s13 0
R13 s13 7 22e2
VS14 8 s14 0
R14 s14 14 10e-2
VS15 9 s15 0
R15 s15 4 18e1
VS16 3 s16 0
R16 s16 2 33e-1
VS17 12 s17 0
V17 e17 s17 DC 68e0
RI17 e17 9 18e-2
VS18 5 s18 0
R18 s18 12 27e3
VS19 13 s19 0
R19 s19 5 68e0
VS20 1 s20 0
R20 s20 14 15e3
VS21 6 s21 0
R21 s21 10 68e1
VS22 11 s22 0
R22 s22 8 33e0
VS23 10 s23 0
I23 s23 5 DC 12e-2
VS24 1 s24 0
R24 s24 4 22e2
VS25 0 s25 0
R25 s25 6 68e2
.control
set numdgt=17
op
print v(1) v(2) v(3) v(4) v(5) v(6) v(7) v(8) v(9) v(10)
print v(11) v(12) v(13) v(14)
print i(vs0) i(vs1) i(vs2) i(vs3) i(vs4) i(vs5) i(vs6) i(vs7) i(vs8) i(vs9)
print i(vs10) i(vs11) i(vs12) i(vs13) i(vs14) i(vs15) i(vs16) i(vs17) i(vs18) i(vs19)
print i(vs20) i(vs21) i(vs22) i(vs23) i(vs24) i(vs25)
.endc
.end
