controls oracle dc-0149
* Generated (plan F2.7, ADR 0012): do not edit; regenerate with `pnpm sim oracle regen`. dc seed 20261030 index 149 nodes 15 elements 22
.options sparse gmin=1e-12 noopac
RG1 1 0 1000000000000
RG2 2 0 1000000000000
RG3 3 0 1000000000000
RG4 4 0 1000000000000
RG5 5 0 1000000000000
RG6 6 0 1000000000000
RG7 7 0 1000000000000
RG8 8 0 1000000000000
RG9 9 0 1000000000000
RG10 10 0 1000000000000
RG11 11 0 1000000000000
RG12 12 0 1000000000000
RG13 13 0 1000000000000
RG14 14 0 1000000000000
VS0 0 s0 0
V0 e0 s0 DC 27e-1
RI0 e0 4 33e-1
VS1 1 s1 0
R1 s1 12 12e3
VS2 3 s2 0
V2 e2 s2 DC 27e1
RI2 e2 2 18e-3
VS3 6 s3 0
R3 s3 10 68e1
VS4 12 s4 0
R4 s4 6 15e-1
VS5 6 s5 0
R5 s5 2 15e1
VS6 0 s6 0
R6 s6 4 22e1
VS7 10 s7 0
V7 e7 s7 DC 22e1
RI7 e7 14 27e-1
VS8 12 s8 0
V8 e8 s8 DC 68e0
RI8 e8 9 18e-2
VS9 3 s9 0
R9 s9 11 68e-2
VS10 3 s10 0
R10 s10 2 33e-1
VS11 1 s11 0
R11 s11 10 12e3
VS12 7 s12 0
R12 s12 11 39e1
VS13 1 s13 0
R13 s13 2 56e-2
VS14 11 s14 0
R14 s14 8 33e0
VS15 1 s15 0
R15 s15 14 15e3
VS16 5 s16 0
R16 s16 12 27e3
VS17 10 s17 0
I17 s17 5 DC 12e-2
VS18 13 s18 0
R18 s18 5 68e0
VS19 1 s19 0
R19 s19 4 22e2
VS20 9 s20 0
R20 s20 4 18e1
VS21 8 s21 0
I21 s21 12 DC 47e-3
.control
set numdgt=17
op
print v(1) v(2) v(3) v(4) v(5) v(6) v(7) v(8) v(9) v(10)
print v(11) v(12) v(13) v(14)
print i(vs0) i(vs1) i(vs2) i(vs3) i(vs4) i(vs5) i(vs6) i(vs7) i(vs8) i(vs9)
print i(vs10) i(vs11) i(vs12) i(vs13) i(vs14) i(vs15) i(vs16) i(vs17) i(vs18) i(vs19)
print i(vs20) i(vs21)
.endc
.end
