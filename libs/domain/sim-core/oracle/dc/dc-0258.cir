controls oracle dc-0258
* Generated (plan F2.7, ADR 0012): do not edit; regenerate with `pnpm sim oracle regen`. dc seed 20261030 index 258 nodes 30 elements 49
.options sparse gmin=1e-12 noopac
RG1 1 0 1000000000000
RG2 2 0 1000000000000
RG3 3 0 1000000000000
RG4 4 0 1000000000000
RG5 5 0 1000000000000
RG6 6 0 1000000000000
RG7 7 0 1000000000000
RG8 8 0 1000000000000
RG9 9 0 1000000000000
RG10 10 0 1000000000000
RG11 11 0 1000000000000
RG12 12 0 1000000000000
RG13 13 0 1000000000000
RG14 14 0 1000000000000
RG15 15 0 1000000000000
RG16 16 0 1000000000000
RG17 17 0 1000000000000
RG18 18 0 1000000000000
RG19 19 0 1000000000000
RG20 20 0 1000000000000
RG21 21 0 1000000000000
RG22 22 0 1000000000000
RG23 23 0 1000000000000
RG24 24 0 1000000000000
RG25 25 0 1000000000000
RG26 26 0 1000000000000
RG27 27 0 1000000000000
RG28 28 0 1000000000000
RG29 29 0 1000000000000
VS0 3 s0 0
R0 s0 23 18e2
VS1 6 s1 0
R1 s1 10 10e-1
VS2 10 s2 0
R2 s2 19 18e1
VS3 14 s3 0
R3 s3 7 56e-1
VS4 27 s4 0
R4 s4 3 68e-1
VS5 0 s5 0
V5 e5 s5 DC 33e0
RI5 e5 15 22e-1
VS6 15 s6 0
R6 s6 13 39e1
VS7 13 s7 0
R7 s7 4 82e-2
VS8 11 s8 0
R8 s8 19 82e3
VS9 11 s9 0
R9 s9 16 15e2
VS10 20 s10 0
R10 s10 25 39e1
VS11 18 s11 0
R11 s11 9 22e-1
VS12 1 s12 0
V12 e12 s12 DC 33e-1
RI12 e12 14 82e-1
VS13 8 s13 0
V13 e13 s13 DC 10e-1
RI13 e13 28 68e-3
VS14 12 s14 0
R14 s14 19 47e2
VS15 28 s15 0
V15 e15 s15 DC 47e1
RI15 e15 24 68e-2
VS16 0 s16 0
R16 s16 4 22e0
VS17 23 s17 0
R17 s17 28 68e0
VS18 3 s18 0
R18 s18 1 18e0
VS19 22 s19 0
R19 s19 26 22e-2
VS20 24 s20 0
I20 s20 5 DC 47e-3
VS21 17 s21 0
I21 s21 10 DC 15e-3
VS22 21 s22 0
R22 s22 10 10e3
VS23 18 s23 0
R23 s23 0 22e1
VS24 24 s24 0
V24 e24 s24 DC 15e0
RI24 e24 13 12e-2
VS25 3 s25 0
R25 s25 0 33e0
VS26 29 s26 0
R26 s26 5 15e3
VS27 7 s27 0
R27 s27 23 68e0
VS28 2 s28 0
R28 s28 1 10e0
VS29 3 s29 0
V29 e29 s29 DC 56e0
RI29 e29 15 18e-2
VS30 22 s30 0
V30 e30 s30 DC 82e1
RI30 e30 15 27e-3
VS31 6 s31 0
R31 s31 14 10e0
VS32 25 s32 0
V32 e32 s32 DC 82e1
RI32 e32 5 68e-3
VS33 27 s33 0
V33 e33 s33 DC 56e0
RI33 e33 18 82e-2
VS34 5 s34 0
R34 s34 19 15e0
VS35 22 s35 0
R35 s35 17 12e3
VS36 17 s36 0
V36 e36 s36 DC 56e0
RI36 e36 9 27e-1
VS37 10 s37 0
I37 s37 13 DC 56e-3
VS38 2 s38 0
R38 s38 8 47e3
VS39 3 s39 0
R39 s39 15 39e-2
VS40 16 s40 0
V40 e40 s40 DC 15e0
RI40 e40 3 56e-1
VS41 26 s41 0
R41 s41 3 27e2
VS42 8 s42 0
I42 s42 19 DC 47e-2
VS43 21 s43 0
R43 s43 26 27e3
VS44 18 s44 0
R44 s44 29 12e0
VS45 20 s45 0
R45 s45 5 39e3
VS46 6 s46 0
V46 e46 s46 DC 15e-1
RI46 e46 12 33e-2
VS47 20 s47 0
R47 s47 15 47e-2
VS48 17 s48 0
R48 s48 0 22e-1
.control
set numdgt=17
op
print v(1) v(2) v(3) v(4) v(5) v(6) v(7) v(8) v(9) v(10)
print v(11) v(12) v(13) v(14) v(15) v(16) v(17) v(18) v(19) v(20)
print v(21) v(22) v(23) v(24) v(25) v(26) v(27) v(28) v(29)
print i(vs0) i(vs1) i(vs2) i(vs3) i(vs4) i(vs5) i(vs6) i(vs7) i(vs8) i(vs9)
print i(vs10) i(vs11) i(vs12) i(vs13) i(vs14) i(vs15) i(vs16) i(vs17) i(vs18) i(vs19)
print i(vs20) i(vs21) i(vs22) i(vs23) i(vs24) i(vs25) i(vs26) i(vs27) i(vs28) i(vs29)
print i(vs30) i(vs31) i(vs32) i(vs33) i(vs34) i(vs35) i(vs36) i(vs37) i(vs38) i(vs39)
print i(vs40) i(vs41) i(vs42) i(vs43) i(vs44) i(vs45) i(vs46) i(vs47) i(vs48)
.endc
.end
