controls oracle dc-0199
* Generated (plan F2.7, ADR 0012): do not edit; regenerate with `pnpm sim oracle regen`. dc seed 20261030 index 199 nodes 24 elements 26
.options sparse gmin=1e-12 noopac
RG1 1 0 1000000000000
RG2 2 0 1000000000000
RG3 3 0 1000000000000
RG4 4 0 1000000000000
RG5 5 0 1000000000000
RG6 6 0 1000000000000
RG7 7 0 1000000000000
RG8 8 0 1000000000000
RG9 9 0 1000000000000
RG10 10 0 1000000000000
RG11 11 0 1000000000000
RG12 12 0 1000000000000
RG13 13 0 1000000000000
RG14 14 0 1000000000000
RG15 15 0 1000000000000
RG16 16 0 1000000000000
RG17 17 0 1000000000000
RG18 18 0 1000000000000
RG19 19 0 1000000000000
RG20 20 0 1000000000000
RG21 21 0 1000000000000
RG22 22 0 1000000000000
RG23 23 0 1000000000000
VS0 17 s0 0
R0 s0 12 12e3
VS1 17 s1 0
R1 s1 19 15e3
VS2 0 s2 0
V2 e2 s2 DC 82e-1
RI2 e2 1 47e-2
VS3 10 s3 0
R3 s3 14 27e-1
VS4 18 s4 0
V4 e4 s4 DC 82e0
RI4 e4 5 15e-3
VS5 15 s5 0
R5 s5 10 12e0
VS6 18 s6 0
V6 e6 s6 DC 33e-1
RI6 e6 22 12e-1
VS7 3 s7 0
R7 s7 10 12e-2
VS8 22 s8 0
R8 s8 23 10e3
VS9 22 s9 0
R9 s9 6 82e-1
VS10 18 s10 0
R10 s10 21 15e-2
VS11 0 s11 0
R11 s11 3 68e-2
VS12 13 s12 0
R12 s12 15 82e-1
VS13 2 s13 0
R13 s13 20 18e-1
VS14 18 s14 0
R14 s14 10 15e0
VS15 15 s15 0
R15 s15 12 68e3
VS16 0 s16 0
R16 s16 20 12e-2
VS17 6 s17 0
V17 e17 s17 DC 27e1
RI17 e17 16 10e-1
VS18 3 s18 0
R18 s18 7 27e0
VS19 18 s19 0
R19 s19 8 33e3
VS20 12 s20 0
R20 s20 22 39e-2
VS21 20 s21 0
V21 e21 s21 DC 10e0
RI21 e21 14 22e-2
VS22 9 s22 0
R22 s22 1 47e2
VS23 4 s23 0
R23 s23 23 15e-2
VS24 22 s24 0
R24 s24 21 15e-1
VS25 18 s25 0
R25 s25 11 27e0
.control
set numdgt=17
op
print v(1) v(2) v(3) v(4) v(5) v(6) v(7) v(8) v(9) v(10)
print v(11) v(12) v(13) v(14) v(15) v(16) v(17) v(18) v(19) v(20)
print v(21) v(22) v(23)
print i(vs0) i(vs1) i(vs2) i(vs3) i(vs4) i(vs5) i(vs6) i(vs7) i(vs8) i(vs9)
print i(vs10) i(vs11) i(vs12) i(vs13) i(vs14) i(vs15) i(vs16) i(vs17) i(vs18) i(vs19)
print i(vs20) i(vs21) i(vs22) i(vs23) i(vs24) i(vs25)
.endc
.end
