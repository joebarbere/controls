controls oracle dc-0199
* Generated (plan F2.7, ADR 0012): do not edit; regenerate with `pnpm sim oracle regen`. dc seed 20261030 index 199 nodes 24 elements 35
.options sparse gmin=1e-12 noopac
RG1 1 0 1000000000000
RG2 2 0 1000000000000
RG3 3 0 1000000000000
RG4 4 0 1000000000000
RG5 5 0 1000000000000
RG6 6 0 1000000000000
RG7 7 0 1000000000000
RG8 8 0 1000000000000
RG9 9 0 1000000000000
RG10 10 0 1000000000000
RG11 11 0 1000000000000
RG12 12 0 1000000000000
RG13 13 0 1000000000000
RG14 14 0 1000000000000
RG15 15 0 1000000000000
RG16 16 0 1000000000000
RG17 17 0 1000000000000
RG18 18 0 1000000000000
RG19 19 0 1000000000000
RG20 20 0 1000000000000
RG21 21 0 1000000000000
RG22 22 0 1000000000000
RG23 23 0 1000000000000
VS0 10 s0 0
R0 s0 20 12e-2
VS1 0 s1 0
R1 s1 11 27e0
VS2 3 s2 0
R2 s2 18 12e-2
VS3 0 s3 0
R3 s3 18 15e0
VS4 5 s4 0
R4 s4 4 15e3
VS5 1 s5 0
R5 s5 5 27e3
VS6 17 s6 0
R6 s6 19 15e3
VS7 9 s7 0
R7 s7 1 47e2
VS8 0 s8 0
V8 e8 s8 DC 82e0
RI8 e8 5 15e-3
VS9 6 s9 0
V9 e9 s9 DC 27e1
RI9 e9 16 10e-1
VS10 0 s10 0
R10 s10 21 15e-2
VS11 2 s11 0
R11 s11 20 18e-1
VS12 17 s12 0
R12 s12 12 12e3
VS13 7 s13 0
R13 s13 14 12e-2
VS14 14 s14 0
R14 s14 13 18e1
VS15 19 s15 0
R15 s15 10 56e-1
VS16 15 s16 0
R16 s16 12 68e3
VS17 22 s17 0
R17 s17 21 15e-1
VS18 22 s18 0
R18 s18 6 82e-1
VS19 20 s19 0
V19 e19 s19 DC 10e0
RI19 e19 14 22e-2
VS20 13 s20 0
R20 s20 15 82e-1
VS21 12 s21 0
R21 s21 22 39e-2
VS22 0 s22 0
V22 e22 s22 DC 33e-1
RI22 e22 22 12e-1
VS23 9 s23 0
R23 s23 0 33e-2
VS24 9 s24 0
V24 e24 s24 DC 82e0
RI24 e24 11 22e-1
VS25 0 s25 0
R25 s25 8 33e3
VS26 15 s26 0
R26 s26 18 12e0
VS27 10 s27 0
R27 s27 3 68e-2
VS28 3 s28 0
R28 s28 7 27e0
VS29 8 s29 0
R29 s29 2 33e-2
VS30 18 s30 0
R30 s30 14 27e-1
VS31 10 s31 0
V31 e31 s31 DC 82e-1
RI31 e31 1 47e-2
VS32 22 s32 0
R32 s32 23 10e3
VS33 4 s33 0
R33 s33 23 15e-2
VS34 0 s34 0
R34 s34 16 18e1
.control
set numdgt=17
op
print v(1) v(2) v(3) v(4) v(5) v(6) v(7) v(8) v(9) v(10)
print v(11) v(12) v(13) v(14) v(15) v(16) v(17) v(18) v(19) v(20)
print v(21) v(22) v(23)
print i(vs0) i(vs1) i(vs2) i(vs3) i(vs4) i(vs5) i(vs6) i(vs7) i(vs8) i(vs9)
print i(vs10) i(vs11) i(vs12) i(vs13) i(vs14) i(vs15) i(vs16) i(vs17) i(vs18) i(vs19)
print i(vs20) i(vs21) i(vs22) i(vs23) i(vs24) i(vs25) i(vs26) i(vs27) i(vs28) i(vs29)
print i(vs30) i(vs31) i(vs32) i(vs33) i(vs34)
.endc
.end
