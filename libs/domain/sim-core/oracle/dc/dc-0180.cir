controls oracle dc-0180
* Generated (plan F2.7, ADR 0012): do not edit; regenerate with `pnpm sim oracle regen`. dc seed 20261030 index 180 nodes 16 elements 26
.options sparse gmin=1e-12 noopac
RG1 1 0 1000000000000
RG2 2 0 1000000000000
RG3 3 0 1000000000000
RG4 4 0 1000000000000
RG5 5 0 1000000000000
RG6 6 0 1000000000000
RG7 7 0 1000000000000
RG8 8 0 1000000000000
RG9 9 0 1000000000000
RG10 10 0 1000000000000
RG11 11 0 1000000000000
RG12 12 0 1000000000000
RG13 13 0 1000000000000
RG14 14 0 1000000000000
RG15 15 0 1000000000000
VS0 10 s0 0
R0 s0 6 15e-2
VS1 13 s1 0
R1 s1 15 18e1
VS2 11 s2 0
R2 s2 3 68e2
VS3 8 s3 0
R3 s3 3 12e2
VS4 5 s4 0
R4 s4 13 15e1
VS5 6 s5 0
I5 s5 8 DC 18e-1
VS6 0 s6 0
V6 e6 s6 DC 18e-1
RI6 e6 13 10e-3
VS7 15 s7 0
R7 s7 6 47e0
VS8 5 s8 0
R8 s8 3 27e1
VS9 14 s9 0
R9 s9 5 68e2
VS10 2 s10 0
R10 s10 11 10e2
VS11 2 s11 0
R11 s11 12 56e3
VS12 13 s12 0
R12 s12 0 56e0
VS13 14 s13 0
R13 s13 0 82e2
VS14 14 s14 0
R14 s14 9 22e1
VS15 4 s15 0
V15 e15 s15 DC 15e0
RI15 e15 13 10e-3
VS16 14 s16 0
I16 s16 10 DC 12e-3
VS17 10 s17 0
I17 s17 5 DC 68e-4
VS18 15 s18 0
R18 s18 6 27e1
VS19 2 s19 0
R19 s19 4 22e3
VS20 2 s20 0
V20 e20 s20 DC 33e-1
RI20 e20 14 39e-3
VS21 13 s21 0
R21 s21 4 82e2
VS22 1 s22 0
V22 e22 s22 DC 33e-1
RI22 e22 7 56e-1
VS23 8 s23 0
R23 s23 14 10e0
VS24 15 s24 0
R24 s24 1 22e1
VS25 6 s25 0
R25 s25 4 18e2
.control
set numdgt=17
op
print v(1) v(2) v(3) v(4) v(5) v(6) v(7) v(8) v(9) v(10)
print v(11) v(12) v(13) v(14) v(15)
print i(vs0) i(vs1) i(vs2) i(vs3) i(vs4) i(vs5) i(vs6) i(vs7) i(vs8) i(vs9)
print i(vs10) i(vs11) i(vs12) i(vs13) i(vs14) i(vs15) i(vs16) i(vs17) i(vs18) i(vs19)
print i(vs20) i(vs21) i(vs22) i(vs23) i(vs24) i(vs25)
.endc
.end
