controls oracle dc-0180
* Generated (plan F2.7, ADR 0012): do not edit; regenerate with `pnpm sim oracle regen`. dc seed 20261030 index 180 nodes 16 elements 29
.options sparse gmin=1e-12 noopac
RG1 1 0 1000000000000
RG2 2 0 1000000000000
RG3 3 0 1000000000000
RG4 4 0 1000000000000
RG5 5 0 1000000000000
RG6 6 0 1000000000000
RG7 7 0 1000000000000
RG8 8 0 1000000000000
RG9 9 0 1000000000000
RG10 10 0 1000000000000
RG11 11 0 1000000000000
RG12 12 0 1000000000000
RG13 13 0 1000000000000
RG14 14 0 1000000000000
RG15 15 0 1000000000000
VS0 14 s0 0
R0 s0 9 22e1
VS1 14 s1 0
R1 s1 5 68e2
VS2 4 s2 0
R2 s2 1 22e1
VS3 11 s3 0
R3 s3 3 68e2
VS4 5 s4 0
R4 s4 13 15e1
VS5 6 s5 0
I5 s5 8 DC 18e-1
VS6 10 s6 0
R6 s6 9 82e0
VS7 2 s7 0
R7 s7 12 56e3
VS8 10 s8 0
I8 s8 5 DC 68e-4
VS9 6 s9 0
R9 s9 0 18e2
VS10 11 s10 0
R10 s10 12 22e2
VS11 14 s11 0
I11 s11 10 DC 12e-3
VS12 13 s12 0
R12 s12 4 18e1
VS13 2 s13 0
R13 s13 11 10e2
VS14 14 s14 0
R14 s14 15 82e2
VS15 5 s15 0
R15 s15 3 27e1
VS16 10 s16 0
R16 s16 6 15e-2
VS17 0 s17 0
V17 e17 s17 DC 15e0
RI17 e17 13 10e-3
VS18 2 s18 0
R18 s18 0 22e3
VS19 8 s19 0
R19 s19 14 10e0
VS20 2 s20 0
V20 e20 s20 DC 33e-1
RI20 e20 14 39e-3
VS21 1 s21 0
V21 e21 s21 DC 33e-1
RI21 e21 7 56e-1
VS22 4 s22 0
R22 s22 6 47e0
VS23 7 s23 0
V23 e23 s23 DC 56e-1
RI23 e23 10 10e-3
VS24 8 s24 0
R24 s24 3 12e2
VS25 15 s25 0
V25 e25 s25 DC 18e-1
RI25 e25 13 10e-3
VS26 13 s26 0
R26 s26 0 82e2
VS27 13 s27 0
R27 s27 15 56e0
VS28 4 s28 0
R28 s28 6 27e1
.control
set numdgt=17
op
print v(1) v(2) v(3) v(4) v(5) v(6) v(7) v(8) v(9) v(10)
print v(11) v(12) v(13) v(14) v(15)
print i(vs0) i(vs1) i(vs2) i(vs3) i(vs4) i(vs5) i(vs6) i(vs7) i(vs8) i(vs9)
print i(vs10) i(vs11) i(vs12) i(vs13) i(vs14) i(vs15) i(vs16) i(vs17) i(vs18) i(vs19)
print i(vs20) i(vs21) i(vs22) i(vs23) i(vs24) i(vs25) i(vs26) i(vs27) i(vs28)
.endc
.end
