controls oracle dc-0190
* Generated (plan F2.7, ADR 0012): do not edit; regenerate with `pnpm sim oracle regen`. dc seed 20261030 index 190 nodes 12 elements 17
.options sparse gmin=1e-12 noopac
RG1 1 0 1000000000000
RG2 2 0 1000000000000
RG3 3 0 1000000000000
RG4 4 0 1000000000000
RG5 5 0 1000000000000
RG6 6 0 1000000000000
RG7 7 0 1000000000000
RG8 8 0 1000000000000
RG9 9 0 1000000000000
RG10 10 0 1000000000000
RG11 11 0 1000000000000
VS0 9 s0 0
R0 s0 7 12e2
VS1 8 s1 0
R1 s1 5 27e-2
VS2 0 s2 0
V2 e2 s2 DC 22e1
RI2 e2 8 22e-3
VS3 2 s3 0
R3 s3 0 82e-1
VS4 7 s4 0
R4 s4 1 27e-2
VS5 10 s5 0
R5 s5 3 33e3
VS6 2 s6 0
V6 e6 s6 DC 68e0
RI6 e6 1 10e-1
VS7 3 s7 0
R7 s7 0 68e1
VS8 11 s8 0
R8 s8 4 68e0
VS9 7 s9 0
V9 e9 s9 DC 10e-1
RI9 e9 5 56e-3
VS10 9 s10 0
R10 s10 11 82e-2
VS11 7 s11 0
R11 s11 0 27e-1
VS12 4 s12 0
R12 s12 0 33e2
VS13 10 s13 0
R13 s13 7 27e1
VS14 11 s14 0
R14 s14 0 82e2
VS15 6 s15 0
R15 s15 10 18e3
VS16 0 s16 0
V16 e16 s16 DC 47e1
RI16 e16 6 47e-2
.control
set numdgt=17
op
print v(1) v(2) v(3) v(4) v(5) v(6) v(7) v(8) v(9) v(10)
print v(11)
print i(vs0) i(vs1) i(vs2) i(vs3) i(vs4) i(vs5) i(vs6) i(vs7) i(vs8) i(vs9)
print i(vs10) i(vs11) i(vs12) i(vs13) i(vs14) i(vs15) i(vs16)
.endc
.end
