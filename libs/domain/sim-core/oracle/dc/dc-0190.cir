controls oracle dc-0190
* Generated (plan F2.7, ADR 0012): do not edit; regenerate with `pnpm sim oracle regen`. dc seed 20261030 index 190 nodes 12 elements 12
.options sparse gmin=1e-12 noopac
RG1 1 0 1000000000000
RG2 2 0 1000000000000
RG3 3 0 1000000000000
RG4 4 0 1000000000000
RG5 5 0 1000000000000
RG6 6 0 1000000000000
RG7 7 0 1000000000000
RG8 8 0 1000000000000
RG9 9 0 1000000000000
RG10 10 0 1000000000000
RG11 11 0 1000000000000
VS0 9 s0 0
R0 s0 7 12e2
VS1 0 s1 0
R1 s1 2 82e-1
VS2 0 s2 0
V2 e2 s2 DC 68e0
RI2 e2 1 10e-1
VS3 2 s3 0
V3 e3 s3 DC 22e1
RI3 e3 8 22e-3
VS4 3 s4 0
R4 s4 2 68e1
VS5 10 s5 0
R5 s5 7 27e1
VS6 7 s6 0
V6 e6 s6 DC 10e-1
RI6 e6 5 56e-3
VS7 4 s7 0
R7 s7 2 33e2
VS8 2 s8 0
V8 e8 s8 DC 47e1
RI8 e8 6 47e-2
VS9 7 s9 0
R9 s9 1 27e-2
VS10 11 s10 0
R10 s10 2 82e2
VS11 7 s11 0
R11 s11 2 27e-1
.control
set numdgt=17
op
print v(1) v(2) v(3) v(4) v(5) v(6) v(7) v(8) v(9) v(10)
print v(11)
print i(vs0) i(vs1) i(vs2) i(vs3) i(vs4) i(vs5) i(vs6) i(vs7) i(vs8) i(vs9)
print i(vs10) i(vs11)
.endc
.end
