controls oracle dc-0165
* Generated (plan F2.7, ADR 0012): do not edit; regenerate with `pnpm sim oracle regen`. dc seed 20261030 index 165 nodes 26 elements 52
.options sparse gmin=1e-12 noopac
RG1 1 0 1000000000000
RG2 2 0 1000000000000
RG3 3 0 1000000000000
RG4 4 0 1000000000000
RG5 5 0 1000000000000
RG6 6 0 1000000000000
RG7 7 0 1000000000000
RG8 8 0 1000000000000
RG9 9 0 1000000000000
RG10 10 0 1000000000000
RG11 11 0 1000000000000
RG12 12 0 1000000000000
RG13 13 0 1000000000000
RG14 14 0 1000000000000
RG15 15 0 1000000000000
RG16 16 0 1000000000000
RG17 17 0 1000000000000
RG18 18 0 1000000000000
RG19 19 0 1000000000000
RG20 20 0 1000000000000
RG21 21 0 1000000000000
RG22 22 0 1000000000000
RG23 23 0 1000000000000
RG24 24 0 1000000000000
RG25 25 0 1000000000000
VS0 3 s0 0
R0 s0 24 27e3
VS1 0 s1 0
V1 e1 s1 DC 18e-1
RI1 e1 22 18e-3
VS2 5 s2 0
V2 e2 s2 DC 68e0
RI2 e2 17 47e-3
VS3 21 s3 0
R3 s3 10 22e3
VS4 18 s4 0
R4 s4 12 33e-1
VS5 22 s5 0
R5 s5 11 56e-1
VS6 17 s6 0
V6 e6 s6 DC 12e0
RI6 e6 10 15e-2
VS7 4 s7 0
V7 e7 s7 DC 15e-1
RI7 e7 21 22e-2
VS8 2 s8 0
R8 s8 19 68e0
VS9 23 s9 0
V9 e9 s9 DC 39e1
RI9 e9 3 10e-1
VS10 25 s10 0
R10 s10 5 82e-1
VS11 12 s11 0
V11 e11 s11 DC 39e-1
RI11 e11 25 12e-3
VS12 9 s12 0
R12 s12 2 10e-2
VS13 4 s13 0
R13 s13 13 15e-1
VS14 11 s14 0
V14 e14 s14 DC 12e1
RI14 e14 17 27e-2
VS15 14 s15 0
V15 e15 s15 DC 33e-1
RI15 e15 2 68e-2
VS16 8 s16 0
R16 s16 5 10e3
VS17 10 s17 0
V17 e17 s17 DC 22e1
RI17 e17 16 47e-3
VS18 15 s18 0
V18 e18 s18 DC 47e-1
RI18 e18 18 15e-3
VS19 13 s19 0
R19 s19 24 82e3
VS20 4 s20 0
I20 s20 3 DC 56e-2
VS21 17 s21 0
R21 s21 2 56e3
VS22 5 s22 0
V22 e22 s22 DC 56e1
RI22 e22 20 27e-3
VS23 25 s23 0
R23 s23 8 39e2
VS24 5 s24 0
I24 s24 8 DC 12e-3
VS25 7 s25 0
R25 s25 4 47e2
VS26 18 s26 0
R26 s26 5 12e-2
VS27 7 s27 0
R27 s27 18 68e-2
VS28 1 s28 0
R28 s28 3 33e1
VS29 5 s29 0
R29 s29 1 33e-2
VS30 0 s30 0
R30 s30 5 47e1
VS31 6 s31 0
R31 s31 21 27e1
VS32 0 s32 0
R32 s32 4 22e1
VS33 7 s33 0
R33 s33 16 68e-2
VS34 25 s34 0
I34 s34 13 DC 10e-2
VS35 15 s35 0
V35 e35 s35 DC 27e-1
RI35 e35 21 18e-1
VS36 10 s36 0
I36 s36 5 DC 27e-4
VS37 3 s37 0
R37 s37 9 47e1
VS38 14 s38 0
R38 s38 9 22e-2
VS39 9 s39 0
R39 s39 19 56e0
VS40 0 s40 0
V40 e40 s40 DC 56e1
RI40 e40 8 18e-2
VS41 0 s41 0
R41 s41 20 15e3
VS42 17 s42 0
I42 s42 20 DC 68e-2
VS43 4 s43 0
R43 s43 2 33e0
VS44 12 s44 0
R44 s44 6 39e2
VS45 8 s45 0
I45 s45 3 DC 22e-3
VS46 20 s46 0
I46 s46 7 DC 15e-3
VS47 22 s47 0
V47 e47 s47 DC 22e1
RI47 e47 13 39e-3
VS48 10 s48 0
R48 s48 21 68e1
VS49 10 s49 0
I49 s49 16 DC 18e-3
VS50 9 s50 0
R50 s50 23 12e-1
VS51 15 s51 0
I51 s51 3 DC 18e-2
.control
set numdgt=17
op
print v(1) v(2) v(3) v(4) v(5) v(6) v(7) v(8) v(9) v(10)
print v(11) v(12) v(13) v(14) v(15) v(16) v(17) v(18) v(19) v(20)
print v(21) v(22) v(23) v(24) v(25)
print i(vs0) i(vs1) i(vs2) i(vs3) i(vs4) i(vs5) i(vs6) i(vs7) i(vs8) i(vs9)
print i(vs10) i(vs11) i(vs12) i(vs13) i(vs14) i(vs15) i(vs16) i(vs17) i(vs18) i(vs19)
print i(vs20) i(vs21) i(vs22) i(vs23) i(vs24) i(vs25) i(vs26) i(vs27) i(vs28) i(vs29)
print i(vs30) i(vs31) i(vs32) i(vs33) i(vs34) i(vs35) i(vs36) i(vs37) i(vs38) i(vs39)
print i(vs40) i(vs41) i(vs42) i(vs43) i(vs44) i(vs45) i(vs46) i(vs47) i(vs48) i(vs49)
print i(vs50) i(vs51)
.endc
.end
