controls oracle dc-0165
* Generated (plan F2.7, ADR 0012): do not edit; regenerate with `pnpm sim oracle regen`. dc seed 20261030 index 165 nodes 26 elements 44
.options sparse gmin=1e-12 noopac
RG1 1 0 1000000000000
RG2 2 0 1000000000000
RG3 3 0 1000000000000
RG4 4 0 1000000000000
RG5 5 0 1000000000000
RG6 6 0 1000000000000
RG7 7 0 1000000000000
RG8 8 0 1000000000000
RG9 9 0 1000000000000
RG10 10 0 1000000000000
RG11 11 0 1000000000000
RG12 12 0 1000000000000
RG13 13 0 1000000000000
RG14 14 0 1000000000000
RG15 15 0 1000000000000
RG16 16 0 1000000000000
RG17 17 0 1000000000000
RG18 18 0 1000000000000
RG19 19 0 1000000000000
RG20 20 0 1000000000000
RG21 21 0 1000000000000
RG22 22 0 1000000000000
RG23 23 0 1000000000000
RG24 24 0 1000000000000
RG25 25 0 1000000000000
VS0 7 s0 0
R0 s0 18 68e-2
VS1 0 s1 0
I1 s1 5 DC 27e-4
VS2 0 s2 0
V2 e2 s2 DC 22e1
RI2 e2 16 47e-3
VS3 7 s3 0
R3 s3 10 47e2
VS4 3 s4 0
R4 s4 9 47e1
VS5 17 s5 0
R5 s5 2 56e3
VS6 13 s6 0
R6 s6 24 82e3
VS7 10 s7 0
R7 s7 13 15e-1
VS8 22 s8 0
R8 s8 11 56e-1
VS9 5 s9 0
R9 s9 1 33e-2
VS10 1 s10 0
R10 s10 3 33e1
VS11 10 s11 0
I11 s11 3 DC 56e-2
VS12 9 s12 0
R12 s12 19 56e0
VS13 17 s13 0
V13 e13 s13 DC 12e0
RI13 e13 0 15e-2
VS14 18 s14 0
R14 s14 5 12e-2
VS15 5 s15 0
I15 s15 8 DC 12e-3
VS16 20 s16 0
I16 s16 7 DC 15e-3
VS17 25 s17 0
R17 s17 8 39e2
VS18 14 s18 0
V18 e18 s18 DC 33e-1
RI18 e18 2 68e-2
VS19 0 s19 0
I19 s19 16 DC 18e-3
VS20 17 s20 0
I20 s20 20 DC 68e-2
VS21 15 s21 0
I21 s21 3 DC 18e-2
VS22 10 s22 0
R22 s22 2 33e0
VS23 0 s23 0
R23 s23 21 68e1
VS24 6 s24 0
R24 s24 21 27e1
VS25 5 s25 0
V25 e25 s25 DC 68e0
RI25 e25 17 47e-3
VS26 4 s26 0
R26 s26 5 47e1
VS27 4 s27 0
R27 s27 10 22e1
VS28 12 s28 0
V28 e28 s28 DC 39e-1
RI28 e28 25 12e-3
VS29 21 s29 0
R29 s29 0 22e3
VS30 10 s30 0
V30 e30 s30 DC 15e-1
RI30 e30 21 22e-2
VS31 15 s31 0
V31 e31 s31 DC 27e-1
RI31 e31 21 18e-1
VS32 18 s32 0
R32 s32 12 33e-1
VS33 22 s33 0
V33 e33 s33 DC 22e1
RI33 e33 13 39e-3
VS34 8 s34 0
R34 s34 5 10e3
VS35 25 s35 0
I35 s35 13 DC 10e-2
VS36 4 s36 0
V36 e36 s36 DC 56e1
RI36 e36 8 18e-2
VS37 4 s37 0
V37 e37 s37 DC 18e-1
RI37 e37 22 18e-3
VS38 9 s38 0
R38 s38 23 12e-1
VS39 4 s39 0
R39 s39 20 15e3
VS40 8 s40 0
I40 s40 3 DC 22e-3
VS41 12 s41 0
R41 s41 6 39e2
VS42 25 s42 0
R42 s42 5 82e-1
VS43 9 s43 0
R43 s43 2 10e-2
.control
set numdgt=17
op
print v(1) v(2) v(3) v(4) v(5) v(6) v(7) v(8) v(9) v(10)
print v(11) v(12) v(13) v(14) v(15) v(16) v(17) v(18) v(19) v(20)
print v(21) v(22) v(23) v(24) v(25)
print i(vs0) i(vs1) i(vs2) i(vs3) i(vs4) i(vs5) i(vs6) i(vs7) i(vs8) i(vs9)
print i(vs10) i(vs11) i(vs12) i(vs13) i(vs14) i(vs15) i(vs16) i(vs17) i(vs18) i(vs19)
print i(vs20) i(vs21) i(vs22) i(vs23) i(vs24) i(vs25) i(vs26) i(vs27) i(vs28) i(vs29)
print i(vs30) i(vs31) i(vs32) i(vs33) i(vs34) i(vs35) i(vs36) i(vs37) i(vs38) i(vs39)
print i(vs40) i(vs41) i(vs42) i(vs43)
.endc
.end
